* user_analog_project_wrapper: TCIM0 SKY130 test chip (reference for LVS)
* reference of the analog macro
.subckt tcim_sky130_array WL0 WL1 WL2 WL3 WL4 WL5 WL6 WL7 WL8 WL9 WL10 WL11 WL12 WL13 WL14 WL15 WL16 WL17 WL18 WL19 WL20 WL21 WL22 WL23 WL24 WL25 WL26 WL27 WL28 WL29 WL30 WL31 WL32 WL33 WL34 WL35 WL36 WL37 WL38 WL39 WL40 WL41 WL42 WL43 WL44 WL45 WL46 WL47 WL48 WL49 WL50 WL51 WL52 WL53 WL54 WL55 WL56 WL57 WL58 WL59 WL60 WL61 WL62 WL63 WL64 WL65 WL66 WL67 WL68 WL69 WL70 WL71 BLP0 BLP1 BLP2 BLP3 BLP4 BLP5 BLP6 BLP7 BLP8 BLP9 BLP10 BLP11 BLP12 BLP13 BLP14 BLP15 BLP16 BLP17 BLP18 BLP19 BLP20 BLP21 BLP22 BLP23 BLN0 BLN1 BLN2 BLN3 BLN4 BLN5 BLN6 BLN7 BLN8 BLN9 BLN10 BLN11 BLN12 BLN13 BLN14 BLN15 BLN16 BLN17 BLN18 BLN19 BLN20 BLN21 BLN22 BLN23 SL0 SL1 SL2 SL3 SL4 SL5 SL6 SL7 SL8 SL9 SL10 SL11 SL12 SL13 SL14 SL15 SL16 SL17 SL18 SL19 SL20 SL21 SL22 SL23 VSS
XMp_0_0 dp_0_0 WL0 SL0 VSS sky130_fd_pr__nfet_g5v0d10v5 w=1 l=0.5
XRp_0_0 BLP0 dp_0_0 sky130_fd_pr_reram__reram_cell area_ox=0.0676
XMn_0_0 dn_0_0 WL0 SL0 VSS sky130_fd_pr__nfet_g5v0d10v5 w=1 l=0.5
XRn_0_0 BLN0 dn_0_0 sky130_fd_pr_reram__reram_cell area_ox=0.0676
XMp_0_1 dp_0_1 WL0 SL1 VSS sky130_fd_pr__nfet_g5v0d10v5 w=1 l=0.5
XRp_0_1 BLP1 dp_0_1 sky130_fd_pr_reram__reram_cell area_ox=0.0676
XMn_0_1 dn_0_1 WL0 SL1 VSS sky130_fd_pr__nfet_g5v0d10v5 w=1 l=0.5
XRn_0_1 BLN1 dn_0_1 sky130_fd_pr_reram__reram_cell area_ox=0.0676
XMp_0_2 dp_0_2 WL0 SL2 VSS sky130_fd_pr__nfet_g5v0d10v5 w=1 l=0.5
XRp_0_2 BLP2 dp_0_2 sky130_fd_pr_reram__reram_cell area_ox=0.0676
XMn_0_2 dn_0_2 WL0 SL2 VSS sky130_fd_pr__nfet_g5v0d10v5 w=1 l=0.5
XRn_0_2 BLN2 dn_0_2 sky130_fd_pr_reram__reram_cell area_ox=0.0676
XMp_0_3 dp_0_3 WL0 SL3 VSS sky130_fd_pr__nfet_g5v0d10v5 w=1 l=0.5
XRp_0_3 BLP3 dp_0_3 sky130_fd_pr_reram__reram_cell area_ox=0.0676
XMn_0_3 dn_0_3 WL0 SL3 VSS sky130_fd_pr__nfet_g5v0d10v5 w=1 l=0.5
XRn_0_3 BLN3 dn_0_3 sky130_fd_pr_reram__reram_cell area_ox=0.0676
XMp_0_4 dp_0_4 WL0 SL4 VSS sky130_fd_pr__nfet_g5v0d10v5 w=1 l=0.5
XRp_0_4 BLP4 dp_0_4 sky130_fd_pr_reram__reram_cell area_ox=0.0676
XMn_0_4 dn_0_4 WL0 SL4 VSS sky130_fd_pr__nfet_g5v0d10v5 w=1 l=0.5
XRn_0_4 BLN4 dn_0_4 sky130_fd_pr_reram__reram_cell area_ox=0.0676
XMp_0_5 dp_0_5 WL0 SL5 VSS sky130_fd_pr__nfet_g5v0d10v5 w=1 l=0.5
XRp_0_5 BLP5 dp_0_5 sky130_fd_pr_reram__reram_cell area_ox=0.0676
XMn_0_5 dn_0_5 WL0 SL5 VSS sky130_fd_pr__nfet_g5v0d10v5 w=1 l=0.5
XRn_0_5 BLN5 dn_0_5 sky130_fd_pr_reram__reram_cell area_ox=0.0676
XMp_0_6 dp_0_6 WL0 SL6 VSS sky130_fd_pr__nfet_g5v0d10v5 w=1 l=0.5
XRp_0_6 BLP6 dp_0_6 sky130_fd_pr_reram__reram_cell area_ox=0.0676
XMn_0_6 dn_0_6 WL0 SL6 VSS sky130_fd_pr__nfet_g5v0d10v5 w=1 l=0.5
XRn_0_6 BLN6 dn_0_6 sky130_fd_pr_reram__reram_cell area_ox=0.0676
XMp_0_7 dp_0_7 WL0 SL7 VSS sky130_fd_pr__nfet_g5v0d10v5 w=1 l=0.5
XRp_0_7 BLP7 dp_0_7 sky130_fd_pr_reram__reram_cell area_ox=0.0676
XMn_0_7 dn_0_7 WL0 SL7 VSS sky130_fd_pr__nfet_g5v0d10v5 w=1 l=0.5
XRn_0_7 BLN7 dn_0_7 sky130_fd_pr_reram__reram_cell area_ox=0.0676
XMp_0_8 dp_0_8 WL0 SL8 VSS sky130_fd_pr__nfet_g5v0d10v5 w=1 l=0.5
XRp_0_8 BLP8 dp_0_8 sky130_fd_pr_reram__reram_cell area_ox=0.0676
XMn_0_8 dn_0_8 WL0 SL8 VSS sky130_fd_pr__nfet_g5v0d10v5 w=1 l=0.5
XRn_0_8 BLN8 dn_0_8 sky130_fd_pr_reram__reram_cell area_ox=0.0676
XMp_0_9 dp_0_9 WL0 SL9 VSS sky130_fd_pr__nfet_g5v0d10v5 w=1 l=0.5
XRp_0_9 BLP9 dp_0_9 sky130_fd_pr_reram__reram_cell area_ox=0.0676
XMn_0_9 dn_0_9 WL0 SL9 VSS sky130_fd_pr__nfet_g5v0d10v5 w=1 l=0.5
XRn_0_9 BLN9 dn_0_9 sky130_fd_pr_reram__reram_cell area_ox=0.0676
XMp_0_10 dp_0_10 WL0 SL10 VSS sky130_fd_pr__nfet_g5v0d10v5 w=1 l=0.5
XRp_0_10 BLP10 dp_0_10 sky130_fd_pr_reram__reram_cell area_ox=0.0676
XMn_0_10 dn_0_10 WL0 SL10 VSS sky130_fd_pr__nfet_g5v0d10v5 w=1 l=0.5
XRn_0_10 BLN10 dn_0_10 sky130_fd_pr_reram__reram_cell area_ox=0.0676
XMp_0_11 dp_0_11 WL0 SL11 VSS sky130_fd_pr__nfet_g5v0d10v5 w=1 l=0.5
XRp_0_11 BLP11 dp_0_11 sky130_fd_pr_reram__reram_cell area_ox=0.0676
XMn_0_11 dn_0_11 WL0 SL11 VSS sky130_fd_pr__nfet_g5v0d10v5 w=1 l=0.5
XRn_0_11 BLN11 dn_0_11 sky130_fd_pr_reram__reram_cell area_ox=0.0676
XMp_0_12 dp_0_12 WL0 SL12 VSS sky130_fd_pr__nfet_g5v0d10v5 w=1 l=0.5
XRp_0_12 BLP12 dp_0_12 sky130_fd_pr_reram__reram_cell area_ox=0.0676
XMn_0_12 dn_0_12 WL0 SL12 VSS sky130_fd_pr__nfet_g5v0d10v5 w=1 l=0.5
XRn_0_12 BLN12 dn_0_12 sky130_fd_pr_reram__reram_cell area_ox=0.0676
XMp_0_13 dp_0_13 WL0 SL13 VSS sky130_fd_pr__nfet_g5v0d10v5 w=1 l=0.5
XRp_0_13 BLP13 dp_0_13 sky130_fd_pr_reram__reram_cell area_ox=0.0676
XMn_0_13 dn_0_13 WL0 SL13 VSS sky130_fd_pr__nfet_g5v0d10v5 w=1 l=0.5
XRn_0_13 BLN13 dn_0_13 sky130_fd_pr_reram__reram_cell area_ox=0.0676
XMp_0_14 dp_0_14 WL0 SL14 VSS sky130_fd_pr__nfet_g5v0d10v5 w=1 l=0.5
XRp_0_14 BLP14 dp_0_14 sky130_fd_pr_reram__reram_cell area_ox=0.0676
XMn_0_14 dn_0_14 WL0 SL14 VSS sky130_fd_pr__nfet_g5v0d10v5 w=1 l=0.5
XRn_0_14 BLN14 dn_0_14 sky130_fd_pr_reram__reram_cell area_ox=0.0676
XMp_0_15 dp_0_15 WL0 SL15 VSS sky130_fd_pr__nfet_g5v0d10v5 w=1 l=0.5
XRp_0_15 BLP15 dp_0_15 sky130_fd_pr_reram__reram_cell area_ox=0.0676
XMn_0_15 dn_0_15 WL0 SL15 VSS sky130_fd_pr__nfet_g5v0d10v5 w=1 l=0.5
XRn_0_15 BLN15 dn_0_15 sky130_fd_pr_reram__reram_cell area_ox=0.0676
XMp_0_16 dp_0_16 WL0 SL16 VSS sky130_fd_pr__nfet_g5v0d10v5 w=1 l=0.5
XRp_0_16 BLP16 dp_0_16 sky130_fd_pr_reram__reram_cell area_ox=0.0676
XMn_0_16 dn_0_16 WL0 SL16 VSS sky130_fd_pr__nfet_g5v0d10v5 w=1 l=0.5
XRn_0_16 BLN16 dn_0_16 sky130_fd_pr_reram__reram_cell area_ox=0.0676
XMp_0_17 dp_0_17 WL0 SL17 VSS sky130_fd_pr__nfet_g5v0d10v5 w=1 l=0.5
XRp_0_17 BLP17 dp_0_17 sky130_fd_pr_reram__reram_cell area_ox=0.0676
XMn_0_17 dn_0_17 WL0 SL17 VSS sky130_fd_pr__nfet_g5v0d10v5 w=1 l=0.5
XRn_0_17 BLN17 dn_0_17 sky130_fd_pr_reram__reram_cell area_ox=0.0676
XMp_0_18 dp_0_18 WL0 SL18 VSS sky130_fd_pr__nfet_g5v0d10v5 w=1 l=0.5
XRp_0_18 BLP18 dp_0_18 sky130_fd_pr_reram__reram_cell area_ox=0.0676
XMn_0_18 dn_0_18 WL0 SL18 VSS sky130_fd_pr__nfet_g5v0d10v5 w=1 l=0.5
XRn_0_18 BLN18 dn_0_18 sky130_fd_pr_reram__reram_cell area_ox=0.0676
XMp_0_19 dp_0_19 WL0 SL19 VSS sky130_fd_pr__nfet_g5v0d10v5 w=1 l=0.5
XRp_0_19 BLP19 dp_0_19 sky130_fd_pr_reram__reram_cell area_ox=0.0676
XMn_0_19 dn_0_19 WL0 SL19 VSS sky130_fd_pr__nfet_g5v0d10v5 w=1 l=0.5
XRn_0_19 BLN19 dn_0_19 sky130_fd_pr_reram__reram_cell area_ox=0.0676
XMp_0_20 dp_0_20 WL0 SL20 VSS sky130_fd_pr__nfet_g5v0d10v5 w=1 l=0.5
XRp_0_20 BLP20 dp_0_20 sky130_fd_pr_reram__reram_cell area_ox=0.0676
XMn_0_20 dn_0_20 WL0 SL20 VSS sky130_fd_pr__nfet_g5v0d10v5 w=1 l=0.5
XRn_0_20 BLN20 dn_0_20 sky130_fd_pr_reram__reram_cell area_ox=0.0676
XMp_0_21 dp_0_21 WL0 SL21 VSS sky130_fd_pr__nfet_g5v0d10v5 w=1 l=0.5
XRp_0_21 BLP21 dp_0_21 sky130_fd_pr_reram__reram_cell area_ox=0.0676
XMn_0_21 dn_0_21 WL0 SL21 VSS sky130_fd_pr__nfet_g5v0d10v5 w=1 l=0.5
XRn_0_21 BLN21 dn_0_21 sky130_fd_pr_reram__reram_cell area_ox=0.0676
XMp_0_22 dp_0_22 WL0 SL22 VSS sky130_fd_pr__nfet_g5v0d10v5 w=1 l=0.5
XRp_0_22 BLP22 dp_0_22 sky130_fd_pr_reram__reram_cell area_ox=0.0676
XMn_0_22 dn_0_22 WL0 SL22 VSS sky130_fd_pr__nfet_g5v0d10v5 w=1 l=0.5
XRn_0_22 BLN22 dn_0_22 sky130_fd_pr_reram__reram_cell area_ox=0.0676
XMp_0_23 dp_0_23 WL0 SL23 VSS sky130_fd_pr__nfet_g5v0d10v5 w=1 l=0.5
XRp_0_23 BLP23 dp_0_23 sky130_fd_pr_reram__reram_cell area_ox=0.0676
XMn_0_23 dn_0_23 WL0 SL23 VSS sky130_fd_pr__nfet_g5v0d10v5 w=1 l=0.5
XRn_0_23 BLN23 dn_0_23 sky130_fd_pr_reram__reram_cell area_ox=0.0676
XMp_1_0 dp_1_0 WL1 SL0 VSS sky130_fd_pr__nfet_g5v0d10v5 w=1 l=0.5
XRp_1_0 BLP0 dp_1_0 sky130_fd_pr_reram__reram_cell area_ox=0.0676
XMn_1_0 dn_1_0 WL1 SL0 VSS sky130_fd_pr__nfet_g5v0d10v5 w=1 l=0.5
XRn_1_0 BLN0 dn_1_0 sky130_fd_pr_reram__reram_cell area_ox=0.0676
XMp_1_1 dp_1_1 WL1 SL1 VSS sky130_fd_pr__nfet_g5v0d10v5 w=1 l=0.5
XRp_1_1 BLP1 dp_1_1 sky130_fd_pr_reram__reram_cell area_ox=0.0676
XMn_1_1 dn_1_1 WL1 SL1 VSS sky130_fd_pr__nfet_g5v0d10v5 w=1 l=0.5
XRn_1_1 BLN1 dn_1_1 sky130_fd_pr_reram__reram_cell area_ox=0.0676
XMp_1_2 dp_1_2 WL1 SL2 VSS sky130_fd_pr__nfet_g5v0d10v5 w=1 l=0.5
XRp_1_2 BLP2 dp_1_2 sky130_fd_pr_reram__reram_cell area_ox=0.0676
XMn_1_2 dn_1_2 WL1 SL2 VSS sky130_fd_pr__nfet_g5v0d10v5 w=1 l=0.5
XRn_1_2 BLN2 dn_1_2 sky130_fd_pr_reram__reram_cell area_ox=0.0676
XMp_1_3 dp_1_3 WL1 SL3 VSS sky130_fd_pr__nfet_g5v0d10v5 w=1 l=0.5
XRp_1_3 BLP3 dp_1_3 sky130_fd_pr_reram__reram_cell area_ox=0.0676
XMn_1_3 dn_1_3 WL1 SL3 VSS sky130_fd_pr__nfet_g5v0d10v5 w=1 l=0.5
XRn_1_3 BLN3 dn_1_3 sky130_fd_pr_reram__reram_cell area_ox=0.0676
XMp_1_4 dp_1_4 WL1 SL4 VSS sky130_fd_pr__nfet_g5v0d10v5 w=1 l=0.5
XRp_1_4 BLP4 dp_1_4 sky130_fd_pr_reram__reram_cell area_ox=0.0676
XMn_1_4 dn_1_4 WL1 SL4 VSS sky130_fd_pr__nfet_g5v0d10v5 w=1 l=0.5
XRn_1_4 BLN4 dn_1_4 sky130_fd_pr_reram__reram_cell area_ox=0.0676
XMp_1_5 dp_1_5 WL1 SL5 VSS sky130_fd_pr__nfet_g5v0d10v5 w=1 l=0.5
XRp_1_5 BLP5 dp_1_5 sky130_fd_pr_reram__reram_cell area_ox=0.0676
XMn_1_5 dn_1_5 WL1 SL5 VSS sky130_fd_pr__nfet_g5v0d10v5 w=1 l=0.5
XRn_1_5 BLN5 dn_1_5 sky130_fd_pr_reram__reram_cell area_ox=0.0676
XMp_1_6 dp_1_6 WL1 SL6 VSS sky130_fd_pr__nfet_g5v0d10v5 w=1 l=0.5
XRp_1_6 BLP6 dp_1_6 sky130_fd_pr_reram__reram_cell area_ox=0.0676
XMn_1_6 dn_1_6 WL1 SL6 VSS sky130_fd_pr__nfet_g5v0d10v5 w=1 l=0.5
XRn_1_6 BLN6 dn_1_6 sky130_fd_pr_reram__reram_cell area_ox=0.0676
XMp_1_7 dp_1_7 WL1 SL7 VSS sky130_fd_pr__nfet_g5v0d10v5 w=1 l=0.5
XRp_1_7 BLP7 dp_1_7 sky130_fd_pr_reram__reram_cell area_ox=0.0676
XMn_1_7 dn_1_7 WL1 SL7 VSS sky130_fd_pr__nfet_g5v0d10v5 w=1 l=0.5
XRn_1_7 BLN7 dn_1_7 sky130_fd_pr_reram__reram_cell area_ox=0.0676
XMp_1_8 dp_1_8 WL1 SL8 VSS sky130_fd_pr__nfet_g5v0d10v5 w=1 l=0.5
XRp_1_8 BLP8 dp_1_8 sky130_fd_pr_reram__reram_cell area_ox=0.0676
XMn_1_8 dn_1_8 WL1 SL8 VSS sky130_fd_pr__nfet_g5v0d10v5 w=1 l=0.5
XRn_1_8 BLN8 dn_1_8 sky130_fd_pr_reram__reram_cell area_ox=0.0676
XMp_1_9 dp_1_9 WL1 SL9 VSS sky130_fd_pr__nfet_g5v0d10v5 w=1 l=0.5
XRp_1_9 BLP9 dp_1_9 sky130_fd_pr_reram__reram_cell area_ox=0.0676
XMn_1_9 dn_1_9 WL1 SL9 VSS sky130_fd_pr__nfet_g5v0d10v5 w=1 l=0.5
XRn_1_9 BLN9 dn_1_9 sky130_fd_pr_reram__reram_cell area_ox=0.0676
XMp_1_10 dp_1_10 WL1 SL10 VSS sky130_fd_pr__nfet_g5v0d10v5 w=1 l=0.5
XRp_1_10 BLP10 dp_1_10 sky130_fd_pr_reram__reram_cell area_ox=0.0676
XMn_1_10 dn_1_10 WL1 SL10 VSS sky130_fd_pr__nfet_g5v0d10v5 w=1 l=0.5
XRn_1_10 BLN10 dn_1_10 sky130_fd_pr_reram__reram_cell area_ox=0.0676
XMp_1_11 dp_1_11 WL1 SL11 VSS sky130_fd_pr__nfet_g5v0d10v5 w=1 l=0.5
XRp_1_11 BLP11 dp_1_11 sky130_fd_pr_reram__reram_cell area_ox=0.0676
XMn_1_11 dn_1_11 WL1 SL11 VSS sky130_fd_pr__nfet_g5v0d10v5 w=1 l=0.5
XRn_1_11 BLN11 dn_1_11 sky130_fd_pr_reram__reram_cell area_ox=0.0676
XMp_1_12 dp_1_12 WL1 SL12 VSS sky130_fd_pr__nfet_g5v0d10v5 w=1 l=0.5
XRp_1_12 BLP12 dp_1_12 sky130_fd_pr_reram__reram_cell area_ox=0.0676
XMn_1_12 dn_1_12 WL1 SL12 VSS sky130_fd_pr__nfet_g5v0d10v5 w=1 l=0.5
XRn_1_12 BLN12 dn_1_12 sky130_fd_pr_reram__reram_cell area_ox=0.0676
XMp_1_13 dp_1_13 WL1 SL13 VSS sky130_fd_pr__nfet_g5v0d10v5 w=1 l=0.5
XRp_1_13 BLP13 dp_1_13 sky130_fd_pr_reram__reram_cell area_ox=0.0676
XMn_1_13 dn_1_13 WL1 SL13 VSS sky130_fd_pr__nfet_g5v0d10v5 w=1 l=0.5
XRn_1_13 BLN13 dn_1_13 sky130_fd_pr_reram__reram_cell area_ox=0.0676
XMp_1_14 dp_1_14 WL1 SL14 VSS sky130_fd_pr__nfet_g5v0d10v5 w=1 l=0.5
XRp_1_14 BLP14 dp_1_14 sky130_fd_pr_reram__reram_cell area_ox=0.0676
XMn_1_14 dn_1_14 WL1 SL14 VSS sky130_fd_pr__nfet_g5v0d10v5 w=1 l=0.5
XRn_1_14 BLN14 dn_1_14 sky130_fd_pr_reram__reram_cell area_ox=0.0676
XMp_1_15 dp_1_15 WL1 SL15 VSS sky130_fd_pr__nfet_g5v0d10v5 w=1 l=0.5
XRp_1_15 BLP15 dp_1_15 sky130_fd_pr_reram__reram_cell area_ox=0.0676
XMn_1_15 dn_1_15 WL1 SL15 VSS sky130_fd_pr__nfet_g5v0d10v5 w=1 l=0.5
XRn_1_15 BLN15 dn_1_15 sky130_fd_pr_reram__reram_cell area_ox=0.0676
XMp_1_16 dp_1_16 WL1 SL16 VSS sky130_fd_pr__nfet_g5v0d10v5 w=1 l=0.5
XRp_1_16 BLP16 dp_1_16 sky130_fd_pr_reram__reram_cell area_ox=0.0676
XMn_1_16 dn_1_16 WL1 SL16 VSS sky130_fd_pr__nfet_g5v0d10v5 w=1 l=0.5
XRn_1_16 BLN16 dn_1_16 sky130_fd_pr_reram__reram_cell area_ox=0.0676
XMp_1_17 dp_1_17 WL1 SL17 VSS sky130_fd_pr__nfet_g5v0d10v5 w=1 l=0.5
XRp_1_17 BLP17 dp_1_17 sky130_fd_pr_reram__reram_cell area_ox=0.0676
XMn_1_17 dn_1_17 WL1 SL17 VSS sky130_fd_pr__nfet_g5v0d10v5 w=1 l=0.5
XRn_1_17 BLN17 dn_1_17 sky130_fd_pr_reram__reram_cell area_ox=0.0676
XMp_1_18 dp_1_18 WL1 SL18 VSS sky130_fd_pr__nfet_g5v0d10v5 w=1 l=0.5
XRp_1_18 BLP18 dp_1_18 sky130_fd_pr_reram__reram_cell area_ox=0.0676
XMn_1_18 dn_1_18 WL1 SL18 VSS sky130_fd_pr__nfet_g5v0d10v5 w=1 l=0.5
XRn_1_18 BLN18 dn_1_18 sky130_fd_pr_reram__reram_cell area_ox=0.0676
XMp_1_19 dp_1_19 WL1 SL19 VSS sky130_fd_pr__nfet_g5v0d10v5 w=1 l=0.5
XRp_1_19 BLP19 dp_1_19 sky130_fd_pr_reram__reram_cell area_ox=0.0676
XMn_1_19 dn_1_19 WL1 SL19 VSS sky130_fd_pr__nfet_g5v0d10v5 w=1 l=0.5
XRn_1_19 BLN19 dn_1_19 sky130_fd_pr_reram__reram_cell area_ox=0.0676
XMp_1_20 dp_1_20 WL1 SL20 VSS sky130_fd_pr__nfet_g5v0d10v5 w=1 l=0.5
XRp_1_20 BLP20 dp_1_20 sky130_fd_pr_reram__reram_cell area_ox=0.0676
XMn_1_20 dn_1_20 WL1 SL20 VSS sky130_fd_pr__nfet_g5v0d10v5 w=1 l=0.5
XRn_1_20 BLN20 dn_1_20 sky130_fd_pr_reram__reram_cell area_ox=0.0676
XMp_1_21 dp_1_21 WL1 SL21 VSS sky130_fd_pr__nfet_g5v0d10v5 w=1 l=0.5
XRp_1_21 BLP21 dp_1_21 sky130_fd_pr_reram__reram_cell area_ox=0.0676
XMn_1_21 dn_1_21 WL1 SL21 VSS sky130_fd_pr__nfet_g5v0d10v5 w=1 l=0.5
XRn_1_21 BLN21 dn_1_21 sky130_fd_pr_reram__reram_cell area_ox=0.0676
XMp_1_22 dp_1_22 WL1 SL22 VSS sky130_fd_pr__nfet_g5v0d10v5 w=1 l=0.5
XRp_1_22 BLP22 dp_1_22 sky130_fd_pr_reram__reram_cell area_ox=0.0676
XMn_1_22 dn_1_22 WL1 SL22 VSS sky130_fd_pr__nfet_g5v0d10v5 w=1 l=0.5
XRn_1_22 BLN22 dn_1_22 sky130_fd_pr_reram__reram_cell area_ox=0.0676
XMp_1_23 dp_1_23 WL1 SL23 VSS sky130_fd_pr__nfet_g5v0d10v5 w=1 l=0.5
XRp_1_23 BLP23 dp_1_23 sky130_fd_pr_reram__reram_cell area_ox=0.0676
XMn_1_23 dn_1_23 WL1 SL23 VSS sky130_fd_pr__nfet_g5v0d10v5 w=1 l=0.5
XRn_1_23 BLN23 dn_1_23 sky130_fd_pr_reram__reram_cell area_ox=0.0676
XMp_2_0 dp_2_0 WL2 SL0 VSS sky130_fd_pr__nfet_g5v0d10v5 w=1 l=0.5
XRp_2_0 BLP0 dp_2_0 sky130_fd_pr_reram__reram_cell area_ox=0.0676
XMn_2_0 dn_2_0 WL2 SL0 VSS sky130_fd_pr__nfet_g5v0d10v5 w=1 l=0.5
XRn_2_0 BLN0 dn_2_0 sky130_fd_pr_reram__reram_cell area_ox=0.0676
XMp_2_1 dp_2_1 WL2 SL1 VSS sky130_fd_pr__nfet_g5v0d10v5 w=1 l=0.5
XRp_2_1 BLP1 dp_2_1 sky130_fd_pr_reram__reram_cell area_ox=0.0676
XMn_2_1 dn_2_1 WL2 SL1 VSS sky130_fd_pr__nfet_g5v0d10v5 w=1 l=0.5
XRn_2_1 BLN1 dn_2_1 sky130_fd_pr_reram__reram_cell area_ox=0.0676
XMp_2_2 dp_2_2 WL2 SL2 VSS sky130_fd_pr__nfet_g5v0d10v5 w=1 l=0.5
XRp_2_2 BLP2 dp_2_2 sky130_fd_pr_reram__reram_cell area_ox=0.0676
XMn_2_2 dn_2_2 WL2 SL2 VSS sky130_fd_pr__nfet_g5v0d10v5 w=1 l=0.5
XRn_2_2 BLN2 dn_2_2 sky130_fd_pr_reram__reram_cell area_ox=0.0676
XMp_2_3 dp_2_3 WL2 SL3 VSS sky130_fd_pr__nfet_g5v0d10v5 w=1 l=0.5
XRp_2_3 BLP3 dp_2_3 sky130_fd_pr_reram__reram_cell area_ox=0.0676
XMn_2_3 dn_2_3 WL2 SL3 VSS sky130_fd_pr__nfet_g5v0d10v5 w=1 l=0.5
XRn_2_3 BLN3 dn_2_3 sky130_fd_pr_reram__reram_cell area_ox=0.0676
XMp_2_4 dp_2_4 WL2 SL4 VSS sky130_fd_pr__nfet_g5v0d10v5 w=1 l=0.5
XRp_2_4 BLP4 dp_2_4 sky130_fd_pr_reram__reram_cell area_ox=0.0676
XMn_2_4 dn_2_4 WL2 SL4 VSS sky130_fd_pr__nfet_g5v0d10v5 w=1 l=0.5
XRn_2_4 BLN4 dn_2_4 sky130_fd_pr_reram__reram_cell area_ox=0.0676
XMp_2_5 dp_2_5 WL2 SL5 VSS sky130_fd_pr__nfet_g5v0d10v5 w=1 l=0.5
XRp_2_5 BLP5 dp_2_5 sky130_fd_pr_reram__reram_cell area_ox=0.0676
XMn_2_5 dn_2_5 WL2 SL5 VSS sky130_fd_pr__nfet_g5v0d10v5 w=1 l=0.5
XRn_2_5 BLN5 dn_2_5 sky130_fd_pr_reram__reram_cell area_ox=0.0676
XMp_2_6 dp_2_6 WL2 SL6 VSS sky130_fd_pr__nfet_g5v0d10v5 w=1 l=0.5
XRp_2_6 BLP6 dp_2_6 sky130_fd_pr_reram__reram_cell area_ox=0.0676
XMn_2_6 dn_2_6 WL2 SL6 VSS sky130_fd_pr__nfet_g5v0d10v5 w=1 l=0.5
XRn_2_6 BLN6 dn_2_6 sky130_fd_pr_reram__reram_cell area_ox=0.0676
XMp_2_7 dp_2_7 WL2 SL7 VSS sky130_fd_pr__nfet_g5v0d10v5 w=1 l=0.5
XRp_2_7 BLP7 dp_2_7 sky130_fd_pr_reram__reram_cell area_ox=0.0676
XMn_2_7 dn_2_7 WL2 SL7 VSS sky130_fd_pr__nfet_g5v0d10v5 w=1 l=0.5
XRn_2_7 BLN7 dn_2_7 sky130_fd_pr_reram__reram_cell area_ox=0.0676
XMp_2_8 dp_2_8 WL2 SL8 VSS sky130_fd_pr__nfet_g5v0d10v5 w=1 l=0.5
XRp_2_8 BLP8 dp_2_8 sky130_fd_pr_reram__reram_cell area_ox=0.0676
XMn_2_8 dn_2_8 WL2 SL8 VSS sky130_fd_pr__nfet_g5v0d10v5 w=1 l=0.5
XRn_2_8 BLN8 dn_2_8 sky130_fd_pr_reram__reram_cell area_ox=0.0676
XMp_2_9 dp_2_9 WL2 SL9 VSS sky130_fd_pr__nfet_g5v0d10v5 w=1 l=0.5
XRp_2_9 BLP9 dp_2_9 sky130_fd_pr_reram__reram_cell area_ox=0.0676
XMn_2_9 dn_2_9 WL2 SL9 VSS sky130_fd_pr__nfet_g5v0d10v5 w=1 l=0.5
XRn_2_9 BLN9 dn_2_9 sky130_fd_pr_reram__reram_cell area_ox=0.0676
XMp_2_10 dp_2_10 WL2 SL10 VSS sky130_fd_pr__nfet_g5v0d10v5 w=1 l=0.5
XRp_2_10 BLP10 dp_2_10 sky130_fd_pr_reram__reram_cell area_ox=0.0676
XMn_2_10 dn_2_10 WL2 SL10 VSS sky130_fd_pr__nfet_g5v0d10v5 w=1 l=0.5
XRn_2_10 BLN10 dn_2_10 sky130_fd_pr_reram__reram_cell area_ox=0.0676
XMp_2_11 dp_2_11 WL2 SL11 VSS sky130_fd_pr__nfet_g5v0d10v5 w=1 l=0.5
XRp_2_11 BLP11 dp_2_11 sky130_fd_pr_reram__reram_cell area_ox=0.0676
XMn_2_11 dn_2_11 WL2 SL11 VSS sky130_fd_pr__nfet_g5v0d10v5 w=1 l=0.5
XRn_2_11 BLN11 dn_2_11 sky130_fd_pr_reram__reram_cell area_ox=0.0676
XMp_2_12 dp_2_12 WL2 SL12 VSS sky130_fd_pr__nfet_g5v0d10v5 w=1 l=0.5
XRp_2_12 BLP12 dp_2_12 sky130_fd_pr_reram__reram_cell area_ox=0.0676
XMn_2_12 dn_2_12 WL2 SL12 VSS sky130_fd_pr__nfet_g5v0d10v5 w=1 l=0.5
XRn_2_12 BLN12 dn_2_12 sky130_fd_pr_reram__reram_cell area_ox=0.0676
XMp_2_13 dp_2_13 WL2 SL13 VSS sky130_fd_pr__nfet_g5v0d10v5 w=1 l=0.5
XRp_2_13 BLP13 dp_2_13 sky130_fd_pr_reram__reram_cell area_ox=0.0676
XMn_2_13 dn_2_13 WL2 SL13 VSS sky130_fd_pr__nfet_g5v0d10v5 w=1 l=0.5
XRn_2_13 BLN13 dn_2_13 sky130_fd_pr_reram__reram_cell area_ox=0.0676
XMp_2_14 dp_2_14 WL2 SL14 VSS sky130_fd_pr__nfet_g5v0d10v5 w=1 l=0.5
XRp_2_14 BLP14 dp_2_14 sky130_fd_pr_reram__reram_cell area_ox=0.0676
XMn_2_14 dn_2_14 WL2 SL14 VSS sky130_fd_pr__nfet_g5v0d10v5 w=1 l=0.5
XRn_2_14 BLN14 dn_2_14 sky130_fd_pr_reram__reram_cell area_ox=0.0676
XMp_2_15 dp_2_15 WL2 SL15 VSS sky130_fd_pr__nfet_g5v0d10v5 w=1 l=0.5
XRp_2_15 BLP15 dp_2_15 sky130_fd_pr_reram__reram_cell area_ox=0.0676
XMn_2_15 dn_2_15 WL2 SL15 VSS sky130_fd_pr__nfet_g5v0d10v5 w=1 l=0.5
XRn_2_15 BLN15 dn_2_15 sky130_fd_pr_reram__reram_cell area_ox=0.0676
XMp_2_16 dp_2_16 WL2 SL16 VSS sky130_fd_pr__nfet_g5v0d10v5 w=1 l=0.5
XRp_2_16 BLP16 dp_2_16 sky130_fd_pr_reram__reram_cell area_ox=0.0676
XMn_2_16 dn_2_16 WL2 SL16 VSS sky130_fd_pr__nfet_g5v0d10v5 w=1 l=0.5
XRn_2_16 BLN16 dn_2_16 sky130_fd_pr_reram__reram_cell area_ox=0.0676
XMp_2_17 dp_2_17 WL2 SL17 VSS sky130_fd_pr__nfet_g5v0d10v5 w=1 l=0.5
XRp_2_17 BLP17 dp_2_17 sky130_fd_pr_reram__reram_cell area_ox=0.0676
XMn_2_17 dn_2_17 WL2 SL17 VSS sky130_fd_pr__nfet_g5v0d10v5 w=1 l=0.5
XRn_2_17 BLN17 dn_2_17 sky130_fd_pr_reram__reram_cell area_ox=0.0676
XMp_2_18 dp_2_18 WL2 SL18 VSS sky130_fd_pr__nfet_g5v0d10v5 w=1 l=0.5
XRp_2_18 BLP18 dp_2_18 sky130_fd_pr_reram__reram_cell area_ox=0.0676
XMn_2_18 dn_2_18 WL2 SL18 VSS sky130_fd_pr__nfet_g5v0d10v5 w=1 l=0.5
XRn_2_18 BLN18 dn_2_18 sky130_fd_pr_reram__reram_cell area_ox=0.0676
XMp_2_19 dp_2_19 WL2 SL19 VSS sky130_fd_pr__nfet_g5v0d10v5 w=1 l=0.5
XRp_2_19 BLP19 dp_2_19 sky130_fd_pr_reram__reram_cell area_ox=0.0676
XMn_2_19 dn_2_19 WL2 SL19 VSS sky130_fd_pr__nfet_g5v0d10v5 w=1 l=0.5
XRn_2_19 BLN19 dn_2_19 sky130_fd_pr_reram__reram_cell area_ox=0.0676
XMp_2_20 dp_2_20 WL2 SL20 VSS sky130_fd_pr__nfet_g5v0d10v5 w=1 l=0.5
XRp_2_20 BLP20 dp_2_20 sky130_fd_pr_reram__reram_cell area_ox=0.0676
XMn_2_20 dn_2_20 WL2 SL20 VSS sky130_fd_pr__nfet_g5v0d10v5 w=1 l=0.5
XRn_2_20 BLN20 dn_2_20 sky130_fd_pr_reram__reram_cell area_ox=0.0676
XMp_2_21 dp_2_21 WL2 SL21 VSS sky130_fd_pr__nfet_g5v0d10v5 w=1 l=0.5
XRp_2_21 BLP21 dp_2_21 sky130_fd_pr_reram__reram_cell area_ox=0.0676
XMn_2_21 dn_2_21 WL2 SL21 VSS sky130_fd_pr__nfet_g5v0d10v5 w=1 l=0.5
XRn_2_21 BLN21 dn_2_21 sky130_fd_pr_reram__reram_cell area_ox=0.0676
XMp_2_22 dp_2_22 WL2 SL22 VSS sky130_fd_pr__nfet_g5v0d10v5 w=1 l=0.5
XRp_2_22 BLP22 dp_2_22 sky130_fd_pr_reram__reram_cell area_ox=0.0676
XMn_2_22 dn_2_22 WL2 SL22 VSS sky130_fd_pr__nfet_g5v0d10v5 w=1 l=0.5
XRn_2_22 BLN22 dn_2_22 sky130_fd_pr_reram__reram_cell area_ox=0.0676
XMp_2_23 dp_2_23 WL2 SL23 VSS sky130_fd_pr__nfet_g5v0d10v5 w=1 l=0.5
XRp_2_23 BLP23 dp_2_23 sky130_fd_pr_reram__reram_cell area_ox=0.0676
XMn_2_23 dn_2_23 WL2 SL23 VSS sky130_fd_pr__nfet_g5v0d10v5 w=1 l=0.5
XRn_2_23 BLN23 dn_2_23 sky130_fd_pr_reram__reram_cell area_ox=0.0676
XMp_3_0 dp_3_0 WL3 SL0 VSS sky130_fd_pr__nfet_g5v0d10v5 w=1 l=0.5
XRp_3_0 BLP0 dp_3_0 sky130_fd_pr_reram__reram_cell area_ox=0.0676
XMn_3_0 dn_3_0 WL3 SL0 VSS sky130_fd_pr__nfet_g5v0d10v5 w=1 l=0.5
XRn_3_0 BLN0 dn_3_0 sky130_fd_pr_reram__reram_cell area_ox=0.0676
XMp_3_1 dp_3_1 WL3 SL1 VSS sky130_fd_pr__nfet_g5v0d10v5 w=1 l=0.5
XRp_3_1 BLP1 dp_3_1 sky130_fd_pr_reram__reram_cell area_ox=0.0676
XMn_3_1 dn_3_1 WL3 SL1 VSS sky130_fd_pr__nfet_g5v0d10v5 w=1 l=0.5
XRn_3_1 BLN1 dn_3_1 sky130_fd_pr_reram__reram_cell area_ox=0.0676
XMp_3_2 dp_3_2 WL3 SL2 VSS sky130_fd_pr__nfet_g5v0d10v5 w=1 l=0.5
XRp_3_2 BLP2 dp_3_2 sky130_fd_pr_reram__reram_cell area_ox=0.0676
XMn_3_2 dn_3_2 WL3 SL2 VSS sky130_fd_pr__nfet_g5v0d10v5 w=1 l=0.5
XRn_3_2 BLN2 dn_3_2 sky130_fd_pr_reram__reram_cell area_ox=0.0676
XMp_3_3 dp_3_3 WL3 SL3 VSS sky130_fd_pr__nfet_g5v0d10v5 w=1 l=0.5
XRp_3_3 BLP3 dp_3_3 sky130_fd_pr_reram__reram_cell area_ox=0.0676
XMn_3_3 dn_3_3 WL3 SL3 VSS sky130_fd_pr__nfet_g5v0d10v5 w=1 l=0.5
XRn_3_3 BLN3 dn_3_3 sky130_fd_pr_reram__reram_cell area_ox=0.0676
XMp_3_4 dp_3_4 WL3 SL4 VSS sky130_fd_pr__nfet_g5v0d10v5 w=1 l=0.5
XRp_3_4 BLP4 dp_3_4 sky130_fd_pr_reram__reram_cell area_ox=0.0676
XMn_3_4 dn_3_4 WL3 SL4 VSS sky130_fd_pr__nfet_g5v0d10v5 w=1 l=0.5
XRn_3_4 BLN4 dn_3_4 sky130_fd_pr_reram__reram_cell area_ox=0.0676
XMp_3_5 dp_3_5 WL3 SL5 VSS sky130_fd_pr__nfet_g5v0d10v5 w=1 l=0.5
XRp_3_5 BLP5 dp_3_5 sky130_fd_pr_reram__reram_cell area_ox=0.0676
XMn_3_5 dn_3_5 WL3 SL5 VSS sky130_fd_pr__nfet_g5v0d10v5 w=1 l=0.5
XRn_3_5 BLN5 dn_3_5 sky130_fd_pr_reram__reram_cell area_ox=0.0676
XMp_3_6 dp_3_6 WL3 SL6 VSS sky130_fd_pr__nfet_g5v0d10v5 w=1 l=0.5
XRp_3_6 BLP6 dp_3_6 sky130_fd_pr_reram__reram_cell area_ox=0.0676
XMn_3_6 dn_3_6 WL3 SL6 VSS sky130_fd_pr__nfet_g5v0d10v5 w=1 l=0.5
XRn_3_6 BLN6 dn_3_6 sky130_fd_pr_reram__reram_cell area_ox=0.0676
XMp_3_7 dp_3_7 WL3 SL7 VSS sky130_fd_pr__nfet_g5v0d10v5 w=1 l=0.5
XRp_3_7 BLP7 dp_3_7 sky130_fd_pr_reram__reram_cell area_ox=0.0676
XMn_3_7 dn_3_7 WL3 SL7 VSS sky130_fd_pr__nfet_g5v0d10v5 w=1 l=0.5
XRn_3_7 BLN7 dn_3_7 sky130_fd_pr_reram__reram_cell area_ox=0.0676
XMp_3_8 dp_3_8 WL3 SL8 VSS sky130_fd_pr__nfet_g5v0d10v5 w=1 l=0.5
XRp_3_8 BLP8 dp_3_8 sky130_fd_pr_reram__reram_cell area_ox=0.0676
XMn_3_8 dn_3_8 WL3 SL8 VSS sky130_fd_pr__nfet_g5v0d10v5 w=1 l=0.5
XRn_3_8 BLN8 dn_3_8 sky130_fd_pr_reram__reram_cell area_ox=0.0676
XMp_3_9 dp_3_9 WL3 SL9 VSS sky130_fd_pr__nfet_g5v0d10v5 w=1 l=0.5
XRp_3_9 BLP9 dp_3_9 sky130_fd_pr_reram__reram_cell area_ox=0.0676
XMn_3_9 dn_3_9 WL3 SL9 VSS sky130_fd_pr__nfet_g5v0d10v5 w=1 l=0.5
XRn_3_9 BLN9 dn_3_9 sky130_fd_pr_reram__reram_cell area_ox=0.0676
XMp_3_10 dp_3_10 WL3 SL10 VSS sky130_fd_pr__nfet_g5v0d10v5 w=1 l=0.5
XRp_3_10 BLP10 dp_3_10 sky130_fd_pr_reram__reram_cell area_ox=0.0676
XMn_3_10 dn_3_10 WL3 SL10 VSS sky130_fd_pr__nfet_g5v0d10v5 w=1 l=0.5
XRn_3_10 BLN10 dn_3_10 sky130_fd_pr_reram__reram_cell area_ox=0.0676
XMp_3_11 dp_3_11 WL3 SL11 VSS sky130_fd_pr__nfet_g5v0d10v5 w=1 l=0.5
XRp_3_11 BLP11 dp_3_11 sky130_fd_pr_reram__reram_cell area_ox=0.0676
XMn_3_11 dn_3_11 WL3 SL11 VSS sky130_fd_pr__nfet_g5v0d10v5 w=1 l=0.5
XRn_3_11 BLN11 dn_3_11 sky130_fd_pr_reram__reram_cell area_ox=0.0676
XMp_3_12 dp_3_12 WL3 SL12 VSS sky130_fd_pr__nfet_g5v0d10v5 w=1 l=0.5
XRp_3_12 BLP12 dp_3_12 sky130_fd_pr_reram__reram_cell area_ox=0.0676
XMn_3_12 dn_3_12 WL3 SL12 VSS sky130_fd_pr__nfet_g5v0d10v5 w=1 l=0.5
XRn_3_12 BLN12 dn_3_12 sky130_fd_pr_reram__reram_cell area_ox=0.0676
XMp_3_13 dp_3_13 WL3 SL13 VSS sky130_fd_pr__nfet_g5v0d10v5 w=1 l=0.5
XRp_3_13 BLP13 dp_3_13 sky130_fd_pr_reram__reram_cell area_ox=0.0676
XMn_3_13 dn_3_13 WL3 SL13 VSS sky130_fd_pr__nfet_g5v0d10v5 w=1 l=0.5
XRn_3_13 BLN13 dn_3_13 sky130_fd_pr_reram__reram_cell area_ox=0.0676
XMp_3_14 dp_3_14 WL3 SL14 VSS sky130_fd_pr__nfet_g5v0d10v5 w=1 l=0.5
XRp_3_14 BLP14 dp_3_14 sky130_fd_pr_reram__reram_cell area_ox=0.0676
XMn_3_14 dn_3_14 WL3 SL14 VSS sky130_fd_pr__nfet_g5v0d10v5 w=1 l=0.5
XRn_3_14 BLN14 dn_3_14 sky130_fd_pr_reram__reram_cell area_ox=0.0676
XMp_3_15 dp_3_15 WL3 SL15 VSS sky130_fd_pr__nfet_g5v0d10v5 w=1 l=0.5
XRp_3_15 BLP15 dp_3_15 sky130_fd_pr_reram__reram_cell area_ox=0.0676
XMn_3_15 dn_3_15 WL3 SL15 VSS sky130_fd_pr__nfet_g5v0d10v5 w=1 l=0.5
XRn_3_15 BLN15 dn_3_15 sky130_fd_pr_reram__reram_cell area_ox=0.0676
XMp_3_16 dp_3_16 WL3 SL16 VSS sky130_fd_pr__nfet_g5v0d10v5 w=1 l=0.5
XRp_3_16 BLP16 dp_3_16 sky130_fd_pr_reram__reram_cell area_ox=0.0676
XMn_3_16 dn_3_16 WL3 SL16 VSS sky130_fd_pr__nfet_g5v0d10v5 w=1 l=0.5
XRn_3_16 BLN16 dn_3_16 sky130_fd_pr_reram__reram_cell area_ox=0.0676
XMp_3_17 dp_3_17 WL3 SL17 VSS sky130_fd_pr__nfet_g5v0d10v5 w=1 l=0.5
XRp_3_17 BLP17 dp_3_17 sky130_fd_pr_reram__reram_cell area_ox=0.0676
XMn_3_17 dn_3_17 WL3 SL17 VSS sky130_fd_pr__nfet_g5v0d10v5 w=1 l=0.5
XRn_3_17 BLN17 dn_3_17 sky130_fd_pr_reram__reram_cell area_ox=0.0676
XMp_3_18 dp_3_18 WL3 SL18 VSS sky130_fd_pr__nfet_g5v0d10v5 w=1 l=0.5
XRp_3_18 BLP18 dp_3_18 sky130_fd_pr_reram__reram_cell area_ox=0.0676
XMn_3_18 dn_3_18 WL3 SL18 VSS sky130_fd_pr__nfet_g5v0d10v5 w=1 l=0.5
XRn_3_18 BLN18 dn_3_18 sky130_fd_pr_reram__reram_cell area_ox=0.0676
XMp_3_19 dp_3_19 WL3 SL19 VSS sky130_fd_pr__nfet_g5v0d10v5 w=1 l=0.5
XRp_3_19 BLP19 dp_3_19 sky130_fd_pr_reram__reram_cell area_ox=0.0676
XMn_3_19 dn_3_19 WL3 SL19 VSS sky130_fd_pr__nfet_g5v0d10v5 w=1 l=0.5
XRn_3_19 BLN19 dn_3_19 sky130_fd_pr_reram__reram_cell area_ox=0.0676
XMp_3_20 dp_3_20 WL3 SL20 VSS sky130_fd_pr__nfet_g5v0d10v5 w=1 l=0.5
XRp_3_20 BLP20 dp_3_20 sky130_fd_pr_reram__reram_cell area_ox=0.0676
XMn_3_20 dn_3_20 WL3 SL20 VSS sky130_fd_pr__nfet_g5v0d10v5 w=1 l=0.5
XRn_3_20 BLN20 dn_3_20 sky130_fd_pr_reram__reram_cell area_ox=0.0676
XMp_3_21 dp_3_21 WL3 SL21 VSS sky130_fd_pr__nfet_g5v0d10v5 w=1 l=0.5
XRp_3_21 BLP21 dp_3_21 sky130_fd_pr_reram__reram_cell area_ox=0.0676
XMn_3_21 dn_3_21 WL3 SL21 VSS sky130_fd_pr__nfet_g5v0d10v5 w=1 l=0.5
XRn_3_21 BLN21 dn_3_21 sky130_fd_pr_reram__reram_cell area_ox=0.0676
XMp_3_22 dp_3_22 WL3 SL22 VSS sky130_fd_pr__nfet_g5v0d10v5 w=1 l=0.5
XRp_3_22 BLP22 dp_3_22 sky130_fd_pr_reram__reram_cell area_ox=0.0676
XMn_3_22 dn_3_22 WL3 SL22 VSS sky130_fd_pr__nfet_g5v0d10v5 w=1 l=0.5
XRn_3_22 BLN22 dn_3_22 sky130_fd_pr_reram__reram_cell area_ox=0.0676
XMp_3_23 dp_3_23 WL3 SL23 VSS sky130_fd_pr__nfet_g5v0d10v5 w=1 l=0.5
XRp_3_23 BLP23 dp_3_23 sky130_fd_pr_reram__reram_cell area_ox=0.0676
XMn_3_23 dn_3_23 WL3 SL23 VSS sky130_fd_pr__nfet_g5v0d10v5 w=1 l=0.5
XRn_3_23 BLN23 dn_3_23 sky130_fd_pr_reram__reram_cell area_ox=0.0676
XMp_4_0 dp_4_0 WL4 SL0 VSS sky130_fd_pr__nfet_g5v0d10v5 w=1 l=0.5
XRp_4_0 BLP0 dp_4_0 sky130_fd_pr_reram__reram_cell area_ox=0.0676
XMn_4_0 dn_4_0 WL4 SL0 VSS sky130_fd_pr__nfet_g5v0d10v5 w=1 l=0.5
XRn_4_0 BLN0 dn_4_0 sky130_fd_pr_reram__reram_cell area_ox=0.0676
XMp_4_1 dp_4_1 WL4 SL1 VSS sky130_fd_pr__nfet_g5v0d10v5 w=1 l=0.5
XRp_4_1 BLP1 dp_4_1 sky130_fd_pr_reram__reram_cell area_ox=0.0676
XMn_4_1 dn_4_1 WL4 SL1 VSS sky130_fd_pr__nfet_g5v0d10v5 w=1 l=0.5
XRn_4_1 BLN1 dn_4_1 sky130_fd_pr_reram__reram_cell area_ox=0.0676
XMp_4_2 dp_4_2 WL4 SL2 VSS sky130_fd_pr__nfet_g5v0d10v5 w=1 l=0.5
XRp_4_2 BLP2 dp_4_2 sky130_fd_pr_reram__reram_cell area_ox=0.0676
XMn_4_2 dn_4_2 WL4 SL2 VSS sky130_fd_pr__nfet_g5v0d10v5 w=1 l=0.5
XRn_4_2 BLN2 dn_4_2 sky130_fd_pr_reram__reram_cell area_ox=0.0676
XMp_4_3 dp_4_3 WL4 SL3 VSS sky130_fd_pr__nfet_g5v0d10v5 w=1 l=0.5
XRp_4_3 BLP3 dp_4_3 sky130_fd_pr_reram__reram_cell area_ox=0.0676
XMn_4_3 dn_4_3 WL4 SL3 VSS sky130_fd_pr__nfet_g5v0d10v5 w=1 l=0.5
XRn_4_3 BLN3 dn_4_3 sky130_fd_pr_reram__reram_cell area_ox=0.0676
XMp_4_4 dp_4_4 WL4 SL4 VSS sky130_fd_pr__nfet_g5v0d10v5 w=1 l=0.5
XRp_4_4 BLP4 dp_4_4 sky130_fd_pr_reram__reram_cell area_ox=0.0676
XMn_4_4 dn_4_4 WL4 SL4 VSS sky130_fd_pr__nfet_g5v0d10v5 w=1 l=0.5
XRn_4_4 BLN4 dn_4_4 sky130_fd_pr_reram__reram_cell area_ox=0.0676
XMp_4_5 dp_4_5 WL4 SL5 VSS sky130_fd_pr__nfet_g5v0d10v5 w=1 l=0.5
XRp_4_5 BLP5 dp_4_5 sky130_fd_pr_reram__reram_cell area_ox=0.0676
XMn_4_5 dn_4_5 WL4 SL5 VSS sky130_fd_pr__nfet_g5v0d10v5 w=1 l=0.5
XRn_4_5 BLN5 dn_4_5 sky130_fd_pr_reram__reram_cell area_ox=0.0676
XMp_4_6 dp_4_6 WL4 SL6 VSS sky130_fd_pr__nfet_g5v0d10v5 w=1 l=0.5
XRp_4_6 BLP6 dp_4_6 sky130_fd_pr_reram__reram_cell area_ox=0.0676
XMn_4_6 dn_4_6 WL4 SL6 VSS sky130_fd_pr__nfet_g5v0d10v5 w=1 l=0.5
XRn_4_6 BLN6 dn_4_6 sky130_fd_pr_reram__reram_cell area_ox=0.0676
XMp_4_7 dp_4_7 WL4 SL7 VSS sky130_fd_pr__nfet_g5v0d10v5 w=1 l=0.5
XRp_4_7 BLP7 dp_4_7 sky130_fd_pr_reram__reram_cell area_ox=0.0676
XMn_4_7 dn_4_7 WL4 SL7 VSS sky130_fd_pr__nfet_g5v0d10v5 w=1 l=0.5
XRn_4_7 BLN7 dn_4_7 sky130_fd_pr_reram__reram_cell area_ox=0.0676
XMp_4_8 dp_4_8 WL4 SL8 VSS sky130_fd_pr__nfet_g5v0d10v5 w=1 l=0.5
XRp_4_8 BLP8 dp_4_8 sky130_fd_pr_reram__reram_cell area_ox=0.0676
XMn_4_8 dn_4_8 WL4 SL8 VSS sky130_fd_pr__nfet_g5v0d10v5 w=1 l=0.5
XRn_4_8 BLN8 dn_4_8 sky130_fd_pr_reram__reram_cell area_ox=0.0676
XMp_4_9 dp_4_9 WL4 SL9 VSS sky130_fd_pr__nfet_g5v0d10v5 w=1 l=0.5
XRp_4_9 BLP9 dp_4_9 sky130_fd_pr_reram__reram_cell area_ox=0.0676
XMn_4_9 dn_4_9 WL4 SL9 VSS sky130_fd_pr__nfet_g5v0d10v5 w=1 l=0.5
XRn_4_9 BLN9 dn_4_9 sky130_fd_pr_reram__reram_cell area_ox=0.0676
XMp_4_10 dp_4_10 WL4 SL10 VSS sky130_fd_pr__nfet_g5v0d10v5 w=1 l=0.5
XRp_4_10 BLP10 dp_4_10 sky130_fd_pr_reram__reram_cell area_ox=0.0676
XMn_4_10 dn_4_10 WL4 SL10 VSS sky130_fd_pr__nfet_g5v0d10v5 w=1 l=0.5
XRn_4_10 BLN10 dn_4_10 sky130_fd_pr_reram__reram_cell area_ox=0.0676
XMp_4_11 dp_4_11 WL4 SL11 VSS sky130_fd_pr__nfet_g5v0d10v5 w=1 l=0.5
XRp_4_11 BLP11 dp_4_11 sky130_fd_pr_reram__reram_cell area_ox=0.0676
XMn_4_11 dn_4_11 WL4 SL11 VSS sky130_fd_pr__nfet_g5v0d10v5 w=1 l=0.5
XRn_4_11 BLN11 dn_4_11 sky130_fd_pr_reram__reram_cell area_ox=0.0676
XMp_4_12 dp_4_12 WL4 SL12 VSS sky130_fd_pr__nfet_g5v0d10v5 w=1 l=0.5
XRp_4_12 BLP12 dp_4_12 sky130_fd_pr_reram__reram_cell area_ox=0.0676
XMn_4_12 dn_4_12 WL4 SL12 VSS sky130_fd_pr__nfet_g5v0d10v5 w=1 l=0.5
XRn_4_12 BLN12 dn_4_12 sky130_fd_pr_reram__reram_cell area_ox=0.0676
XMp_4_13 dp_4_13 WL4 SL13 VSS sky130_fd_pr__nfet_g5v0d10v5 w=1 l=0.5
XRp_4_13 BLP13 dp_4_13 sky130_fd_pr_reram__reram_cell area_ox=0.0676
XMn_4_13 dn_4_13 WL4 SL13 VSS sky130_fd_pr__nfet_g5v0d10v5 w=1 l=0.5
XRn_4_13 BLN13 dn_4_13 sky130_fd_pr_reram__reram_cell area_ox=0.0676
XMp_4_14 dp_4_14 WL4 SL14 VSS sky130_fd_pr__nfet_g5v0d10v5 w=1 l=0.5
XRp_4_14 BLP14 dp_4_14 sky130_fd_pr_reram__reram_cell area_ox=0.0676
XMn_4_14 dn_4_14 WL4 SL14 VSS sky130_fd_pr__nfet_g5v0d10v5 w=1 l=0.5
XRn_4_14 BLN14 dn_4_14 sky130_fd_pr_reram__reram_cell area_ox=0.0676
XMp_4_15 dp_4_15 WL4 SL15 VSS sky130_fd_pr__nfet_g5v0d10v5 w=1 l=0.5
XRp_4_15 BLP15 dp_4_15 sky130_fd_pr_reram__reram_cell area_ox=0.0676
XMn_4_15 dn_4_15 WL4 SL15 VSS sky130_fd_pr__nfet_g5v0d10v5 w=1 l=0.5
XRn_4_15 BLN15 dn_4_15 sky130_fd_pr_reram__reram_cell area_ox=0.0676
XMp_4_16 dp_4_16 WL4 SL16 VSS sky130_fd_pr__nfet_g5v0d10v5 w=1 l=0.5
XRp_4_16 BLP16 dp_4_16 sky130_fd_pr_reram__reram_cell area_ox=0.0676
XMn_4_16 dn_4_16 WL4 SL16 VSS sky130_fd_pr__nfet_g5v0d10v5 w=1 l=0.5
XRn_4_16 BLN16 dn_4_16 sky130_fd_pr_reram__reram_cell area_ox=0.0676
XMp_4_17 dp_4_17 WL4 SL17 VSS sky130_fd_pr__nfet_g5v0d10v5 w=1 l=0.5
XRp_4_17 BLP17 dp_4_17 sky130_fd_pr_reram__reram_cell area_ox=0.0676
XMn_4_17 dn_4_17 WL4 SL17 VSS sky130_fd_pr__nfet_g5v0d10v5 w=1 l=0.5
XRn_4_17 BLN17 dn_4_17 sky130_fd_pr_reram__reram_cell area_ox=0.0676
XMp_4_18 dp_4_18 WL4 SL18 VSS sky130_fd_pr__nfet_g5v0d10v5 w=1 l=0.5
XRp_4_18 BLP18 dp_4_18 sky130_fd_pr_reram__reram_cell area_ox=0.0676
XMn_4_18 dn_4_18 WL4 SL18 VSS sky130_fd_pr__nfet_g5v0d10v5 w=1 l=0.5
XRn_4_18 BLN18 dn_4_18 sky130_fd_pr_reram__reram_cell area_ox=0.0676
XMp_4_19 dp_4_19 WL4 SL19 VSS sky130_fd_pr__nfet_g5v0d10v5 w=1 l=0.5
XRp_4_19 BLP19 dp_4_19 sky130_fd_pr_reram__reram_cell area_ox=0.0676
XMn_4_19 dn_4_19 WL4 SL19 VSS sky130_fd_pr__nfet_g5v0d10v5 w=1 l=0.5
XRn_4_19 BLN19 dn_4_19 sky130_fd_pr_reram__reram_cell area_ox=0.0676
XMp_4_20 dp_4_20 WL4 SL20 VSS sky130_fd_pr__nfet_g5v0d10v5 w=1 l=0.5
XRp_4_20 BLP20 dp_4_20 sky130_fd_pr_reram__reram_cell area_ox=0.0676
XMn_4_20 dn_4_20 WL4 SL20 VSS sky130_fd_pr__nfet_g5v0d10v5 w=1 l=0.5
XRn_4_20 BLN20 dn_4_20 sky130_fd_pr_reram__reram_cell area_ox=0.0676
XMp_4_21 dp_4_21 WL4 SL21 VSS sky130_fd_pr__nfet_g5v0d10v5 w=1 l=0.5
XRp_4_21 BLP21 dp_4_21 sky130_fd_pr_reram__reram_cell area_ox=0.0676
XMn_4_21 dn_4_21 WL4 SL21 VSS sky130_fd_pr__nfet_g5v0d10v5 w=1 l=0.5
XRn_4_21 BLN21 dn_4_21 sky130_fd_pr_reram__reram_cell area_ox=0.0676
XMp_4_22 dp_4_22 WL4 SL22 VSS sky130_fd_pr__nfet_g5v0d10v5 w=1 l=0.5
XRp_4_22 BLP22 dp_4_22 sky130_fd_pr_reram__reram_cell area_ox=0.0676
XMn_4_22 dn_4_22 WL4 SL22 VSS sky130_fd_pr__nfet_g5v0d10v5 w=1 l=0.5
XRn_4_22 BLN22 dn_4_22 sky130_fd_pr_reram__reram_cell area_ox=0.0676
XMp_4_23 dp_4_23 WL4 SL23 VSS sky130_fd_pr__nfet_g5v0d10v5 w=1 l=0.5
XRp_4_23 BLP23 dp_4_23 sky130_fd_pr_reram__reram_cell area_ox=0.0676
XMn_4_23 dn_4_23 WL4 SL23 VSS sky130_fd_pr__nfet_g5v0d10v5 w=1 l=0.5
XRn_4_23 BLN23 dn_4_23 sky130_fd_pr_reram__reram_cell area_ox=0.0676
XMp_5_0 dp_5_0 WL5 SL0 VSS sky130_fd_pr__nfet_g5v0d10v5 w=1 l=0.5
XRp_5_0 BLP0 dp_5_0 sky130_fd_pr_reram__reram_cell area_ox=0.0676
XMn_5_0 dn_5_0 WL5 SL0 VSS sky130_fd_pr__nfet_g5v0d10v5 w=1 l=0.5
XRn_5_0 BLN0 dn_5_0 sky130_fd_pr_reram__reram_cell area_ox=0.0676
XMp_5_1 dp_5_1 WL5 SL1 VSS sky130_fd_pr__nfet_g5v0d10v5 w=1 l=0.5
XRp_5_1 BLP1 dp_5_1 sky130_fd_pr_reram__reram_cell area_ox=0.0676
XMn_5_1 dn_5_1 WL5 SL1 VSS sky130_fd_pr__nfet_g5v0d10v5 w=1 l=0.5
XRn_5_1 BLN1 dn_5_1 sky130_fd_pr_reram__reram_cell area_ox=0.0676
XMp_5_2 dp_5_2 WL5 SL2 VSS sky130_fd_pr__nfet_g5v0d10v5 w=1 l=0.5
XRp_5_2 BLP2 dp_5_2 sky130_fd_pr_reram__reram_cell area_ox=0.0676
XMn_5_2 dn_5_2 WL5 SL2 VSS sky130_fd_pr__nfet_g5v0d10v5 w=1 l=0.5
XRn_5_2 BLN2 dn_5_2 sky130_fd_pr_reram__reram_cell area_ox=0.0676
XMp_5_3 dp_5_3 WL5 SL3 VSS sky130_fd_pr__nfet_g5v0d10v5 w=1 l=0.5
XRp_5_3 BLP3 dp_5_3 sky130_fd_pr_reram__reram_cell area_ox=0.0676
XMn_5_3 dn_5_3 WL5 SL3 VSS sky130_fd_pr__nfet_g5v0d10v5 w=1 l=0.5
XRn_5_3 BLN3 dn_5_3 sky130_fd_pr_reram__reram_cell area_ox=0.0676
XMp_5_4 dp_5_4 WL5 SL4 VSS sky130_fd_pr__nfet_g5v0d10v5 w=1 l=0.5
XRp_5_4 BLP4 dp_5_4 sky130_fd_pr_reram__reram_cell area_ox=0.0676
XMn_5_4 dn_5_4 WL5 SL4 VSS sky130_fd_pr__nfet_g5v0d10v5 w=1 l=0.5
XRn_5_4 BLN4 dn_5_4 sky130_fd_pr_reram__reram_cell area_ox=0.0676
XMp_5_5 dp_5_5 WL5 SL5 VSS sky130_fd_pr__nfet_g5v0d10v5 w=1 l=0.5
XRp_5_5 BLP5 dp_5_5 sky130_fd_pr_reram__reram_cell area_ox=0.0676
XMn_5_5 dn_5_5 WL5 SL5 VSS sky130_fd_pr__nfet_g5v0d10v5 w=1 l=0.5
XRn_5_5 BLN5 dn_5_5 sky130_fd_pr_reram__reram_cell area_ox=0.0676
XMp_5_6 dp_5_6 WL5 SL6 VSS sky130_fd_pr__nfet_g5v0d10v5 w=1 l=0.5
XRp_5_6 BLP6 dp_5_6 sky130_fd_pr_reram__reram_cell area_ox=0.0676
XMn_5_6 dn_5_6 WL5 SL6 VSS sky130_fd_pr__nfet_g5v0d10v5 w=1 l=0.5
XRn_5_6 BLN6 dn_5_6 sky130_fd_pr_reram__reram_cell area_ox=0.0676
XMp_5_7 dp_5_7 WL5 SL7 VSS sky130_fd_pr__nfet_g5v0d10v5 w=1 l=0.5
XRp_5_7 BLP7 dp_5_7 sky130_fd_pr_reram__reram_cell area_ox=0.0676
XMn_5_7 dn_5_7 WL5 SL7 VSS sky130_fd_pr__nfet_g5v0d10v5 w=1 l=0.5
XRn_5_7 BLN7 dn_5_7 sky130_fd_pr_reram__reram_cell area_ox=0.0676
XMp_5_8 dp_5_8 WL5 SL8 VSS sky130_fd_pr__nfet_g5v0d10v5 w=1 l=0.5
XRp_5_8 BLP8 dp_5_8 sky130_fd_pr_reram__reram_cell area_ox=0.0676
XMn_5_8 dn_5_8 WL5 SL8 VSS sky130_fd_pr__nfet_g5v0d10v5 w=1 l=0.5
XRn_5_8 BLN8 dn_5_8 sky130_fd_pr_reram__reram_cell area_ox=0.0676
XMp_5_9 dp_5_9 WL5 SL9 VSS sky130_fd_pr__nfet_g5v0d10v5 w=1 l=0.5
XRp_5_9 BLP9 dp_5_9 sky130_fd_pr_reram__reram_cell area_ox=0.0676
XMn_5_9 dn_5_9 WL5 SL9 VSS sky130_fd_pr__nfet_g5v0d10v5 w=1 l=0.5
XRn_5_9 BLN9 dn_5_9 sky130_fd_pr_reram__reram_cell area_ox=0.0676
XMp_5_10 dp_5_10 WL5 SL10 VSS sky130_fd_pr__nfet_g5v0d10v5 w=1 l=0.5
XRp_5_10 BLP10 dp_5_10 sky130_fd_pr_reram__reram_cell area_ox=0.0676
XMn_5_10 dn_5_10 WL5 SL10 VSS sky130_fd_pr__nfet_g5v0d10v5 w=1 l=0.5
XRn_5_10 BLN10 dn_5_10 sky130_fd_pr_reram__reram_cell area_ox=0.0676
XMp_5_11 dp_5_11 WL5 SL11 VSS sky130_fd_pr__nfet_g5v0d10v5 w=1 l=0.5
XRp_5_11 BLP11 dp_5_11 sky130_fd_pr_reram__reram_cell area_ox=0.0676
XMn_5_11 dn_5_11 WL5 SL11 VSS sky130_fd_pr__nfet_g5v0d10v5 w=1 l=0.5
XRn_5_11 BLN11 dn_5_11 sky130_fd_pr_reram__reram_cell area_ox=0.0676
XMp_5_12 dp_5_12 WL5 SL12 VSS sky130_fd_pr__nfet_g5v0d10v5 w=1 l=0.5
XRp_5_12 BLP12 dp_5_12 sky130_fd_pr_reram__reram_cell area_ox=0.0676
XMn_5_12 dn_5_12 WL5 SL12 VSS sky130_fd_pr__nfet_g5v0d10v5 w=1 l=0.5
XRn_5_12 BLN12 dn_5_12 sky130_fd_pr_reram__reram_cell area_ox=0.0676
XMp_5_13 dp_5_13 WL5 SL13 VSS sky130_fd_pr__nfet_g5v0d10v5 w=1 l=0.5
XRp_5_13 BLP13 dp_5_13 sky130_fd_pr_reram__reram_cell area_ox=0.0676
XMn_5_13 dn_5_13 WL5 SL13 VSS sky130_fd_pr__nfet_g5v0d10v5 w=1 l=0.5
XRn_5_13 BLN13 dn_5_13 sky130_fd_pr_reram__reram_cell area_ox=0.0676
XMp_5_14 dp_5_14 WL5 SL14 VSS sky130_fd_pr__nfet_g5v0d10v5 w=1 l=0.5
XRp_5_14 BLP14 dp_5_14 sky130_fd_pr_reram__reram_cell area_ox=0.0676
XMn_5_14 dn_5_14 WL5 SL14 VSS sky130_fd_pr__nfet_g5v0d10v5 w=1 l=0.5
XRn_5_14 BLN14 dn_5_14 sky130_fd_pr_reram__reram_cell area_ox=0.0676
XMp_5_15 dp_5_15 WL5 SL15 VSS sky130_fd_pr__nfet_g5v0d10v5 w=1 l=0.5
XRp_5_15 BLP15 dp_5_15 sky130_fd_pr_reram__reram_cell area_ox=0.0676
XMn_5_15 dn_5_15 WL5 SL15 VSS sky130_fd_pr__nfet_g5v0d10v5 w=1 l=0.5
XRn_5_15 BLN15 dn_5_15 sky130_fd_pr_reram__reram_cell area_ox=0.0676
XMp_5_16 dp_5_16 WL5 SL16 VSS sky130_fd_pr__nfet_g5v0d10v5 w=1 l=0.5
XRp_5_16 BLP16 dp_5_16 sky130_fd_pr_reram__reram_cell area_ox=0.0676
XMn_5_16 dn_5_16 WL5 SL16 VSS sky130_fd_pr__nfet_g5v0d10v5 w=1 l=0.5
XRn_5_16 BLN16 dn_5_16 sky130_fd_pr_reram__reram_cell area_ox=0.0676
XMp_5_17 dp_5_17 WL5 SL17 VSS sky130_fd_pr__nfet_g5v0d10v5 w=1 l=0.5
XRp_5_17 BLP17 dp_5_17 sky130_fd_pr_reram__reram_cell area_ox=0.0676
XMn_5_17 dn_5_17 WL5 SL17 VSS sky130_fd_pr__nfet_g5v0d10v5 w=1 l=0.5
XRn_5_17 BLN17 dn_5_17 sky130_fd_pr_reram__reram_cell area_ox=0.0676
XMp_5_18 dp_5_18 WL5 SL18 VSS sky130_fd_pr__nfet_g5v0d10v5 w=1 l=0.5
XRp_5_18 BLP18 dp_5_18 sky130_fd_pr_reram__reram_cell area_ox=0.0676
XMn_5_18 dn_5_18 WL5 SL18 VSS sky130_fd_pr__nfet_g5v0d10v5 w=1 l=0.5
XRn_5_18 BLN18 dn_5_18 sky130_fd_pr_reram__reram_cell area_ox=0.0676
XMp_5_19 dp_5_19 WL5 SL19 VSS sky130_fd_pr__nfet_g5v0d10v5 w=1 l=0.5
XRp_5_19 BLP19 dp_5_19 sky130_fd_pr_reram__reram_cell area_ox=0.0676
XMn_5_19 dn_5_19 WL5 SL19 VSS sky130_fd_pr__nfet_g5v0d10v5 w=1 l=0.5
XRn_5_19 BLN19 dn_5_19 sky130_fd_pr_reram__reram_cell area_ox=0.0676
XMp_5_20 dp_5_20 WL5 SL20 VSS sky130_fd_pr__nfet_g5v0d10v5 w=1 l=0.5
XRp_5_20 BLP20 dp_5_20 sky130_fd_pr_reram__reram_cell area_ox=0.0676
XMn_5_20 dn_5_20 WL5 SL20 VSS sky130_fd_pr__nfet_g5v0d10v5 w=1 l=0.5
XRn_5_20 BLN20 dn_5_20 sky130_fd_pr_reram__reram_cell area_ox=0.0676
XMp_5_21 dp_5_21 WL5 SL21 VSS sky130_fd_pr__nfet_g5v0d10v5 w=1 l=0.5
XRp_5_21 BLP21 dp_5_21 sky130_fd_pr_reram__reram_cell area_ox=0.0676
XMn_5_21 dn_5_21 WL5 SL21 VSS sky130_fd_pr__nfet_g5v0d10v5 w=1 l=0.5
XRn_5_21 BLN21 dn_5_21 sky130_fd_pr_reram__reram_cell area_ox=0.0676
XMp_5_22 dp_5_22 WL5 SL22 VSS sky130_fd_pr__nfet_g5v0d10v5 w=1 l=0.5
XRp_5_22 BLP22 dp_5_22 sky130_fd_pr_reram__reram_cell area_ox=0.0676
XMn_5_22 dn_5_22 WL5 SL22 VSS sky130_fd_pr__nfet_g5v0d10v5 w=1 l=0.5
XRn_5_22 BLN22 dn_5_22 sky130_fd_pr_reram__reram_cell area_ox=0.0676
XMp_5_23 dp_5_23 WL5 SL23 VSS sky130_fd_pr__nfet_g5v0d10v5 w=1 l=0.5
XRp_5_23 BLP23 dp_5_23 sky130_fd_pr_reram__reram_cell area_ox=0.0676
XMn_5_23 dn_5_23 WL5 SL23 VSS sky130_fd_pr__nfet_g5v0d10v5 w=1 l=0.5
XRn_5_23 BLN23 dn_5_23 sky130_fd_pr_reram__reram_cell area_ox=0.0676
XMp_6_0 dp_6_0 WL6 SL0 VSS sky130_fd_pr__nfet_g5v0d10v5 w=1 l=0.5
XRp_6_0 BLP0 dp_6_0 sky130_fd_pr_reram__reram_cell area_ox=0.0676
XMn_6_0 dn_6_0 WL6 SL0 VSS sky130_fd_pr__nfet_g5v0d10v5 w=1 l=0.5
XRn_6_0 BLN0 dn_6_0 sky130_fd_pr_reram__reram_cell area_ox=0.0676
XMp_6_1 dp_6_1 WL6 SL1 VSS sky130_fd_pr__nfet_g5v0d10v5 w=1 l=0.5
XRp_6_1 BLP1 dp_6_1 sky130_fd_pr_reram__reram_cell area_ox=0.0676
XMn_6_1 dn_6_1 WL6 SL1 VSS sky130_fd_pr__nfet_g5v0d10v5 w=1 l=0.5
XRn_6_1 BLN1 dn_6_1 sky130_fd_pr_reram__reram_cell area_ox=0.0676
XMp_6_2 dp_6_2 WL6 SL2 VSS sky130_fd_pr__nfet_g5v0d10v5 w=1 l=0.5
XRp_6_2 BLP2 dp_6_2 sky130_fd_pr_reram__reram_cell area_ox=0.0676
XMn_6_2 dn_6_2 WL6 SL2 VSS sky130_fd_pr__nfet_g5v0d10v5 w=1 l=0.5
XRn_6_2 BLN2 dn_6_2 sky130_fd_pr_reram__reram_cell area_ox=0.0676
XMp_6_3 dp_6_3 WL6 SL3 VSS sky130_fd_pr__nfet_g5v0d10v5 w=1 l=0.5
XRp_6_3 BLP3 dp_6_3 sky130_fd_pr_reram__reram_cell area_ox=0.0676
XMn_6_3 dn_6_3 WL6 SL3 VSS sky130_fd_pr__nfet_g5v0d10v5 w=1 l=0.5
XRn_6_3 BLN3 dn_6_3 sky130_fd_pr_reram__reram_cell area_ox=0.0676
XMp_6_4 dp_6_4 WL6 SL4 VSS sky130_fd_pr__nfet_g5v0d10v5 w=1 l=0.5
XRp_6_4 BLP4 dp_6_4 sky130_fd_pr_reram__reram_cell area_ox=0.0676
XMn_6_4 dn_6_4 WL6 SL4 VSS sky130_fd_pr__nfet_g5v0d10v5 w=1 l=0.5
XRn_6_4 BLN4 dn_6_4 sky130_fd_pr_reram__reram_cell area_ox=0.0676
XMp_6_5 dp_6_5 WL6 SL5 VSS sky130_fd_pr__nfet_g5v0d10v5 w=1 l=0.5
XRp_6_5 BLP5 dp_6_5 sky130_fd_pr_reram__reram_cell area_ox=0.0676
XMn_6_5 dn_6_5 WL6 SL5 VSS sky130_fd_pr__nfet_g5v0d10v5 w=1 l=0.5
XRn_6_5 BLN5 dn_6_5 sky130_fd_pr_reram__reram_cell area_ox=0.0676
XMp_6_6 dp_6_6 WL6 SL6 VSS sky130_fd_pr__nfet_g5v0d10v5 w=1 l=0.5
XRp_6_6 BLP6 dp_6_6 sky130_fd_pr_reram__reram_cell area_ox=0.0676
XMn_6_6 dn_6_6 WL6 SL6 VSS sky130_fd_pr__nfet_g5v0d10v5 w=1 l=0.5
XRn_6_6 BLN6 dn_6_6 sky130_fd_pr_reram__reram_cell area_ox=0.0676
XMp_6_7 dp_6_7 WL6 SL7 VSS sky130_fd_pr__nfet_g5v0d10v5 w=1 l=0.5
XRp_6_7 BLP7 dp_6_7 sky130_fd_pr_reram__reram_cell area_ox=0.0676
XMn_6_7 dn_6_7 WL6 SL7 VSS sky130_fd_pr__nfet_g5v0d10v5 w=1 l=0.5
XRn_6_7 BLN7 dn_6_7 sky130_fd_pr_reram__reram_cell area_ox=0.0676
XMp_6_8 dp_6_8 WL6 SL8 VSS sky130_fd_pr__nfet_g5v0d10v5 w=1 l=0.5
XRp_6_8 BLP8 dp_6_8 sky130_fd_pr_reram__reram_cell area_ox=0.0676
XMn_6_8 dn_6_8 WL6 SL8 VSS sky130_fd_pr__nfet_g5v0d10v5 w=1 l=0.5
XRn_6_8 BLN8 dn_6_8 sky130_fd_pr_reram__reram_cell area_ox=0.0676
XMp_6_9 dp_6_9 WL6 SL9 VSS sky130_fd_pr__nfet_g5v0d10v5 w=1 l=0.5
XRp_6_9 BLP9 dp_6_9 sky130_fd_pr_reram__reram_cell area_ox=0.0676
XMn_6_9 dn_6_9 WL6 SL9 VSS sky130_fd_pr__nfet_g5v0d10v5 w=1 l=0.5
XRn_6_9 BLN9 dn_6_9 sky130_fd_pr_reram__reram_cell area_ox=0.0676
XMp_6_10 dp_6_10 WL6 SL10 VSS sky130_fd_pr__nfet_g5v0d10v5 w=1 l=0.5
XRp_6_10 BLP10 dp_6_10 sky130_fd_pr_reram__reram_cell area_ox=0.0676
XMn_6_10 dn_6_10 WL6 SL10 VSS sky130_fd_pr__nfet_g5v0d10v5 w=1 l=0.5
XRn_6_10 BLN10 dn_6_10 sky130_fd_pr_reram__reram_cell area_ox=0.0676
XMp_6_11 dp_6_11 WL6 SL11 VSS sky130_fd_pr__nfet_g5v0d10v5 w=1 l=0.5
XRp_6_11 BLP11 dp_6_11 sky130_fd_pr_reram__reram_cell area_ox=0.0676
XMn_6_11 dn_6_11 WL6 SL11 VSS sky130_fd_pr__nfet_g5v0d10v5 w=1 l=0.5
XRn_6_11 BLN11 dn_6_11 sky130_fd_pr_reram__reram_cell area_ox=0.0676
XMp_6_12 dp_6_12 WL6 SL12 VSS sky130_fd_pr__nfet_g5v0d10v5 w=1 l=0.5
XRp_6_12 BLP12 dp_6_12 sky130_fd_pr_reram__reram_cell area_ox=0.0676
XMn_6_12 dn_6_12 WL6 SL12 VSS sky130_fd_pr__nfet_g5v0d10v5 w=1 l=0.5
XRn_6_12 BLN12 dn_6_12 sky130_fd_pr_reram__reram_cell area_ox=0.0676
XMp_6_13 dp_6_13 WL6 SL13 VSS sky130_fd_pr__nfet_g5v0d10v5 w=1 l=0.5
XRp_6_13 BLP13 dp_6_13 sky130_fd_pr_reram__reram_cell area_ox=0.0676
XMn_6_13 dn_6_13 WL6 SL13 VSS sky130_fd_pr__nfet_g5v0d10v5 w=1 l=0.5
XRn_6_13 BLN13 dn_6_13 sky130_fd_pr_reram__reram_cell area_ox=0.0676
XMp_6_14 dp_6_14 WL6 SL14 VSS sky130_fd_pr__nfet_g5v0d10v5 w=1 l=0.5
XRp_6_14 BLP14 dp_6_14 sky130_fd_pr_reram__reram_cell area_ox=0.0676
XMn_6_14 dn_6_14 WL6 SL14 VSS sky130_fd_pr__nfet_g5v0d10v5 w=1 l=0.5
XRn_6_14 BLN14 dn_6_14 sky130_fd_pr_reram__reram_cell area_ox=0.0676
XMp_6_15 dp_6_15 WL6 SL15 VSS sky130_fd_pr__nfet_g5v0d10v5 w=1 l=0.5
XRp_6_15 BLP15 dp_6_15 sky130_fd_pr_reram__reram_cell area_ox=0.0676
XMn_6_15 dn_6_15 WL6 SL15 VSS sky130_fd_pr__nfet_g5v0d10v5 w=1 l=0.5
XRn_6_15 BLN15 dn_6_15 sky130_fd_pr_reram__reram_cell area_ox=0.0676
XMp_6_16 dp_6_16 WL6 SL16 VSS sky130_fd_pr__nfet_g5v0d10v5 w=1 l=0.5
XRp_6_16 BLP16 dp_6_16 sky130_fd_pr_reram__reram_cell area_ox=0.0676
XMn_6_16 dn_6_16 WL6 SL16 VSS sky130_fd_pr__nfet_g5v0d10v5 w=1 l=0.5
XRn_6_16 BLN16 dn_6_16 sky130_fd_pr_reram__reram_cell area_ox=0.0676
XMp_6_17 dp_6_17 WL6 SL17 VSS sky130_fd_pr__nfet_g5v0d10v5 w=1 l=0.5
XRp_6_17 BLP17 dp_6_17 sky130_fd_pr_reram__reram_cell area_ox=0.0676
XMn_6_17 dn_6_17 WL6 SL17 VSS sky130_fd_pr__nfet_g5v0d10v5 w=1 l=0.5
XRn_6_17 BLN17 dn_6_17 sky130_fd_pr_reram__reram_cell area_ox=0.0676
XMp_6_18 dp_6_18 WL6 SL18 VSS sky130_fd_pr__nfet_g5v0d10v5 w=1 l=0.5
XRp_6_18 BLP18 dp_6_18 sky130_fd_pr_reram__reram_cell area_ox=0.0676
XMn_6_18 dn_6_18 WL6 SL18 VSS sky130_fd_pr__nfet_g5v0d10v5 w=1 l=0.5
XRn_6_18 BLN18 dn_6_18 sky130_fd_pr_reram__reram_cell area_ox=0.0676
XMp_6_19 dp_6_19 WL6 SL19 VSS sky130_fd_pr__nfet_g5v0d10v5 w=1 l=0.5
XRp_6_19 BLP19 dp_6_19 sky130_fd_pr_reram__reram_cell area_ox=0.0676
XMn_6_19 dn_6_19 WL6 SL19 VSS sky130_fd_pr__nfet_g5v0d10v5 w=1 l=0.5
XRn_6_19 BLN19 dn_6_19 sky130_fd_pr_reram__reram_cell area_ox=0.0676
XMp_6_20 dp_6_20 WL6 SL20 VSS sky130_fd_pr__nfet_g5v0d10v5 w=1 l=0.5
XRp_6_20 BLP20 dp_6_20 sky130_fd_pr_reram__reram_cell area_ox=0.0676
XMn_6_20 dn_6_20 WL6 SL20 VSS sky130_fd_pr__nfet_g5v0d10v5 w=1 l=0.5
XRn_6_20 BLN20 dn_6_20 sky130_fd_pr_reram__reram_cell area_ox=0.0676
XMp_6_21 dp_6_21 WL6 SL21 VSS sky130_fd_pr__nfet_g5v0d10v5 w=1 l=0.5
XRp_6_21 BLP21 dp_6_21 sky130_fd_pr_reram__reram_cell area_ox=0.0676
XMn_6_21 dn_6_21 WL6 SL21 VSS sky130_fd_pr__nfet_g5v0d10v5 w=1 l=0.5
XRn_6_21 BLN21 dn_6_21 sky130_fd_pr_reram__reram_cell area_ox=0.0676
XMp_6_22 dp_6_22 WL6 SL22 VSS sky130_fd_pr__nfet_g5v0d10v5 w=1 l=0.5
XRp_6_22 BLP22 dp_6_22 sky130_fd_pr_reram__reram_cell area_ox=0.0676
XMn_6_22 dn_6_22 WL6 SL22 VSS sky130_fd_pr__nfet_g5v0d10v5 w=1 l=0.5
XRn_6_22 BLN22 dn_6_22 sky130_fd_pr_reram__reram_cell area_ox=0.0676
XMp_6_23 dp_6_23 WL6 SL23 VSS sky130_fd_pr__nfet_g5v0d10v5 w=1 l=0.5
XRp_6_23 BLP23 dp_6_23 sky130_fd_pr_reram__reram_cell area_ox=0.0676
XMn_6_23 dn_6_23 WL6 SL23 VSS sky130_fd_pr__nfet_g5v0d10v5 w=1 l=0.5
XRn_6_23 BLN23 dn_6_23 sky130_fd_pr_reram__reram_cell area_ox=0.0676
XMp_7_0 dp_7_0 WL7 SL0 VSS sky130_fd_pr__nfet_g5v0d10v5 w=1 l=0.5
XRp_7_0 BLP0 dp_7_0 sky130_fd_pr_reram__reram_cell area_ox=0.0676
XMn_7_0 dn_7_0 WL7 SL0 VSS sky130_fd_pr__nfet_g5v0d10v5 w=1 l=0.5
XRn_7_0 BLN0 dn_7_0 sky130_fd_pr_reram__reram_cell area_ox=0.0676
XMp_7_1 dp_7_1 WL7 SL1 VSS sky130_fd_pr__nfet_g5v0d10v5 w=1 l=0.5
XRp_7_1 BLP1 dp_7_1 sky130_fd_pr_reram__reram_cell area_ox=0.0676
XMn_7_1 dn_7_1 WL7 SL1 VSS sky130_fd_pr__nfet_g5v0d10v5 w=1 l=0.5
XRn_7_1 BLN1 dn_7_1 sky130_fd_pr_reram__reram_cell area_ox=0.0676
XMp_7_2 dp_7_2 WL7 SL2 VSS sky130_fd_pr__nfet_g5v0d10v5 w=1 l=0.5
XRp_7_2 BLP2 dp_7_2 sky130_fd_pr_reram__reram_cell area_ox=0.0676
XMn_7_2 dn_7_2 WL7 SL2 VSS sky130_fd_pr__nfet_g5v0d10v5 w=1 l=0.5
XRn_7_2 BLN2 dn_7_2 sky130_fd_pr_reram__reram_cell area_ox=0.0676
XMp_7_3 dp_7_3 WL7 SL3 VSS sky130_fd_pr__nfet_g5v0d10v5 w=1 l=0.5
XRp_7_3 BLP3 dp_7_3 sky130_fd_pr_reram__reram_cell area_ox=0.0676
XMn_7_3 dn_7_3 WL7 SL3 VSS sky130_fd_pr__nfet_g5v0d10v5 w=1 l=0.5
XRn_7_3 BLN3 dn_7_3 sky130_fd_pr_reram__reram_cell area_ox=0.0676
XMp_7_4 dp_7_4 WL7 SL4 VSS sky130_fd_pr__nfet_g5v0d10v5 w=1 l=0.5
XRp_7_4 BLP4 dp_7_4 sky130_fd_pr_reram__reram_cell area_ox=0.0676
XMn_7_4 dn_7_4 WL7 SL4 VSS sky130_fd_pr__nfet_g5v0d10v5 w=1 l=0.5
XRn_7_4 BLN4 dn_7_4 sky130_fd_pr_reram__reram_cell area_ox=0.0676
XMp_7_5 dp_7_5 WL7 SL5 VSS sky130_fd_pr__nfet_g5v0d10v5 w=1 l=0.5
XRp_7_5 BLP5 dp_7_5 sky130_fd_pr_reram__reram_cell area_ox=0.0676
XMn_7_5 dn_7_5 WL7 SL5 VSS sky130_fd_pr__nfet_g5v0d10v5 w=1 l=0.5
XRn_7_5 BLN5 dn_7_5 sky130_fd_pr_reram__reram_cell area_ox=0.0676
XMp_7_6 dp_7_6 WL7 SL6 VSS sky130_fd_pr__nfet_g5v0d10v5 w=1 l=0.5
XRp_7_6 BLP6 dp_7_6 sky130_fd_pr_reram__reram_cell area_ox=0.0676
XMn_7_6 dn_7_6 WL7 SL6 VSS sky130_fd_pr__nfet_g5v0d10v5 w=1 l=0.5
XRn_7_6 BLN6 dn_7_6 sky130_fd_pr_reram__reram_cell area_ox=0.0676
XMp_7_7 dp_7_7 WL7 SL7 VSS sky130_fd_pr__nfet_g5v0d10v5 w=1 l=0.5
XRp_7_7 BLP7 dp_7_7 sky130_fd_pr_reram__reram_cell area_ox=0.0676
XMn_7_7 dn_7_7 WL7 SL7 VSS sky130_fd_pr__nfet_g5v0d10v5 w=1 l=0.5
XRn_7_7 BLN7 dn_7_7 sky130_fd_pr_reram__reram_cell area_ox=0.0676
XMp_7_8 dp_7_8 WL7 SL8 VSS sky130_fd_pr__nfet_g5v0d10v5 w=1 l=0.5
XRp_7_8 BLP8 dp_7_8 sky130_fd_pr_reram__reram_cell area_ox=0.0676
XMn_7_8 dn_7_8 WL7 SL8 VSS sky130_fd_pr__nfet_g5v0d10v5 w=1 l=0.5
XRn_7_8 BLN8 dn_7_8 sky130_fd_pr_reram__reram_cell area_ox=0.0676
XMp_7_9 dp_7_9 WL7 SL9 VSS sky130_fd_pr__nfet_g5v0d10v5 w=1 l=0.5
XRp_7_9 BLP9 dp_7_9 sky130_fd_pr_reram__reram_cell area_ox=0.0676
XMn_7_9 dn_7_9 WL7 SL9 VSS sky130_fd_pr__nfet_g5v0d10v5 w=1 l=0.5
XRn_7_9 BLN9 dn_7_9 sky130_fd_pr_reram__reram_cell area_ox=0.0676
XMp_7_10 dp_7_10 WL7 SL10 VSS sky130_fd_pr__nfet_g5v0d10v5 w=1 l=0.5
XRp_7_10 BLP10 dp_7_10 sky130_fd_pr_reram__reram_cell area_ox=0.0676
XMn_7_10 dn_7_10 WL7 SL10 VSS sky130_fd_pr__nfet_g5v0d10v5 w=1 l=0.5
XRn_7_10 BLN10 dn_7_10 sky130_fd_pr_reram__reram_cell area_ox=0.0676
XMp_7_11 dp_7_11 WL7 SL11 VSS sky130_fd_pr__nfet_g5v0d10v5 w=1 l=0.5
XRp_7_11 BLP11 dp_7_11 sky130_fd_pr_reram__reram_cell area_ox=0.0676
XMn_7_11 dn_7_11 WL7 SL11 VSS sky130_fd_pr__nfet_g5v0d10v5 w=1 l=0.5
XRn_7_11 BLN11 dn_7_11 sky130_fd_pr_reram__reram_cell area_ox=0.0676
XMp_7_12 dp_7_12 WL7 SL12 VSS sky130_fd_pr__nfet_g5v0d10v5 w=1 l=0.5
XRp_7_12 BLP12 dp_7_12 sky130_fd_pr_reram__reram_cell area_ox=0.0676
XMn_7_12 dn_7_12 WL7 SL12 VSS sky130_fd_pr__nfet_g5v0d10v5 w=1 l=0.5
XRn_7_12 BLN12 dn_7_12 sky130_fd_pr_reram__reram_cell area_ox=0.0676
XMp_7_13 dp_7_13 WL7 SL13 VSS sky130_fd_pr__nfet_g5v0d10v5 w=1 l=0.5
XRp_7_13 BLP13 dp_7_13 sky130_fd_pr_reram__reram_cell area_ox=0.0676
XMn_7_13 dn_7_13 WL7 SL13 VSS sky130_fd_pr__nfet_g5v0d10v5 w=1 l=0.5
XRn_7_13 BLN13 dn_7_13 sky130_fd_pr_reram__reram_cell area_ox=0.0676
XMp_7_14 dp_7_14 WL7 SL14 VSS sky130_fd_pr__nfet_g5v0d10v5 w=1 l=0.5
XRp_7_14 BLP14 dp_7_14 sky130_fd_pr_reram__reram_cell area_ox=0.0676
XMn_7_14 dn_7_14 WL7 SL14 VSS sky130_fd_pr__nfet_g5v0d10v5 w=1 l=0.5
XRn_7_14 BLN14 dn_7_14 sky130_fd_pr_reram__reram_cell area_ox=0.0676
XMp_7_15 dp_7_15 WL7 SL15 VSS sky130_fd_pr__nfet_g5v0d10v5 w=1 l=0.5
XRp_7_15 BLP15 dp_7_15 sky130_fd_pr_reram__reram_cell area_ox=0.0676
XMn_7_15 dn_7_15 WL7 SL15 VSS sky130_fd_pr__nfet_g5v0d10v5 w=1 l=0.5
XRn_7_15 BLN15 dn_7_15 sky130_fd_pr_reram__reram_cell area_ox=0.0676
XMp_7_16 dp_7_16 WL7 SL16 VSS sky130_fd_pr__nfet_g5v0d10v5 w=1 l=0.5
XRp_7_16 BLP16 dp_7_16 sky130_fd_pr_reram__reram_cell area_ox=0.0676
XMn_7_16 dn_7_16 WL7 SL16 VSS sky130_fd_pr__nfet_g5v0d10v5 w=1 l=0.5
XRn_7_16 BLN16 dn_7_16 sky130_fd_pr_reram__reram_cell area_ox=0.0676
XMp_7_17 dp_7_17 WL7 SL17 VSS sky130_fd_pr__nfet_g5v0d10v5 w=1 l=0.5
XRp_7_17 BLP17 dp_7_17 sky130_fd_pr_reram__reram_cell area_ox=0.0676
XMn_7_17 dn_7_17 WL7 SL17 VSS sky130_fd_pr__nfet_g5v0d10v5 w=1 l=0.5
XRn_7_17 BLN17 dn_7_17 sky130_fd_pr_reram__reram_cell area_ox=0.0676
XMp_7_18 dp_7_18 WL7 SL18 VSS sky130_fd_pr__nfet_g5v0d10v5 w=1 l=0.5
XRp_7_18 BLP18 dp_7_18 sky130_fd_pr_reram__reram_cell area_ox=0.0676
XMn_7_18 dn_7_18 WL7 SL18 VSS sky130_fd_pr__nfet_g5v0d10v5 w=1 l=0.5
XRn_7_18 BLN18 dn_7_18 sky130_fd_pr_reram__reram_cell area_ox=0.0676
XMp_7_19 dp_7_19 WL7 SL19 VSS sky130_fd_pr__nfet_g5v0d10v5 w=1 l=0.5
XRp_7_19 BLP19 dp_7_19 sky130_fd_pr_reram__reram_cell area_ox=0.0676
XMn_7_19 dn_7_19 WL7 SL19 VSS sky130_fd_pr__nfet_g5v0d10v5 w=1 l=0.5
XRn_7_19 BLN19 dn_7_19 sky130_fd_pr_reram__reram_cell area_ox=0.0676
XMp_7_20 dp_7_20 WL7 SL20 VSS sky130_fd_pr__nfet_g5v0d10v5 w=1 l=0.5
XRp_7_20 BLP20 dp_7_20 sky130_fd_pr_reram__reram_cell area_ox=0.0676
XMn_7_20 dn_7_20 WL7 SL20 VSS sky130_fd_pr__nfet_g5v0d10v5 w=1 l=0.5
XRn_7_20 BLN20 dn_7_20 sky130_fd_pr_reram__reram_cell area_ox=0.0676
XMp_7_21 dp_7_21 WL7 SL21 VSS sky130_fd_pr__nfet_g5v0d10v5 w=1 l=0.5
XRp_7_21 BLP21 dp_7_21 sky130_fd_pr_reram__reram_cell area_ox=0.0676
XMn_7_21 dn_7_21 WL7 SL21 VSS sky130_fd_pr__nfet_g5v0d10v5 w=1 l=0.5
XRn_7_21 BLN21 dn_7_21 sky130_fd_pr_reram__reram_cell area_ox=0.0676
XMp_7_22 dp_7_22 WL7 SL22 VSS sky130_fd_pr__nfet_g5v0d10v5 w=1 l=0.5
XRp_7_22 BLP22 dp_7_22 sky130_fd_pr_reram__reram_cell area_ox=0.0676
XMn_7_22 dn_7_22 WL7 SL22 VSS sky130_fd_pr__nfet_g5v0d10v5 w=1 l=0.5
XRn_7_22 BLN22 dn_7_22 sky130_fd_pr_reram__reram_cell area_ox=0.0676
XMp_7_23 dp_7_23 WL7 SL23 VSS sky130_fd_pr__nfet_g5v0d10v5 w=1 l=0.5
XRp_7_23 BLP23 dp_7_23 sky130_fd_pr_reram__reram_cell area_ox=0.0676
XMn_7_23 dn_7_23 WL7 SL23 VSS sky130_fd_pr__nfet_g5v0d10v5 w=1 l=0.5
XRn_7_23 BLN23 dn_7_23 sky130_fd_pr_reram__reram_cell area_ox=0.0676
XMp_8_0 dp_8_0 WL8 SL0 VSS sky130_fd_pr__nfet_g5v0d10v5 w=1 l=0.5
XRp_8_0 BLP0 dp_8_0 sky130_fd_pr_reram__reram_cell area_ox=0.0676
XMn_8_0 dn_8_0 WL8 SL0 VSS sky130_fd_pr__nfet_g5v0d10v5 w=1 l=0.5
XRn_8_0 BLN0 dn_8_0 sky130_fd_pr_reram__reram_cell area_ox=0.0676
XMp_8_1 dp_8_1 WL8 SL1 VSS sky130_fd_pr__nfet_g5v0d10v5 w=1 l=0.5
XRp_8_1 BLP1 dp_8_1 sky130_fd_pr_reram__reram_cell area_ox=0.0676
XMn_8_1 dn_8_1 WL8 SL1 VSS sky130_fd_pr__nfet_g5v0d10v5 w=1 l=0.5
XRn_8_1 BLN1 dn_8_1 sky130_fd_pr_reram__reram_cell area_ox=0.0676
XMp_8_2 dp_8_2 WL8 SL2 VSS sky130_fd_pr__nfet_g5v0d10v5 w=1 l=0.5
XRp_8_2 BLP2 dp_8_2 sky130_fd_pr_reram__reram_cell area_ox=0.0676
XMn_8_2 dn_8_2 WL8 SL2 VSS sky130_fd_pr__nfet_g5v0d10v5 w=1 l=0.5
XRn_8_2 BLN2 dn_8_2 sky130_fd_pr_reram__reram_cell area_ox=0.0676
XMp_8_3 dp_8_3 WL8 SL3 VSS sky130_fd_pr__nfet_g5v0d10v5 w=1 l=0.5
XRp_8_3 BLP3 dp_8_3 sky130_fd_pr_reram__reram_cell area_ox=0.0676
XMn_8_3 dn_8_3 WL8 SL3 VSS sky130_fd_pr__nfet_g5v0d10v5 w=1 l=0.5
XRn_8_3 BLN3 dn_8_3 sky130_fd_pr_reram__reram_cell area_ox=0.0676
XMp_8_4 dp_8_4 WL8 SL4 VSS sky130_fd_pr__nfet_g5v0d10v5 w=1 l=0.5
XRp_8_4 BLP4 dp_8_4 sky130_fd_pr_reram__reram_cell area_ox=0.0676
XMn_8_4 dn_8_4 WL8 SL4 VSS sky130_fd_pr__nfet_g5v0d10v5 w=1 l=0.5
XRn_8_4 BLN4 dn_8_4 sky130_fd_pr_reram__reram_cell area_ox=0.0676
XMp_8_5 dp_8_5 WL8 SL5 VSS sky130_fd_pr__nfet_g5v0d10v5 w=1 l=0.5
XRp_8_5 BLP5 dp_8_5 sky130_fd_pr_reram__reram_cell area_ox=0.0676
XMn_8_5 dn_8_5 WL8 SL5 VSS sky130_fd_pr__nfet_g5v0d10v5 w=1 l=0.5
XRn_8_5 BLN5 dn_8_5 sky130_fd_pr_reram__reram_cell area_ox=0.0676
XMp_8_6 dp_8_6 WL8 SL6 VSS sky130_fd_pr__nfet_g5v0d10v5 w=1 l=0.5
XRp_8_6 BLP6 dp_8_6 sky130_fd_pr_reram__reram_cell area_ox=0.0676
XMn_8_6 dn_8_6 WL8 SL6 VSS sky130_fd_pr__nfet_g5v0d10v5 w=1 l=0.5
XRn_8_6 BLN6 dn_8_6 sky130_fd_pr_reram__reram_cell area_ox=0.0676
XMp_8_7 dp_8_7 WL8 SL7 VSS sky130_fd_pr__nfet_g5v0d10v5 w=1 l=0.5
XRp_8_7 BLP7 dp_8_7 sky130_fd_pr_reram__reram_cell area_ox=0.0676
XMn_8_7 dn_8_7 WL8 SL7 VSS sky130_fd_pr__nfet_g5v0d10v5 w=1 l=0.5
XRn_8_7 BLN7 dn_8_7 sky130_fd_pr_reram__reram_cell area_ox=0.0676
XMp_8_8 dp_8_8 WL8 SL8 VSS sky130_fd_pr__nfet_g5v0d10v5 w=1 l=0.5
XRp_8_8 BLP8 dp_8_8 sky130_fd_pr_reram__reram_cell area_ox=0.0676
XMn_8_8 dn_8_8 WL8 SL8 VSS sky130_fd_pr__nfet_g5v0d10v5 w=1 l=0.5
XRn_8_8 BLN8 dn_8_8 sky130_fd_pr_reram__reram_cell area_ox=0.0676
XMp_8_9 dp_8_9 WL8 SL9 VSS sky130_fd_pr__nfet_g5v0d10v5 w=1 l=0.5
XRp_8_9 BLP9 dp_8_9 sky130_fd_pr_reram__reram_cell area_ox=0.0676
XMn_8_9 dn_8_9 WL8 SL9 VSS sky130_fd_pr__nfet_g5v0d10v5 w=1 l=0.5
XRn_8_9 BLN9 dn_8_9 sky130_fd_pr_reram__reram_cell area_ox=0.0676
XMp_8_10 dp_8_10 WL8 SL10 VSS sky130_fd_pr__nfet_g5v0d10v5 w=1 l=0.5
XRp_8_10 BLP10 dp_8_10 sky130_fd_pr_reram__reram_cell area_ox=0.0676
XMn_8_10 dn_8_10 WL8 SL10 VSS sky130_fd_pr__nfet_g5v0d10v5 w=1 l=0.5
XRn_8_10 BLN10 dn_8_10 sky130_fd_pr_reram__reram_cell area_ox=0.0676
XMp_8_11 dp_8_11 WL8 SL11 VSS sky130_fd_pr__nfet_g5v0d10v5 w=1 l=0.5
XRp_8_11 BLP11 dp_8_11 sky130_fd_pr_reram__reram_cell area_ox=0.0676
XMn_8_11 dn_8_11 WL8 SL11 VSS sky130_fd_pr__nfet_g5v0d10v5 w=1 l=0.5
XRn_8_11 BLN11 dn_8_11 sky130_fd_pr_reram__reram_cell area_ox=0.0676
XMp_8_12 dp_8_12 WL8 SL12 VSS sky130_fd_pr__nfet_g5v0d10v5 w=1 l=0.5
XRp_8_12 BLP12 dp_8_12 sky130_fd_pr_reram__reram_cell area_ox=0.0676
XMn_8_12 dn_8_12 WL8 SL12 VSS sky130_fd_pr__nfet_g5v0d10v5 w=1 l=0.5
XRn_8_12 BLN12 dn_8_12 sky130_fd_pr_reram__reram_cell area_ox=0.0676
XMp_8_13 dp_8_13 WL8 SL13 VSS sky130_fd_pr__nfet_g5v0d10v5 w=1 l=0.5
XRp_8_13 BLP13 dp_8_13 sky130_fd_pr_reram__reram_cell area_ox=0.0676
XMn_8_13 dn_8_13 WL8 SL13 VSS sky130_fd_pr__nfet_g5v0d10v5 w=1 l=0.5
XRn_8_13 BLN13 dn_8_13 sky130_fd_pr_reram__reram_cell area_ox=0.0676
XMp_8_14 dp_8_14 WL8 SL14 VSS sky130_fd_pr__nfet_g5v0d10v5 w=1 l=0.5
XRp_8_14 BLP14 dp_8_14 sky130_fd_pr_reram__reram_cell area_ox=0.0676
XMn_8_14 dn_8_14 WL8 SL14 VSS sky130_fd_pr__nfet_g5v0d10v5 w=1 l=0.5
XRn_8_14 BLN14 dn_8_14 sky130_fd_pr_reram__reram_cell area_ox=0.0676
XMp_8_15 dp_8_15 WL8 SL15 VSS sky130_fd_pr__nfet_g5v0d10v5 w=1 l=0.5
XRp_8_15 BLP15 dp_8_15 sky130_fd_pr_reram__reram_cell area_ox=0.0676
XMn_8_15 dn_8_15 WL8 SL15 VSS sky130_fd_pr__nfet_g5v0d10v5 w=1 l=0.5
XRn_8_15 BLN15 dn_8_15 sky130_fd_pr_reram__reram_cell area_ox=0.0676
XMp_8_16 dp_8_16 WL8 SL16 VSS sky130_fd_pr__nfet_g5v0d10v5 w=1 l=0.5
XRp_8_16 BLP16 dp_8_16 sky130_fd_pr_reram__reram_cell area_ox=0.0676
XMn_8_16 dn_8_16 WL8 SL16 VSS sky130_fd_pr__nfet_g5v0d10v5 w=1 l=0.5
XRn_8_16 BLN16 dn_8_16 sky130_fd_pr_reram__reram_cell area_ox=0.0676
XMp_8_17 dp_8_17 WL8 SL17 VSS sky130_fd_pr__nfet_g5v0d10v5 w=1 l=0.5
XRp_8_17 BLP17 dp_8_17 sky130_fd_pr_reram__reram_cell area_ox=0.0676
XMn_8_17 dn_8_17 WL8 SL17 VSS sky130_fd_pr__nfet_g5v0d10v5 w=1 l=0.5
XRn_8_17 BLN17 dn_8_17 sky130_fd_pr_reram__reram_cell area_ox=0.0676
XMp_8_18 dp_8_18 WL8 SL18 VSS sky130_fd_pr__nfet_g5v0d10v5 w=1 l=0.5
XRp_8_18 BLP18 dp_8_18 sky130_fd_pr_reram__reram_cell area_ox=0.0676
XMn_8_18 dn_8_18 WL8 SL18 VSS sky130_fd_pr__nfet_g5v0d10v5 w=1 l=0.5
XRn_8_18 BLN18 dn_8_18 sky130_fd_pr_reram__reram_cell area_ox=0.0676
XMp_8_19 dp_8_19 WL8 SL19 VSS sky130_fd_pr__nfet_g5v0d10v5 w=1 l=0.5
XRp_8_19 BLP19 dp_8_19 sky130_fd_pr_reram__reram_cell area_ox=0.0676
XMn_8_19 dn_8_19 WL8 SL19 VSS sky130_fd_pr__nfet_g5v0d10v5 w=1 l=0.5
XRn_8_19 BLN19 dn_8_19 sky130_fd_pr_reram__reram_cell area_ox=0.0676
XMp_8_20 dp_8_20 WL8 SL20 VSS sky130_fd_pr__nfet_g5v0d10v5 w=1 l=0.5
XRp_8_20 BLP20 dp_8_20 sky130_fd_pr_reram__reram_cell area_ox=0.0676
XMn_8_20 dn_8_20 WL8 SL20 VSS sky130_fd_pr__nfet_g5v0d10v5 w=1 l=0.5
XRn_8_20 BLN20 dn_8_20 sky130_fd_pr_reram__reram_cell area_ox=0.0676
XMp_8_21 dp_8_21 WL8 SL21 VSS sky130_fd_pr__nfet_g5v0d10v5 w=1 l=0.5
XRp_8_21 BLP21 dp_8_21 sky130_fd_pr_reram__reram_cell area_ox=0.0676
XMn_8_21 dn_8_21 WL8 SL21 VSS sky130_fd_pr__nfet_g5v0d10v5 w=1 l=0.5
XRn_8_21 BLN21 dn_8_21 sky130_fd_pr_reram__reram_cell area_ox=0.0676
XMp_8_22 dp_8_22 WL8 SL22 VSS sky130_fd_pr__nfet_g5v0d10v5 w=1 l=0.5
XRp_8_22 BLP22 dp_8_22 sky130_fd_pr_reram__reram_cell area_ox=0.0676
XMn_8_22 dn_8_22 WL8 SL22 VSS sky130_fd_pr__nfet_g5v0d10v5 w=1 l=0.5
XRn_8_22 BLN22 dn_8_22 sky130_fd_pr_reram__reram_cell area_ox=0.0676
XMp_8_23 dp_8_23 WL8 SL23 VSS sky130_fd_pr__nfet_g5v0d10v5 w=1 l=0.5
XRp_8_23 BLP23 dp_8_23 sky130_fd_pr_reram__reram_cell area_ox=0.0676
XMn_8_23 dn_8_23 WL8 SL23 VSS sky130_fd_pr__nfet_g5v0d10v5 w=1 l=0.5
XRn_8_23 BLN23 dn_8_23 sky130_fd_pr_reram__reram_cell area_ox=0.0676
XMp_9_0 dp_9_0 WL9 SL0 VSS sky130_fd_pr__nfet_g5v0d10v5 w=1 l=0.5
XRp_9_0 BLP0 dp_9_0 sky130_fd_pr_reram__reram_cell area_ox=0.0676
XMn_9_0 dn_9_0 WL9 SL0 VSS sky130_fd_pr__nfet_g5v0d10v5 w=1 l=0.5
XRn_9_0 BLN0 dn_9_0 sky130_fd_pr_reram__reram_cell area_ox=0.0676
XMp_9_1 dp_9_1 WL9 SL1 VSS sky130_fd_pr__nfet_g5v0d10v5 w=1 l=0.5
XRp_9_1 BLP1 dp_9_1 sky130_fd_pr_reram__reram_cell area_ox=0.0676
XMn_9_1 dn_9_1 WL9 SL1 VSS sky130_fd_pr__nfet_g5v0d10v5 w=1 l=0.5
XRn_9_1 BLN1 dn_9_1 sky130_fd_pr_reram__reram_cell area_ox=0.0676
XMp_9_2 dp_9_2 WL9 SL2 VSS sky130_fd_pr__nfet_g5v0d10v5 w=1 l=0.5
XRp_9_2 BLP2 dp_9_2 sky130_fd_pr_reram__reram_cell area_ox=0.0676
XMn_9_2 dn_9_2 WL9 SL2 VSS sky130_fd_pr__nfet_g5v0d10v5 w=1 l=0.5
XRn_9_2 BLN2 dn_9_2 sky130_fd_pr_reram__reram_cell area_ox=0.0676
XMp_9_3 dp_9_3 WL9 SL3 VSS sky130_fd_pr__nfet_g5v0d10v5 w=1 l=0.5
XRp_9_3 BLP3 dp_9_3 sky130_fd_pr_reram__reram_cell area_ox=0.0676
XMn_9_3 dn_9_3 WL9 SL3 VSS sky130_fd_pr__nfet_g5v0d10v5 w=1 l=0.5
XRn_9_3 BLN3 dn_9_3 sky130_fd_pr_reram__reram_cell area_ox=0.0676
XMp_9_4 dp_9_4 WL9 SL4 VSS sky130_fd_pr__nfet_g5v0d10v5 w=1 l=0.5
XRp_9_4 BLP4 dp_9_4 sky130_fd_pr_reram__reram_cell area_ox=0.0676
XMn_9_4 dn_9_4 WL9 SL4 VSS sky130_fd_pr__nfet_g5v0d10v5 w=1 l=0.5
XRn_9_4 BLN4 dn_9_4 sky130_fd_pr_reram__reram_cell area_ox=0.0676
XMp_9_5 dp_9_5 WL9 SL5 VSS sky130_fd_pr__nfet_g5v0d10v5 w=1 l=0.5
XRp_9_5 BLP5 dp_9_5 sky130_fd_pr_reram__reram_cell area_ox=0.0676
XMn_9_5 dn_9_5 WL9 SL5 VSS sky130_fd_pr__nfet_g5v0d10v5 w=1 l=0.5
XRn_9_5 BLN5 dn_9_5 sky130_fd_pr_reram__reram_cell area_ox=0.0676
XMp_9_6 dp_9_6 WL9 SL6 VSS sky130_fd_pr__nfet_g5v0d10v5 w=1 l=0.5
XRp_9_6 BLP6 dp_9_6 sky130_fd_pr_reram__reram_cell area_ox=0.0676
XMn_9_6 dn_9_6 WL9 SL6 VSS sky130_fd_pr__nfet_g5v0d10v5 w=1 l=0.5
XRn_9_6 BLN6 dn_9_6 sky130_fd_pr_reram__reram_cell area_ox=0.0676
XMp_9_7 dp_9_7 WL9 SL7 VSS sky130_fd_pr__nfet_g5v0d10v5 w=1 l=0.5
XRp_9_7 BLP7 dp_9_7 sky130_fd_pr_reram__reram_cell area_ox=0.0676
XMn_9_7 dn_9_7 WL9 SL7 VSS sky130_fd_pr__nfet_g5v0d10v5 w=1 l=0.5
XRn_9_7 BLN7 dn_9_7 sky130_fd_pr_reram__reram_cell area_ox=0.0676
XMp_9_8 dp_9_8 WL9 SL8 VSS sky130_fd_pr__nfet_g5v0d10v5 w=1 l=0.5
XRp_9_8 BLP8 dp_9_8 sky130_fd_pr_reram__reram_cell area_ox=0.0676
XMn_9_8 dn_9_8 WL9 SL8 VSS sky130_fd_pr__nfet_g5v0d10v5 w=1 l=0.5
XRn_9_8 BLN8 dn_9_8 sky130_fd_pr_reram__reram_cell area_ox=0.0676
XMp_9_9 dp_9_9 WL9 SL9 VSS sky130_fd_pr__nfet_g5v0d10v5 w=1 l=0.5
XRp_9_9 BLP9 dp_9_9 sky130_fd_pr_reram__reram_cell area_ox=0.0676
XMn_9_9 dn_9_9 WL9 SL9 VSS sky130_fd_pr__nfet_g5v0d10v5 w=1 l=0.5
XRn_9_9 BLN9 dn_9_9 sky130_fd_pr_reram__reram_cell area_ox=0.0676
XMp_9_10 dp_9_10 WL9 SL10 VSS sky130_fd_pr__nfet_g5v0d10v5 w=1 l=0.5
XRp_9_10 BLP10 dp_9_10 sky130_fd_pr_reram__reram_cell area_ox=0.0676
XMn_9_10 dn_9_10 WL9 SL10 VSS sky130_fd_pr__nfet_g5v0d10v5 w=1 l=0.5
XRn_9_10 BLN10 dn_9_10 sky130_fd_pr_reram__reram_cell area_ox=0.0676
XMp_9_11 dp_9_11 WL9 SL11 VSS sky130_fd_pr__nfet_g5v0d10v5 w=1 l=0.5
XRp_9_11 BLP11 dp_9_11 sky130_fd_pr_reram__reram_cell area_ox=0.0676
XMn_9_11 dn_9_11 WL9 SL11 VSS sky130_fd_pr__nfet_g5v0d10v5 w=1 l=0.5
XRn_9_11 BLN11 dn_9_11 sky130_fd_pr_reram__reram_cell area_ox=0.0676
XMp_9_12 dp_9_12 WL9 SL12 VSS sky130_fd_pr__nfet_g5v0d10v5 w=1 l=0.5
XRp_9_12 BLP12 dp_9_12 sky130_fd_pr_reram__reram_cell area_ox=0.0676
XMn_9_12 dn_9_12 WL9 SL12 VSS sky130_fd_pr__nfet_g5v0d10v5 w=1 l=0.5
XRn_9_12 BLN12 dn_9_12 sky130_fd_pr_reram__reram_cell area_ox=0.0676
XMp_9_13 dp_9_13 WL9 SL13 VSS sky130_fd_pr__nfet_g5v0d10v5 w=1 l=0.5
XRp_9_13 BLP13 dp_9_13 sky130_fd_pr_reram__reram_cell area_ox=0.0676
XMn_9_13 dn_9_13 WL9 SL13 VSS sky130_fd_pr__nfet_g5v0d10v5 w=1 l=0.5
XRn_9_13 BLN13 dn_9_13 sky130_fd_pr_reram__reram_cell area_ox=0.0676
XMp_9_14 dp_9_14 WL9 SL14 VSS sky130_fd_pr__nfet_g5v0d10v5 w=1 l=0.5
XRp_9_14 BLP14 dp_9_14 sky130_fd_pr_reram__reram_cell area_ox=0.0676
XMn_9_14 dn_9_14 WL9 SL14 VSS sky130_fd_pr__nfet_g5v0d10v5 w=1 l=0.5
XRn_9_14 BLN14 dn_9_14 sky130_fd_pr_reram__reram_cell area_ox=0.0676
XMp_9_15 dp_9_15 WL9 SL15 VSS sky130_fd_pr__nfet_g5v0d10v5 w=1 l=0.5
XRp_9_15 BLP15 dp_9_15 sky130_fd_pr_reram__reram_cell area_ox=0.0676
XMn_9_15 dn_9_15 WL9 SL15 VSS sky130_fd_pr__nfet_g5v0d10v5 w=1 l=0.5
XRn_9_15 BLN15 dn_9_15 sky130_fd_pr_reram__reram_cell area_ox=0.0676
XMp_9_16 dp_9_16 WL9 SL16 VSS sky130_fd_pr__nfet_g5v0d10v5 w=1 l=0.5
XRp_9_16 BLP16 dp_9_16 sky130_fd_pr_reram__reram_cell area_ox=0.0676
XMn_9_16 dn_9_16 WL9 SL16 VSS sky130_fd_pr__nfet_g5v0d10v5 w=1 l=0.5
XRn_9_16 BLN16 dn_9_16 sky130_fd_pr_reram__reram_cell area_ox=0.0676
XMp_9_17 dp_9_17 WL9 SL17 VSS sky130_fd_pr__nfet_g5v0d10v5 w=1 l=0.5
XRp_9_17 BLP17 dp_9_17 sky130_fd_pr_reram__reram_cell area_ox=0.0676
XMn_9_17 dn_9_17 WL9 SL17 VSS sky130_fd_pr__nfet_g5v0d10v5 w=1 l=0.5
XRn_9_17 BLN17 dn_9_17 sky130_fd_pr_reram__reram_cell area_ox=0.0676
XMp_9_18 dp_9_18 WL9 SL18 VSS sky130_fd_pr__nfet_g5v0d10v5 w=1 l=0.5
XRp_9_18 BLP18 dp_9_18 sky130_fd_pr_reram__reram_cell area_ox=0.0676
XMn_9_18 dn_9_18 WL9 SL18 VSS sky130_fd_pr__nfet_g5v0d10v5 w=1 l=0.5
XRn_9_18 BLN18 dn_9_18 sky130_fd_pr_reram__reram_cell area_ox=0.0676
XMp_9_19 dp_9_19 WL9 SL19 VSS sky130_fd_pr__nfet_g5v0d10v5 w=1 l=0.5
XRp_9_19 BLP19 dp_9_19 sky130_fd_pr_reram__reram_cell area_ox=0.0676
XMn_9_19 dn_9_19 WL9 SL19 VSS sky130_fd_pr__nfet_g5v0d10v5 w=1 l=0.5
XRn_9_19 BLN19 dn_9_19 sky130_fd_pr_reram__reram_cell area_ox=0.0676
XMp_9_20 dp_9_20 WL9 SL20 VSS sky130_fd_pr__nfet_g5v0d10v5 w=1 l=0.5
XRp_9_20 BLP20 dp_9_20 sky130_fd_pr_reram__reram_cell area_ox=0.0676
XMn_9_20 dn_9_20 WL9 SL20 VSS sky130_fd_pr__nfet_g5v0d10v5 w=1 l=0.5
XRn_9_20 BLN20 dn_9_20 sky130_fd_pr_reram__reram_cell area_ox=0.0676
XMp_9_21 dp_9_21 WL9 SL21 VSS sky130_fd_pr__nfet_g5v0d10v5 w=1 l=0.5
XRp_9_21 BLP21 dp_9_21 sky130_fd_pr_reram__reram_cell area_ox=0.0676
XMn_9_21 dn_9_21 WL9 SL21 VSS sky130_fd_pr__nfet_g5v0d10v5 w=1 l=0.5
XRn_9_21 BLN21 dn_9_21 sky130_fd_pr_reram__reram_cell area_ox=0.0676
XMp_9_22 dp_9_22 WL9 SL22 VSS sky130_fd_pr__nfet_g5v0d10v5 w=1 l=0.5
XRp_9_22 BLP22 dp_9_22 sky130_fd_pr_reram__reram_cell area_ox=0.0676
XMn_9_22 dn_9_22 WL9 SL22 VSS sky130_fd_pr__nfet_g5v0d10v5 w=1 l=0.5
XRn_9_22 BLN22 dn_9_22 sky130_fd_pr_reram__reram_cell area_ox=0.0676
XMp_9_23 dp_9_23 WL9 SL23 VSS sky130_fd_pr__nfet_g5v0d10v5 w=1 l=0.5
XRp_9_23 BLP23 dp_9_23 sky130_fd_pr_reram__reram_cell area_ox=0.0676
XMn_9_23 dn_9_23 WL9 SL23 VSS sky130_fd_pr__nfet_g5v0d10v5 w=1 l=0.5
XRn_9_23 BLN23 dn_9_23 sky130_fd_pr_reram__reram_cell area_ox=0.0676
XMp_10_0 dp_10_0 WL10 SL0 VSS sky130_fd_pr__nfet_g5v0d10v5 w=1 l=0.5
XRp_10_0 BLP0 dp_10_0 sky130_fd_pr_reram__reram_cell area_ox=0.0676
XMn_10_0 dn_10_0 WL10 SL0 VSS sky130_fd_pr__nfet_g5v0d10v5 w=1 l=0.5
XRn_10_0 BLN0 dn_10_0 sky130_fd_pr_reram__reram_cell area_ox=0.0676
XMp_10_1 dp_10_1 WL10 SL1 VSS sky130_fd_pr__nfet_g5v0d10v5 w=1 l=0.5
XRp_10_1 BLP1 dp_10_1 sky130_fd_pr_reram__reram_cell area_ox=0.0676
XMn_10_1 dn_10_1 WL10 SL1 VSS sky130_fd_pr__nfet_g5v0d10v5 w=1 l=0.5
XRn_10_1 BLN1 dn_10_1 sky130_fd_pr_reram__reram_cell area_ox=0.0676
XMp_10_2 dp_10_2 WL10 SL2 VSS sky130_fd_pr__nfet_g5v0d10v5 w=1 l=0.5
XRp_10_2 BLP2 dp_10_2 sky130_fd_pr_reram__reram_cell area_ox=0.0676
XMn_10_2 dn_10_2 WL10 SL2 VSS sky130_fd_pr__nfet_g5v0d10v5 w=1 l=0.5
XRn_10_2 BLN2 dn_10_2 sky130_fd_pr_reram__reram_cell area_ox=0.0676
XMp_10_3 dp_10_3 WL10 SL3 VSS sky130_fd_pr__nfet_g5v0d10v5 w=1 l=0.5
XRp_10_3 BLP3 dp_10_3 sky130_fd_pr_reram__reram_cell area_ox=0.0676
XMn_10_3 dn_10_3 WL10 SL3 VSS sky130_fd_pr__nfet_g5v0d10v5 w=1 l=0.5
XRn_10_3 BLN3 dn_10_3 sky130_fd_pr_reram__reram_cell area_ox=0.0676
XMp_10_4 dp_10_4 WL10 SL4 VSS sky130_fd_pr__nfet_g5v0d10v5 w=1 l=0.5
XRp_10_4 BLP4 dp_10_4 sky130_fd_pr_reram__reram_cell area_ox=0.0676
XMn_10_4 dn_10_4 WL10 SL4 VSS sky130_fd_pr__nfet_g5v0d10v5 w=1 l=0.5
XRn_10_4 BLN4 dn_10_4 sky130_fd_pr_reram__reram_cell area_ox=0.0676
XMp_10_5 dp_10_5 WL10 SL5 VSS sky130_fd_pr__nfet_g5v0d10v5 w=1 l=0.5
XRp_10_5 BLP5 dp_10_5 sky130_fd_pr_reram__reram_cell area_ox=0.0676
XMn_10_5 dn_10_5 WL10 SL5 VSS sky130_fd_pr__nfet_g5v0d10v5 w=1 l=0.5
XRn_10_5 BLN5 dn_10_5 sky130_fd_pr_reram__reram_cell area_ox=0.0676
XMp_10_6 dp_10_6 WL10 SL6 VSS sky130_fd_pr__nfet_g5v0d10v5 w=1 l=0.5
XRp_10_6 BLP6 dp_10_6 sky130_fd_pr_reram__reram_cell area_ox=0.0676
XMn_10_6 dn_10_6 WL10 SL6 VSS sky130_fd_pr__nfet_g5v0d10v5 w=1 l=0.5
XRn_10_6 BLN6 dn_10_6 sky130_fd_pr_reram__reram_cell area_ox=0.0676
XMp_10_7 dp_10_7 WL10 SL7 VSS sky130_fd_pr__nfet_g5v0d10v5 w=1 l=0.5
XRp_10_7 BLP7 dp_10_7 sky130_fd_pr_reram__reram_cell area_ox=0.0676
XMn_10_7 dn_10_7 WL10 SL7 VSS sky130_fd_pr__nfet_g5v0d10v5 w=1 l=0.5
XRn_10_7 BLN7 dn_10_7 sky130_fd_pr_reram__reram_cell area_ox=0.0676
XMp_10_8 dp_10_8 WL10 SL8 VSS sky130_fd_pr__nfet_g5v0d10v5 w=1 l=0.5
XRp_10_8 BLP8 dp_10_8 sky130_fd_pr_reram__reram_cell area_ox=0.0676
XMn_10_8 dn_10_8 WL10 SL8 VSS sky130_fd_pr__nfet_g5v0d10v5 w=1 l=0.5
XRn_10_8 BLN8 dn_10_8 sky130_fd_pr_reram__reram_cell area_ox=0.0676
XMp_10_9 dp_10_9 WL10 SL9 VSS sky130_fd_pr__nfet_g5v0d10v5 w=1 l=0.5
XRp_10_9 BLP9 dp_10_9 sky130_fd_pr_reram__reram_cell area_ox=0.0676
XMn_10_9 dn_10_9 WL10 SL9 VSS sky130_fd_pr__nfet_g5v0d10v5 w=1 l=0.5
XRn_10_9 BLN9 dn_10_9 sky130_fd_pr_reram__reram_cell area_ox=0.0676
XMp_10_10 dp_10_10 WL10 SL10 VSS sky130_fd_pr__nfet_g5v0d10v5 w=1 l=0.5
XRp_10_10 BLP10 dp_10_10 sky130_fd_pr_reram__reram_cell area_ox=0.0676
XMn_10_10 dn_10_10 WL10 SL10 VSS sky130_fd_pr__nfet_g5v0d10v5 w=1 l=0.5
XRn_10_10 BLN10 dn_10_10 sky130_fd_pr_reram__reram_cell area_ox=0.0676
XMp_10_11 dp_10_11 WL10 SL11 VSS sky130_fd_pr__nfet_g5v0d10v5 w=1 l=0.5
XRp_10_11 BLP11 dp_10_11 sky130_fd_pr_reram__reram_cell area_ox=0.0676
XMn_10_11 dn_10_11 WL10 SL11 VSS sky130_fd_pr__nfet_g5v0d10v5 w=1 l=0.5
XRn_10_11 BLN11 dn_10_11 sky130_fd_pr_reram__reram_cell area_ox=0.0676
XMp_10_12 dp_10_12 WL10 SL12 VSS sky130_fd_pr__nfet_g5v0d10v5 w=1 l=0.5
XRp_10_12 BLP12 dp_10_12 sky130_fd_pr_reram__reram_cell area_ox=0.0676
XMn_10_12 dn_10_12 WL10 SL12 VSS sky130_fd_pr__nfet_g5v0d10v5 w=1 l=0.5
XRn_10_12 BLN12 dn_10_12 sky130_fd_pr_reram__reram_cell area_ox=0.0676
XMp_10_13 dp_10_13 WL10 SL13 VSS sky130_fd_pr__nfet_g5v0d10v5 w=1 l=0.5
XRp_10_13 BLP13 dp_10_13 sky130_fd_pr_reram__reram_cell area_ox=0.0676
XMn_10_13 dn_10_13 WL10 SL13 VSS sky130_fd_pr__nfet_g5v0d10v5 w=1 l=0.5
XRn_10_13 BLN13 dn_10_13 sky130_fd_pr_reram__reram_cell area_ox=0.0676
XMp_10_14 dp_10_14 WL10 SL14 VSS sky130_fd_pr__nfet_g5v0d10v5 w=1 l=0.5
XRp_10_14 BLP14 dp_10_14 sky130_fd_pr_reram__reram_cell area_ox=0.0676
XMn_10_14 dn_10_14 WL10 SL14 VSS sky130_fd_pr__nfet_g5v0d10v5 w=1 l=0.5
XRn_10_14 BLN14 dn_10_14 sky130_fd_pr_reram__reram_cell area_ox=0.0676
XMp_10_15 dp_10_15 WL10 SL15 VSS sky130_fd_pr__nfet_g5v0d10v5 w=1 l=0.5
XRp_10_15 BLP15 dp_10_15 sky130_fd_pr_reram__reram_cell area_ox=0.0676
XMn_10_15 dn_10_15 WL10 SL15 VSS sky130_fd_pr__nfet_g5v0d10v5 w=1 l=0.5
XRn_10_15 BLN15 dn_10_15 sky130_fd_pr_reram__reram_cell area_ox=0.0676
XMp_10_16 dp_10_16 WL10 SL16 VSS sky130_fd_pr__nfet_g5v0d10v5 w=1 l=0.5
XRp_10_16 BLP16 dp_10_16 sky130_fd_pr_reram__reram_cell area_ox=0.0676
XMn_10_16 dn_10_16 WL10 SL16 VSS sky130_fd_pr__nfet_g5v0d10v5 w=1 l=0.5
XRn_10_16 BLN16 dn_10_16 sky130_fd_pr_reram__reram_cell area_ox=0.0676
XMp_10_17 dp_10_17 WL10 SL17 VSS sky130_fd_pr__nfet_g5v0d10v5 w=1 l=0.5
XRp_10_17 BLP17 dp_10_17 sky130_fd_pr_reram__reram_cell area_ox=0.0676
XMn_10_17 dn_10_17 WL10 SL17 VSS sky130_fd_pr__nfet_g5v0d10v5 w=1 l=0.5
XRn_10_17 BLN17 dn_10_17 sky130_fd_pr_reram__reram_cell area_ox=0.0676
XMp_10_18 dp_10_18 WL10 SL18 VSS sky130_fd_pr__nfet_g5v0d10v5 w=1 l=0.5
XRp_10_18 BLP18 dp_10_18 sky130_fd_pr_reram__reram_cell area_ox=0.0676
XMn_10_18 dn_10_18 WL10 SL18 VSS sky130_fd_pr__nfet_g5v0d10v5 w=1 l=0.5
XRn_10_18 BLN18 dn_10_18 sky130_fd_pr_reram__reram_cell area_ox=0.0676
XMp_10_19 dp_10_19 WL10 SL19 VSS sky130_fd_pr__nfet_g5v0d10v5 w=1 l=0.5
XRp_10_19 BLP19 dp_10_19 sky130_fd_pr_reram__reram_cell area_ox=0.0676
XMn_10_19 dn_10_19 WL10 SL19 VSS sky130_fd_pr__nfet_g5v0d10v5 w=1 l=0.5
XRn_10_19 BLN19 dn_10_19 sky130_fd_pr_reram__reram_cell area_ox=0.0676
XMp_10_20 dp_10_20 WL10 SL20 VSS sky130_fd_pr__nfet_g5v0d10v5 w=1 l=0.5
XRp_10_20 BLP20 dp_10_20 sky130_fd_pr_reram__reram_cell area_ox=0.0676
XMn_10_20 dn_10_20 WL10 SL20 VSS sky130_fd_pr__nfet_g5v0d10v5 w=1 l=0.5
XRn_10_20 BLN20 dn_10_20 sky130_fd_pr_reram__reram_cell area_ox=0.0676
XMp_10_21 dp_10_21 WL10 SL21 VSS sky130_fd_pr__nfet_g5v0d10v5 w=1 l=0.5
XRp_10_21 BLP21 dp_10_21 sky130_fd_pr_reram__reram_cell area_ox=0.0676
XMn_10_21 dn_10_21 WL10 SL21 VSS sky130_fd_pr__nfet_g5v0d10v5 w=1 l=0.5
XRn_10_21 BLN21 dn_10_21 sky130_fd_pr_reram__reram_cell area_ox=0.0676
XMp_10_22 dp_10_22 WL10 SL22 VSS sky130_fd_pr__nfet_g5v0d10v5 w=1 l=0.5
XRp_10_22 BLP22 dp_10_22 sky130_fd_pr_reram__reram_cell area_ox=0.0676
XMn_10_22 dn_10_22 WL10 SL22 VSS sky130_fd_pr__nfet_g5v0d10v5 w=1 l=0.5
XRn_10_22 BLN22 dn_10_22 sky130_fd_pr_reram__reram_cell area_ox=0.0676
XMp_10_23 dp_10_23 WL10 SL23 VSS sky130_fd_pr__nfet_g5v0d10v5 w=1 l=0.5
XRp_10_23 BLP23 dp_10_23 sky130_fd_pr_reram__reram_cell area_ox=0.0676
XMn_10_23 dn_10_23 WL10 SL23 VSS sky130_fd_pr__nfet_g5v0d10v5 w=1 l=0.5
XRn_10_23 BLN23 dn_10_23 sky130_fd_pr_reram__reram_cell area_ox=0.0676
XMp_11_0 dp_11_0 WL11 SL0 VSS sky130_fd_pr__nfet_g5v0d10v5 w=1 l=0.5
XRp_11_0 BLP0 dp_11_0 sky130_fd_pr_reram__reram_cell area_ox=0.0676
XMn_11_0 dn_11_0 WL11 SL0 VSS sky130_fd_pr__nfet_g5v0d10v5 w=1 l=0.5
XRn_11_0 BLN0 dn_11_0 sky130_fd_pr_reram__reram_cell area_ox=0.0676
XMp_11_1 dp_11_1 WL11 SL1 VSS sky130_fd_pr__nfet_g5v0d10v5 w=1 l=0.5
XRp_11_1 BLP1 dp_11_1 sky130_fd_pr_reram__reram_cell area_ox=0.0676
XMn_11_1 dn_11_1 WL11 SL1 VSS sky130_fd_pr__nfet_g5v0d10v5 w=1 l=0.5
XRn_11_1 BLN1 dn_11_1 sky130_fd_pr_reram__reram_cell area_ox=0.0676
XMp_11_2 dp_11_2 WL11 SL2 VSS sky130_fd_pr__nfet_g5v0d10v5 w=1 l=0.5
XRp_11_2 BLP2 dp_11_2 sky130_fd_pr_reram__reram_cell area_ox=0.0676
XMn_11_2 dn_11_2 WL11 SL2 VSS sky130_fd_pr__nfet_g5v0d10v5 w=1 l=0.5
XRn_11_2 BLN2 dn_11_2 sky130_fd_pr_reram__reram_cell area_ox=0.0676
XMp_11_3 dp_11_3 WL11 SL3 VSS sky130_fd_pr__nfet_g5v0d10v5 w=1 l=0.5
XRp_11_3 BLP3 dp_11_3 sky130_fd_pr_reram__reram_cell area_ox=0.0676
XMn_11_3 dn_11_3 WL11 SL3 VSS sky130_fd_pr__nfet_g5v0d10v5 w=1 l=0.5
XRn_11_3 BLN3 dn_11_3 sky130_fd_pr_reram__reram_cell area_ox=0.0676
XMp_11_4 dp_11_4 WL11 SL4 VSS sky130_fd_pr__nfet_g5v0d10v5 w=1 l=0.5
XRp_11_4 BLP4 dp_11_4 sky130_fd_pr_reram__reram_cell area_ox=0.0676
XMn_11_4 dn_11_4 WL11 SL4 VSS sky130_fd_pr__nfet_g5v0d10v5 w=1 l=0.5
XRn_11_4 BLN4 dn_11_4 sky130_fd_pr_reram__reram_cell area_ox=0.0676
XMp_11_5 dp_11_5 WL11 SL5 VSS sky130_fd_pr__nfet_g5v0d10v5 w=1 l=0.5
XRp_11_5 BLP5 dp_11_5 sky130_fd_pr_reram__reram_cell area_ox=0.0676
XMn_11_5 dn_11_5 WL11 SL5 VSS sky130_fd_pr__nfet_g5v0d10v5 w=1 l=0.5
XRn_11_5 BLN5 dn_11_5 sky130_fd_pr_reram__reram_cell area_ox=0.0676
XMp_11_6 dp_11_6 WL11 SL6 VSS sky130_fd_pr__nfet_g5v0d10v5 w=1 l=0.5
XRp_11_6 BLP6 dp_11_6 sky130_fd_pr_reram__reram_cell area_ox=0.0676
XMn_11_6 dn_11_6 WL11 SL6 VSS sky130_fd_pr__nfet_g5v0d10v5 w=1 l=0.5
XRn_11_6 BLN6 dn_11_6 sky130_fd_pr_reram__reram_cell area_ox=0.0676
XMp_11_7 dp_11_7 WL11 SL7 VSS sky130_fd_pr__nfet_g5v0d10v5 w=1 l=0.5
XRp_11_7 BLP7 dp_11_7 sky130_fd_pr_reram__reram_cell area_ox=0.0676
XMn_11_7 dn_11_7 WL11 SL7 VSS sky130_fd_pr__nfet_g5v0d10v5 w=1 l=0.5
XRn_11_7 BLN7 dn_11_7 sky130_fd_pr_reram__reram_cell area_ox=0.0676
XMp_11_8 dp_11_8 WL11 SL8 VSS sky130_fd_pr__nfet_g5v0d10v5 w=1 l=0.5
XRp_11_8 BLP8 dp_11_8 sky130_fd_pr_reram__reram_cell area_ox=0.0676
XMn_11_8 dn_11_8 WL11 SL8 VSS sky130_fd_pr__nfet_g5v0d10v5 w=1 l=0.5
XRn_11_8 BLN8 dn_11_8 sky130_fd_pr_reram__reram_cell area_ox=0.0676
XMp_11_9 dp_11_9 WL11 SL9 VSS sky130_fd_pr__nfet_g5v0d10v5 w=1 l=0.5
XRp_11_9 BLP9 dp_11_9 sky130_fd_pr_reram__reram_cell area_ox=0.0676
XMn_11_9 dn_11_9 WL11 SL9 VSS sky130_fd_pr__nfet_g5v0d10v5 w=1 l=0.5
XRn_11_9 BLN9 dn_11_9 sky130_fd_pr_reram__reram_cell area_ox=0.0676
XMp_11_10 dp_11_10 WL11 SL10 VSS sky130_fd_pr__nfet_g5v0d10v5 w=1 l=0.5
XRp_11_10 BLP10 dp_11_10 sky130_fd_pr_reram__reram_cell area_ox=0.0676
XMn_11_10 dn_11_10 WL11 SL10 VSS sky130_fd_pr__nfet_g5v0d10v5 w=1 l=0.5
XRn_11_10 BLN10 dn_11_10 sky130_fd_pr_reram__reram_cell area_ox=0.0676
XMp_11_11 dp_11_11 WL11 SL11 VSS sky130_fd_pr__nfet_g5v0d10v5 w=1 l=0.5
XRp_11_11 BLP11 dp_11_11 sky130_fd_pr_reram__reram_cell area_ox=0.0676
XMn_11_11 dn_11_11 WL11 SL11 VSS sky130_fd_pr__nfet_g5v0d10v5 w=1 l=0.5
XRn_11_11 BLN11 dn_11_11 sky130_fd_pr_reram__reram_cell area_ox=0.0676
XMp_11_12 dp_11_12 WL11 SL12 VSS sky130_fd_pr__nfet_g5v0d10v5 w=1 l=0.5
XRp_11_12 BLP12 dp_11_12 sky130_fd_pr_reram__reram_cell area_ox=0.0676
XMn_11_12 dn_11_12 WL11 SL12 VSS sky130_fd_pr__nfet_g5v0d10v5 w=1 l=0.5
XRn_11_12 BLN12 dn_11_12 sky130_fd_pr_reram__reram_cell area_ox=0.0676
XMp_11_13 dp_11_13 WL11 SL13 VSS sky130_fd_pr__nfet_g5v0d10v5 w=1 l=0.5
XRp_11_13 BLP13 dp_11_13 sky130_fd_pr_reram__reram_cell area_ox=0.0676
XMn_11_13 dn_11_13 WL11 SL13 VSS sky130_fd_pr__nfet_g5v0d10v5 w=1 l=0.5
XRn_11_13 BLN13 dn_11_13 sky130_fd_pr_reram__reram_cell area_ox=0.0676
XMp_11_14 dp_11_14 WL11 SL14 VSS sky130_fd_pr__nfet_g5v0d10v5 w=1 l=0.5
XRp_11_14 BLP14 dp_11_14 sky130_fd_pr_reram__reram_cell area_ox=0.0676
XMn_11_14 dn_11_14 WL11 SL14 VSS sky130_fd_pr__nfet_g5v0d10v5 w=1 l=0.5
XRn_11_14 BLN14 dn_11_14 sky130_fd_pr_reram__reram_cell area_ox=0.0676
XMp_11_15 dp_11_15 WL11 SL15 VSS sky130_fd_pr__nfet_g5v0d10v5 w=1 l=0.5
XRp_11_15 BLP15 dp_11_15 sky130_fd_pr_reram__reram_cell area_ox=0.0676
XMn_11_15 dn_11_15 WL11 SL15 VSS sky130_fd_pr__nfet_g5v0d10v5 w=1 l=0.5
XRn_11_15 BLN15 dn_11_15 sky130_fd_pr_reram__reram_cell area_ox=0.0676
XMp_11_16 dp_11_16 WL11 SL16 VSS sky130_fd_pr__nfet_g5v0d10v5 w=1 l=0.5
XRp_11_16 BLP16 dp_11_16 sky130_fd_pr_reram__reram_cell area_ox=0.0676
XMn_11_16 dn_11_16 WL11 SL16 VSS sky130_fd_pr__nfet_g5v0d10v5 w=1 l=0.5
XRn_11_16 BLN16 dn_11_16 sky130_fd_pr_reram__reram_cell area_ox=0.0676
XMp_11_17 dp_11_17 WL11 SL17 VSS sky130_fd_pr__nfet_g5v0d10v5 w=1 l=0.5
XRp_11_17 BLP17 dp_11_17 sky130_fd_pr_reram__reram_cell area_ox=0.0676
XMn_11_17 dn_11_17 WL11 SL17 VSS sky130_fd_pr__nfet_g5v0d10v5 w=1 l=0.5
XRn_11_17 BLN17 dn_11_17 sky130_fd_pr_reram__reram_cell area_ox=0.0676
XMp_11_18 dp_11_18 WL11 SL18 VSS sky130_fd_pr__nfet_g5v0d10v5 w=1 l=0.5
XRp_11_18 BLP18 dp_11_18 sky130_fd_pr_reram__reram_cell area_ox=0.0676
XMn_11_18 dn_11_18 WL11 SL18 VSS sky130_fd_pr__nfet_g5v0d10v5 w=1 l=0.5
XRn_11_18 BLN18 dn_11_18 sky130_fd_pr_reram__reram_cell area_ox=0.0676
XMp_11_19 dp_11_19 WL11 SL19 VSS sky130_fd_pr__nfet_g5v0d10v5 w=1 l=0.5
XRp_11_19 BLP19 dp_11_19 sky130_fd_pr_reram__reram_cell area_ox=0.0676
XMn_11_19 dn_11_19 WL11 SL19 VSS sky130_fd_pr__nfet_g5v0d10v5 w=1 l=0.5
XRn_11_19 BLN19 dn_11_19 sky130_fd_pr_reram__reram_cell area_ox=0.0676
XMp_11_20 dp_11_20 WL11 SL20 VSS sky130_fd_pr__nfet_g5v0d10v5 w=1 l=0.5
XRp_11_20 BLP20 dp_11_20 sky130_fd_pr_reram__reram_cell area_ox=0.0676
XMn_11_20 dn_11_20 WL11 SL20 VSS sky130_fd_pr__nfet_g5v0d10v5 w=1 l=0.5
XRn_11_20 BLN20 dn_11_20 sky130_fd_pr_reram__reram_cell area_ox=0.0676
XMp_11_21 dp_11_21 WL11 SL21 VSS sky130_fd_pr__nfet_g5v0d10v5 w=1 l=0.5
XRp_11_21 BLP21 dp_11_21 sky130_fd_pr_reram__reram_cell area_ox=0.0676
XMn_11_21 dn_11_21 WL11 SL21 VSS sky130_fd_pr__nfet_g5v0d10v5 w=1 l=0.5
XRn_11_21 BLN21 dn_11_21 sky130_fd_pr_reram__reram_cell area_ox=0.0676
XMp_11_22 dp_11_22 WL11 SL22 VSS sky130_fd_pr__nfet_g5v0d10v5 w=1 l=0.5
XRp_11_22 BLP22 dp_11_22 sky130_fd_pr_reram__reram_cell area_ox=0.0676
XMn_11_22 dn_11_22 WL11 SL22 VSS sky130_fd_pr__nfet_g5v0d10v5 w=1 l=0.5
XRn_11_22 BLN22 dn_11_22 sky130_fd_pr_reram__reram_cell area_ox=0.0676
XMp_11_23 dp_11_23 WL11 SL23 VSS sky130_fd_pr__nfet_g5v0d10v5 w=1 l=0.5
XRp_11_23 BLP23 dp_11_23 sky130_fd_pr_reram__reram_cell area_ox=0.0676
XMn_11_23 dn_11_23 WL11 SL23 VSS sky130_fd_pr__nfet_g5v0d10v5 w=1 l=0.5
XRn_11_23 BLN23 dn_11_23 sky130_fd_pr_reram__reram_cell area_ox=0.0676
XMp_12_0 dp_12_0 WL12 SL0 VSS sky130_fd_pr__nfet_g5v0d10v5 w=1 l=0.5
XRp_12_0 BLP0 dp_12_0 sky130_fd_pr_reram__reram_cell area_ox=0.0676
XMn_12_0 dn_12_0 WL12 SL0 VSS sky130_fd_pr__nfet_g5v0d10v5 w=1 l=0.5
XRn_12_0 BLN0 dn_12_0 sky130_fd_pr_reram__reram_cell area_ox=0.0676
XMp_12_1 dp_12_1 WL12 SL1 VSS sky130_fd_pr__nfet_g5v0d10v5 w=1 l=0.5
XRp_12_1 BLP1 dp_12_1 sky130_fd_pr_reram__reram_cell area_ox=0.0676
XMn_12_1 dn_12_1 WL12 SL1 VSS sky130_fd_pr__nfet_g5v0d10v5 w=1 l=0.5
XRn_12_1 BLN1 dn_12_1 sky130_fd_pr_reram__reram_cell area_ox=0.0676
XMp_12_2 dp_12_2 WL12 SL2 VSS sky130_fd_pr__nfet_g5v0d10v5 w=1 l=0.5
XRp_12_2 BLP2 dp_12_2 sky130_fd_pr_reram__reram_cell area_ox=0.0676
XMn_12_2 dn_12_2 WL12 SL2 VSS sky130_fd_pr__nfet_g5v0d10v5 w=1 l=0.5
XRn_12_2 BLN2 dn_12_2 sky130_fd_pr_reram__reram_cell area_ox=0.0676
XMp_12_3 dp_12_3 WL12 SL3 VSS sky130_fd_pr__nfet_g5v0d10v5 w=1 l=0.5
XRp_12_3 BLP3 dp_12_3 sky130_fd_pr_reram__reram_cell area_ox=0.0676
XMn_12_3 dn_12_3 WL12 SL3 VSS sky130_fd_pr__nfet_g5v0d10v5 w=1 l=0.5
XRn_12_3 BLN3 dn_12_3 sky130_fd_pr_reram__reram_cell area_ox=0.0676
XMp_12_4 dp_12_4 WL12 SL4 VSS sky130_fd_pr__nfet_g5v0d10v5 w=1 l=0.5
XRp_12_4 BLP4 dp_12_4 sky130_fd_pr_reram__reram_cell area_ox=0.0676
XMn_12_4 dn_12_4 WL12 SL4 VSS sky130_fd_pr__nfet_g5v0d10v5 w=1 l=0.5
XRn_12_4 BLN4 dn_12_4 sky130_fd_pr_reram__reram_cell area_ox=0.0676
XMp_12_5 dp_12_5 WL12 SL5 VSS sky130_fd_pr__nfet_g5v0d10v5 w=1 l=0.5
XRp_12_5 BLP5 dp_12_5 sky130_fd_pr_reram__reram_cell area_ox=0.0676
XMn_12_5 dn_12_5 WL12 SL5 VSS sky130_fd_pr__nfet_g5v0d10v5 w=1 l=0.5
XRn_12_5 BLN5 dn_12_5 sky130_fd_pr_reram__reram_cell area_ox=0.0676
XMp_12_6 dp_12_6 WL12 SL6 VSS sky130_fd_pr__nfet_g5v0d10v5 w=1 l=0.5
XRp_12_6 BLP6 dp_12_6 sky130_fd_pr_reram__reram_cell area_ox=0.0676
XMn_12_6 dn_12_6 WL12 SL6 VSS sky130_fd_pr__nfet_g5v0d10v5 w=1 l=0.5
XRn_12_6 BLN6 dn_12_6 sky130_fd_pr_reram__reram_cell area_ox=0.0676
XMp_12_7 dp_12_7 WL12 SL7 VSS sky130_fd_pr__nfet_g5v0d10v5 w=1 l=0.5
XRp_12_7 BLP7 dp_12_7 sky130_fd_pr_reram__reram_cell area_ox=0.0676
XMn_12_7 dn_12_7 WL12 SL7 VSS sky130_fd_pr__nfet_g5v0d10v5 w=1 l=0.5
XRn_12_7 BLN7 dn_12_7 sky130_fd_pr_reram__reram_cell area_ox=0.0676
XMp_12_8 dp_12_8 WL12 SL8 VSS sky130_fd_pr__nfet_g5v0d10v5 w=1 l=0.5
XRp_12_8 BLP8 dp_12_8 sky130_fd_pr_reram__reram_cell area_ox=0.0676
XMn_12_8 dn_12_8 WL12 SL8 VSS sky130_fd_pr__nfet_g5v0d10v5 w=1 l=0.5
XRn_12_8 BLN8 dn_12_8 sky130_fd_pr_reram__reram_cell area_ox=0.0676
XMp_12_9 dp_12_9 WL12 SL9 VSS sky130_fd_pr__nfet_g5v0d10v5 w=1 l=0.5
XRp_12_9 BLP9 dp_12_9 sky130_fd_pr_reram__reram_cell area_ox=0.0676
XMn_12_9 dn_12_9 WL12 SL9 VSS sky130_fd_pr__nfet_g5v0d10v5 w=1 l=0.5
XRn_12_9 BLN9 dn_12_9 sky130_fd_pr_reram__reram_cell area_ox=0.0676
XMp_12_10 dp_12_10 WL12 SL10 VSS sky130_fd_pr__nfet_g5v0d10v5 w=1 l=0.5
XRp_12_10 BLP10 dp_12_10 sky130_fd_pr_reram__reram_cell area_ox=0.0676
XMn_12_10 dn_12_10 WL12 SL10 VSS sky130_fd_pr__nfet_g5v0d10v5 w=1 l=0.5
XRn_12_10 BLN10 dn_12_10 sky130_fd_pr_reram__reram_cell area_ox=0.0676
XMp_12_11 dp_12_11 WL12 SL11 VSS sky130_fd_pr__nfet_g5v0d10v5 w=1 l=0.5
XRp_12_11 BLP11 dp_12_11 sky130_fd_pr_reram__reram_cell area_ox=0.0676
XMn_12_11 dn_12_11 WL12 SL11 VSS sky130_fd_pr__nfet_g5v0d10v5 w=1 l=0.5
XRn_12_11 BLN11 dn_12_11 sky130_fd_pr_reram__reram_cell area_ox=0.0676
XMp_12_12 dp_12_12 WL12 SL12 VSS sky130_fd_pr__nfet_g5v0d10v5 w=1 l=0.5
XRp_12_12 BLP12 dp_12_12 sky130_fd_pr_reram__reram_cell area_ox=0.0676
XMn_12_12 dn_12_12 WL12 SL12 VSS sky130_fd_pr__nfet_g5v0d10v5 w=1 l=0.5
XRn_12_12 BLN12 dn_12_12 sky130_fd_pr_reram__reram_cell area_ox=0.0676
XMp_12_13 dp_12_13 WL12 SL13 VSS sky130_fd_pr__nfet_g5v0d10v5 w=1 l=0.5
XRp_12_13 BLP13 dp_12_13 sky130_fd_pr_reram__reram_cell area_ox=0.0676
XMn_12_13 dn_12_13 WL12 SL13 VSS sky130_fd_pr__nfet_g5v0d10v5 w=1 l=0.5
XRn_12_13 BLN13 dn_12_13 sky130_fd_pr_reram__reram_cell area_ox=0.0676
XMp_12_14 dp_12_14 WL12 SL14 VSS sky130_fd_pr__nfet_g5v0d10v5 w=1 l=0.5
XRp_12_14 BLP14 dp_12_14 sky130_fd_pr_reram__reram_cell area_ox=0.0676
XMn_12_14 dn_12_14 WL12 SL14 VSS sky130_fd_pr__nfet_g5v0d10v5 w=1 l=0.5
XRn_12_14 BLN14 dn_12_14 sky130_fd_pr_reram__reram_cell area_ox=0.0676
XMp_12_15 dp_12_15 WL12 SL15 VSS sky130_fd_pr__nfet_g5v0d10v5 w=1 l=0.5
XRp_12_15 BLP15 dp_12_15 sky130_fd_pr_reram__reram_cell area_ox=0.0676
XMn_12_15 dn_12_15 WL12 SL15 VSS sky130_fd_pr__nfet_g5v0d10v5 w=1 l=0.5
XRn_12_15 BLN15 dn_12_15 sky130_fd_pr_reram__reram_cell area_ox=0.0676
XMp_12_16 dp_12_16 WL12 SL16 VSS sky130_fd_pr__nfet_g5v0d10v5 w=1 l=0.5
XRp_12_16 BLP16 dp_12_16 sky130_fd_pr_reram__reram_cell area_ox=0.0676
XMn_12_16 dn_12_16 WL12 SL16 VSS sky130_fd_pr__nfet_g5v0d10v5 w=1 l=0.5
XRn_12_16 BLN16 dn_12_16 sky130_fd_pr_reram__reram_cell area_ox=0.0676
XMp_12_17 dp_12_17 WL12 SL17 VSS sky130_fd_pr__nfet_g5v0d10v5 w=1 l=0.5
XRp_12_17 BLP17 dp_12_17 sky130_fd_pr_reram__reram_cell area_ox=0.0676
XMn_12_17 dn_12_17 WL12 SL17 VSS sky130_fd_pr__nfet_g5v0d10v5 w=1 l=0.5
XRn_12_17 BLN17 dn_12_17 sky130_fd_pr_reram__reram_cell area_ox=0.0676
XMp_12_18 dp_12_18 WL12 SL18 VSS sky130_fd_pr__nfet_g5v0d10v5 w=1 l=0.5
XRp_12_18 BLP18 dp_12_18 sky130_fd_pr_reram__reram_cell area_ox=0.0676
XMn_12_18 dn_12_18 WL12 SL18 VSS sky130_fd_pr__nfet_g5v0d10v5 w=1 l=0.5
XRn_12_18 BLN18 dn_12_18 sky130_fd_pr_reram__reram_cell area_ox=0.0676
XMp_12_19 dp_12_19 WL12 SL19 VSS sky130_fd_pr__nfet_g5v0d10v5 w=1 l=0.5
XRp_12_19 BLP19 dp_12_19 sky130_fd_pr_reram__reram_cell area_ox=0.0676
XMn_12_19 dn_12_19 WL12 SL19 VSS sky130_fd_pr__nfet_g5v0d10v5 w=1 l=0.5
XRn_12_19 BLN19 dn_12_19 sky130_fd_pr_reram__reram_cell area_ox=0.0676
XMp_12_20 dp_12_20 WL12 SL20 VSS sky130_fd_pr__nfet_g5v0d10v5 w=1 l=0.5
XRp_12_20 BLP20 dp_12_20 sky130_fd_pr_reram__reram_cell area_ox=0.0676
XMn_12_20 dn_12_20 WL12 SL20 VSS sky130_fd_pr__nfet_g5v0d10v5 w=1 l=0.5
XRn_12_20 BLN20 dn_12_20 sky130_fd_pr_reram__reram_cell area_ox=0.0676
XMp_12_21 dp_12_21 WL12 SL21 VSS sky130_fd_pr__nfet_g5v0d10v5 w=1 l=0.5
XRp_12_21 BLP21 dp_12_21 sky130_fd_pr_reram__reram_cell area_ox=0.0676
XMn_12_21 dn_12_21 WL12 SL21 VSS sky130_fd_pr__nfet_g5v0d10v5 w=1 l=0.5
XRn_12_21 BLN21 dn_12_21 sky130_fd_pr_reram__reram_cell area_ox=0.0676
XMp_12_22 dp_12_22 WL12 SL22 VSS sky130_fd_pr__nfet_g5v0d10v5 w=1 l=0.5
XRp_12_22 BLP22 dp_12_22 sky130_fd_pr_reram__reram_cell area_ox=0.0676
XMn_12_22 dn_12_22 WL12 SL22 VSS sky130_fd_pr__nfet_g5v0d10v5 w=1 l=0.5
XRn_12_22 BLN22 dn_12_22 sky130_fd_pr_reram__reram_cell area_ox=0.0676
XMp_12_23 dp_12_23 WL12 SL23 VSS sky130_fd_pr__nfet_g5v0d10v5 w=1 l=0.5
XRp_12_23 BLP23 dp_12_23 sky130_fd_pr_reram__reram_cell area_ox=0.0676
XMn_12_23 dn_12_23 WL12 SL23 VSS sky130_fd_pr__nfet_g5v0d10v5 w=1 l=0.5
XRn_12_23 BLN23 dn_12_23 sky130_fd_pr_reram__reram_cell area_ox=0.0676
XMp_13_0 dp_13_0 WL13 SL0 VSS sky130_fd_pr__nfet_g5v0d10v5 w=1 l=0.5
XRp_13_0 BLP0 dp_13_0 sky130_fd_pr_reram__reram_cell area_ox=0.0676
XMn_13_0 dn_13_0 WL13 SL0 VSS sky130_fd_pr__nfet_g5v0d10v5 w=1 l=0.5
XRn_13_0 BLN0 dn_13_0 sky130_fd_pr_reram__reram_cell area_ox=0.0676
XMp_13_1 dp_13_1 WL13 SL1 VSS sky130_fd_pr__nfet_g5v0d10v5 w=1 l=0.5
XRp_13_1 BLP1 dp_13_1 sky130_fd_pr_reram__reram_cell area_ox=0.0676
XMn_13_1 dn_13_1 WL13 SL1 VSS sky130_fd_pr__nfet_g5v0d10v5 w=1 l=0.5
XRn_13_1 BLN1 dn_13_1 sky130_fd_pr_reram__reram_cell area_ox=0.0676
XMp_13_2 dp_13_2 WL13 SL2 VSS sky130_fd_pr__nfet_g5v0d10v5 w=1 l=0.5
XRp_13_2 BLP2 dp_13_2 sky130_fd_pr_reram__reram_cell area_ox=0.0676
XMn_13_2 dn_13_2 WL13 SL2 VSS sky130_fd_pr__nfet_g5v0d10v5 w=1 l=0.5
XRn_13_2 BLN2 dn_13_2 sky130_fd_pr_reram__reram_cell area_ox=0.0676
XMp_13_3 dp_13_3 WL13 SL3 VSS sky130_fd_pr__nfet_g5v0d10v5 w=1 l=0.5
XRp_13_3 BLP3 dp_13_3 sky130_fd_pr_reram__reram_cell area_ox=0.0676
XMn_13_3 dn_13_3 WL13 SL3 VSS sky130_fd_pr__nfet_g5v0d10v5 w=1 l=0.5
XRn_13_3 BLN3 dn_13_3 sky130_fd_pr_reram__reram_cell area_ox=0.0676
XMp_13_4 dp_13_4 WL13 SL4 VSS sky130_fd_pr__nfet_g5v0d10v5 w=1 l=0.5
XRp_13_4 BLP4 dp_13_4 sky130_fd_pr_reram__reram_cell area_ox=0.0676
XMn_13_4 dn_13_4 WL13 SL4 VSS sky130_fd_pr__nfet_g5v0d10v5 w=1 l=0.5
XRn_13_4 BLN4 dn_13_4 sky130_fd_pr_reram__reram_cell area_ox=0.0676
XMp_13_5 dp_13_5 WL13 SL5 VSS sky130_fd_pr__nfet_g5v0d10v5 w=1 l=0.5
XRp_13_5 BLP5 dp_13_5 sky130_fd_pr_reram__reram_cell area_ox=0.0676
XMn_13_5 dn_13_5 WL13 SL5 VSS sky130_fd_pr__nfet_g5v0d10v5 w=1 l=0.5
XRn_13_5 BLN5 dn_13_5 sky130_fd_pr_reram__reram_cell area_ox=0.0676
XMp_13_6 dp_13_6 WL13 SL6 VSS sky130_fd_pr__nfet_g5v0d10v5 w=1 l=0.5
XRp_13_6 BLP6 dp_13_6 sky130_fd_pr_reram__reram_cell area_ox=0.0676
XMn_13_6 dn_13_6 WL13 SL6 VSS sky130_fd_pr__nfet_g5v0d10v5 w=1 l=0.5
XRn_13_6 BLN6 dn_13_6 sky130_fd_pr_reram__reram_cell area_ox=0.0676
XMp_13_7 dp_13_7 WL13 SL7 VSS sky130_fd_pr__nfet_g5v0d10v5 w=1 l=0.5
XRp_13_7 BLP7 dp_13_7 sky130_fd_pr_reram__reram_cell area_ox=0.0676
XMn_13_7 dn_13_7 WL13 SL7 VSS sky130_fd_pr__nfet_g5v0d10v5 w=1 l=0.5
XRn_13_7 BLN7 dn_13_7 sky130_fd_pr_reram__reram_cell area_ox=0.0676
XMp_13_8 dp_13_8 WL13 SL8 VSS sky130_fd_pr__nfet_g5v0d10v5 w=1 l=0.5
XRp_13_8 BLP8 dp_13_8 sky130_fd_pr_reram__reram_cell area_ox=0.0676
XMn_13_8 dn_13_8 WL13 SL8 VSS sky130_fd_pr__nfet_g5v0d10v5 w=1 l=0.5
XRn_13_8 BLN8 dn_13_8 sky130_fd_pr_reram__reram_cell area_ox=0.0676
XMp_13_9 dp_13_9 WL13 SL9 VSS sky130_fd_pr__nfet_g5v0d10v5 w=1 l=0.5
XRp_13_9 BLP9 dp_13_9 sky130_fd_pr_reram__reram_cell area_ox=0.0676
XMn_13_9 dn_13_9 WL13 SL9 VSS sky130_fd_pr__nfet_g5v0d10v5 w=1 l=0.5
XRn_13_9 BLN9 dn_13_9 sky130_fd_pr_reram__reram_cell area_ox=0.0676
XMp_13_10 dp_13_10 WL13 SL10 VSS sky130_fd_pr__nfet_g5v0d10v5 w=1 l=0.5
XRp_13_10 BLP10 dp_13_10 sky130_fd_pr_reram__reram_cell area_ox=0.0676
XMn_13_10 dn_13_10 WL13 SL10 VSS sky130_fd_pr__nfet_g5v0d10v5 w=1 l=0.5
XRn_13_10 BLN10 dn_13_10 sky130_fd_pr_reram__reram_cell area_ox=0.0676
XMp_13_11 dp_13_11 WL13 SL11 VSS sky130_fd_pr__nfet_g5v0d10v5 w=1 l=0.5
XRp_13_11 BLP11 dp_13_11 sky130_fd_pr_reram__reram_cell area_ox=0.0676
XMn_13_11 dn_13_11 WL13 SL11 VSS sky130_fd_pr__nfet_g5v0d10v5 w=1 l=0.5
XRn_13_11 BLN11 dn_13_11 sky130_fd_pr_reram__reram_cell area_ox=0.0676
XMp_13_12 dp_13_12 WL13 SL12 VSS sky130_fd_pr__nfet_g5v0d10v5 w=1 l=0.5
XRp_13_12 BLP12 dp_13_12 sky130_fd_pr_reram__reram_cell area_ox=0.0676
XMn_13_12 dn_13_12 WL13 SL12 VSS sky130_fd_pr__nfet_g5v0d10v5 w=1 l=0.5
XRn_13_12 BLN12 dn_13_12 sky130_fd_pr_reram__reram_cell area_ox=0.0676
XMp_13_13 dp_13_13 WL13 SL13 VSS sky130_fd_pr__nfet_g5v0d10v5 w=1 l=0.5
XRp_13_13 BLP13 dp_13_13 sky130_fd_pr_reram__reram_cell area_ox=0.0676
XMn_13_13 dn_13_13 WL13 SL13 VSS sky130_fd_pr__nfet_g5v0d10v5 w=1 l=0.5
XRn_13_13 BLN13 dn_13_13 sky130_fd_pr_reram__reram_cell area_ox=0.0676
XMp_13_14 dp_13_14 WL13 SL14 VSS sky130_fd_pr__nfet_g5v0d10v5 w=1 l=0.5
XRp_13_14 BLP14 dp_13_14 sky130_fd_pr_reram__reram_cell area_ox=0.0676
XMn_13_14 dn_13_14 WL13 SL14 VSS sky130_fd_pr__nfet_g5v0d10v5 w=1 l=0.5
XRn_13_14 BLN14 dn_13_14 sky130_fd_pr_reram__reram_cell area_ox=0.0676
XMp_13_15 dp_13_15 WL13 SL15 VSS sky130_fd_pr__nfet_g5v0d10v5 w=1 l=0.5
XRp_13_15 BLP15 dp_13_15 sky130_fd_pr_reram__reram_cell area_ox=0.0676
XMn_13_15 dn_13_15 WL13 SL15 VSS sky130_fd_pr__nfet_g5v0d10v5 w=1 l=0.5
XRn_13_15 BLN15 dn_13_15 sky130_fd_pr_reram__reram_cell area_ox=0.0676
XMp_13_16 dp_13_16 WL13 SL16 VSS sky130_fd_pr__nfet_g5v0d10v5 w=1 l=0.5
XRp_13_16 BLP16 dp_13_16 sky130_fd_pr_reram__reram_cell area_ox=0.0676
XMn_13_16 dn_13_16 WL13 SL16 VSS sky130_fd_pr__nfet_g5v0d10v5 w=1 l=0.5
XRn_13_16 BLN16 dn_13_16 sky130_fd_pr_reram__reram_cell area_ox=0.0676
XMp_13_17 dp_13_17 WL13 SL17 VSS sky130_fd_pr__nfet_g5v0d10v5 w=1 l=0.5
XRp_13_17 BLP17 dp_13_17 sky130_fd_pr_reram__reram_cell area_ox=0.0676
XMn_13_17 dn_13_17 WL13 SL17 VSS sky130_fd_pr__nfet_g5v0d10v5 w=1 l=0.5
XRn_13_17 BLN17 dn_13_17 sky130_fd_pr_reram__reram_cell area_ox=0.0676
XMp_13_18 dp_13_18 WL13 SL18 VSS sky130_fd_pr__nfet_g5v0d10v5 w=1 l=0.5
XRp_13_18 BLP18 dp_13_18 sky130_fd_pr_reram__reram_cell area_ox=0.0676
XMn_13_18 dn_13_18 WL13 SL18 VSS sky130_fd_pr__nfet_g5v0d10v5 w=1 l=0.5
XRn_13_18 BLN18 dn_13_18 sky130_fd_pr_reram__reram_cell area_ox=0.0676
XMp_13_19 dp_13_19 WL13 SL19 VSS sky130_fd_pr__nfet_g5v0d10v5 w=1 l=0.5
XRp_13_19 BLP19 dp_13_19 sky130_fd_pr_reram__reram_cell area_ox=0.0676
XMn_13_19 dn_13_19 WL13 SL19 VSS sky130_fd_pr__nfet_g5v0d10v5 w=1 l=0.5
XRn_13_19 BLN19 dn_13_19 sky130_fd_pr_reram__reram_cell area_ox=0.0676
XMp_13_20 dp_13_20 WL13 SL20 VSS sky130_fd_pr__nfet_g5v0d10v5 w=1 l=0.5
XRp_13_20 BLP20 dp_13_20 sky130_fd_pr_reram__reram_cell area_ox=0.0676
XMn_13_20 dn_13_20 WL13 SL20 VSS sky130_fd_pr__nfet_g5v0d10v5 w=1 l=0.5
XRn_13_20 BLN20 dn_13_20 sky130_fd_pr_reram__reram_cell area_ox=0.0676
XMp_13_21 dp_13_21 WL13 SL21 VSS sky130_fd_pr__nfet_g5v0d10v5 w=1 l=0.5
XRp_13_21 BLP21 dp_13_21 sky130_fd_pr_reram__reram_cell area_ox=0.0676
XMn_13_21 dn_13_21 WL13 SL21 VSS sky130_fd_pr__nfet_g5v0d10v5 w=1 l=0.5
XRn_13_21 BLN21 dn_13_21 sky130_fd_pr_reram__reram_cell area_ox=0.0676
XMp_13_22 dp_13_22 WL13 SL22 VSS sky130_fd_pr__nfet_g5v0d10v5 w=1 l=0.5
XRp_13_22 BLP22 dp_13_22 sky130_fd_pr_reram__reram_cell area_ox=0.0676
XMn_13_22 dn_13_22 WL13 SL22 VSS sky130_fd_pr__nfet_g5v0d10v5 w=1 l=0.5
XRn_13_22 BLN22 dn_13_22 sky130_fd_pr_reram__reram_cell area_ox=0.0676
XMp_13_23 dp_13_23 WL13 SL23 VSS sky130_fd_pr__nfet_g5v0d10v5 w=1 l=0.5
XRp_13_23 BLP23 dp_13_23 sky130_fd_pr_reram__reram_cell area_ox=0.0676
XMn_13_23 dn_13_23 WL13 SL23 VSS sky130_fd_pr__nfet_g5v0d10v5 w=1 l=0.5
XRn_13_23 BLN23 dn_13_23 sky130_fd_pr_reram__reram_cell area_ox=0.0676
XMp_14_0 dp_14_0 WL14 SL0 VSS sky130_fd_pr__nfet_g5v0d10v5 w=1 l=0.5
XRp_14_0 BLP0 dp_14_0 sky130_fd_pr_reram__reram_cell area_ox=0.0676
XMn_14_0 dn_14_0 WL14 SL0 VSS sky130_fd_pr__nfet_g5v0d10v5 w=1 l=0.5
XRn_14_0 BLN0 dn_14_0 sky130_fd_pr_reram__reram_cell area_ox=0.0676
XMp_14_1 dp_14_1 WL14 SL1 VSS sky130_fd_pr__nfet_g5v0d10v5 w=1 l=0.5
XRp_14_1 BLP1 dp_14_1 sky130_fd_pr_reram__reram_cell area_ox=0.0676
XMn_14_1 dn_14_1 WL14 SL1 VSS sky130_fd_pr__nfet_g5v0d10v5 w=1 l=0.5
XRn_14_1 BLN1 dn_14_1 sky130_fd_pr_reram__reram_cell area_ox=0.0676
XMp_14_2 dp_14_2 WL14 SL2 VSS sky130_fd_pr__nfet_g5v0d10v5 w=1 l=0.5
XRp_14_2 BLP2 dp_14_2 sky130_fd_pr_reram__reram_cell area_ox=0.0676
XMn_14_2 dn_14_2 WL14 SL2 VSS sky130_fd_pr__nfet_g5v0d10v5 w=1 l=0.5
XRn_14_2 BLN2 dn_14_2 sky130_fd_pr_reram__reram_cell area_ox=0.0676
XMp_14_3 dp_14_3 WL14 SL3 VSS sky130_fd_pr__nfet_g5v0d10v5 w=1 l=0.5
XRp_14_3 BLP3 dp_14_3 sky130_fd_pr_reram__reram_cell area_ox=0.0676
XMn_14_3 dn_14_3 WL14 SL3 VSS sky130_fd_pr__nfet_g5v0d10v5 w=1 l=0.5
XRn_14_3 BLN3 dn_14_3 sky130_fd_pr_reram__reram_cell area_ox=0.0676
XMp_14_4 dp_14_4 WL14 SL4 VSS sky130_fd_pr__nfet_g5v0d10v5 w=1 l=0.5
XRp_14_4 BLP4 dp_14_4 sky130_fd_pr_reram__reram_cell area_ox=0.0676
XMn_14_4 dn_14_4 WL14 SL4 VSS sky130_fd_pr__nfet_g5v0d10v5 w=1 l=0.5
XRn_14_4 BLN4 dn_14_4 sky130_fd_pr_reram__reram_cell area_ox=0.0676
XMp_14_5 dp_14_5 WL14 SL5 VSS sky130_fd_pr__nfet_g5v0d10v5 w=1 l=0.5
XRp_14_5 BLP5 dp_14_5 sky130_fd_pr_reram__reram_cell area_ox=0.0676
XMn_14_5 dn_14_5 WL14 SL5 VSS sky130_fd_pr__nfet_g5v0d10v5 w=1 l=0.5
XRn_14_5 BLN5 dn_14_5 sky130_fd_pr_reram__reram_cell area_ox=0.0676
XMp_14_6 dp_14_6 WL14 SL6 VSS sky130_fd_pr__nfet_g5v0d10v5 w=1 l=0.5
XRp_14_6 BLP6 dp_14_6 sky130_fd_pr_reram__reram_cell area_ox=0.0676
XMn_14_6 dn_14_6 WL14 SL6 VSS sky130_fd_pr__nfet_g5v0d10v5 w=1 l=0.5
XRn_14_6 BLN6 dn_14_6 sky130_fd_pr_reram__reram_cell area_ox=0.0676
XMp_14_7 dp_14_7 WL14 SL7 VSS sky130_fd_pr__nfet_g5v0d10v5 w=1 l=0.5
XRp_14_7 BLP7 dp_14_7 sky130_fd_pr_reram__reram_cell area_ox=0.0676
XMn_14_7 dn_14_7 WL14 SL7 VSS sky130_fd_pr__nfet_g5v0d10v5 w=1 l=0.5
XRn_14_7 BLN7 dn_14_7 sky130_fd_pr_reram__reram_cell area_ox=0.0676
XMp_14_8 dp_14_8 WL14 SL8 VSS sky130_fd_pr__nfet_g5v0d10v5 w=1 l=0.5
XRp_14_8 BLP8 dp_14_8 sky130_fd_pr_reram__reram_cell area_ox=0.0676
XMn_14_8 dn_14_8 WL14 SL8 VSS sky130_fd_pr__nfet_g5v0d10v5 w=1 l=0.5
XRn_14_8 BLN8 dn_14_8 sky130_fd_pr_reram__reram_cell area_ox=0.0676
XMp_14_9 dp_14_9 WL14 SL9 VSS sky130_fd_pr__nfet_g5v0d10v5 w=1 l=0.5
XRp_14_9 BLP9 dp_14_9 sky130_fd_pr_reram__reram_cell area_ox=0.0676
XMn_14_9 dn_14_9 WL14 SL9 VSS sky130_fd_pr__nfet_g5v0d10v5 w=1 l=0.5
XRn_14_9 BLN9 dn_14_9 sky130_fd_pr_reram__reram_cell area_ox=0.0676
XMp_14_10 dp_14_10 WL14 SL10 VSS sky130_fd_pr__nfet_g5v0d10v5 w=1 l=0.5
XRp_14_10 BLP10 dp_14_10 sky130_fd_pr_reram__reram_cell area_ox=0.0676
XMn_14_10 dn_14_10 WL14 SL10 VSS sky130_fd_pr__nfet_g5v0d10v5 w=1 l=0.5
XRn_14_10 BLN10 dn_14_10 sky130_fd_pr_reram__reram_cell area_ox=0.0676
XMp_14_11 dp_14_11 WL14 SL11 VSS sky130_fd_pr__nfet_g5v0d10v5 w=1 l=0.5
XRp_14_11 BLP11 dp_14_11 sky130_fd_pr_reram__reram_cell area_ox=0.0676
XMn_14_11 dn_14_11 WL14 SL11 VSS sky130_fd_pr__nfet_g5v0d10v5 w=1 l=0.5
XRn_14_11 BLN11 dn_14_11 sky130_fd_pr_reram__reram_cell area_ox=0.0676
XMp_14_12 dp_14_12 WL14 SL12 VSS sky130_fd_pr__nfet_g5v0d10v5 w=1 l=0.5
XRp_14_12 BLP12 dp_14_12 sky130_fd_pr_reram__reram_cell area_ox=0.0676
XMn_14_12 dn_14_12 WL14 SL12 VSS sky130_fd_pr__nfet_g5v0d10v5 w=1 l=0.5
XRn_14_12 BLN12 dn_14_12 sky130_fd_pr_reram__reram_cell area_ox=0.0676
XMp_14_13 dp_14_13 WL14 SL13 VSS sky130_fd_pr__nfet_g5v0d10v5 w=1 l=0.5
XRp_14_13 BLP13 dp_14_13 sky130_fd_pr_reram__reram_cell area_ox=0.0676
XMn_14_13 dn_14_13 WL14 SL13 VSS sky130_fd_pr__nfet_g5v0d10v5 w=1 l=0.5
XRn_14_13 BLN13 dn_14_13 sky130_fd_pr_reram__reram_cell area_ox=0.0676
XMp_14_14 dp_14_14 WL14 SL14 VSS sky130_fd_pr__nfet_g5v0d10v5 w=1 l=0.5
XRp_14_14 BLP14 dp_14_14 sky130_fd_pr_reram__reram_cell area_ox=0.0676
XMn_14_14 dn_14_14 WL14 SL14 VSS sky130_fd_pr__nfet_g5v0d10v5 w=1 l=0.5
XRn_14_14 BLN14 dn_14_14 sky130_fd_pr_reram__reram_cell area_ox=0.0676
XMp_14_15 dp_14_15 WL14 SL15 VSS sky130_fd_pr__nfet_g5v0d10v5 w=1 l=0.5
XRp_14_15 BLP15 dp_14_15 sky130_fd_pr_reram__reram_cell area_ox=0.0676
XMn_14_15 dn_14_15 WL14 SL15 VSS sky130_fd_pr__nfet_g5v0d10v5 w=1 l=0.5
XRn_14_15 BLN15 dn_14_15 sky130_fd_pr_reram__reram_cell area_ox=0.0676
XMp_14_16 dp_14_16 WL14 SL16 VSS sky130_fd_pr__nfet_g5v0d10v5 w=1 l=0.5
XRp_14_16 BLP16 dp_14_16 sky130_fd_pr_reram__reram_cell area_ox=0.0676
XMn_14_16 dn_14_16 WL14 SL16 VSS sky130_fd_pr__nfet_g5v0d10v5 w=1 l=0.5
XRn_14_16 BLN16 dn_14_16 sky130_fd_pr_reram__reram_cell area_ox=0.0676
XMp_14_17 dp_14_17 WL14 SL17 VSS sky130_fd_pr__nfet_g5v0d10v5 w=1 l=0.5
XRp_14_17 BLP17 dp_14_17 sky130_fd_pr_reram__reram_cell area_ox=0.0676
XMn_14_17 dn_14_17 WL14 SL17 VSS sky130_fd_pr__nfet_g5v0d10v5 w=1 l=0.5
XRn_14_17 BLN17 dn_14_17 sky130_fd_pr_reram__reram_cell area_ox=0.0676
XMp_14_18 dp_14_18 WL14 SL18 VSS sky130_fd_pr__nfet_g5v0d10v5 w=1 l=0.5
XRp_14_18 BLP18 dp_14_18 sky130_fd_pr_reram__reram_cell area_ox=0.0676
XMn_14_18 dn_14_18 WL14 SL18 VSS sky130_fd_pr__nfet_g5v0d10v5 w=1 l=0.5
XRn_14_18 BLN18 dn_14_18 sky130_fd_pr_reram__reram_cell area_ox=0.0676
XMp_14_19 dp_14_19 WL14 SL19 VSS sky130_fd_pr__nfet_g5v0d10v5 w=1 l=0.5
XRp_14_19 BLP19 dp_14_19 sky130_fd_pr_reram__reram_cell area_ox=0.0676
XMn_14_19 dn_14_19 WL14 SL19 VSS sky130_fd_pr__nfet_g5v0d10v5 w=1 l=0.5
XRn_14_19 BLN19 dn_14_19 sky130_fd_pr_reram__reram_cell area_ox=0.0676
XMp_14_20 dp_14_20 WL14 SL20 VSS sky130_fd_pr__nfet_g5v0d10v5 w=1 l=0.5
XRp_14_20 BLP20 dp_14_20 sky130_fd_pr_reram__reram_cell area_ox=0.0676
XMn_14_20 dn_14_20 WL14 SL20 VSS sky130_fd_pr__nfet_g5v0d10v5 w=1 l=0.5
XRn_14_20 BLN20 dn_14_20 sky130_fd_pr_reram__reram_cell area_ox=0.0676
XMp_14_21 dp_14_21 WL14 SL21 VSS sky130_fd_pr__nfet_g5v0d10v5 w=1 l=0.5
XRp_14_21 BLP21 dp_14_21 sky130_fd_pr_reram__reram_cell area_ox=0.0676
XMn_14_21 dn_14_21 WL14 SL21 VSS sky130_fd_pr__nfet_g5v0d10v5 w=1 l=0.5
XRn_14_21 BLN21 dn_14_21 sky130_fd_pr_reram__reram_cell area_ox=0.0676
XMp_14_22 dp_14_22 WL14 SL22 VSS sky130_fd_pr__nfet_g5v0d10v5 w=1 l=0.5
XRp_14_22 BLP22 dp_14_22 sky130_fd_pr_reram__reram_cell area_ox=0.0676
XMn_14_22 dn_14_22 WL14 SL22 VSS sky130_fd_pr__nfet_g5v0d10v5 w=1 l=0.5
XRn_14_22 BLN22 dn_14_22 sky130_fd_pr_reram__reram_cell area_ox=0.0676
XMp_14_23 dp_14_23 WL14 SL23 VSS sky130_fd_pr__nfet_g5v0d10v5 w=1 l=0.5
XRp_14_23 BLP23 dp_14_23 sky130_fd_pr_reram__reram_cell area_ox=0.0676
XMn_14_23 dn_14_23 WL14 SL23 VSS sky130_fd_pr__nfet_g5v0d10v5 w=1 l=0.5
XRn_14_23 BLN23 dn_14_23 sky130_fd_pr_reram__reram_cell area_ox=0.0676
XMp_15_0 dp_15_0 WL15 SL0 VSS sky130_fd_pr__nfet_g5v0d10v5 w=1 l=0.5
XRp_15_0 BLP0 dp_15_0 sky130_fd_pr_reram__reram_cell area_ox=0.0676
XMn_15_0 dn_15_0 WL15 SL0 VSS sky130_fd_pr__nfet_g5v0d10v5 w=1 l=0.5
XRn_15_0 BLN0 dn_15_0 sky130_fd_pr_reram__reram_cell area_ox=0.0676
XMp_15_1 dp_15_1 WL15 SL1 VSS sky130_fd_pr__nfet_g5v0d10v5 w=1 l=0.5
XRp_15_1 BLP1 dp_15_1 sky130_fd_pr_reram__reram_cell area_ox=0.0676
XMn_15_1 dn_15_1 WL15 SL1 VSS sky130_fd_pr__nfet_g5v0d10v5 w=1 l=0.5
XRn_15_1 BLN1 dn_15_1 sky130_fd_pr_reram__reram_cell area_ox=0.0676
XMp_15_2 dp_15_2 WL15 SL2 VSS sky130_fd_pr__nfet_g5v0d10v5 w=1 l=0.5
XRp_15_2 BLP2 dp_15_2 sky130_fd_pr_reram__reram_cell area_ox=0.0676
XMn_15_2 dn_15_2 WL15 SL2 VSS sky130_fd_pr__nfet_g5v0d10v5 w=1 l=0.5
XRn_15_2 BLN2 dn_15_2 sky130_fd_pr_reram__reram_cell area_ox=0.0676
XMp_15_3 dp_15_3 WL15 SL3 VSS sky130_fd_pr__nfet_g5v0d10v5 w=1 l=0.5
XRp_15_3 BLP3 dp_15_3 sky130_fd_pr_reram__reram_cell area_ox=0.0676
XMn_15_3 dn_15_3 WL15 SL3 VSS sky130_fd_pr__nfet_g5v0d10v5 w=1 l=0.5
XRn_15_3 BLN3 dn_15_3 sky130_fd_pr_reram__reram_cell area_ox=0.0676
XMp_15_4 dp_15_4 WL15 SL4 VSS sky130_fd_pr__nfet_g5v0d10v5 w=1 l=0.5
XRp_15_4 BLP4 dp_15_4 sky130_fd_pr_reram__reram_cell area_ox=0.0676
XMn_15_4 dn_15_4 WL15 SL4 VSS sky130_fd_pr__nfet_g5v0d10v5 w=1 l=0.5
XRn_15_4 BLN4 dn_15_4 sky130_fd_pr_reram__reram_cell area_ox=0.0676
XMp_15_5 dp_15_5 WL15 SL5 VSS sky130_fd_pr__nfet_g5v0d10v5 w=1 l=0.5
XRp_15_5 BLP5 dp_15_5 sky130_fd_pr_reram__reram_cell area_ox=0.0676
XMn_15_5 dn_15_5 WL15 SL5 VSS sky130_fd_pr__nfet_g5v0d10v5 w=1 l=0.5
XRn_15_5 BLN5 dn_15_5 sky130_fd_pr_reram__reram_cell area_ox=0.0676
XMp_15_6 dp_15_6 WL15 SL6 VSS sky130_fd_pr__nfet_g5v0d10v5 w=1 l=0.5
XRp_15_6 BLP6 dp_15_6 sky130_fd_pr_reram__reram_cell area_ox=0.0676
XMn_15_6 dn_15_6 WL15 SL6 VSS sky130_fd_pr__nfet_g5v0d10v5 w=1 l=0.5
XRn_15_6 BLN6 dn_15_6 sky130_fd_pr_reram__reram_cell area_ox=0.0676
XMp_15_7 dp_15_7 WL15 SL7 VSS sky130_fd_pr__nfet_g5v0d10v5 w=1 l=0.5
XRp_15_7 BLP7 dp_15_7 sky130_fd_pr_reram__reram_cell area_ox=0.0676
XMn_15_7 dn_15_7 WL15 SL7 VSS sky130_fd_pr__nfet_g5v0d10v5 w=1 l=0.5
XRn_15_7 BLN7 dn_15_7 sky130_fd_pr_reram__reram_cell area_ox=0.0676
XMp_15_8 dp_15_8 WL15 SL8 VSS sky130_fd_pr__nfet_g5v0d10v5 w=1 l=0.5
XRp_15_8 BLP8 dp_15_8 sky130_fd_pr_reram__reram_cell area_ox=0.0676
XMn_15_8 dn_15_8 WL15 SL8 VSS sky130_fd_pr__nfet_g5v0d10v5 w=1 l=0.5
XRn_15_8 BLN8 dn_15_8 sky130_fd_pr_reram__reram_cell area_ox=0.0676
XMp_15_9 dp_15_9 WL15 SL9 VSS sky130_fd_pr__nfet_g5v0d10v5 w=1 l=0.5
XRp_15_9 BLP9 dp_15_9 sky130_fd_pr_reram__reram_cell area_ox=0.0676
XMn_15_9 dn_15_9 WL15 SL9 VSS sky130_fd_pr__nfet_g5v0d10v5 w=1 l=0.5
XRn_15_9 BLN9 dn_15_9 sky130_fd_pr_reram__reram_cell area_ox=0.0676
XMp_15_10 dp_15_10 WL15 SL10 VSS sky130_fd_pr__nfet_g5v0d10v5 w=1 l=0.5
XRp_15_10 BLP10 dp_15_10 sky130_fd_pr_reram__reram_cell area_ox=0.0676
XMn_15_10 dn_15_10 WL15 SL10 VSS sky130_fd_pr__nfet_g5v0d10v5 w=1 l=0.5
XRn_15_10 BLN10 dn_15_10 sky130_fd_pr_reram__reram_cell area_ox=0.0676
XMp_15_11 dp_15_11 WL15 SL11 VSS sky130_fd_pr__nfet_g5v0d10v5 w=1 l=0.5
XRp_15_11 BLP11 dp_15_11 sky130_fd_pr_reram__reram_cell area_ox=0.0676
XMn_15_11 dn_15_11 WL15 SL11 VSS sky130_fd_pr__nfet_g5v0d10v5 w=1 l=0.5
XRn_15_11 BLN11 dn_15_11 sky130_fd_pr_reram__reram_cell area_ox=0.0676
XMp_15_12 dp_15_12 WL15 SL12 VSS sky130_fd_pr__nfet_g5v0d10v5 w=1 l=0.5
XRp_15_12 BLP12 dp_15_12 sky130_fd_pr_reram__reram_cell area_ox=0.0676
XMn_15_12 dn_15_12 WL15 SL12 VSS sky130_fd_pr__nfet_g5v0d10v5 w=1 l=0.5
XRn_15_12 BLN12 dn_15_12 sky130_fd_pr_reram__reram_cell area_ox=0.0676
XMp_15_13 dp_15_13 WL15 SL13 VSS sky130_fd_pr__nfet_g5v0d10v5 w=1 l=0.5
XRp_15_13 BLP13 dp_15_13 sky130_fd_pr_reram__reram_cell area_ox=0.0676
XMn_15_13 dn_15_13 WL15 SL13 VSS sky130_fd_pr__nfet_g5v0d10v5 w=1 l=0.5
XRn_15_13 BLN13 dn_15_13 sky130_fd_pr_reram__reram_cell area_ox=0.0676
XMp_15_14 dp_15_14 WL15 SL14 VSS sky130_fd_pr__nfet_g5v0d10v5 w=1 l=0.5
XRp_15_14 BLP14 dp_15_14 sky130_fd_pr_reram__reram_cell area_ox=0.0676
XMn_15_14 dn_15_14 WL15 SL14 VSS sky130_fd_pr__nfet_g5v0d10v5 w=1 l=0.5
XRn_15_14 BLN14 dn_15_14 sky130_fd_pr_reram__reram_cell area_ox=0.0676
XMp_15_15 dp_15_15 WL15 SL15 VSS sky130_fd_pr__nfet_g5v0d10v5 w=1 l=0.5
XRp_15_15 BLP15 dp_15_15 sky130_fd_pr_reram__reram_cell area_ox=0.0676
XMn_15_15 dn_15_15 WL15 SL15 VSS sky130_fd_pr__nfet_g5v0d10v5 w=1 l=0.5
XRn_15_15 BLN15 dn_15_15 sky130_fd_pr_reram__reram_cell area_ox=0.0676
XMp_15_16 dp_15_16 WL15 SL16 VSS sky130_fd_pr__nfet_g5v0d10v5 w=1 l=0.5
XRp_15_16 BLP16 dp_15_16 sky130_fd_pr_reram__reram_cell area_ox=0.0676
XMn_15_16 dn_15_16 WL15 SL16 VSS sky130_fd_pr__nfet_g5v0d10v5 w=1 l=0.5
XRn_15_16 BLN16 dn_15_16 sky130_fd_pr_reram__reram_cell area_ox=0.0676
XMp_15_17 dp_15_17 WL15 SL17 VSS sky130_fd_pr__nfet_g5v0d10v5 w=1 l=0.5
XRp_15_17 BLP17 dp_15_17 sky130_fd_pr_reram__reram_cell area_ox=0.0676
XMn_15_17 dn_15_17 WL15 SL17 VSS sky130_fd_pr__nfet_g5v0d10v5 w=1 l=0.5
XRn_15_17 BLN17 dn_15_17 sky130_fd_pr_reram__reram_cell area_ox=0.0676
XMp_15_18 dp_15_18 WL15 SL18 VSS sky130_fd_pr__nfet_g5v0d10v5 w=1 l=0.5
XRp_15_18 BLP18 dp_15_18 sky130_fd_pr_reram__reram_cell area_ox=0.0676
XMn_15_18 dn_15_18 WL15 SL18 VSS sky130_fd_pr__nfet_g5v0d10v5 w=1 l=0.5
XRn_15_18 BLN18 dn_15_18 sky130_fd_pr_reram__reram_cell area_ox=0.0676
XMp_15_19 dp_15_19 WL15 SL19 VSS sky130_fd_pr__nfet_g5v0d10v5 w=1 l=0.5
XRp_15_19 BLP19 dp_15_19 sky130_fd_pr_reram__reram_cell area_ox=0.0676
XMn_15_19 dn_15_19 WL15 SL19 VSS sky130_fd_pr__nfet_g5v0d10v5 w=1 l=0.5
XRn_15_19 BLN19 dn_15_19 sky130_fd_pr_reram__reram_cell area_ox=0.0676
XMp_15_20 dp_15_20 WL15 SL20 VSS sky130_fd_pr__nfet_g5v0d10v5 w=1 l=0.5
XRp_15_20 BLP20 dp_15_20 sky130_fd_pr_reram__reram_cell area_ox=0.0676
XMn_15_20 dn_15_20 WL15 SL20 VSS sky130_fd_pr__nfet_g5v0d10v5 w=1 l=0.5
XRn_15_20 BLN20 dn_15_20 sky130_fd_pr_reram__reram_cell area_ox=0.0676
XMp_15_21 dp_15_21 WL15 SL21 VSS sky130_fd_pr__nfet_g5v0d10v5 w=1 l=0.5
XRp_15_21 BLP21 dp_15_21 sky130_fd_pr_reram__reram_cell area_ox=0.0676
XMn_15_21 dn_15_21 WL15 SL21 VSS sky130_fd_pr__nfet_g5v0d10v5 w=1 l=0.5
XRn_15_21 BLN21 dn_15_21 sky130_fd_pr_reram__reram_cell area_ox=0.0676
XMp_15_22 dp_15_22 WL15 SL22 VSS sky130_fd_pr__nfet_g5v0d10v5 w=1 l=0.5
XRp_15_22 BLP22 dp_15_22 sky130_fd_pr_reram__reram_cell area_ox=0.0676
XMn_15_22 dn_15_22 WL15 SL22 VSS sky130_fd_pr__nfet_g5v0d10v5 w=1 l=0.5
XRn_15_22 BLN22 dn_15_22 sky130_fd_pr_reram__reram_cell area_ox=0.0676
XMp_15_23 dp_15_23 WL15 SL23 VSS sky130_fd_pr__nfet_g5v0d10v5 w=1 l=0.5
XRp_15_23 BLP23 dp_15_23 sky130_fd_pr_reram__reram_cell area_ox=0.0676
XMn_15_23 dn_15_23 WL15 SL23 VSS sky130_fd_pr__nfet_g5v0d10v5 w=1 l=0.5
XRn_15_23 BLN23 dn_15_23 sky130_fd_pr_reram__reram_cell area_ox=0.0676
XMp_16_0 dp_16_0 WL16 SL0 VSS sky130_fd_pr__nfet_g5v0d10v5 w=1 l=0.5
XRp_16_0 BLP0 dp_16_0 sky130_fd_pr_reram__reram_cell area_ox=0.0676
XMn_16_0 dn_16_0 WL16 SL0 VSS sky130_fd_pr__nfet_g5v0d10v5 w=1 l=0.5
XRn_16_0 BLN0 dn_16_0 sky130_fd_pr_reram__reram_cell area_ox=0.0676
XMp_16_1 dp_16_1 WL16 SL1 VSS sky130_fd_pr__nfet_g5v0d10v5 w=1 l=0.5
XRp_16_1 BLP1 dp_16_1 sky130_fd_pr_reram__reram_cell area_ox=0.0676
XMn_16_1 dn_16_1 WL16 SL1 VSS sky130_fd_pr__nfet_g5v0d10v5 w=1 l=0.5
XRn_16_1 BLN1 dn_16_1 sky130_fd_pr_reram__reram_cell area_ox=0.0676
XMp_16_2 dp_16_2 WL16 SL2 VSS sky130_fd_pr__nfet_g5v0d10v5 w=1 l=0.5
XRp_16_2 BLP2 dp_16_2 sky130_fd_pr_reram__reram_cell area_ox=0.0676
XMn_16_2 dn_16_2 WL16 SL2 VSS sky130_fd_pr__nfet_g5v0d10v5 w=1 l=0.5
XRn_16_2 BLN2 dn_16_2 sky130_fd_pr_reram__reram_cell area_ox=0.0676
XMp_16_3 dp_16_3 WL16 SL3 VSS sky130_fd_pr__nfet_g5v0d10v5 w=1 l=0.5
XRp_16_3 BLP3 dp_16_3 sky130_fd_pr_reram__reram_cell area_ox=0.0676
XMn_16_3 dn_16_3 WL16 SL3 VSS sky130_fd_pr__nfet_g5v0d10v5 w=1 l=0.5
XRn_16_3 BLN3 dn_16_3 sky130_fd_pr_reram__reram_cell area_ox=0.0676
XMp_16_4 dp_16_4 WL16 SL4 VSS sky130_fd_pr__nfet_g5v0d10v5 w=1 l=0.5
XRp_16_4 BLP4 dp_16_4 sky130_fd_pr_reram__reram_cell area_ox=0.0676
XMn_16_4 dn_16_4 WL16 SL4 VSS sky130_fd_pr__nfet_g5v0d10v5 w=1 l=0.5
XRn_16_4 BLN4 dn_16_4 sky130_fd_pr_reram__reram_cell area_ox=0.0676
XMp_16_5 dp_16_5 WL16 SL5 VSS sky130_fd_pr__nfet_g5v0d10v5 w=1 l=0.5
XRp_16_5 BLP5 dp_16_5 sky130_fd_pr_reram__reram_cell area_ox=0.0676
XMn_16_5 dn_16_5 WL16 SL5 VSS sky130_fd_pr__nfet_g5v0d10v5 w=1 l=0.5
XRn_16_5 BLN5 dn_16_5 sky130_fd_pr_reram__reram_cell area_ox=0.0676
XMp_16_6 dp_16_6 WL16 SL6 VSS sky130_fd_pr__nfet_g5v0d10v5 w=1 l=0.5
XRp_16_6 BLP6 dp_16_6 sky130_fd_pr_reram__reram_cell area_ox=0.0676
XMn_16_6 dn_16_6 WL16 SL6 VSS sky130_fd_pr__nfet_g5v0d10v5 w=1 l=0.5
XRn_16_6 BLN6 dn_16_6 sky130_fd_pr_reram__reram_cell area_ox=0.0676
XMp_16_7 dp_16_7 WL16 SL7 VSS sky130_fd_pr__nfet_g5v0d10v5 w=1 l=0.5
XRp_16_7 BLP7 dp_16_7 sky130_fd_pr_reram__reram_cell area_ox=0.0676
XMn_16_7 dn_16_7 WL16 SL7 VSS sky130_fd_pr__nfet_g5v0d10v5 w=1 l=0.5
XRn_16_7 BLN7 dn_16_7 sky130_fd_pr_reram__reram_cell area_ox=0.0676
XMp_16_8 dp_16_8 WL16 SL8 VSS sky130_fd_pr__nfet_g5v0d10v5 w=1 l=0.5
XRp_16_8 BLP8 dp_16_8 sky130_fd_pr_reram__reram_cell area_ox=0.0676
XMn_16_8 dn_16_8 WL16 SL8 VSS sky130_fd_pr__nfet_g5v0d10v5 w=1 l=0.5
XRn_16_8 BLN8 dn_16_8 sky130_fd_pr_reram__reram_cell area_ox=0.0676
XMp_16_9 dp_16_9 WL16 SL9 VSS sky130_fd_pr__nfet_g5v0d10v5 w=1 l=0.5
XRp_16_9 BLP9 dp_16_9 sky130_fd_pr_reram__reram_cell area_ox=0.0676
XMn_16_9 dn_16_9 WL16 SL9 VSS sky130_fd_pr__nfet_g5v0d10v5 w=1 l=0.5
XRn_16_9 BLN9 dn_16_9 sky130_fd_pr_reram__reram_cell area_ox=0.0676
XMp_16_10 dp_16_10 WL16 SL10 VSS sky130_fd_pr__nfet_g5v0d10v5 w=1 l=0.5
XRp_16_10 BLP10 dp_16_10 sky130_fd_pr_reram__reram_cell area_ox=0.0676
XMn_16_10 dn_16_10 WL16 SL10 VSS sky130_fd_pr__nfet_g5v0d10v5 w=1 l=0.5
XRn_16_10 BLN10 dn_16_10 sky130_fd_pr_reram__reram_cell area_ox=0.0676
XMp_16_11 dp_16_11 WL16 SL11 VSS sky130_fd_pr__nfet_g5v0d10v5 w=1 l=0.5
XRp_16_11 BLP11 dp_16_11 sky130_fd_pr_reram__reram_cell area_ox=0.0676
XMn_16_11 dn_16_11 WL16 SL11 VSS sky130_fd_pr__nfet_g5v0d10v5 w=1 l=0.5
XRn_16_11 BLN11 dn_16_11 sky130_fd_pr_reram__reram_cell area_ox=0.0676
XMp_16_12 dp_16_12 WL16 SL12 VSS sky130_fd_pr__nfet_g5v0d10v5 w=1 l=0.5
XRp_16_12 BLP12 dp_16_12 sky130_fd_pr_reram__reram_cell area_ox=0.0676
XMn_16_12 dn_16_12 WL16 SL12 VSS sky130_fd_pr__nfet_g5v0d10v5 w=1 l=0.5
XRn_16_12 BLN12 dn_16_12 sky130_fd_pr_reram__reram_cell area_ox=0.0676
XMp_16_13 dp_16_13 WL16 SL13 VSS sky130_fd_pr__nfet_g5v0d10v5 w=1 l=0.5
XRp_16_13 BLP13 dp_16_13 sky130_fd_pr_reram__reram_cell area_ox=0.0676
XMn_16_13 dn_16_13 WL16 SL13 VSS sky130_fd_pr__nfet_g5v0d10v5 w=1 l=0.5
XRn_16_13 BLN13 dn_16_13 sky130_fd_pr_reram__reram_cell area_ox=0.0676
XMp_16_14 dp_16_14 WL16 SL14 VSS sky130_fd_pr__nfet_g5v0d10v5 w=1 l=0.5
XRp_16_14 BLP14 dp_16_14 sky130_fd_pr_reram__reram_cell area_ox=0.0676
XMn_16_14 dn_16_14 WL16 SL14 VSS sky130_fd_pr__nfet_g5v0d10v5 w=1 l=0.5
XRn_16_14 BLN14 dn_16_14 sky130_fd_pr_reram__reram_cell area_ox=0.0676
XMp_16_15 dp_16_15 WL16 SL15 VSS sky130_fd_pr__nfet_g5v0d10v5 w=1 l=0.5
XRp_16_15 BLP15 dp_16_15 sky130_fd_pr_reram__reram_cell area_ox=0.0676
XMn_16_15 dn_16_15 WL16 SL15 VSS sky130_fd_pr__nfet_g5v0d10v5 w=1 l=0.5
XRn_16_15 BLN15 dn_16_15 sky130_fd_pr_reram__reram_cell area_ox=0.0676
XMp_16_16 dp_16_16 WL16 SL16 VSS sky130_fd_pr__nfet_g5v0d10v5 w=1 l=0.5
XRp_16_16 BLP16 dp_16_16 sky130_fd_pr_reram__reram_cell area_ox=0.0676
XMn_16_16 dn_16_16 WL16 SL16 VSS sky130_fd_pr__nfet_g5v0d10v5 w=1 l=0.5
XRn_16_16 BLN16 dn_16_16 sky130_fd_pr_reram__reram_cell area_ox=0.0676
XMp_16_17 dp_16_17 WL16 SL17 VSS sky130_fd_pr__nfet_g5v0d10v5 w=1 l=0.5
XRp_16_17 BLP17 dp_16_17 sky130_fd_pr_reram__reram_cell area_ox=0.0676
XMn_16_17 dn_16_17 WL16 SL17 VSS sky130_fd_pr__nfet_g5v0d10v5 w=1 l=0.5
XRn_16_17 BLN17 dn_16_17 sky130_fd_pr_reram__reram_cell area_ox=0.0676
XMp_16_18 dp_16_18 WL16 SL18 VSS sky130_fd_pr__nfet_g5v0d10v5 w=1 l=0.5
XRp_16_18 BLP18 dp_16_18 sky130_fd_pr_reram__reram_cell area_ox=0.0676
XMn_16_18 dn_16_18 WL16 SL18 VSS sky130_fd_pr__nfet_g5v0d10v5 w=1 l=0.5
XRn_16_18 BLN18 dn_16_18 sky130_fd_pr_reram__reram_cell area_ox=0.0676
XMp_16_19 dp_16_19 WL16 SL19 VSS sky130_fd_pr__nfet_g5v0d10v5 w=1 l=0.5
XRp_16_19 BLP19 dp_16_19 sky130_fd_pr_reram__reram_cell area_ox=0.0676
XMn_16_19 dn_16_19 WL16 SL19 VSS sky130_fd_pr__nfet_g5v0d10v5 w=1 l=0.5
XRn_16_19 BLN19 dn_16_19 sky130_fd_pr_reram__reram_cell area_ox=0.0676
XMp_16_20 dp_16_20 WL16 SL20 VSS sky130_fd_pr__nfet_g5v0d10v5 w=1 l=0.5
XRp_16_20 BLP20 dp_16_20 sky130_fd_pr_reram__reram_cell area_ox=0.0676
XMn_16_20 dn_16_20 WL16 SL20 VSS sky130_fd_pr__nfet_g5v0d10v5 w=1 l=0.5
XRn_16_20 BLN20 dn_16_20 sky130_fd_pr_reram__reram_cell area_ox=0.0676
XMp_16_21 dp_16_21 WL16 SL21 VSS sky130_fd_pr__nfet_g5v0d10v5 w=1 l=0.5
XRp_16_21 BLP21 dp_16_21 sky130_fd_pr_reram__reram_cell area_ox=0.0676
XMn_16_21 dn_16_21 WL16 SL21 VSS sky130_fd_pr__nfet_g5v0d10v5 w=1 l=0.5
XRn_16_21 BLN21 dn_16_21 sky130_fd_pr_reram__reram_cell area_ox=0.0676
XMp_16_22 dp_16_22 WL16 SL22 VSS sky130_fd_pr__nfet_g5v0d10v5 w=1 l=0.5
XRp_16_22 BLP22 dp_16_22 sky130_fd_pr_reram__reram_cell area_ox=0.0676
XMn_16_22 dn_16_22 WL16 SL22 VSS sky130_fd_pr__nfet_g5v0d10v5 w=1 l=0.5
XRn_16_22 BLN22 dn_16_22 sky130_fd_pr_reram__reram_cell area_ox=0.0676
XMp_16_23 dp_16_23 WL16 SL23 VSS sky130_fd_pr__nfet_g5v0d10v5 w=1 l=0.5
XRp_16_23 BLP23 dp_16_23 sky130_fd_pr_reram__reram_cell area_ox=0.0676
XMn_16_23 dn_16_23 WL16 SL23 VSS sky130_fd_pr__nfet_g5v0d10v5 w=1 l=0.5
XRn_16_23 BLN23 dn_16_23 sky130_fd_pr_reram__reram_cell area_ox=0.0676
XMp_17_0 dp_17_0 WL17 SL0 VSS sky130_fd_pr__nfet_g5v0d10v5 w=1 l=0.5
XRp_17_0 BLP0 dp_17_0 sky130_fd_pr_reram__reram_cell area_ox=0.0676
XMn_17_0 dn_17_0 WL17 SL0 VSS sky130_fd_pr__nfet_g5v0d10v5 w=1 l=0.5
XRn_17_0 BLN0 dn_17_0 sky130_fd_pr_reram__reram_cell area_ox=0.0676
XMp_17_1 dp_17_1 WL17 SL1 VSS sky130_fd_pr__nfet_g5v0d10v5 w=1 l=0.5
XRp_17_1 BLP1 dp_17_1 sky130_fd_pr_reram__reram_cell area_ox=0.0676
XMn_17_1 dn_17_1 WL17 SL1 VSS sky130_fd_pr__nfet_g5v0d10v5 w=1 l=0.5
XRn_17_1 BLN1 dn_17_1 sky130_fd_pr_reram__reram_cell area_ox=0.0676
XMp_17_2 dp_17_2 WL17 SL2 VSS sky130_fd_pr__nfet_g5v0d10v5 w=1 l=0.5
XRp_17_2 BLP2 dp_17_2 sky130_fd_pr_reram__reram_cell area_ox=0.0676
XMn_17_2 dn_17_2 WL17 SL2 VSS sky130_fd_pr__nfet_g5v0d10v5 w=1 l=0.5
XRn_17_2 BLN2 dn_17_2 sky130_fd_pr_reram__reram_cell area_ox=0.0676
XMp_17_3 dp_17_3 WL17 SL3 VSS sky130_fd_pr__nfet_g5v0d10v5 w=1 l=0.5
XRp_17_3 BLP3 dp_17_3 sky130_fd_pr_reram__reram_cell area_ox=0.0676
XMn_17_3 dn_17_3 WL17 SL3 VSS sky130_fd_pr__nfet_g5v0d10v5 w=1 l=0.5
XRn_17_3 BLN3 dn_17_3 sky130_fd_pr_reram__reram_cell area_ox=0.0676
XMp_17_4 dp_17_4 WL17 SL4 VSS sky130_fd_pr__nfet_g5v0d10v5 w=1 l=0.5
XRp_17_4 BLP4 dp_17_4 sky130_fd_pr_reram__reram_cell area_ox=0.0676
XMn_17_4 dn_17_4 WL17 SL4 VSS sky130_fd_pr__nfet_g5v0d10v5 w=1 l=0.5
XRn_17_4 BLN4 dn_17_4 sky130_fd_pr_reram__reram_cell area_ox=0.0676
XMp_17_5 dp_17_5 WL17 SL5 VSS sky130_fd_pr__nfet_g5v0d10v5 w=1 l=0.5
XRp_17_5 BLP5 dp_17_5 sky130_fd_pr_reram__reram_cell area_ox=0.0676
XMn_17_5 dn_17_5 WL17 SL5 VSS sky130_fd_pr__nfet_g5v0d10v5 w=1 l=0.5
XRn_17_5 BLN5 dn_17_5 sky130_fd_pr_reram__reram_cell area_ox=0.0676
XMp_17_6 dp_17_6 WL17 SL6 VSS sky130_fd_pr__nfet_g5v0d10v5 w=1 l=0.5
XRp_17_6 BLP6 dp_17_6 sky130_fd_pr_reram__reram_cell area_ox=0.0676
XMn_17_6 dn_17_6 WL17 SL6 VSS sky130_fd_pr__nfet_g5v0d10v5 w=1 l=0.5
XRn_17_6 BLN6 dn_17_6 sky130_fd_pr_reram__reram_cell area_ox=0.0676
XMp_17_7 dp_17_7 WL17 SL7 VSS sky130_fd_pr__nfet_g5v0d10v5 w=1 l=0.5
XRp_17_7 BLP7 dp_17_7 sky130_fd_pr_reram__reram_cell area_ox=0.0676
XMn_17_7 dn_17_7 WL17 SL7 VSS sky130_fd_pr__nfet_g5v0d10v5 w=1 l=0.5
XRn_17_7 BLN7 dn_17_7 sky130_fd_pr_reram__reram_cell area_ox=0.0676
XMp_17_8 dp_17_8 WL17 SL8 VSS sky130_fd_pr__nfet_g5v0d10v5 w=1 l=0.5
XRp_17_8 BLP8 dp_17_8 sky130_fd_pr_reram__reram_cell area_ox=0.0676
XMn_17_8 dn_17_8 WL17 SL8 VSS sky130_fd_pr__nfet_g5v0d10v5 w=1 l=0.5
XRn_17_8 BLN8 dn_17_8 sky130_fd_pr_reram__reram_cell area_ox=0.0676
XMp_17_9 dp_17_9 WL17 SL9 VSS sky130_fd_pr__nfet_g5v0d10v5 w=1 l=0.5
XRp_17_9 BLP9 dp_17_9 sky130_fd_pr_reram__reram_cell area_ox=0.0676
XMn_17_9 dn_17_9 WL17 SL9 VSS sky130_fd_pr__nfet_g5v0d10v5 w=1 l=0.5
XRn_17_9 BLN9 dn_17_9 sky130_fd_pr_reram__reram_cell area_ox=0.0676
XMp_17_10 dp_17_10 WL17 SL10 VSS sky130_fd_pr__nfet_g5v0d10v5 w=1 l=0.5
XRp_17_10 BLP10 dp_17_10 sky130_fd_pr_reram__reram_cell area_ox=0.0676
XMn_17_10 dn_17_10 WL17 SL10 VSS sky130_fd_pr__nfet_g5v0d10v5 w=1 l=0.5
XRn_17_10 BLN10 dn_17_10 sky130_fd_pr_reram__reram_cell area_ox=0.0676
XMp_17_11 dp_17_11 WL17 SL11 VSS sky130_fd_pr__nfet_g5v0d10v5 w=1 l=0.5
XRp_17_11 BLP11 dp_17_11 sky130_fd_pr_reram__reram_cell area_ox=0.0676
XMn_17_11 dn_17_11 WL17 SL11 VSS sky130_fd_pr__nfet_g5v0d10v5 w=1 l=0.5
XRn_17_11 BLN11 dn_17_11 sky130_fd_pr_reram__reram_cell area_ox=0.0676
XMp_17_12 dp_17_12 WL17 SL12 VSS sky130_fd_pr__nfet_g5v0d10v5 w=1 l=0.5
XRp_17_12 BLP12 dp_17_12 sky130_fd_pr_reram__reram_cell area_ox=0.0676
XMn_17_12 dn_17_12 WL17 SL12 VSS sky130_fd_pr__nfet_g5v0d10v5 w=1 l=0.5
XRn_17_12 BLN12 dn_17_12 sky130_fd_pr_reram__reram_cell area_ox=0.0676
XMp_17_13 dp_17_13 WL17 SL13 VSS sky130_fd_pr__nfet_g5v0d10v5 w=1 l=0.5
XRp_17_13 BLP13 dp_17_13 sky130_fd_pr_reram__reram_cell area_ox=0.0676
XMn_17_13 dn_17_13 WL17 SL13 VSS sky130_fd_pr__nfet_g5v0d10v5 w=1 l=0.5
XRn_17_13 BLN13 dn_17_13 sky130_fd_pr_reram__reram_cell area_ox=0.0676
XMp_17_14 dp_17_14 WL17 SL14 VSS sky130_fd_pr__nfet_g5v0d10v5 w=1 l=0.5
XRp_17_14 BLP14 dp_17_14 sky130_fd_pr_reram__reram_cell area_ox=0.0676
XMn_17_14 dn_17_14 WL17 SL14 VSS sky130_fd_pr__nfet_g5v0d10v5 w=1 l=0.5
XRn_17_14 BLN14 dn_17_14 sky130_fd_pr_reram__reram_cell area_ox=0.0676
XMp_17_15 dp_17_15 WL17 SL15 VSS sky130_fd_pr__nfet_g5v0d10v5 w=1 l=0.5
XRp_17_15 BLP15 dp_17_15 sky130_fd_pr_reram__reram_cell area_ox=0.0676
XMn_17_15 dn_17_15 WL17 SL15 VSS sky130_fd_pr__nfet_g5v0d10v5 w=1 l=0.5
XRn_17_15 BLN15 dn_17_15 sky130_fd_pr_reram__reram_cell area_ox=0.0676
XMp_17_16 dp_17_16 WL17 SL16 VSS sky130_fd_pr__nfet_g5v0d10v5 w=1 l=0.5
XRp_17_16 BLP16 dp_17_16 sky130_fd_pr_reram__reram_cell area_ox=0.0676
XMn_17_16 dn_17_16 WL17 SL16 VSS sky130_fd_pr__nfet_g5v0d10v5 w=1 l=0.5
XRn_17_16 BLN16 dn_17_16 sky130_fd_pr_reram__reram_cell area_ox=0.0676
XMp_17_17 dp_17_17 WL17 SL17 VSS sky130_fd_pr__nfet_g5v0d10v5 w=1 l=0.5
XRp_17_17 BLP17 dp_17_17 sky130_fd_pr_reram__reram_cell area_ox=0.0676
XMn_17_17 dn_17_17 WL17 SL17 VSS sky130_fd_pr__nfet_g5v0d10v5 w=1 l=0.5
XRn_17_17 BLN17 dn_17_17 sky130_fd_pr_reram__reram_cell area_ox=0.0676
XMp_17_18 dp_17_18 WL17 SL18 VSS sky130_fd_pr__nfet_g5v0d10v5 w=1 l=0.5
XRp_17_18 BLP18 dp_17_18 sky130_fd_pr_reram__reram_cell area_ox=0.0676
XMn_17_18 dn_17_18 WL17 SL18 VSS sky130_fd_pr__nfet_g5v0d10v5 w=1 l=0.5
XRn_17_18 BLN18 dn_17_18 sky130_fd_pr_reram__reram_cell area_ox=0.0676
XMp_17_19 dp_17_19 WL17 SL19 VSS sky130_fd_pr__nfet_g5v0d10v5 w=1 l=0.5
XRp_17_19 BLP19 dp_17_19 sky130_fd_pr_reram__reram_cell area_ox=0.0676
XMn_17_19 dn_17_19 WL17 SL19 VSS sky130_fd_pr__nfet_g5v0d10v5 w=1 l=0.5
XRn_17_19 BLN19 dn_17_19 sky130_fd_pr_reram__reram_cell area_ox=0.0676
XMp_17_20 dp_17_20 WL17 SL20 VSS sky130_fd_pr__nfet_g5v0d10v5 w=1 l=0.5
XRp_17_20 BLP20 dp_17_20 sky130_fd_pr_reram__reram_cell area_ox=0.0676
XMn_17_20 dn_17_20 WL17 SL20 VSS sky130_fd_pr__nfet_g5v0d10v5 w=1 l=0.5
XRn_17_20 BLN20 dn_17_20 sky130_fd_pr_reram__reram_cell area_ox=0.0676
XMp_17_21 dp_17_21 WL17 SL21 VSS sky130_fd_pr__nfet_g5v0d10v5 w=1 l=0.5
XRp_17_21 BLP21 dp_17_21 sky130_fd_pr_reram__reram_cell area_ox=0.0676
XMn_17_21 dn_17_21 WL17 SL21 VSS sky130_fd_pr__nfet_g5v0d10v5 w=1 l=0.5
XRn_17_21 BLN21 dn_17_21 sky130_fd_pr_reram__reram_cell area_ox=0.0676
XMp_17_22 dp_17_22 WL17 SL22 VSS sky130_fd_pr__nfet_g5v0d10v5 w=1 l=0.5
XRp_17_22 BLP22 dp_17_22 sky130_fd_pr_reram__reram_cell area_ox=0.0676
XMn_17_22 dn_17_22 WL17 SL22 VSS sky130_fd_pr__nfet_g5v0d10v5 w=1 l=0.5
XRn_17_22 BLN22 dn_17_22 sky130_fd_pr_reram__reram_cell area_ox=0.0676
XMp_17_23 dp_17_23 WL17 SL23 VSS sky130_fd_pr__nfet_g5v0d10v5 w=1 l=0.5
XRp_17_23 BLP23 dp_17_23 sky130_fd_pr_reram__reram_cell area_ox=0.0676
XMn_17_23 dn_17_23 WL17 SL23 VSS sky130_fd_pr__nfet_g5v0d10v5 w=1 l=0.5
XRn_17_23 BLN23 dn_17_23 sky130_fd_pr_reram__reram_cell area_ox=0.0676
XMp_18_0 dp_18_0 WL18 SL0 VSS sky130_fd_pr__nfet_g5v0d10v5 w=1 l=0.5
XRp_18_0 BLP0 dp_18_0 sky130_fd_pr_reram__reram_cell area_ox=0.0676
XMn_18_0 dn_18_0 WL18 SL0 VSS sky130_fd_pr__nfet_g5v0d10v5 w=1 l=0.5
XRn_18_0 BLN0 dn_18_0 sky130_fd_pr_reram__reram_cell area_ox=0.0676
XMp_18_1 dp_18_1 WL18 SL1 VSS sky130_fd_pr__nfet_g5v0d10v5 w=1 l=0.5
XRp_18_1 BLP1 dp_18_1 sky130_fd_pr_reram__reram_cell area_ox=0.0676
XMn_18_1 dn_18_1 WL18 SL1 VSS sky130_fd_pr__nfet_g5v0d10v5 w=1 l=0.5
XRn_18_1 BLN1 dn_18_1 sky130_fd_pr_reram__reram_cell area_ox=0.0676
XMp_18_2 dp_18_2 WL18 SL2 VSS sky130_fd_pr__nfet_g5v0d10v5 w=1 l=0.5
XRp_18_2 BLP2 dp_18_2 sky130_fd_pr_reram__reram_cell area_ox=0.0676
XMn_18_2 dn_18_2 WL18 SL2 VSS sky130_fd_pr__nfet_g5v0d10v5 w=1 l=0.5
XRn_18_2 BLN2 dn_18_2 sky130_fd_pr_reram__reram_cell area_ox=0.0676
XMp_18_3 dp_18_3 WL18 SL3 VSS sky130_fd_pr__nfet_g5v0d10v5 w=1 l=0.5
XRp_18_3 BLP3 dp_18_3 sky130_fd_pr_reram__reram_cell area_ox=0.0676
XMn_18_3 dn_18_3 WL18 SL3 VSS sky130_fd_pr__nfet_g5v0d10v5 w=1 l=0.5
XRn_18_3 BLN3 dn_18_3 sky130_fd_pr_reram__reram_cell area_ox=0.0676
XMp_18_4 dp_18_4 WL18 SL4 VSS sky130_fd_pr__nfet_g5v0d10v5 w=1 l=0.5
XRp_18_4 BLP4 dp_18_4 sky130_fd_pr_reram__reram_cell area_ox=0.0676
XMn_18_4 dn_18_4 WL18 SL4 VSS sky130_fd_pr__nfet_g5v0d10v5 w=1 l=0.5
XRn_18_4 BLN4 dn_18_4 sky130_fd_pr_reram__reram_cell area_ox=0.0676
XMp_18_5 dp_18_5 WL18 SL5 VSS sky130_fd_pr__nfet_g5v0d10v5 w=1 l=0.5
XRp_18_5 BLP5 dp_18_5 sky130_fd_pr_reram__reram_cell area_ox=0.0676
XMn_18_5 dn_18_5 WL18 SL5 VSS sky130_fd_pr__nfet_g5v0d10v5 w=1 l=0.5
XRn_18_5 BLN5 dn_18_5 sky130_fd_pr_reram__reram_cell area_ox=0.0676
XMp_18_6 dp_18_6 WL18 SL6 VSS sky130_fd_pr__nfet_g5v0d10v5 w=1 l=0.5
XRp_18_6 BLP6 dp_18_6 sky130_fd_pr_reram__reram_cell area_ox=0.0676
XMn_18_6 dn_18_6 WL18 SL6 VSS sky130_fd_pr__nfet_g5v0d10v5 w=1 l=0.5
XRn_18_6 BLN6 dn_18_6 sky130_fd_pr_reram__reram_cell area_ox=0.0676
XMp_18_7 dp_18_7 WL18 SL7 VSS sky130_fd_pr__nfet_g5v0d10v5 w=1 l=0.5
XRp_18_7 BLP7 dp_18_7 sky130_fd_pr_reram__reram_cell area_ox=0.0676
XMn_18_7 dn_18_7 WL18 SL7 VSS sky130_fd_pr__nfet_g5v0d10v5 w=1 l=0.5
XRn_18_7 BLN7 dn_18_7 sky130_fd_pr_reram__reram_cell area_ox=0.0676
XMp_18_8 dp_18_8 WL18 SL8 VSS sky130_fd_pr__nfet_g5v0d10v5 w=1 l=0.5
XRp_18_8 BLP8 dp_18_8 sky130_fd_pr_reram__reram_cell area_ox=0.0676
XMn_18_8 dn_18_8 WL18 SL8 VSS sky130_fd_pr__nfet_g5v0d10v5 w=1 l=0.5
XRn_18_8 BLN8 dn_18_8 sky130_fd_pr_reram__reram_cell area_ox=0.0676
XMp_18_9 dp_18_9 WL18 SL9 VSS sky130_fd_pr__nfet_g5v0d10v5 w=1 l=0.5
XRp_18_9 BLP9 dp_18_9 sky130_fd_pr_reram__reram_cell area_ox=0.0676
XMn_18_9 dn_18_9 WL18 SL9 VSS sky130_fd_pr__nfet_g5v0d10v5 w=1 l=0.5
XRn_18_9 BLN9 dn_18_9 sky130_fd_pr_reram__reram_cell area_ox=0.0676
XMp_18_10 dp_18_10 WL18 SL10 VSS sky130_fd_pr__nfet_g5v0d10v5 w=1 l=0.5
XRp_18_10 BLP10 dp_18_10 sky130_fd_pr_reram__reram_cell area_ox=0.0676
XMn_18_10 dn_18_10 WL18 SL10 VSS sky130_fd_pr__nfet_g5v0d10v5 w=1 l=0.5
XRn_18_10 BLN10 dn_18_10 sky130_fd_pr_reram__reram_cell area_ox=0.0676
XMp_18_11 dp_18_11 WL18 SL11 VSS sky130_fd_pr__nfet_g5v0d10v5 w=1 l=0.5
XRp_18_11 BLP11 dp_18_11 sky130_fd_pr_reram__reram_cell area_ox=0.0676
XMn_18_11 dn_18_11 WL18 SL11 VSS sky130_fd_pr__nfet_g5v0d10v5 w=1 l=0.5
XRn_18_11 BLN11 dn_18_11 sky130_fd_pr_reram__reram_cell area_ox=0.0676
XMp_18_12 dp_18_12 WL18 SL12 VSS sky130_fd_pr__nfet_g5v0d10v5 w=1 l=0.5
XRp_18_12 BLP12 dp_18_12 sky130_fd_pr_reram__reram_cell area_ox=0.0676
XMn_18_12 dn_18_12 WL18 SL12 VSS sky130_fd_pr__nfet_g5v0d10v5 w=1 l=0.5
XRn_18_12 BLN12 dn_18_12 sky130_fd_pr_reram__reram_cell area_ox=0.0676
XMp_18_13 dp_18_13 WL18 SL13 VSS sky130_fd_pr__nfet_g5v0d10v5 w=1 l=0.5
XRp_18_13 BLP13 dp_18_13 sky130_fd_pr_reram__reram_cell area_ox=0.0676
XMn_18_13 dn_18_13 WL18 SL13 VSS sky130_fd_pr__nfet_g5v0d10v5 w=1 l=0.5
XRn_18_13 BLN13 dn_18_13 sky130_fd_pr_reram__reram_cell area_ox=0.0676
XMp_18_14 dp_18_14 WL18 SL14 VSS sky130_fd_pr__nfet_g5v0d10v5 w=1 l=0.5
XRp_18_14 BLP14 dp_18_14 sky130_fd_pr_reram__reram_cell area_ox=0.0676
XMn_18_14 dn_18_14 WL18 SL14 VSS sky130_fd_pr__nfet_g5v0d10v5 w=1 l=0.5
XRn_18_14 BLN14 dn_18_14 sky130_fd_pr_reram__reram_cell area_ox=0.0676
XMp_18_15 dp_18_15 WL18 SL15 VSS sky130_fd_pr__nfet_g5v0d10v5 w=1 l=0.5
XRp_18_15 BLP15 dp_18_15 sky130_fd_pr_reram__reram_cell area_ox=0.0676
XMn_18_15 dn_18_15 WL18 SL15 VSS sky130_fd_pr__nfet_g5v0d10v5 w=1 l=0.5
XRn_18_15 BLN15 dn_18_15 sky130_fd_pr_reram__reram_cell area_ox=0.0676
XMp_18_16 dp_18_16 WL18 SL16 VSS sky130_fd_pr__nfet_g5v0d10v5 w=1 l=0.5
XRp_18_16 BLP16 dp_18_16 sky130_fd_pr_reram__reram_cell area_ox=0.0676
XMn_18_16 dn_18_16 WL18 SL16 VSS sky130_fd_pr__nfet_g5v0d10v5 w=1 l=0.5
XRn_18_16 BLN16 dn_18_16 sky130_fd_pr_reram__reram_cell area_ox=0.0676
XMp_18_17 dp_18_17 WL18 SL17 VSS sky130_fd_pr__nfet_g5v0d10v5 w=1 l=0.5
XRp_18_17 BLP17 dp_18_17 sky130_fd_pr_reram__reram_cell area_ox=0.0676
XMn_18_17 dn_18_17 WL18 SL17 VSS sky130_fd_pr__nfet_g5v0d10v5 w=1 l=0.5
XRn_18_17 BLN17 dn_18_17 sky130_fd_pr_reram__reram_cell area_ox=0.0676
XMp_18_18 dp_18_18 WL18 SL18 VSS sky130_fd_pr__nfet_g5v0d10v5 w=1 l=0.5
XRp_18_18 BLP18 dp_18_18 sky130_fd_pr_reram__reram_cell area_ox=0.0676
XMn_18_18 dn_18_18 WL18 SL18 VSS sky130_fd_pr__nfet_g5v0d10v5 w=1 l=0.5
XRn_18_18 BLN18 dn_18_18 sky130_fd_pr_reram__reram_cell area_ox=0.0676
XMp_18_19 dp_18_19 WL18 SL19 VSS sky130_fd_pr__nfet_g5v0d10v5 w=1 l=0.5
XRp_18_19 BLP19 dp_18_19 sky130_fd_pr_reram__reram_cell area_ox=0.0676
XMn_18_19 dn_18_19 WL18 SL19 VSS sky130_fd_pr__nfet_g5v0d10v5 w=1 l=0.5
XRn_18_19 BLN19 dn_18_19 sky130_fd_pr_reram__reram_cell area_ox=0.0676
XMp_18_20 dp_18_20 WL18 SL20 VSS sky130_fd_pr__nfet_g5v0d10v5 w=1 l=0.5
XRp_18_20 BLP20 dp_18_20 sky130_fd_pr_reram__reram_cell area_ox=0.0676
XMn_18_20 dn_18_20 WL18 SL20 VSS sky130_fd_pr__nfet_g5v0d10v5 w=1 l=0.5
XRn_18_20 BLN20 dn_18_20 sky130_fd_pr_reram__reram_cell area_ox=0.0676
XMp_18_21 dp_18_21 WL18 SL21 VSS sky130_fd_pr__nfet_g5v0d10v5 w=1 l=0.5
XRp_18_21 BLP21 dp_18_21 sky130_fd_pr_reram__reram_cell area_ox=0.0676
XMn_18_21 dn_18_21 WL18 SL21 VSS sky130_fd_pr__nfet_g5v0d10v5 w=1 l=0.5
XRn_18_21 BLN21 dn_18_21 sky130_fd_pr_reram__reram_cell area_ox=0.0676
XMp_18_22 dp_18_22 WL18 SL22 VSS sky130_fd_pr__nfet_g5v0d10v5 w=1 l=0.5
XRp_18_22 BLP22 dp_18_22 sky130_fd_pr_reram__reram_cell area_ox=0.0676
XMn_18_22 dn_18_22 WL18 SL22 VSS sky130_fd_pr__nfet_g5v0d10v5 w=1 l=0.5
XRn_18_22 BLN22 dn_18_22 sky130_fd_pr_reram__reram_cell area_ox=0.0676
XMp_18_23 dp_18_23 WL18 SL23 VSS sky130_fd_pr__nfet_g5v0d10v5 w=1 l=0.5
XRp_18_23 BLP23 dp_18_23 sky130_fd_pr_reram__reram_cell area_ox=0.0676
XMn_18_23 dn_18_23 WL18 SL23 VSS sky130_fd_pr__nfet_g5v0d10v5 w=1 l=0.5
XRn_18_23 BLN23 dn_18_23 sky130_fd_pr_reram__reram_cell area_ox=0.0676
XMp_19_0 dp_19_0 WL19 SL0 VSS sky130_fd_pr__nfet_g5v0d10v5 w=1 l=0.5
XRp_19_0 BLP0 dp_19_0 sky130_fd_pr_reram__reram_cell area_ox=0.0676
XMn_19_0 dn_19_0 WL19 SL0 VSS sky130_fd_pr__nfet_g5v0d10v5 w=1 l=0.5
XRn_19_0 BLN0 dn_19_0 sky130_fd_pr_reram__reram_cell area_ox=0.0676
XMp_19_1 dp_19_1 WL19 SL1 VSS sky130_fd_pr__nfet_g5v0d10v5 w=1 l=0.5
XRp_19_1 BLP1 dp_19_1 sky130_fd_pr_reram__reram_cell area_ox=0.0676
XMn_19_1 dn_19_1 WL19 SL1 VSS sky130_fd_pr__nfet_g5v0d10v5 w=1 l=0.5
XRn_19_1 BLN1 dn_19_1 sky130_fd_pr_reram__reram_cell area_ox=0.0676
XMp_19_2 dp_19_2 WL19 SL2 VSS sky130_fd_pr__nfet_g5v0d10v5 w=1 l=0.5
XRp_19_2 BLP2 dp_19_2 sky130_fd_pr_reram__reram_cell area_ox=0.0676
XMn_19_2 dn_19_2 WL19 SL2 VSS sky130_fd_pr__nfet_g5v0d10v5 w=1 l=0.5
XRn_19_2 BLN2 dn_19_2 sky130_fd_pr_reram__reram_cell area_ox=0.0676
XMp_19_3 dp_19_3 WL19 SL3 VSS sky130_fd_pr__nfet_g5v0d10v5 w=1 l=0.5
XRp_19_3 BLP3 dp_19_3 sky130_fd_pr_reram__reram_cell area_ox=0.0676
XMn_19_3 dn_19_3 WL19 SL3 VSS sky130_fd_pr__nfet_g5v0d10v5 w=1 l=0.5
XRn_19_3 BLN3 dn_19_3 sky130_fd_pr_reram__reram_cell area_ox=0.0676
XMp_19_4 dp_19_4 WL19 SL4 VSS sky130_fd_pr__nfet_g5v0d10v5 w=1 l=0.5
XRp_19_4 BLP4 dp_19_4 sky130_fd_pr_reram__reram_cell area_ox=0.0676
XMn_19_4 dn_19_4 WL19 SL4 VSS sky130_fd_pr__nfet_g5v0d10v5 w=1 l=0.5
XRn_19_4 BLN4 dn_19_4 sky130_fd_pr_reram__reram_cell area_ox=0.0676
XMp_19_5 dp_19_5 WL19 SL5 VSS sky130_fd_pr__nfet_g5v0d10v5 w=1 l=0.5
XRp_19_5 BLP5 dp_19_5 sky130_fd_pr_reram__reram_cell area_ox=0.0676
XMn_19_5 dn_19_5 WL19 SL5 VSS sky130_fd_pr__nfet_g5v0d10v5 w=1 l=0.5
XRn_19_5 BLN5 dn_19_5 sky130_fd_pr_reram__reram_cell area_ox=0.0676
XMp_19_6 dp_19_6 WL19 SL6 VSS sky130_fd_pr__nfet_g5v0d10v5 w=1 l=0.5
XRp_19_6 BLP6 dp_19_6 sky130_fd_pr_reram__reram_cell area_ox=0.0676
XMn_19_6 dn_19_6 WL19 SL6 VSS sky130_fd_pr__nfet_g5v0d10v5 w=1 l=0.5
XRn_19_6 BLN6 dn_19_6 sky130_fd_pr_reram__reram_cell area_ox=0.0676
XMp_19_7 dp_19_7 WL19 SL7 VSS sky130_fd_pr__nfet_g5v0d10v5 w=1 l=0.5
XRp_19_7 BLP7 dp_19_7 sky130_fd_pr_reram__reram_cell area_ox=0.0676
XMn_19_7 dn_19_7 WL19 SL7 VSS sky130_fd_pr__nfet_g5v0d10v5 w=1 l=0.5
XRn_19_7 BLN7 dn_19_7 sky130_fd_pr_reram__reram_cell area_ox=0.0676
XMp_19_8 dp_19_8 WL19 SL8 VSS sky130_fd_pr__nfet_g5v0d10v5 w=1 l=0.5
XRp_19_8 BLP8 dp_19_8 sky130_fd_pr_reram__reram_cell area_ox=0.0676
XMn_19_8 dn_19_8 WL19 SL8 VSS sky130_fd_pr__nfet_g5v0d10v5 w=1 l=0.5
XRn_19_8 BLN8 dn_19_8 sky130_fd_pr_reram__reram_cell area_ox=0.0676
XMp_19_9 dp_19_9 WL19 SL9 VSS sky130_fd_pr__nfet_g5v0d10v5 w=1 l=0.5
XRp_19_9 BLP9 dp_19_9 sky130_fd_pr_reram__reram_cell area_ox=0.0676
XMn_19_9 dn_19_9 WL19 SL9 VSS sky130_fd_pr__nfet_g5v0d10v5 w=1 l=0.5
XRn_19_9 BLN9 dn_19_9 sky130_fd_pr_reram__reram_cell area_ox=0.0676
XMp_19_10 dp_19_10 WL19 SL10 VSS sky130_fd_pr__nfet_g5v0d10v5 w=1 l=0.5
XRp_19_10 BLP10 dp_19_10 sky130_fd_pr_reram__reram_cell area_ox=0.0676
XMn_19_10 dn_19_10 WL19 SL10 VSS sky130_fd_pr__nfet_g5v0d10v5 w=1 l=0.5
XRn_19_10 BLN10 dn_19_10 sky130_fd_pr_reram__reram_cell area_ox=0.0676
XMp_19_11 dp_19_11 WL19 SL11 VSS sky130_fd_pr__nfet_g5v0d10v5 w=1 l=0.5
XRp_19_11 BLP11 dp_19_11 sky130_fd_pr_reram__reram_cell area_ox=0.0676
XMn_19_11 dn_19_11 WL19 SL11 VSS sky130_fd_pr__nfet_g5v0d10v5 w=1 l=0.5
XRn_19_11 BLN11 dn_19_11 sky130_fd_pr_reram__reram_cell area_ox=0.0676
XMp_19_12 dp_19_12 WL19 SL12 VSS sky130_fd_pr__nfet_g5v0d10v5 w=1 l=0.5
XRp_19_12 BLP12 dp_19_12 sky130_fd_pr_reram__reram_cell area_ox=0.0676
XMn_19_12 dn_19_12 WL19 SL12 VSS sky130_fd_pr__nfet_g5v0d10v5 w=1 l=0.5
XRn_19_12 BLN12 dn_19_12 sky130_fd_pr_reram__reram_cell area_ox=0.0676
XMp_19_13 dp_19_13 WL19 SL13 VSS sky130_fd_pr__nfet_g5v0d10v5 w=1 l=0.5
XRp_19_13 BLP13 dp_19_13 sky130_fd_pr_reram__reram_cell area_ox=0.0676
XMn_19_13 dn_19_13 WL19 SL13 VSS sky130_fd_pr__nfet_g5v0d10v5 w=1 l=0.5
XRn_19_13 BLN13 dn_19_13 sky130_fd_pr_reram__reram_cell area_ox=0.0676
XMp_19_14 dp_19_14 WL19 SL14 VSS sky130_fd_pr__nfet_g5v0d10v5 w=1 l=0.5
XRp_19_14 BLP14 dp_19_14 sky130_fd_pr_reram__reram_cell area_ox=0.0676
XMn_19_14 dn_19_14 WL19 SL14 VSS sky130_fd_pr__nfet_g5v0d10v5 w=1 l=0.5
XRn_19_14 BLN14 dn_19_14 sky130_fd_pr_reram__reram_cell area_ox=0.0676
XMp_19_15 dp_19_15 WL19 SL15 VSS sky130_fd_pr__nfet_g5v0d10v5 w=1 l=0.5
XRp_19_15 BLP15 dp_19_15 sky130_fd_pr_reram__reram_cell area_ox=0.0676
XMn_19_15 dn_19_15 WL19 SL15 VSS sky130_fd_pr__nfet_g5v0d10v5 w=1 l=0.5
XRn_19_15 BLN15 dn_19_15 sky130_fd_pr_reram__reram_cell area_ox=0.0676
XMp_19_16 dp_19_16 WL19 SL16 VSS sky130_fd_pr__nfet_g5v0d10v5 w=1 l=0.5
XRp_19_16 BLP16 dp_19_16 sky130_fd_pr_reram__reram_cell area_ox=0.0676
XMn_19_16 dn_19_16 WL19 SL16 VSS sky130_fd_pr__nfet_g5v0d10v5 w=1 l=0.5
XRn_19_16 BLN16 dn_19_16 sky130_fd_pr_reram__reram_cell area_ox=0.0676
XMp_19_17 dp_19_17 WL19 SL17 VSS sky130_fd_pr__nfet_g5v0d10v5 w=1 l=0.5
XRp_19_17 BLP17 dp_19_17 sky130_fd_pr_reram__reram_cell area_ox=0.0676
XMn_19_17 dn_19_17 WL19 SL17 VSS sky130_fd_pr__nfet_g5v0d10v5 w=1 l=0.5
XRn_19_17 BLN17 dn_19_17 sky130_fd_pr_reram__reram_cell area_ox=0.0676
XMp_19_18 dp_19_18 WL19 SL18 VSS sky130_fd_pr__nfet_g5v0d10v5 w=1 l=0.5
XRp_19_18 BLP18 dp_19_18 sky130_fd_pr_reram__reram_cell area_ox=0.0676
XMn_19_18 dn_19_18 WL19 SL18 VSS sky130_fd_pr__nfet_g5v0d10v5 w=1 l=0.5
XRn_19_18 BLN18 dn_19_18 sky130_fd_pr_reram__reram_cell area_ox=0.0676
XMp_19_19 dp_19_19 WL19 SL19 VSS sky130_fd_pr__nfet_g5v0d10v5 w=1 l=0.5
XRp_19_19 BLP19 dp_19_19 sky130_fd_pr_reram__reram_cell area_ox=0.0676
XMn_19_19 dn_19_19 WL19 SL19 VSS sky130_fd_pr__nfet_g5v0d10v5 w=1 l=0.5
XRn_19_19 BLN19 dn_19_19 sky130_fd_pr_reram__reram_cell area_ox=0.0676
XMp_19_20 dp_19_20 WL19 SL20 VSS sky130_fd_pr__nfet_g5v0d10v5 w=1 l=0.5
XRp_19_20 BLP20 dp_19_20 sky130_fd_pr_reram__reram_cell area_ox=0.0676
XMn_19_20 dn_19_20 WL19 SL20 VSS sky130_fd_pr__nfet_g5v0d10v5 w=1 l=0.5
XRn_19_20 BLN20 dn_19_20 sky130_fd_pr_reram__reram_cell area_ox=0.0676
XMp_19_21 dp_19_21 WL19 SL21 VSS sky130_fd_pr__nfet_g5v0d10v5 w=1 l=0.5
XRp_19_21 BLP21 dp_19_21 sky130_fd_pr_reram__reram_cell area_ox=0.0676
XMn_19_21 dn_19_21 WL19 SL21 VSS sky130_fd_pr__nfet_g5v0d10v5 w=1 l=0.5
XRn_19_21 BLN21 dn_19_21 sky130_fd_pr_reram__reram_cell area_ox=0.0676
XMp_19_22 dp_19_22 WL19 SL22 VSS sky130_fd_pr__nfet_g5v0d10v5 w=1 l=0.5
XRp_19_22 BLP22 dp_19_22 sky130_fd_pr_reram__reram_cell area_ox=0.0676
XMn_19_22 dn_19_22 WL19 SL22 VSS sky130_fd_pr__nfet_g5v0d10v5 w=1 l=0.5
XRn_19_22 BLN22 dn_19_22 sky130_fd_pr_reram__reram_cell area_ox=0.0676
XMp_19_23 dp_19_23 WL19 SL23 VSS sky130_fd_pr__nfet_g5v0d10v5 w=1 l=0.5
XRp_19_23 BLP23 dp_19_23 sky130_fd_pr_reram__reram_cell area_ox=0.0676
XMn_19_23 dn_19_23 WL19 SL23 VSS sky130_fd_pr__nfet_g5v0d10v5 w=1 l=0.5
XRn_19_23 BLN23 dn_19_23 sky130_fd_pr_reram__reram_cell area_ox=0.0676
XMp_20_0 dp_20_0 WL20 SL0 VSS sky130_fd_pr__nfet_g5v0d10v5 w=1 l=0.5
XRp_20_0 BLP0 dp_20_0 sky130_fd_pr_reram__reram_cell area_ox=0.0676
XMn_20_0 dn_20_0 WL20 SL0 VSS sky130_fd_pr__nfet_g5v0d10v5 w=1 l=0.5
XRn_20_0 BLN0 dn_20_0 sky130_fd_pr_reram__reram_cell area_ox=0.0676
XMp_20_1 dp_20_1 WL20 SL1 VSS sky130_fd_pr__nfet_g5v0d10v5 w=1 l=0.5
XRp_20_1 BLP1 dp_20_1 sky130_fd_pr_reram__reram_cell area_ox=0.0676
XMn_20_1 dn_20_1 WL20 SL1 VSS sky130_fd_pr__nfet_g5v0d10v5 w=1 l=0.5
XRn_20_1 BLN1 dn_20_1 sky130_fd_pr_reram__reram_cell area_ox=0.0676
XMp_20_2 dp_20_2 WL20 SL2 VSS sky130_fd_pr__nfet_g5v0d10v5 w=1 l=0.5
XRp_20_2 BLP2 dp_20_2 sky130_fd_pr_reram__reram_cell area_ox=0.0676
XMn_20_2 dn_20_2 WL20 SL2 VSS sky130_fd_pr__nfet_g5v0d10v5 w=1 l=0.5
XRn_20_2 BLN2 dn_20_2 sky130_fd_pr_reram__reram_cell area_ox=0.0676
XMp_20_3 dp_20_3 WL20 SL3 VSS sky130_fd_pr__nfet_g5v0d10v5 w=1 l=0.5
XRp_20_3 BLP3 dp_20_3 sky130_fd_pr_reram__reram_cell area_ox=0.0676
XMn_20_3 dn_20_3 WL20 SL3 VSS sky130_fd_pr__nfet_g5v0d10v5 w=1 l=0.5
XRn_20_3 BLN3 dn_20_3 sky130_fd_pr_reram__reram_cell area_ox=0.0676
XMp_20_4 dp_20_4 WL20 SL4 VSS sky130_fd_pr__nfet_g5v0d10v5 w=1 l=0.5
XRp_20_4 BLP4 dp_20_4 sky130_fd_pr_reram__reram_cell area_ox=0.0676
XMn_20_4 dn_20_4 WL20 SL4 VSS sky130_fd_pr__nfet_g5v0d10v5 w=1 l=0.5
XRn_20_4 BLN4 dn_20_4 sky130_fd_pr_reram__reram_cell area_ox=0.0676
XMp_20_5 dp_20_5 WL20 SL5 VSS sky130_fd_pr__nfet_g5v0d10v5 w=1 l=0.5
XRp_20_5 BLP5 dp_20_5 sky130_fd_pr_reram__reram_cell area_ox=0.0676
XMn_20_5 dn_20_5 WL20 SL5 VSS sky130_fd_pr__nfet_g5v0d10v5 w=1 l=0.5
XRn_20_5 BLN5 dn_20_5 sky130_fd_pr_reram__reram_cell area_ox=0.0676
XMp_20_6 dp_20_6 WL20 SL6 VSS sky130_fd_pr__nfet_g5v0d10v5 w=1 l=0.5
XRp_20_6 BLP6 dp_20_6 sky130_fd_pr_reram__reram_cell area_ox=0.0676
XMn_20_6 dn_20_6 WL20 SL6 VSS sky130_fd_pr__nfet_g5v0d10v5 w=1 l=0.5
XRn_20_6 BLN6 dn_20_6 sky130_fd_pr_reram__reram_cell area_ox=0.0676
XMp_20_7 dp_20_7 WL20 SL7 VSS sky130_fd_pr__nfet_g5v0d10v5 w=1 l=0.5
XRp_20_7 BLP7 dp_20_7 sky130_fd_pr_reram__reram_cell area_ox=0.0676
XMn_20_7 dn_20_7 WL20 SL7 VSS sky130_fd_pr__nfet_g5v0d10v5 w=1 l=0.5
XRn_20_7 BLN7 dn_20_7 sky130_fd_pr_reram__reram_cell area_ox=0.0676
XMp_20_8 dp_20_8 WL20 SL8 VSS sky130_fd_pr__nfet_g5v0d10v5 w=1 l=0.5
XRp_20_8 BLP8 dp_20_8 sky130_fd_pr_reram__reram_cell area_ox=0.0676
XMn_20_8 dn_20_8 WL20 SL8 VSS sky130_fd_pr__nfet_g5v0d10v5 w=1 l=0.5
XRn_20_8 BLN8 dn_20_8 sky130_fd_pr_reram__reram_cell area_ox=0.0676
XMp_20_9 dp_20_9 WL20 SL9 VSS sky130_fd_pr__nfet_g5v0d10v5 w=1 l=0.5
XRp_20_9 BLP9 dp_20_9 sky130_fd_pr_reram__reram_cell area_ox=0.0676
XMn_20_9 dn_20_9 WL20 SL9 VSS sky130_fd_pr__nfet_g5v0d10v5 w=1 l=0.5
XRn_20_9 BLN9 dn_20_9 sky130_fd_pr_reram__reram_cell area_ox=0.0676
XMp_20_10 dp_20_10 WL20 SL10 VSS sky130_fd_pr__nfet_g5v0d10v5 w=1 l=0.5
XRp_20_10 BLP10 dp_20_10 sky130_fd_pr_reram__reram_cell area_ox=0.0676
XMn_20_10 dn_20_10 WL20 SL10 VSS sky130_fd_pr__nfet_g5v0d10v5 w=1 l=0.5
XRn_20_10 BLN10 dn_20_10 sky130_fd_pr_reram__reram_cell area_ox=0.0676
XMp_20_11 dp_20_11 WL20 SL11 VSS sky130_fd_pr__nfet_g5v0d10v5 w=1 l=0.5
XRp_20_11 BLP11 dp_20_11 sky130_fd_pr_reram__reram_cell area_ox=0.0676
XMn_20_11 dn_20_11 WL20 SL11 VSS sky130_fd_pr__nfet_g5v0d10v5 w=1 l=0.5
XRn_20_11 BLN11 dn_20_11 sky130_fd_pr_reram__reram_cell area_ox=0.0676
XMp_20_12 dp_20_12 WL20 SL12 VSS sky130_fd_pr__nfet_g5v0d10v5 w=1 l=0.5
XRp_20_12 BLP12 dp_20_12 sky130_fd_pr_reram__reram_cell area_ox=0.0676
XMn_20_12 dn_20_12 WL20 SL12 VSS sky130_fd_pr__nfet_g5v0d10v5 w=1 l=0.5
XRn_20_12 BLN12 dn_20_12 sky130_fd_pr_reram__reram_cell area_ox=0.0676
XMp_20_13 dp_20_13 WL20 SL13 VSS sky130_fd_pr__nfet_g5v0d10v5 w=1 l=0.5
XRp_20_13 BLP13 dp_20_13 sky130_fd_pr_reram__reram_cell area_ox=0.0676
XMn_20_13 dn_20_13 WL20 SL13 VSS sky130_fd_pr__nfet_g5v0d10v5 w=1 l=0.5
XRn_20_13 BLN13 dn_20_13 sky130_fd_pr_reram__reram_cell area_ox=0.0676
XMp_20_14 dp_20_14 WL20 SL14 VSS sky130_fd_pr__nfet_g5v0d10v5 w=1 l=0.5
XRp_20_14 BLP14 dp_20_14 sky130_fd_pr_reram__reram_cell area_ox=0.0676
XMn_20_14 dn_20_14 WL20 SL14 VSS sky130_fd_pr__nfet_g5v0d10v5 w=1 l=0.5
XRn_20_14 BLN14 dn_20_14 sky130_fd_pr_reram__reram_cell area_ox=0.0676
XMp_20_15 dp_20_15 WL20 SL15 VSS sky130_fd_pr__nfet_g5v0d10v5 w=1 l=0.5
XRp_20_15 BLP15 dp_20_15 sky130_fd_pr_reram__reram_cell area_ox=0.0676
XMn_20_15 dn_20_15 WL20 SL15 VSS sky130_fd_pr__nfet_g5v0d10v5 w=1 l=0.5
XRn_20_15 BLN15 dn_20_15 sky130_fd_pr_reram__reram_cell area_ox=0.0676
XMp_20_16 dp_20_16 WL20 SL16 VSS sky130_fd_pr__nfet_g5v0d10v5 w=1 l=0.5
XRp_20_16 BLP16 dp_20_16 sky130_fd_pr_reram__reram_cell area_ox=0.0676
XMn_20_16 dn_20_16 WL20 SL16 VSS sky130_fd_pr__nfet_g5v0d10v5 w=1 l=0.5
XRn_20_16 BLN16 dn_20_16 sky130_fd_pr_reram__reram_cell area_ox=0.0676
XMp_20_17 dp_20_17 WL20 SL17 VSS sky130_fd_pr__nfet_g5v0d10v5 w=1 l=0.5
XRp_20_17 BLP17 dp_20_17 sky130_fd_pr_reram__reram_cell area_ox=0.0676
XMn_20_17 dn_20_17 WL20 SL17 VSS sky130_fd_pr__nfet_g5v0d10v5 w=1 l=0.5
XRn_20_17 BLN17 dn_20_17 sky130_fd_pr_reram__reram_cell area_ox=0.0676
XMp_20_18 dp_20_18 WL20 SL18 VSS sky130_fd_pr__nfet_g5v0d10v5 w=1 l=0.5
XRp_20_18 BLP18 dp_20_18 sky130_fd_pr_reram__reram_cell area_ox=0.0676
XMn_20_18 dn_20_18 WL20 SL18 VSS sky130_fd_pr__nfet_g5v0d10v5 w=1 l=0.5
XRn_20_18 BLN18 dn_20_18 sky130_fd_pr_reram__reram_cell area_ox=0.0676
XMp_20_19 dp_20_19 WL20 SL19 VSS sky130_fd_pr__nfet_g5v0d10v5 w=1 l=0.5
XRp_20_19 BLP19 dp_20_19 sky130_fd_pr_reram__reram_cell area_ox=0.0676
XMn_20_19 dn_20_19 WL20 SL19 VSS sky130_fd_pr__nfet_g5v0d10v5 w=1 l=0.5
XRn_20_19 BLN19 dn_20_19 sky130_fd_pr_reram__reram_cell area_ox=0.0676
XMp_20_20 dp_20_20 WL20 SL20 VSS sky130_fd_pr__nfet_g5v0d10v5 w=1 l=0.5
XRp_20_20 BLP20 dp_20_20 sky130_fd_pr_reram__reram_cell area_ox=0.0676
XMn_20_20 dn_20_20 WL20 SL20 VSS sky130_fd_pr__nfet_g5v0d10v5 w=1 l=0.5
XRn_20_20 BLN20 dn_20_20 sky130_fd_pr_reram__reram_cell area_ox=0.0676
XMp_20_21 dp_20_21 WL20 SL21 VSS sky130_fd_pr__nfet_g5v0d10v5 w=1 l=0.5
XRp_20_21 BLP21 dp_20_21 sky130_fd_pr_reram__reram_cell area_ox=0.0676
XMn_20_21 dn_20_21 WL20 SL21 VSS sky130_fd_pr__nfet_g5v0d10v5 w=1 l=0.5
XRn_20_21 BLN21 dn_20_21 sky130_fd_pr_reram__reram_cell area_ox=0.0676
XMp_20_22 dp_20_22 WL20 SL22 VSS sky130_fd_pr__nfet_g5v0d10v5 w=1 l=0.5
XRp_20_22 BLP22 dp_20_22 sky130_fd_pr_reram__reram_cell area_ox=0.0676
XMn_20_22 dn_20_22 WL20 SL22 VSS sky130_fd_pr__nfet_g5v0d10v5 w=1 l=0.5
XRn_20_22 BLN22 dn_20_22 sky130_fd_pr_reram__reram_cell area_ox=0.0676
XMp_20_23 dp_20_23 WL20 SL23 VSS sky130_fd_pr__nfet_g5v0d10v5 w=1 l=0.5
XRp_20_23 BLP23 dp_20_23 sky130_fd_pr_reram__reram_cell area_ox=0.0676
XMn_20_23 dn_20_23 WL20 SL23 VSS sky130_fd_pr__nfet_g5v0d10v5 w=1 l=0.5
XRn_20_23 BLN23 dn_20_23 sky130_fd_pr_reram__reram_cell area_ox=0.0676
XMp_21_0 dp_21_0 WL21 SL0 VSS sky130_fd_pr__nfet_g5v0d10v5 w=1 l=0.5
XRp_21_0 BLP0 dp_21_0 sky130_fd_pr_reram__reram_cell area_ox=0.0676
XMn_21_0 dn_21_0 WL21 SL0 VSS sky130_fd_pr__nfet_g5v0d10v5 w=1 l=0.5
XRn_21_0 BLN0 dn_21_0 sky130_fd_pr_reram__reram_cell area_ox=0.0676
XMp_21_1 dp_21_1 WL21 SL1 VSS sky130_fd_pr__nfet_g5v0d10v5 w=1 l=0.5
XRp_21_1 BLP1 dp_21_1 sky130_fd_pr_reram__reram_cell area_ox=0.0676
XMn_21_1 dn_21_1 WL21 SL1 VSS sky130_fd_pr__nfet_g5v0d10v5 w=1 l=0.5
XRn_21_1 BLN1 dn_21_1 sky130_fd_pr_reram__reram_cell area_ox=0.0676
XMp_21_2 dp_21_2 WL21 SL2 VSS sky130_fd_pr__nfet_g5v0d10v5 w=1 l=0.5
XRp_21_2 BLP2 dp_21_2 sky130_fd_pr_reram__reram_cell area_ox=0.0676
XMn_21_2 dn_21_2 WL21 SL2 VSS sky130_fd_pr__nfet_g5v0d10v5 w=1 l=0.5
XRn_21_2 BLN2 dn_21_2 sky130_fd_pr_reram__reram_cell area_ox=0.0676
XMp_21_3 dp_21_3 WL21 SL3 VSS sky130_fd_pr__nfet_g5v0d10v5 w=1 l=0.5
XRp_21_3 BLP3 dp_21_3 sky130_fd_pr_reram__reram_cell area_ox=0.0676
XMn_21_3 dn_21_3 WL21 SL3 VSS sky130_fd_pr__nfet_g5v0d10v5 w=1 l=0.5
XRn_21_3 BLN3 dn_21_3 sky130_fd_pr_reram__reram_cell area_ox=0.0676
XMp_21_4 dp_21_4 WL21 SL4 VSS sky130_fd_pr__nfet_g5v0d10v5 w=1 l=0.5
XRp_21_4 BLP4 dp_21_4 sky130_fd_pr_reram__reram_cell area_ox=0.0676
XMn_21_4 dn_21_4 WL21 SL4 VSS sky130_fd_pr__nfet_g5v0d10v5 w=1 l=0.5
XRn_21_4 BLN4 dn_21_4 sky130_fd_pr_reram__reram_cell area_ox=0.0676
XMp_21_5 dp_21_5 WL21 SL5 VSS sky130_fd_pr__nfet_g5v0d10v5 w=1 l=0.5
XRp_21_5 BLP5 dp_21_5 sky130_fd_pr_reram__reram_cell area_ox=0.0676
XMn_21_5 dn_21_5 WL21 SL5 VSS sky130_fd_pr__nfet_g5v0d10v5 w=1 l=0.5
XRn_21_5 BLN5 dn_21_5 sky130_fd_pr_reram__reram_cell area_ox=0.0676
XMp_21_6 dp_21_6 WL21 SL6 VSS sky130_fd_pr__nfet_g5v0d10v5 w=1 l=0.5
XRp_21_6 BLP6 dp_21_6 sky130_fd_pr_reram__reram_cell area_ox=0.0676
XMn_21_6 dn_21_6 WL21 SL6 VSS sky130_fd_pr__nfet_g5v0d10v5 w=1 l=0.5
XRn_21_6 BLN6 dn_21_6 sky130_fd_pr_reram__reram_cell area_ox=0.0676
XMp_21_7 dp_21_7 WL21 SL7 VSS sky130_fd_pr__nfet_g5v0d10v5 w=1 l=0.5
XRp_21_7 BLP7 dp_21_7 sky130_fd_pr_reram__reram_cell area_ox=0.0676
XMn_21_7 dn_21_7 WL21 SL7 VSS sky130_fd_pr__nfet_g5v0d10v5 w=1 l=0.5
XRn_21_7 BLN7 dn_21_7 sky130_fd_pr_reram__reram_cell area_ox=0.0676
XMp_21_8 dp_21_8 WL21 SL8 VSS sky130_fd_pr__nfet_g5v0d10v5 w=1 l=0.5
XRp_21_8 BLP8 dp_21_8 sky130_fd_pr_reram__reram_cell area_ox=0.0676
XMn_21_8 dn_21_8 WL21 SL8 VSS sky130_fd_pr__nfet_g5v0d10v5 w=1 l=0.5
XRn_21_8 BLN8 dn_21_8 sky130_fd_pr_reram__reram_cell area_ox=0.0676
XMp_21_9 dp_21_9 WL21 SL9 VSS sky130_fd_pr__nfet_g5v0d10v5 w=1 l=0.5
XRp_21_9 BLP9 dp_21_9 sky130_fd_pr_reram__reram_cell area_ox=0.0676
XMn_21_9 dn_21_9 WL21 SL9 VSS sky130_fd_pr__nfet_g5v0d10v5 w=1 l=0.5
XRn_21_9 BLN9 dn_21_9 sky130_fd_pr_reram__reram_cell area_ox=0.0676
XMp_21_10 dp_21_10 WL21 SL10 VSS sky130_fd_pr__nfet_g5v0d10v5 w=1 l=0.5
XRp_21_10 BLP10 dp_21_10 sky130_fd_pr_reram__reram_cell area_ox=0.0676
XMn_21_10 dn_21_10 WL21 SL10 VSS sky130_fd_pr__nfet_g5v0d10v5 w=1 l=0.5
XRn_21_10 BLN10 dn_21_10 sky130_fd_pr_reram__reram_cell area_ox=0.0676
XMp_21_11 dp_21_11 WL21 SL11 VSS sky130_fd_pr__nfet_g5v0d10v5 w=1 l=0.5
XRp_21_11 BLP11 dp_21_11 sky130_fd_pr_reram__reram_cell area_ox=0.0676
XMn_21_11 dn_21_11 WL21 SL11 VSS sky130_fd_pr__nfet_g5v0d10v5 w=1 l=0.5
XRn_21_11 BLN11 dn_21_11 sky130_fd_pr_reram__reram_cell area_ox=0.0676
XMp_21_12 dp_21_12 WL21 SL12 VSS sky130_fd_pr__nfet_g5v0d10v5 w=1 l=0.5
XRp_21_12 BLP12 dp_21_12 sky130_fd_pr_reram__reram_cell area_ox=0.0676
XMn_21_12 dn_21_12 WL21 SL12 VSS sky130_fd_pr__nfet_g5v0d10v5 w=1 l=0.5
XRn_21_12 BLN12 dn_21_12 sky130_fd_pr_reram__reram_cell area_ox=0.0676
XMp_21_13 dp_21_13 WL21 SL13 VSS sky130_fd_pr__nfet_g5v0d10v5 w=1 l=0.5
XRp_21_13 BLP13 dp_21_13 sky130_fd_pr_reram__reram_cell area_ox=0.0676
XMn_21_13 dn_21_13 WL21 SL13 VSS sky130_fd_pr__nfet_g5v0d10v5 w=1 l=0.5
XRn_21_13 BLN13 dn_21_13 sky130_fd_pr_reram__reram_cell area_ox=0.0676
XMp_21_14 dp_21_14 WL21 SL14 VSS sky130_fd_pr__nfet_g5v0d10v5 w=1 l=0.5
XRp_21_14 BLP14 dp_21_14 sky130_fd_pr_reram__reram_cell area_ox=0.0676
XMn_21_14 dn_21_14 WL21 SL14 VSS sky130_fd_pr__nfet_g5v0d10v5 w=1 l=0.5
XRn_21_14 BLN14 dn_21_14 sky130_fd_pr_reram__reram_cell area_ox=0.0676
XMp_21_15 dp_21_15 WL21 SL15 VSS sky130_fd_pr__nfet_g5v0d10v5 w=1 l=0.5
XRp_21_15 BLP15 dp_21_15 sky130_fd_pr_reram__reram_cell area_ox=0.0676
XMn_21_15 dn_21_15 WL21 SL15 VSS sky130_fd_pr__nfet_g5v0d10v5 w=1 l=0.5
XRn_21_15 BLN15 dn_21_15 sky130_fd_pr_reram__reram_cell area_ox=0.0676
XMp_21_16 dp_21_16 WL21 SL16 VSS sky130_fd_pr__nfet_g5v0d10v5 w=1 l=0.5
XRp_21_16 BLP16 dp_21_16 sky130_fd_pr_reram__reram_cell area_ox=0.0676
XMn_21_16 dn_21_16 WL21 SL16 VSS sky130_fd_pr__nfet_g5v0d10v5 w=1 l=0.5
XRn_21_16 BLN16 dn_21_16 sky130_fd_pr_reram__reram_cell area_ox=0.0676
XMp_21_17 dp_21_17 WL21 SL17 VSS sky130_fd_pr__nfet_g5v0d10v5 w=1 l=0.5
XRp_21_17 BLP17 dp_21_17 sky130_fd_pr_reram__reram_cell area_ox=0.0676
XMn_21_17 dn_21_17 WL21 SL17 VSS sky130_fd_pr__nfet_g5v0d10v5 w=1 l=0.5
XRn_21_17 BLN17 dn_21_17 sky130_fd_pr_reram__reram_cell area_ox=0.0676
XMp_21_18 dp_21_18 WL21 SL18 VSS sky130_fd_pr__nfet_g5v0d10v5 w=1 l=0.5
XRp_21_18 BLP18 dp_21_18 sky130_fd_pr_reram__reram_cell area_ox=0.0676
XMn_21_18 dn_21_18 WL21 SL18 VSS sky130_fd_pr__nfet_g5v0d10v5 w=1 l=0.5
XRn_21_18 BLN18 dn_21_18 sky130_fd_pr_reram__reram_cell area_ox=0.0676
XMp_21_19 dp_21_19 WL21 SL19 VSS sky130_fd_pr__nfet_g5v0d10v5 w=1 l=0.5
XRp_21_19 BLP19 dp_21_19 sky130_fd_pr_reram__reram_cell area_ox=0.0676
XMn_21_19 dn_21_19 WL21 SL19 VSS sky130_fd_pr__nfet_g5v0d10v5 w=1 l=0.5
XRn_21_19 BLN19 dn_21_19 sky130_fd_pr_reram__reram_cell area_ox=0.0676
XMp_21_20 dp_21_20 WL21 SL20 VSS sky130_fd_pr__nfet_g5v0d10v5 w=1 l=0.5
XRp_21_20 BLP20 dp_21_20 sky130_fd_pr_reram__reram_cell area_ox=0.0676
XMn_21_20 dn_21_20 WL21 SL20 VSS sky130_fd_pr__nfet_g5v0d10v5 w=1 l=0.5
XRn_21_20 BLN20 dn_21_20 sky130_fd_pr_reram__reram_cell area_ox=0.0676
XMp_21_21 dp_21_21 WL21 SL21 VSS sky130_fd_pr__nfet_g5v0d10v5 w=1 l=0.5
XRp_21_21 BLP21 dp_21_21 sky130_fd_pr_reram__reram_cell area_ox=0.0676
XMn_21_21 dn_21_21 WL21 SL21 VSS sky130_fd_pr__nfet_g5v0d10v5 w=1 l=0.5
XRn_21_21 BLN21 dn_21_21 sky130_fd_pr_reram__reram_cell area_ox=0.0676
XMp_21_22 dp_21_22 WL21 SL22 VSS sky130_fd_pr__nfet_g5v0d10v5 w=1 l=0.5
XRp_21_22 BLP22 dp_21_22 sky130_fd_pr_reram__reram_cell area_ox=0.0676
XMn_21_22 dn_21_22 WL21 SL22 VSS sky130_fd_pr__nfet_g5v0d10v5 w=1 l=0.5
XRn_21_22 BLN22 dn_21_22 sky130_fd_pr_reram__reram_cell area_ox=0.0676
XMp_21_23 dp_21_23 WL21 SL23 VSS sky130_fd_pr__nfet_g5v0d10v5 w=1 l=0.5
XRp_21_23 BLP23 dp_21_23 sky130_fd_pr_reram__reram_cell area_ox=0.0676
XMn_21_23 dn_21_23 WL21 SL23 VSS sky130_fd_pr__nfet_g5v0d10v5 w=1 l=0.5
XRn_21_23 BLN23 dn_21_23 sky130_fd_pr_reram__reram_cell area_ox=0.0676
XMp_22_0 dp_22_0 WL22 SL0 VSS sky130_fd_pr__nfet_g5v0d10v5 w=1 l=0.5
XRp_22_0 BLP0 dp_22_0 sky130_fd_pr_reram__reram_cell area_ox=0.0676
XMn_22_0 dn_22_0 WL22 SL0 VSS sky130_fd_pr__nfet_g5v0d10v5 w=1 l=0.5
XRn_22_0 BLN0 dn_22_0 sky130_fd_pr_reram__reram_cell area_ox=0.0676
XMp_22_1 dp_22_1 WL22 SL1 VSS sky130_fd_pr__nfet_g5v0d10v5 w=1 l=0.5
XRp_22_1 BLP1 dp_22_1 sky130_fd_pr_reram__reram_cell area_ox=0.0676
XMn_22_1 dn_22_1 WL22 SL1 VSS sky130_fd_pr__nfet_g5v0d10v5 w=1 l=0.5
XRn_22_1 BLN1 dn_22_1 sky130_fd_pr_reram__reram_cell area_ox=0.0676
XMp_22_2 dp_22_2 WL22 SL2 VSS sky130_fd_pr__nfet_g5v0d10v5 w=1 l=0.5
XRp_22_2 BLP2 dp_22_2 sky130_fd_pr_reram__reram_cell area_ox=0.0676
XMn_22_2 dn_22_2 WL22 SL2 VSS sky130_fd_pr__nfet_g5v0d10v5 w=1 l=0.5
XRn_22_2 BLN2 dn_22_2 sky130_fd_pr_reram__reram_cell area_ox=0.0676
XMp_22_3 dp_22_3 WL22 SL3 VSS sky130_fd_pr__nfet_g5v0d10v5 w=1 l=0.5
XRp_22_3 BLP3 dp_22_3 sky130_fd_pr_reram__reram_cell area_ox=0.0676
XMn_22_3 dn_22_3 WL22 SL3 VSS sky130_fd_pr__nfet_g5v0d10v5 w=1 l=0.5
XRn_22_3 BLN3 dn_22_3 sky130_fd_pr_reram__reram_cell area_ox=0.0676
XMp_22_4 dp_22_4 WL22 SL4 VSS sky130_fd_pr__nfet_g5v0d10v5 w=1 l=0.5
XRp_22_4 BLP4 dp_22_4 sky130_fd_pr_reram__reram_cell area_ox=0.0676
XMn_22_4 dn_22_4 WL22 SL4 VSS sky130_fd_pr__nfet_g5v0d10v5 w=1 l=0.5
XRn_22_4 BLN4 dn_22_4 sky130_fd_pr_reram__reram_cell area_ox=0.0676
XMp_22_5 dp_22_5 WL22 SL5 VSS sky130_fd_pr__nfet_g5v0d10v5 w=1 l=0.5
XRp_22_5 BLP5 dp_22_5 sky130_fd_pr_reram__reram_cell area_ox=0.0676
XMn_22_5 dn_22_5 WL22 SL5 VSS sky130_fd_pr__nfet_g5v0d10v5 w=1 l=0.5
XRn_22_5 BLN5 dn_22_5 sky130_fd_pr_reram__reram_cell area_ox=0.0676
XMp_22_6 dp_22_6 WL22 SL6 VSS sky130_fd_pr__nfet_g5v0d10v5 w=1 l=0.5
XRp_22_6 BLP6 dp_22_6 sky130_fd_pr_reram__reram_cell area_ox=0.0676
XMn_22_6 dn_22_6 WL22 SL6 VSS sky130_fd_pr__nfet_g5v0d10v5 w=1 l=0.5
XRn_22_6 BLN6 dn_22_6 sky130_fd_pr_reram__reram_cell area_ox=0.0676
XMp_22_7 dp_22_7 WL22 SL7 VSS sky130_fd_pr__nfet_g5v0d10v5 w=1 l=0.5
XRp_22_7 BLP7 dp_22_7 sky130_fd_pr_reram__reram_cell area_ox=0.0676
XMn_22_7 dn_22_7 WL22 SL7 VSS sky130_fd_pr__nfet_g5v0d10v5 w=1 l=0.5
XRn_22_7 BLN7 dn_22_7 sky130_fd_pr_reram__reram_cell area_ox=0.0676
XMp_22_8 dp_22_8 WL22 SL8 VSS sky130_fd_pr__nfet_g5v0d10v5 w=1 l=0.5
XRp_22_8 BLP8 dp_22_8 sky130_fd_pr_reram__reram_cell area_ox=0.0676
XMn_22_8 dn_22_8 WL22 SL8 VSS sky130_fd_pr__nfet_g5v0d10v5 w=1 l=0.5
XRn_22_8 BLN8 dn_22_8 sky130_fd_pr_reram__reram_cell area_ox=0.0676
XMp_22_9 dp_22_9 WL22 SL9 VSS sky130_fd_pr__nfet_g5v0d10v5 w=1 l=0.5
XRp_22_9 BLP9 dp_22_9 sky130_fd_pr_reram__reram_cell area_ox=0.0676
XMn_22_9 dn_22_9 WL22 SL9 VSS sky130_fd_pr__nfet_g5v0d10v5 w=1 l=0.5
XRn_22_9 BLN9 dn_22_9 sky130_fd_pr_reram__reram_cell area_ox=0.0676
XMp_22_10 dp_22_10 WL22 SL10 VSS sky130_fd_pr__nfet_g5v0d10v5 w=1 l=0.5
XRp_22_10 BLP10 dp_22_10 sky130_fd_pr_reram__reram_cell area_ox=0.0676
XMn_22_10 dn_22_10 WL22 SL10 VSS sky130_fd_pr__nfet_g5v0d10v5 w=1 l=0.5
XRn_22_10 BLN10 dn_22_10 sky130_fd_pr_reram__reram_cell area_ox=0.0676
XMp_22_11 dp_22_11 WL22 SL11 VSS sky130_fd_pr__nfet_g5v0d10v5 w=1 l=0.5
XRp_22_11 BLP11 dp_22_11 sky130_fd_pr_reram__reram_cell area_ox=0.0676
XMn_22_11 dn_22_11 WL22 SL11 VSS sky130_fd_pr__nfet_g5v0d10v5 w=1 l=0.5
XRn_22_11 BLN11 dn_22_11 sky130_fd_pr_reram__reram_cell area_ox=0.0676
XMp_22_12 dp_22_12 WL22 SL12 VSS sky130_fd_pr__nfet_g5v0d10v5 w=1 l=0.5
XRp_22_12 BLP12 dp_22_12 sky130_fd_pr_reram__reram_cell area_ox=0.0676
XMn_22_12 dn_22_12 WL22 SL12 VSS sky130_fd_pr__nfet_g5v0d10v5 w=1 l=0.5
XRn_22_12 BLN12 dn_22_12 sky130_fd_pr_reram__reram_cell area_ox=0.0676
XMp_22_13 dp_22_13 WL22 SL13 VSS sky130_fd_pr__nfet_g5v0d10v5 w=1 l=0.5
XRp_22_13 BLP13 dp_22_13 sky130_fd_pr_reram__reram_cell area_ox=0.0676
XMn_22_13 dn_22_13 WL22 SL13 VSS sky130_fd_pr__nfet_g5v0d10v5 w=1 l=0.5
XRn_22_13 BLN13 dn_22_13 sky130_fd_pr_reram__reram_cell area_ox=0.0676
XMp_22_14 dp_22_14 WL22 SL14 VSS sky130_fd_pr__nfet_g5v0d10v5 w=1 l=0.5
XRp_22_14 BLP14 dp_22_14 sky130_fd_pr_reram__reram_cell area_ox=0.0676
XMn_22_14 dn_22_14 WL22 SL14 VSS sky130_fd_pr__nfet_g5v0d10v5 w=1 l=0.5
XRn_22_14 BLN14 dn_22_14 sky130_fd_pr_reram__reram_cell area_ox=0.0676
XMp_22_15 dp_22_15 WL22 SL15 VSS sky130_fd_pr__nfet_g5v0d10v5 w=1 l=0.5
XRp_22_15 BLP15 dp_22_15 sky130_fd_pr_reram__reram_cell area_ox=0.0676
XMn_22_15 dn_22_15 WL22 SL15 VSS sky130_fd_pr__nfet_g5v0d10v5 w=1 l=0.5
XRn_22_15 BLN15 dn_22_15 sky130_fd_pr_reram__reram_cell area_ox=0.0676
XMp_22_16 dp_22_16 WL22 SL16 VSS sky130_fd_pr__nfet_g5v0d10v5 w=1 l=0.5
XRp_22_16 BLP16 dp_22_16 sky130_fd_pr_reram__reram_cell area_ox=0.0676
XMn_22_16 dn_22_16 WL22 SL16 VSS sky130_fd_pr__nfet_g5v0d10v5 w=1 l=0.5
XRn_22_16 BLN16 dn_22_16 sky130_fd_pr_reram__reram_cell area_ox=0.0676
XMp_22_17 dp_22_17 WL22 SL17 VSS sky130_fd_pr__nfet_g5v0d10v5 w=1 l=0.5
XRp_22_17 BLP17 dp_22_17 sky130_fd_pr_reram__reram_cell area_ox=0.0676
XMn_22_17 dn_22_17 WL22 SL17 VSS sky130_fd_pr__nfet_g5v0d10v5 w=1 l=0.5
XRn_22_17 BLN17 dn_22_17 sky130_fd_pr_reram__reram_cell area_ox=0.0676
XMp_22_18 dp_22_18 WL22 SL18 VSS sky130_fd_pr__nfet_g5v0d10v5 w=1 l=0.5
XRp_22_18 BLP18 dp_22_18 sky130_fd_pr_reram__reram_cell area_ox=0.0676
XMn_22_18 dn_22_18 WL22 SL18 VSS sky130_fd_pr__nfet_g5v0d10v5 w=1 l=0.5
XRn_22_18 BLN18 dn_22_18 sky130_fd_pr_reram__reram_cell area_ox=0.0676
XMp_22_19 dp_22_19 WL22 SL19 VSS sky130_fd_pr__nfet_g5v0d10v5 w=1 l=0.5
XRp_22_19 BLP19 dp_22_19 sky130_fd_pr_reram__reram_cell area_ox=0.0676
XMn_22_19 dn_22_19 WL22 SL19 VSS sky130_fd_pr__nfet_g5v0d10v5 w=1 l=0.5
XRn_22_19 BLN19 dn_22_19 sky130_fd_pr_reram__reram_cell area_ox=0.0676
XMp_22_20 dp_22_20 WL22 SL20 VSS sky130_fd_pr__nfet_g5v0d10v5 w=1 l=0.5
XRp_22_20 BLP20 dp_22_20 sky130_fd_pr_reram__reram_cell area_ox=0.0676
XMn_22_20 dn_22_20 WL22 SL20 VSS sky130_fd_pr__nfet_g5v0d10v5 w=1 l=0.5
XRn_22_20 BLN20 dn_22_20 sky130_fd_pr_reram__reram_cell area_ox=0.0676
XMp_22_21 dp_22_21 WL22 SL21 VSS sky130_fd_pr__nfet_g5v0d10v5 w=1 l=0.5
XRp_22_21 BLP21 dp_22_21 sky130_fd_pr_reram__reram_cell area_ox=0.0676
XMn_22_21 dn_22_21 WL22 SL21 VSS sky130_fd_pr__nfet_g5v0d10v5 w=1 l=0.5
XRn_22_21 BLN21 dn_22_21 sky130_fd_pr_reram__reram_cell area_ox=0.0676
XMp_22_22 dp_22_22 WL22 SL22 VSS sky130_fd_pr__nfet_g5v0d10v5 w=1 l=0.5
XRp_22_22 BLP22 dp_22_22 sky130_fd_pr_reram__reram_cell area_ox=0.0676
XMn_22_22 dn_22_22 WL22 SL22 VSS sky130_fd_pr__nfet_g5v0d10v5 w=1 l=0.5
XRn_22_22 BLN22 dn_22_22 sky130_fd_pr_reram__reram_cell area_ox=0.0676
XMp_22_23 dp_22_23 WL22 SL23 VSS sky130_fd_pr__nfet_g5v0d10v5 w=1 l=0.5
XRp_22_23 BLP23 dp_22_23 sky130_fd_pr_reram__reram_cell area_ox=0.0676
XMn_22_23 dn_22_23 WL22 SL23 VSS sky130_fd_pr__nfet_g5v0d10v5 w=1 l=0.5
XRn_22_23 BLN23 dn_22_23 sky130_fd_pr_reram__reram_cell area_ox=0.0676
XMp_23_0 dp_23_0 WL23 SL0 VSS sky130_fd_pr__nfet_g5v0d10v5 w=1 l=0.5
XRp_23_0 BLP0 dp_23_0 sky130_fd_pr_reram__reram_cell area_ox=0.0676
XMn_23_0 dn_23_0 WL23 SL0 VSS sky130_fd_pr__nfet_g5v0d10v5 w=1 l=0.5
XRn_23_0 BLN0 dn_23_0 sky130_fd_pr_reram__reram_cell area_ox=0.0676
XMp_23_1 dp_23_1 WL23 SL1 VSS sky130_fd_pr__nfet_g5v0d10v5 w=1 l=0.5
XRp_23_1 BLP1 dp_23_1 sky130_fd_pr_reram__reram_cell area_ox=0.0676
XMn_23_1 dn_23_1 WL23 SL1 VSS sky130_fd_pr__nfet_g5v0d10v5 w=1 l=0.5
XRn_23_1 BLN1 dn_23_1 sky130_fd_pr_reram__reram_cell area_ox=0.0676
XMp_23_2 dp_23_2 WL23 SL2 VSS sky130_fd_pr__nfet_g5v0d10v5 w=1 l=0.5
XRp_23_2 BLP2 dp_23_2 sky130_fd_pr_reram__reram_cell area_ox=0.0676
XMn_23_2 dn_23_2 WL23 SL2 VSS sky130_fd_pr__nfet_g5v0d10v5 w=1 l=0.5
XRn_23_2 BLN2 dn_23_2 sky130_fd_pr_reram__reram_cell area_ox=0.0676
XMp_23_3 dp_23_3 WL23 SL3 VSS sky130_fd_pr__nfet_g5v0d10v5 w=1 l=0.5
XRp_23_3 BLP3 dp_23_3 sky130_fd_pr_reram__reram_cell area_ox=0.0676
XMn_23_3 dn_23_3 WL23 SL3 VSS sky130_fd_pr__nfet_g5v0d10v5 w=1 l=0.5
XRn_23_3 BLN3 dn_23_3 sky130_fd_pr_reram__reram_cell area_ox=0.0676
XMp_23_4 dp_23_4 WL23 SL4 VSS sky130_fd_pr__nfet_g5v0d10v5 w=1 l=0.5
XRp_23_4 BLP4 dp_23_4 sky130_fd_pr_reram__reram_cell area_ox=0.0676
XMn_23_4 dn_23_4 WL23 SL4 VSS sky130_fd_pr__nfet_g5v0d10v5 w=1 l=0.5
XRn_23_4 BLN4 dn_23_4 sky130_fd_pr_reram__reram_cell area_ox=0.0676
XMp_23_5 dp_23_5 WL23 SL5 VSS sky130_fd_pr__nfet_g5v0d10v5 w=1 l=0.5
XRp_23_5 BLP5 dp_23_5 sky130_fd_pr_reram__reram_cell area_ox=0.0676
XMn_23_5 dn_23_5 WL23 SL5 VSS sky130_fd_pr__nfet_g5v0d10v5 w=1 l=0.5
XRn_23_5 BLN5 dn_23_5 sky130_fd_pr_reram__reram_cell area_ox=0.0676
XMp_23_6 dp_23_6 WL23 SL6 VSS sky130_fd_pr__nfet_g5v0d10v5 w=1 l=0.5
XRp_23_6 BLP6 dp_23_6 sky130_fd_pr_reram__reram_cell area_ox=0.0676
XMn_23_6 dn_23_6 WL23 SL6 VSS sky130_fd_pr__nfet_g5v0d10v5 w=1 l=0.5
XRn_23_6 BLN6 dn_23_6 sky130_fd_pr_reram__reram_cell area_ox=0.0676
XMp_23_7 dp_23_7 WL23 SL7 VSS sky130_fd_pr__nfet_g5v0d10v5 w=1 l=0.5
XRp_23_7 BLP7 dp_23_7 sky130_fd_pr_reram__reram_cell area_ox=0.0676
XMn_23_7 dn_23_7 WL23 SL7 VSS sky130_fd_pr__nfet_g5v0d10v5 w=1 l=0.5
XRn_23_7 BLN7 dn_23_7 sky130_fd_pr_reram__reram_cell area_ox=0.0676
XMp_23_8 dp_23_8 WL23 SL8 VSS sky130_fd_pr__nfet_g5v0d10v5 w=1 l=0.5
XRp_23_8 BLP8 dp_23_8 sky130_fd_pr_reram__reram_cell area_ox=0.0676
XMn_23_8 dn_23_8 WL23 SL8 VSS sky130_fd_pr__nfet_g5v0d10v5 w=1 l=0.5
XRn_23_8 BLN8 dn_23_8 sky130_fd_pr_reram__reram_cell area_ox=0.0676
XMp_23_9 dp_23_9 WL23 SL9 VSS sky130_fd_pr__nfet_g5v0d10v5 w=1 l=0.5
XRp_23_9 BLP9 dp_23_9 sky130_fd_pr_reram__reram_cell area_ox=0.0676
XMn_23_9 dn_23_9 WL23 SL9 VSS sky130_fd_pr__nfet_g5v0d10v5 w=1 l=0.5
XRn_23_9 BLN9 dn_23_9 sky130_fd_pr_reram__reram_cell area_ox=0.0676
XMp_23_10 dp_23_10 WL23 SL10 VSS sky130_fd_pr__nfet_g5v0d10v5 w=1 l=0.5
XRp_23_10 BLP10 dp_23_10 sky130_fd_pr_reram__reram_cell area_ox=0.0676
XMn_23_10 dn_23_10 WL23 SL10 VSS sky130_fd_pr__nfet_g5v0d10v5 w=1 l=0.5
XRn_23_10 BLN10 dn_23_10 sky130_fd_pr_reram__reram_cell area_ox=0.0676
XMp_23_11 dp_23_11 WL23 SL11 VSS sky130_fd_pr__nfet_g5v0d10v5 w=1 l=0.5
XRp_23_11 BLP11 dp_23_11 sky130_fd_pr_reram__reram_cell area_ox=0.0676
XMn_23_11 dn_23_11 WL23 SL11 VSS sky130_fd_pr__nfet_g5v0d10v5 w=1 l=0.5
XRn_23_11 BLN11 dn_23_11 sky130_fd_pr_reram__reram_cell area_ox=0.0676
XMp_23_12 dp_23_12 WL23 SL12 VSS sky130_fd_pr__nfet_g5v0d10v5 w=1 l=0.5
XRp_23_12 BLP12 dp_23_12 sky130_fd_pr_reram__reram_cell area_ox=0.0676
XMn_23_12 dn_23_12 WL23 SL12 VSS sky130_fd_pr__nfet_g5v0d10v5 w=1 l=0.5
XRn_23_12 BLN12 dn_23_12 sky130_fd_pr_reram__reram_cell area_ox=0.0676
XMp_23_13 dp_23_13 WL23 SL13 VSS sky130_fd_pr__nfet_g5v0d10v5 w=1 l=0.5
XRp_23_13 BLP13 dp_23_13 sky130_fd_pr_reram__reram_cell area_ox=0.0676
XMn_23_13 dn_23_13 WL23 SL13 VSS sky130_fd_pr__nfet_g5v0d10v5 w=1 l=0.5
XRn_23_13 BLN13 dn_23_13 sky130_fd_pr_reram__reram_cell area_ox=0.0676
XMp_23_14 dp_23_14 WL23 SL14 VSS sky130_fd_pr__nfet_g5v0d10v5 w=1 l=0.5
XRp_23_14 BLP14 dp_23_14 sky130_fd_pr_reram__reram_cell area_ox=0.0676
XMn_23_14 dn_23_14 WL23 SL14 VSS sky130_fd_pr__nfet_g5v0d10v5 w=1 l=0.5
XRn_23_14 BLN14 dn_23_14 sky130_fd_pr_reram__reram_cell area_ox=0.0676
XMp_23_15 dp_23_15 WL23 SL15 VSS sky130_fd_pr__nfet_g5v0d10v5 w=1 l=0.5
XRp_23_15 BLP15 dp_23_15 sky130_fd_pr_reram__reram_cell area_ox=0.0676
XMn_23_15 dn_23_15 WL23 SL15 VSS sky130_fd_pr__nfet_g5v0d10v5 w=1 l=0.5
XRn_23_15 BLN15 dn_23_15 sky130_fd_pr_reram__reram_cell area_ox=0.0676
XMp_23_16 dp_23_16 WL23 SL16 VSS sky130_fd_pr__nfet_g5v0d10v5 w=1 l=0.5
XRp_23_16 BLP16 dp_23_16 sky130_fd_pr_reram__reram_cell area_ox=0.0676
XMn_23_16 dn_23_16 WL23 SL16 VSS sky130_fd_pr__nfet_g5v0d10v5 w=1 l=0.5
XRn_23_16 BLN16 dn_23_16 sky130_fd_pr_reram__reram_cell area_ox=0.0676
XMp_23_17 dp_23_17 WL23 SL17 VSS sky130_fd_pr__nfet_g5v0d10v5 w=1 l=0.5
XRp_23_17 BLP17 dp_23_17 sky130_fd_pr_reram__reram_cell area_ox=0.0676
XMn_23_17 dn_23_17 WL23 SL17 VSS sky130_fd_pr__nfet_g5v0d10v5 w=1 l=0.5
XRn_23_17 BLN17 dn_23_17 sky130_fd_pr_reram__reram_cell area_ox=0.0676
XMp_23_18 dp_23_18 WL23 SL18 VSS sky130_fd_pr__nfet_g5v0d10v5 w=1 l=0.5
XRp_23_18 BLP18 dp_23_18 sky130_fd_pr_reram__reram_cell area_ox=0.0676
XMn_23_18 dn_23_18 WL23 SL18 VSS sky130_fd_pr__nfet_g5v0d10v5 w=1 l=0.5
XRn_23_18 BLN18 dn_23_18 sky130_fd_pr_reram__reram_cell area_ox=0.0676
XMp_23_19 dp_23_19 WL23 SL19 VSS sky130_fd_pr__nfet_g5v0d10v5 w=1 l=0.5
XRp_23_19 BLP19 dp_23_19 sky130_fd_pr_reram__reram_cell area_ox=0.0676
XMn_23_19 dn_23_19 WL23 SL19 VSS sky130_fd_pr__nfet_g5v0d10v5 w=1 l=0.5
XRn_23_19 BLN19 dn_23_19 sky130_fd_pr_reram__reram_cell area_ox=0.0676
XMp_23_20 dp_23_20 WL23 SL20 VSS sky130_fd_pr__nfet_g5v0d10v5 w=1 l=0.5
XRp_23_20 BLP20 dp_23_20 sky130_fd_pr_reram__reram_cell area_ox=0.0676
XMn_23_20 dn_23_20 WL23 SL20 VSS sky130_fd_pr__nfet_g5v0d10v5 w=1 l=0.5
XRn_23_20 BLN20 dn_23_20 sky130_fd_pr_reram__reram_cell area_ox=0.0676
XMp_23_21 dp_23_21 WL23 SL21 VSS sky130_fd_pr__nfet_g5v0d10v5 w=1 l=0.5
XRp_23_21 BLP21 dp_23_21 sky130_fd_pr_reram__reram_cell area_ox=0.0676
XMn_23_21 dn_23_21 WL23 SL21 VSS sky130_fd_pr__nfet_g5v0d10v5 w=1 l=0.5
XRn_23_21 BLN21 dn_23_21 sky130_fd_pr_reram__reram_cell area_ox=0.0676
XMp_23_22 dp_23_22 WL23 SL22 VSS sky130_fd_pr__nfet_g5v0d10v5 w=1 l=0.5
XRp_23_22 BLP22 dp_23_22 sky130_fd_pr_reram__reram_cell area_ox=0.0676
XMn_23_22 dn_23_22 WL23 SL22 VSS sky130_fd_pr__nfet_g5v0d10v5 w=1 l=0.5
XRn_23_22 BLN22 dn_23_22 sky130_fd_pr_reram__reram_cell area_ox=0.0676
XMp_23_23 dp_23_23 WL23 SL23 VSS sky130_fd_pr__nfet_g5v0d10v5 w=1 l=0.5
XRp_23_23 BLP23 dp_23_23 sky130_fd_pr_reram__reram_cell area_ox=0.0676
XMn_23_23 dn_23_23 WL23 SL23 VSS sky130_fd_pr__nfet_g5v0d10v5 w=1 l=0.5
XRn_23_23 BLN23 dn_23_23 sky130_fd_pr_reram__reram_cell area_ox=0.0676
XMp_24_0 dp_24_0 WL24 SL0 VSS sky130_fd_pr__nfet_g5v0d10v5 w=1 l=0.5
XRp_24_0 BLP0 dp_24_0 sky130_fd_pr_reram__reram_cell area_ox=0.0676
XMn_24_0 dn_24_0 WL24 SL0 VSS sky130_fd_pr__nfet_g5v0d10v5 w=1 l=0.5
XRn_24_0 BLN0 dn_24_0 sky130_fd_pr_reram__reram_cell area_ox=0.0676
XMp_24_1 dp_24_1 WL24 SL1 VSS sky130_fd_pr__nfet_g5v0d10v5 w=1 l=0.5
XRp_24_1 BLP1 dp_24_1 sky130_fd_pr_reram__reram_cell area_ox=0.0676
XMn_24_1 dn_24_1 WL24 SL1 VSS sky130_fd_pr__nfet_g5v0d10v5 w=1 l=0.5
XRn_24_1 BLN1 dn_24_1 sky130_fd_pr_reram__reram_cell area_ox=0.0676
XMp_24_2 dp_24_2 WL24 SL2 VSS sky130_fd_pr__nfet_g5v0d10v5 w=1 l=0.5
XRp_24_2 BLP2 dp_24_2 sky130_fd_pr_reram__reram_cell area_ox=0.0676
XMn_24_2 dn_24_2 WL24 SL2 VSS sky130_fd_pr__nfet_g5v0d10v5 w=1 l=0.5
XRn_24_2 BLN2 dn_24_2 sky130_fd_pr_reram__reram_cell area_ox=0.0676
XMp_24_3 dp_24_3 WL24 SL3 VSS sky130_fd_pr__nfet_g5v0d10v5 w=1 l=0.5
XRp_24_3 BLP3 dp_24_3 sky130_fd_pr_reram__reram_cell area_ox=0.0676
XMn_24_3 dn_24_3 WL24 SL3 VSS sky130_fd_pr__nfet_g5v0d10v5 w=1 l=0.5
XRn_24_3 BLN3 dn_24_3 sky130_fd_pr_reram__reram_cell area_ox=0.0676
XMp_24_4 dp_24_4 WL24 SL4 VSS sky130_fd_pr__nfet_g5v0d10v5 w=1 l=0.5
XRp_24_4 BLP4 dp_24_4 sky130_fd_pr_reram__reram_cell area_ox=0.0676
XMn_24_4 dn_24_4 WL24 SL4 VSS sky130_fd_pr__nfet_g5v0d10v5 w=1 l=0.5
XRn_24_4 BLN4 dn_24_4 sky130_fd_pr_reram__reram_cell area_ox=0.0676
XMp_24_5 dp_24_5 WL24 SL5 VSS sky130_fd_pr__nfet_g5v0d10v5 w=1 l=0.5
XRp_24_5 BLP5 dp_24_5 sky130_fd_pr_reram__reram_cell area_ox=0.0676
XMn_24_5 dn_24_5 WL24 SL5 VSS sky130_fd_pr__nfet_g5v0d10v5 w=1 l=0.5
XRn_24_5 BLN5 dn_24_5 sky130_fd_pr_reram__reram_cell area_ox=0.0676
XMp_24_6 dp_24_6 WL24 SL6 VSS sky130_fd_pr__nfet_g5v0d10v5 w=1 l=0.5
XRp_24_6 BLP6 dp_24_6 sky130_fd_pr_reram__reram_cell area_ox=0.0676
XMn_24_6 dn_24_6 WL24 SL6 VSS sky130_fd_pr__nfet_g5v0d10v5 w=1 l=0.5
XRn_24_6 BLN6 dn_24_6 sky130_fd_pr_reram__reram_cell area_ox=0.0676
XMp_24_7 dp_24_7 WL24 SL7 VSS sky130_fd_pr__nfet_g5v0d10v5 w=1 l=0.5
XRp_24_7 BLP7 dp_24_7 sky130_fd_pr_reram__reram_cell area_ox=0.0676
XMn_24_7 dn_24_7 WL24 SL7 VSS sky130_fd_pr__nfet_g5v0d10v5 w=1 l=0.5
XRn_24_7 BLN7 dn_24_7 sky130_fd_pr_reram__reram_cell area_ox=0.0676
XMp_24_8 dp_24_8 WL24 SL8 VSS sky130_fd_pr__nfet_g5v0d10v5 w=1 l=0.5
XRp_24_8 BLP8 dp_24_8 sky130_fd_pr_reram__reram_cell area_ox=0.0676
XMn_24_8 dn_24_8 WL24 SL8 VSS sky130_fd_pr__nfet_g5v0d10v5 w=1 l=0.5
XRn_24_8 BLN8 dn_24_8 sky130_fd_pr_reram__reram_cell area_ox=0.0676
XMp_24_9 dp_24_9 WL24 SL9 VSS sky130_fd_pr__nfet_g5v0d10v5 w=1 l=0.5
XRp_24_9 BLP9 dp_24_9 sky130_fd_pr_reram__reram_cell area_ox=0.0676
XMn_24_9 dn_24_9 WL24 SL9 VSS sky130_fd_pr__nfet_g5v0d10v5 w=1 l=0.5
XRn_24_9 BLN9 dn_24_9 sky130_fd_pr_reram__reram_cell area_ox=0.0676
XMp_24_10 dp_24_10 WL24 SL10 VSS sky130_fd_pr__nfet_g5v0d10v5 w=1 l=0.5
XRp_24_10 BLP10 dp_24_10 sky130_fd_pr_reram__reram_cell area_ox=0.0676
XMn_24_10 dn_24_10 WL24 SL10 VSS sky130_fd_pr__nfet_g5v0d10v5 w=1 l=0.5
XRn_24_10 BLN10 dn_24_10 sky130_fd_pr_reram__reram_cell area_ox=0.0676
XMp_24_11 dp_24_11 WL24 SL11 VSS sky130_fd_pr__nfet_g5v0d10v5 w=1 l=0.5
XRp_24_11 BLP11 dp_24_11 sky130_fd_pr_reram__reram_cell area_ox=0.0676
XMn_24_11 dn_24_11 WL24 SL11 VSS sky130_fd_pr__nfet_g5v0d10v5 w=1 l=0.5
XRn_24_11 BLN11 dn_24_11 sky130_fd_pr_reram__reram_cell area_ox=0.0676
XMp_24_12 dp_24_12 WL24 SL12 VSS sky130_fd_pr__nfet_g5v0d10v5 w=1 l=0.5
XRp_24_12 BLP12 dp_24_12 sky130_fd_pr_reram__reram_cell area_ox=0.0676
XMn_24_12 dn_24_12 WL24 SL12 VSS sky130_fd_pr__nfet_g5v0d10v5 w=1 l=0.5
XRn_24_12 BLN12 dn_24_12 sky130_fd_pr_reram__reram_cell area_ox=0.0676
XMp_24_13 dp_24_13 WL24 SL13 VSS sky130_fd_pr__nfet_g5v0d10v5 w=1 l=0.5
XRp_24_13 BLP13 dp_24_13 sky130_fd_pr_reram__reram_cell area_ox=0.0676
XMn_24_13 dn_24_13 WL24 SL13 VSS sky130_fd_pr__nfet_g5v0d10v5 w=1 l=0.5
XRn_24_13 BLN13 dn_24_13 sky130_fd_pr_reram__reram_cell area_ox=0.0676
XMp_24_14 dp_24_14 WL24 SL14 VSS sky130_fd_pr__nfet_g5v0d10v5 w=1 l=0.5
XRp_24_14 BLP14 dp_24_14 sky130_fd_pr_reram__reram_cell area_ox=0.0676
XMn_24_14 dn_24_14 WL24 SL14 VSS sky130_fd_pr__nfet_g5v0d10v5 w=1 l=0.5
XRn_24_14 BLN14 dn_24_14 sky130_fd_pr_reram__reram_cell area_ox=0.0676
XMp_24_15 dp_24_15 WL24 SL15 VSS sky130_fd_pr__nfet_g5v0d10v5 w=1 l=0.5
XRp_24_15 BLP15 dp_24_15 sky130_fd_pr_reram__reram_cell area_ox=0.0676
XMn_24_15 dn_24_15 WL24 SL15 VSS sky130_fd_pr__nfet_g5v0d10v5 w=1 l=0.5
XRn_24_15 BLN15 dn_24_15 sky130_fd_pr_reram__reram_cell area_ox=0.0676
XMp_24_16 dp_24_16 WL24 SL16 VSS sky130_fd_pr__nfet_g5v0d10v5 w=1 l=0.5
XRp_24_16 BLP16 dp_24_16 sky130_fd_pr_reram__reram_cell area_ox=0.0676
XMn_24_16 dn_24_16 WL24 SL16 VSS sky130_fd_pr__nfet_g5v0d10v5 w=1 l=0.5
XRn_24_16 BLN16 dn_24_16 sky130_fd_pr_reram__reram_cell area_ox=0.0676
XMp_24_17 dp_24_17 WL24 SL17 VSS sky130_fd_pr__nfet_g5v0d10v5 w=1 l=0.5
XRp_24_17 BLP17 dp_24_17 sky130_fd_pr_reram__reram_cell area_ox=0.0676
XMn_24_17 dn_24_17 WL24 SL17 VSS sky130_fd_pr__nfet_g5v0d10v5 w=1 l=0.5
XRn_24_17 BLN17 dn_24_17 sky130_fd_pr_reram__reram_cell area_ox=0.0676
XMp_24_18 dp_24_18 WL24 SL18 VSS sky130_fd_pr__nfet_g5v0d10v5 w=1 l=0.5
XRp_24_18 BLP18 dp_24_18 sky130_fd_pr_reram__reram_cell area_ox=0.0676
XMn_24_18 dn_24_18 WL24 SL18 VSS sky130_fd_pr__nfet_g5v0d10v5 w=1 l=0.5
XRn_24_18 BLN18 dn_24_18 sky130_fd_pr_reram__reram_cell area_ox=0.0676
XMp_24_19 dp_24_19 WL24 SL19 VSS sky130_fd_pr__nfet_g5v0d10v5 w=1 l=0.5
XRp_24_19 BLP19 dp_24_19 sky130_fd_pr_reram__reram_cell area_ox=0.0676
XMn_24_19 dn_24_19 WL24 SL19 VSS sky130_fd_pr__nfet_g5v0d10v5 w=1 l=0.5
XRn_24_19 BLN19 dn_24_19 sky130_fd_pr_reram__reram_cell area_ox=0.0676
XMp_24_20 dp_24_20 WL24 SL20 VSS sky130_fd_pr__nfet_g5v0d10v5 w=1 l=0.5
XRp_24_20 BLP20 dp_24_20 sky130_fd_pr_reram__reram_cell area_ox=0.0676
XMn_24_20 dn_24_20 WL24 SL20 VSS sky130_fd_pr__nfet_g5v0d10v5 w=1 l=0.5
XRn_24_20 BLN20 dn_24_20 sky130_fd_pr_reram__reram_cell area_ox=0.0676
XMp_24_21 dp_24_21 WL24 SL21 VSS sky130_fd_pr__nfet_g5v0d10v5 w=1 l=0.5
XRp_24_21 BLP21 dp_24_21 sky130_fd_pr_reram__reram_cell area_ox=0.0676
XMn_24_21 dn_24_21 WL24 SL21 VSS sky130_fd_pr__nfet_g5v0d10v5 w=1 l=0.5
XRn_24_21 BLN21 dn_24_21 sky130_fd_pr_reram__reram_cell area_ox=0.0676
XMp_24_22 dp_24_22 WL24 SL22 VSS sky130_fd_pr__nfet_g5v0d10v5 w=1 l=0.5
XRp_24_22 BLP22 dp_24_22 sky130_fd_pr_reram__reram_cell area_ox=0.0676
XMn_24_22 dn_24_22 WL24 SL22 VSS sky130_fd_pr__nfet_g5v0d10v5 w=1 l=0.5
XRn_24_22 BLN22 dn_24_22 sky130_fd_pr_reram__reram_cell area_ox=0.0676
XMp_24_23 dp_24_23 WL24 SL23 VSS sky130_fd_pr__nfet_g5v0d10v5 w=1 l=0.5
XRp_24_23 BLP23 dp_24_23 sky130_fd_pr_reram__reram_cell area_ox=0.0676
XMn_24_23 dn_24_23 WL24 SL23 VSS sky130_fd_pr__nfet_g5v0d10v5 w=1 l=0.5
XRn_24_23 BLN23 dn_24_23 sky130_fd_pr_reram__reram_cell area_ox=0.0676
XMp_25_0 dp_25_0 WL25 SL0 VSS sky130_fd_pr__nfet_g5v0d10v5 w=1 l=0.5
XRp_25_0 BLP0 dp_25_0 sky130_fd_pr_reram__reram_cell area_ox=0.0676
XMn_25_0 dn_25_0 WL25 SL0 VSS sky130_fd_pr__nfet_g5v0d10v5 w=1 l=0.5
XRn_25_0 BLN0 dn_25_0 sky130_fd_pr_reram__reram_cell area_ox=0.0676
XMp_25_1 dp_25_1 WL25 SL1 VSS sky130_fd_pr__nfet_g5v0d10v5 w=1 l=0.5
XRp_25_1 BLP1 dp_25_1 sky130_fd_pr_reram__reram_cell area_ox=0.0676
XMn_25_1 dn_25_1 WL25 SL1 VSS sky130_fd_pr__nfet_g5v0d10v5 w=1 l=0.5
XRn_25_1 BLN1 dn_25_1 sky130_fd_pr_reram__reram_cell area_ox=0.0676
XMp_25_2 dp_25_2 WL25 SL2 VSS sky130_fd_pr__nfet_g5v0d10v5 w=1 l=0.5
XRp_25_2 BLP2 dp_25_2 sky130_fd_pr_reram__reram_cell area_ox=0.0676
XMn_25_2 dn_25_2 WL25 SL2 VSS sky130_fd_pr__nfet_g5v0d10v5 w=1 l=0.5
XRn_25_2 BLN2 dn_25_2 sky130_fd_pr_reram__reram_cell area_ox=0.0676
XMp_25_3 dp_25_3 WL25 SL3 VSS sky130_fd_pr__nfet_g5v0d10v5 w=1 l=0.5
XRp_25_3 BLP3 dp_25_3 sky130_fd_pr_reram__reram_cell area_ox=0.0676
XMn_25_3 dn_25_3 WL25 SL3 VSS sky130_fd_pr__nfet_g5v0d10v5 w=1 l=0.5
XRn_25_3 BLN3 dn_25_3 sky130_fd_pr_reram__reram_cell area_ox=0.0676
XMp_25_4 dp_25_4 WL25 SL4 VSS sky130_fd_pr__nfet_g5v0d10v5 w=1 l=0.5
XRp_25_4 BLP4 dp_25_4 sky130_fd_pr_reram__reram_cell area_ox=0.0676
XMn_25_4 dn_25_4 WL25 SL4 VSS sky130_fd_pr__nfet_g5v0d10v5 w=1 l=0.5
XRn_25_4 BLN4 dn_25_4 sky130_fd_pr_reram__reram_cell area_ox=0.0676
XMp_25_5 dp_25_5 WL25 SL5 VSS sky130_fd_pr__nfet_g5v0d10v5 w=1 l=0.5
XRp_25_5 BLP5 dp_25_5 sky130_fd_pr_reram__reram_cell area_ox=0.0676
XMn_25_5 dn_25_5 WL25 SL5 VSS sky130_fd_pr__nfet_g5v0d10v5 w=1 l=0.5
XRn_25_5 BLN5 dn_25_5 sky130_fd_pr_reram__reram_cell area_ox=0.0676
XMp_25_6 dp_25_6 WL25 SL6 VSS sky130_fd_pr__nfet_g5v0d10v5 w=1 l=0.5
XRp_25_6 BLP6 dp_25_6 sky130_fd_pr_reram__reram_cell area_ox=0.0676
XMn_25_6 dn_25_6 WL25 SL6 VSS sky130_fd_pr__nfet_g5v0d10v5 w=1 l=0.5
XRn_25_6 BLN6 dn_25_6 sky130_fd_pr_reram__reram_cell area_ox=0.0676
XMp_25_7 dp_25_7 WL25 SL7 VSS sky130_fd_pr__nfet_g5v0d10v5 w=1 l=0.5
XRp_25_7 BLP7 dp_25_7 sky130_fd_pr_reram__reram_cell area_ox=0.0676
XMn_25_7 dn_25_7 WL25 SL7 VSS sky130_fd_pr__nfet_g5v0d10v5 w=1 l=0.5
XRn_25_7 BLN7 dn_25_7 sky130_fd_pr_reram__reram_cell area_ox=0.0676
XMp_25_8 dp_25_8 WL25 SL8 VSS sky130_fd_pr__nfet_g5v0d10v5 w=1 l=0.5
XRp_25_8 BLP8 dp_25_8 sky130_fd_pr_reram__reram_cell area_ox=0.0676
XMn_25_8 dn_25_8 WL25 SL8 VSS sky130_fd_pr__nfet_g5v0d10v5 w=1 l=0.5
XRn_25_8 BLN8 dn_25_8 sky130_fd_pr_reram__reram_cell area_ox=0.0676
XMp_25_9 dp_25_9 WL25 SL9 VSS sky130_fd_pr__nfet_g5v0d10v5 w=1 l=0.5
XRp_25_9 BLP9 dp_25_9 sky130_fd_pr_reram__reram_cell area_ox=0.0676
XMn_25_9 dn_25_9 WL25 SL9 VSS sky130_fd_pr__nfet_g5v0d10v5 w=1 l=0.5
XRn_25_9 BLN9 dn_25_9 sky130_fd_pr_reram__reram_cell area_ox=0.0676
XMp_25_10 dp_25_10 WL25 SL10 VSS sky130_fd_pr__nfet_g5v0d10v5 w=1 l=0.5
XRp_25_10 BLP10 dp_25_10 sky130_fd_pr_reram__reram_cell area_ox=0.0676
XMn_25_10 dn_25_10 WL25 SL10 VSS sky130_fd_pr__nfet_g5v0d10v5 w=1 l=0.5
XRn_25_10 BLN10 dn_25_10 sky130_fd_pr_reram__reram_cell area_ox=0.0676
XMp_25_11 dp_25_11 WL25 SL11 VSS sky130_fd_pr__nfet_g5v0d10v5 w=1 l=0.5
XRp_25_11 BLP11 dp_25_11 sky130_fd_pr_reram__reram_cell area_ox=0.0676
XMn_25_11 dn_25_11 WL25 SL11 VSS sky130_fd_pr__nfet_g5v0d10v5 w=1 l=0.5
XRn_25_11 BLN11 dn_25_11 sky130_fd_pr_reram__reram_cell area_ox=0.0676
XMp_25_12 dp_25_12 WL25 SL12 VSS sky130_fd_pr__nfet_g5v0d10v5 w=1 l=0.5
XRp_25_12 BLP12 dp_25_12 sky130_fd_pr_reram__reram_cell area_ox=0.0676
XMn_25_12 dn_25_12 WL25 SL12 VSS sky130_fd_pr__nfet_g5v0d10v5 w=1 l=0.5
XRn_25_12 BLN12 dn_25_12 sky130_fd_pr_reram__reram_cell area_ox=0.0676
XMp_25_13 dp_25_13 WL25 SL13 VSS sky130_fd_pr__nfet_g5v0d10v5 w=1 l=0.5
XRp_25_13 BLP13 dp_25_13 sky130_fd_pr_reram__reram_cell area_ox=0.0676
XMn_25_13 dn_25_13 WL25 SL13 VSS sky130_fd_pr__nfet_g5v0d10v5 w=1 l=0.5
XRn_25_13 BLN13 dn_25_13 sky130_fd_pr_reram__reram_cell area_ox=0.0676
XMp_25_14 dp_25_14 WL25 SL14 VSS sky130_fd_pr__nfet_g5v0d10v5 w=1 l=0.5
XRp_25_14 BLP14 dp_25_14 sky130_fd_pr_reram__reram_cell area_ox=0.0676
XMn_25_14 dn_25_14 WL25 SL14 VSS sky130_fd_pr__nfet_g5v0d10v5 w=1 l=0.5
XRn_25_14 BLN14 dn_25_14 sky130_fd_pr_reram__reram_cell area_ox=0.0676
XMp_25_15 dp_25_15 WL25 SL15 VSS sky130_fd_pr__nfet_g5v0d10v5 w=1 l=0.5
XRp_25_15 BLP15 dp_25_15 sky130_fd_pr_reram__reram_cell area_ox=0.0676
XMn_25_15 dn_25_15 WL25 SL15 VSS sky130_fd_pr__nfet_g5v0d10v5 w=1 l=0.5
XRn_25_15 BLN15 dn_25_15 sky130_fd_pr_reram__reram_cell area_ox=0.0676
XMp_25_16 dp_25_16 WL25 SL16 VSS sky130_fd_pr__nfet_g5v0d10v5 w=1 l=0.5
XRp_25_16 BLP16 dp_25_16 sky130_fd_pr_reram__reram_cell area_ox=0.0676
XMn_25_16 dn_25_16 WL25 SL16 VSS sky130_fd_pr__nfet_g5v0d10v5 w=1 l=0.5
XRn_25_16 BLN16 dn_25_16 sky130_fd_pr_reram__reram_cell area_ox=0.0676
XMp_25_17 dp_25_17 WL25 SL17 VSS sky130_fd_pr__nfet_g5v0d10v5 w=1 l=0.5
XRp_25_17 BLP17 dp_25_17 sky130_fd_pr_reram__reram_cell area_ox=0.0676
XMn_25_17 dn_25_17 WL25 SL17 VSS sky130_fd_pr__nfet_g5v0d10v5 w=1 l=0.5
XRn_25_17 BLN17 dn_25_17 sky130_fd_pr_reram__reram_cell area_ox=0.0676
XMp_25_18 dp_25_18 WL25 SL18 VSS sky130_fd_pr__nfet_g5v0d10v5 w=1 l=0.5
XRp_25_18 BLP18 dp_25_18 sky130_fd_pr_reram__reram_cell area_ox=0.0676
XMn_25_18 dn_25_18 WL25 SL18 VSS sky130_fd_pr__nfet_g5v0d10v5 w=1 l=0.5
XRn_25_18 BLN18 dn_25_18 sky130_fd_pr_reram__reram_cell area_ox=0.0676
XMp_25_19 dp_25_19 WL25 SL19 VSS sky130_fd_pr__nfet_g5v0d10v5 w=1 l=0.5
XRp_25_19 BLP19 dp_25_19 sky130_fd_pr_reram__reram_cell area_ox=0.0676
XMn_25_19 dn_25_19 WL25 SL19 VSS sky130_fd_pr__nfet_g5v0d10v5 w=1 l=0.5
XRn_25_19 BLN19 dn_25_19 sky130_fd_pr_reram__reram_cell area_ox=0.0676
XMp_25_20 dp_25_20 WL25 SL20 VSS sky130_fd_pr__nfet_g5v0d10v5 w=1 l=0.5
XRp_25_20 BLP20 dp_25_20 sky130_fd_pr_reram__reram_cell area_ox=0.0676
XMn_25_20 dn_25_20 WL25 SL20 VSS sky130_fd_pr__nfet_g5v0d10v5 w=1 l=0.5
XRn_25_20 BLN20 dn_25_20 sky130_fd_pr_reram__reram_cell area_ox=0.0676
XMp_25_21 dp_25_21 WL25 SL21 VSS sky130_fd_pr__nfet_g5v0d10v5 w=1 l=0.5
XRp_25_21 BLP21 dp_25_21 sky130_fd_pr_reram__reram_cell area_ox=0.0676
XMn_25_21 dn_25_21 WL25 SL21 VSS sky130_fd_pr__nfet_g5v0d10v5 w=1 l=0.5
XRn_25_21 BLN21 dn_25_21 sky130_fd_pr_reram__reram_cell area_ox=0.0676
XMp_25_22 dp_25_22 WL25 SL22 VSS sky130_fd_pr__nfet_g5v0d10v5 w=1 l=0.5
XRp_25_22 BLP22 dp_25_22 sky130_fd_pr_reram__reram_cell area_ox=0.0676
XMn_25_22 dn_25_22 WL25 SL22 VSS sky130_fd_pr__nfet_g5v0d10v5 w=1 l=0.5
XRn_25_22 BLN22 dn_25_22 sky130_fd_pr_reram__reram_cell area_ox=0.0676
XMp_25_23 dp_25_23 WL25 SL23 VSS sky130_fd_pr__nfet_g5v0d10v5 w=1 l=0.5
XRp_25_23 BLP23 dp_25_23 sky130_fd_pr_reram__reram_cell area_ox=0.0676
XMn_25_23 dn_25_23 WL25 SL23 VSS sky130_fd_pr__nfet_g5v0d10v5 w=1 l=0.5
XRn_25_23 BLN23 dn_25_23 sky130_fd_pr_reram__reram_cell area_ox=0.0676
XMp_26_0 dp_26_0 WL26 SL0 VSS sky130_fd_pr__nfet_g5v0d10v5 w=1 l=0.5
XRp_26_0 BLP0 dp_26_0 sky130_fd_pr_reram__reram_cell area_ox=0.0676
XMn_26_0 dn_26_0 WL26 SL0 VSS sky130_fd_pr__nfet_g5v0d10v5 w=1 l=0.5
XRn_26_0 BLN0 dn_26_0 sky130_fd_pr_reram__reram_cell area_ox=0.0676
XMp_26_1 dp_26_1 WL26 SL1 VSS sky130_fd_pr__nfet_g5v0d10v5 w=1 l=0.5
XRp_26_1 BLP1 dp_26_1 sky130_fd_pr_reram__reram_cell area_ox=0.0676
XMn_26_1 dn_26_1 WL26 SL1 VSS sky130_fd_pr__nfet_g5v0d10v5 w=1 l=0.5
XRn_26_1 BLN1 dn_26_1 sky130_fd_pr_reram__reram_cell area_ox=0.0676
XMp_26_2 dp_26_2 WL26 SL2 VSS sky130_fd_pr__nfet_g5v0d10v5 w=1 l=0.5
XRp_26_2 BLP2 dp_26_2 sky130_fd_pr_reram__reram_cell area_ox=0.0676
XMn_26_2 dn_26_2 WL26 SL2 VSS sky130_fd_pr__nfet_g5v0d10v5 w=1 l=0.5
XRn_26_2 BLN2 dn_26_2 sky130_fd_pr_reram__reram_cell area_ox=0.0676
XMp_26_3 dp_26_3 WL26 SL3 VSS sky130_fd_pr__nfet_g5v0d10v5 w=1 l=0.5
XRp_26_3 BLP3 dp_26_3 sky130_fd_pr_reram__reram_cell area_ox=0.0676
XMn_26_3 dn_26_3 WL26 SL3 VSS sky130_fd_pr__nfet_g5v0d10v5 w=1 l=0.5
XRn_26_3 BLN3 dn_26_3 sky130_fd_pr_reram__reram_cell area_ox=0.0676
XMp_26_4 dp_26_4 WL26 SL4 VSS sky130_fd_pr__nfet_g5v0d10v5 w=1 l=0.5
XRp_26_4 BLP4 dp_26_4 sky130_fd_pr_reram__reram_cell area_ox=0.0676
XMn_26_4 dn_26_4 WL26 SL4 VSS sky130_fd_pr__nfet_g5v0d10v5 w=1 l=0.5
XRn_26_4 BLN4 dn_26_4 sky130_fd_pr_reram__reram_cell area_ox=0.0676
XMp_26_5 dp_26_5 WL26 SL5 VSS sky130_fd_pr__nfet_g5v0d10v5 w=1 l=0.5
XRp_26_5 BLP5 dp_26_5 sky130_fd_pr_reram__reram_cell area_ox=0.0676
XMn_26_5 dn_26_5 WL26 SL5 VSS sky130_fd_pr__nfet_g5v0d10v5 w=1 l=0.5
XRn_26_5 BLN5 dn_26_5 sky130_fd_pr_reram__reram_cell area_ox=0.0676
XMp_26_6 dp_26_6 WL26 SL6 VSS sky130_fd_pr__nfet_g5v0d10v5 w=1 l=0.5
XRp_26_6 BLP6 dp_26_6 sky130_fd_pr_reram__reram_cell area_ox=0.0676
XMn_26_6 dn_26_6 WL26 SL6 VSS sky130_fd_pr__nfet_g5v0d10v5 w=1 l=0.5
XRn_26_6 BLN6 dn_26_6 sky130_fd_pr_reram__reram_cell area_ox=0.0676
XMp_26_7 dp_26_7 WL26 SL7 VSS sky130_fd_pr__nfet_g5v0d10v5 w=1 l=0.5
XRp_26_7 BLP7 dp_26_7 sky130_fd_pr_reram__reram_cell area_ox=0.0676
XMn_26_7 dn_26_7 WL26 SL7 VSS sky130_fd_pr__nfet_g5v0d10v5 w=1 l=0.5
XRn_26_7 BLN7 dn_26_7 sky130_fd_pr_reram__reram_cell area_ox=0.0676
XMp_26_8 dp_26_8 WL26 SL8 VSS sky130_fd_pr__nfet_g5v0d10v5 w=1 l=0.5
XRp_26_8 BLP8 dp_26_8 sky130_fd_pr_reram__reram_cell area_ox=0.0676
XMn_26_8 dn_26_8 WL26 SL8 VSS sky130_fd_pr__nfet_g5v0d10v5 w=1 l=0.5
XRn_26_8 BLN8 dn_26_8 sky130_fd_pr_reram__reram_cell area_ox=0.0676
XMp_26_9 dp_26_9 WL26 SL9 VSS sky130_fd_pr__nfet_g5v0d10v5 w=1 l=0.5
XRp_26_9 BLP9 dp_26_9 sky130_fd_pr_reram__reram_cell area_ox=0.0676
XMn_26_9 dn_26_9 WL26 SL9 VSS sky130_fd_pr__nfet_g5v0d10v5 w=1 l=0.5
XRn_26_9 BLN9 dn_26_9 sky130_fd_pr_reram__reram_cell area_ox=0.0676
XMp_26_10 dp_26_10 WL26 SL10 VSS sky130_fd_pr__nfet_g5v0d10v5 w=1 l=0.5
XRp_26_10 BLP10 dp_26_10 sky130_fd_pr_reram__reram_cell area_ox=0.0676
XMn_26_10 dn_26_10 WL26 SL10 VSS sky130_fd_pr__nfet_g5v0d10v5 w=1 l=0.5
XRn_26_10 BLN10 dn_26_10 sky130_fd_pr_reram__reram_cell area_ox=0.0676
XMp_26_11 dp_26_11 WL26 SL11 VSS sky130_fd_pr__nfet_g5v0d10v5 w=1 l=0.5
XRp_26_11 BLP11 dp_26_11 sky130_fd_pr_reram__reram_cell area_ox=0.0676
XMn_26_11 dn_26_11 WL26 SL11 VSS sky130_fd_pr__nfet_g5v0d10v5 w=1 l=0.5
XRn_26_11 BLN11 dn_26_11 sky130_fd_pr_reram__reram_cell area_ox=0.0676
XMp_26_12 dp_26_12 WL26 SL12 VSS sky130_fd_pr__nfet_g5v0d10v5 w=1 l=0.5
XRp_26_12 BLP12 dp_26_12 sky130_fd_pr_reram__reram_cell area_ox=0.0676
XMn_26_12 dn_26_12 WL26 SL12 VSS sky130_fd_pr__nfet_g5v0d10v5 w=1 l=0.5
XRn_26_12 BLN12 dn_26_12 sky130_fd_pr_reram__reram_cell area_ox=0.0676
XMp_26_13 dp_26_13 WL26 SL13 VSS sky130_fd_pr__nfet_g5v0d10v5 w=1 l=0.5
XRp_26_13 BLP13 dp_26_13 sky130_fd_pr_reram__reram_cell area_ox=0.0676
XMn_26_13 dn_26_13 WL26 SL13 VSS sky130_fd_pr__nfet_g5v0d10v5 w=1 l=0.5
XRn_26_13 BLN13 dn_26_13 sky130_fd_pr_reram__reram_cell area_ox=0.0676
XMp_26_14 dp_26_14 WL26 SL14 VSS sky130_fd_pr__nfet_g5v0d10v5 w=1 l=0.5
XRp_26_14 BLP14 dp_26_14 sky130_fd_pr_reram__reram_cell area_ox=0.0676
XMn_26_14 dn_26_14 WL26 SL14 VSS sky130_fd_pr__nfet_g5v0d10v5 w=1 l=0.5
XRn_26_14 BLN14 dn_26_14 sky130_fd_pr_reram__reram_cell area_ox=0.0676
XMp_26_15 dp_26_15 WL26 SL15 VSS sky130_fd_pr__nfet_g5v0d10v5 w=1 l=0.5
XRp_26_15 BLP15 dp_26_15 sky130_fd_pr_reram__reram_cell area_ox=0.0676
XMn_26_15 dn_26_15 WL26 SL15 VSS sky130_fd_pr__nfet_g5v0d10v5 w=1 l=0.5
XRn_26_15 BLN15 dn_26_15 sky130_fd_pr_reram__reram_cell area_ox=0.0676
XMp_26_16 dp_26_16 WL26 SL16 VSS sky130_fd_pr__nfet_g5v0d10v5 w=1 l=0.5
XRp_26_16 BLP16 dp_26_16 sky130_fd_pr_reram__reram_cell area_ox=0.0676
XMn_26_16 dn_26_16 WL26 SL16 VSS sky130_fd_pr__nfet_g5v0d10v5 w=1 l=0.5
XRn_26_16 BLN16 dn_26_16 sky130_fd_pr_reram__reram_cell area_ox=0.0676
XMp_26_17 dp_26_17 WL26 SL17 VSS sky130_fd_pr__nfet_g5v0d10v5 w=1 l=0.5
XRp_26_17 BLP17 dp_26_17 sky130_fd_pr_reram__reram_cell area_ox=0.0676
XMn_26_17 dn_26_17 WL26 SL17 VSS sky130_fd_pr__nfet_g5v0d10v5 w=1 l=0.5
XRn_26_17 BLN17 dn_26_17 sky130_fd_pr_reram__reram_cell area_ox=0.0676
XMp_26_18 dp_26_18 WL26 SL18 VSS sky130_fd_pr__nfet_g5v0d10v5 w=1 l=0.5
XRp_26_18 BLP18 dp_26_18 sky130_fd_pr_reram__reram_cell area_ox=0.0676
XMn_26_18 dn_26_18 WL26 SL18 VSS sky130_fd_pr__nfet_g5v0d10v5 w=1 l=0.5
XRn_26_18 BLN18 dn_26_18 sky130_fd_pr_reram__reram_cell area_ox=0.0676
XMp_26_19 dp_26_19 WL26 SL19 VSS sky130_fd_pr__nfet_g5v0d10v5 w=1 l=0.5
XRp_26_19 BLP19 dp_26_19 sky130_fd_pr_reram__reram_cell area_ox=0.0676
XMn_26_19 dn_26_19 WL26 SL19 VSS sky130_fd_pr__nfet_g5v0d10v5 w=1 l=0.5
XRn_26_19 BLN19 dn_26_19 sky130_fd_pr_reram__reram_cell area_ox=0.0676
XMp_26_20 dp_26_20 WL26 SL20 VSS sky130_fd_pr__nfet_g5v0d10v5 w=1 l=0.5
XRp_26_20 BLP20 dp_26_20 sky130_fd_pr_reram__reram_cell area_ox=0.0676
XMn_26_20 dn_26_20 WL26 SL20 VSS sky130_fd_pr__nfet_g5v0d10v5 w=1 l=0.5
XRn_26_20 BLN20 dn_26_20 sky130_fd_pr_reram__reram_cell area_ox=0.0676
XMp_26_21 dp_26_21 WL26 SL21 VSS sky130_fd_pr__nfet_g5v0d10v5 w=1 l=0.5
XRp_26_21 BLP21 dp_26_21 sky130_fd_pr_reram__reram_cell area_ox=0.0676
XMn_26_21 dn_26_21 WL26 SL21 VSS sky130_fd_pr__nfet_g5v0d10v5 w=1 l=0.5
XRn_26_21 BLN21 dn_26_21 sky130_fd_pr_reram__reram_cell area_ox=0.0676
XMp_26_22 dp_26_22 WL26 SL22 VSS sky130_fd_pr__nfet_g5v0d10v5 w=1 l=0.5
XRp_26_22 BLP22 dp_26_22 sky130_fd_pr_reram__reram_cell area_ox=0.0676
XMn_26_22 dn_26_22 WL26 SL22 VSS sky130_fd_pr__nfet_g5v0d10v5 w=1 l=0.5
XRn_26_22 BLN22 dn_26_22 sky130_fd_pr_reram__reram_cell area_ox=0.0676
XMp_26_23 dp_26_23 WL26 SL23 VSS sky130_fd_pr__nfet_g5v0d10v5 w=1 l=0.5
XRp_26_23 BLP23 dp_26_23 sky130_fd_pr_reram__reram_cell area_ox=0.0676
XMn_26_23 dn_26_23 WL26 SL23 VSS sky130_fd_pr__nfet_g5v0d10v5 w=1 l=0.5
XRn_26_23 BLN23 dn_26_23 sky130_fd_pr_reram__reram_cell area_ox=0.0676
XMp_27_0 dp_27_0 WL27 SL0 VSS sky130_fd_pr__nfet_g5v0d10v5 w=1 l=0.5
XRp_27_0 BLP0 dp_27_0 sky130_fd_pr_reram__reram_cell area_ox=0.0676
XMn_27_0 dn_27_0 WL27 SL0 VSS sky130_fd_pr__nfet_g5v0d10v5 w=1 l=0.5
XRn_27_0 BLN0 dn_27_0 sky130_fd_pr_reram__reram_cell area_ox=0.0676
XMp_27_1 dp_27_1 WL27 SL1 VSS sky130_fd_pr__nfet_g5v0d10v5 w=1 l=0.5
XRp_27_1 BLP1 dp_27_1 sky130_fd_pr_reram__reram_cell area_ox=0.0676
XMn_27_1 dn_27_1 WL27 SL1 VSS sky130_fd_pr__nfet_g5v0d10v5 w=1 l=0.5
XRn_27_1 BLN1 dn_27_1 sky130_fd_pr_reram__reram_cell area_ox=0.0676
XMp_27_2 dp_27_2 WL27 SL2 VSS sky130_fd_pr__nfet_g5v0d10v5 w=1 l=0.5
XRp_27_2 BLP2 dp_27_2 sky130_fd_pr_reram__reram_cell area_ox=0.0676
XMn_27_2 dn_27_2 WL27 SL2 VSS sky130_fd_pr__nfet_g5v0d10v5 w=1 l=0.5
XRn_27_2 BLN2 dn_27_2 sky130_fd_pr_reram__reram_cell area_ox=0.0676
XMp_27_3 dp_27_3 WL27 SL3 VSS sky130_fd_pr__nfet_g5v0d10v5 w=1 l=0.5
XRp_27_3 BLP3 dp_27_3 sky130_fd_pr_reram__reram_cell area_ox=0.0676
XMn_27_3 dn_27_3 WL27 SL3 VSS sky130_fd_pr__nfet_g5v0d10v5 w=1 l=0.5
XRn_27_3 BLN3 dn_27_3 sky130_fd_pr_reram__reram_cell area_ox=0.0676
XMp_27_4 dp_27_4 WL27 SL4 VSS sky130_fd_pr__nfet_g5v0d10v5 w=1 l=0.5
XRp_27_4 BLP4 dp_27_4 sky130_fd_pr_reram__reram_cell area_ox=0.0676
XMn_27_4 dn_27_4 WL27 SL4 VSS sky130_fd_pr__nfet_g5v0d10v5 w=1 l=0.5
XRn_27_4 BLN4 dn_27_4 sky130_fd_pr_reram__reram_cell area_ox=0.0676
XMp_27_5 dp_27_5 WL27 SL5 VSS sky130_fd_pr__nfet_g5v0d10v5 w=1 l=0.5
XRp_27_5 BLP5 dp_27_5 sky130_fd_pr_reram__reram_cell area_ox=0.0676
XMn_27_5 dn_27_5 WL27 SL5 VSS sky130_fd_pr__nfet_g5v0d10v5 w=1 l=0.5
XRn_27_5 BLN5 dn_27_5 sky130_fd_pr_reram__reram_cell area_ox=0.0676
XMp_27_6 dp_27_6 WL27 SL6 VSS sky130_fd_pr__nfet_g5v0d10v5 w=1 l=0.5
XRp_27_6 BLP6 dp_27_6 sky130_fd_pr_reram__reram_cell area_ox=0.0676
XMn_27_6 dn_27_6 WL27 SL6 VSS sky130_fd_pr__nfet_g5v0d10v5 w=1 l=0.5
XRn_27_6 BLN6 dn_27_6 sky130_fd_pr_reram__reram_cell area_ox=0.0676
XMp_27_7 dp_27_7 WL27 SL7 VSS sky130_fd_pr__nfet_g5v0d10v5 w=1 l=0.5
XRp_27_7 BLP7 dp_27_7 sky130_fd_pr_reram__reram_cell area_ox=0.0676
XMn_27_7 dn_27_7 WL27 SL7 VSS sky130_fd_pr__nfet_g5v0d10v5 w=1 l=0.5
XRn_27_7 BLN7 dn_27_7 sky130_fd_pr_reram__reram_cell area_ox=0.0676
XMp_27_8 dp_27_8 WL27 SL8 VSS sky130_fd_pr__nfet_g5v0d10v5 w=1 l=0.5
XRp_27_8 BLP8 dp_27_8 sky130_fd_pr_reram__reram_cell area_ox=0.0676
XMn_27_8 dn_27_8 WL27 SL8 VSS sky130_fd_pr__nfet_g5v0d10v5 w=1 l=0.5
XRn_27_8 BLN8 dn_27_8 sky130_fd_pr_reram__reram_cell area_ox=0.0676
XMp_27_9 dp_27_9 WL27 SL9 VSS sky130_fd_pr__nfet_g5v0d10v5 w=1 l=0.5
XRp_27_9 BLP9 dp_27_9 sky130_fd_pr_reram__reram_cell area_ox=0.0676
XMn_27_9 dn_27_9 WL27 SL9 VSS sky130_fd_pr__nfet_g5v0d10v5 w=1 l=0.5
XRn_27_9 BLN9 dn_27_9 sky130_fd_pr_reram__reram_cell area_ox=0.0676
XMp_27_10 dp_27_10 WL27 SL10 VSS sky130_fd_pr__nfet_g5v0d10v5 w=1 l=0.5
XRp_27_10 BLP10 dp_27_10 sky130_fd_pr_reram__reram_cell area_ox=0.0676
XMn_27_10 dn_27_10 WL27 SL10 VSS sky130_fd_pr__nfet_g5v0d10v5 w=1 l=0.5
XRn_27_10 BLN10 dn_27_10 sky130_fd_pr_reram__reram_cell area_ox=0.0676
XMp_27_11 dp_27_11 WL27 SL11 VSS sky130_fd_pr__nfet_g5v0d10v5 w=1 l=0.5
XRp_27_11 BLP11 dp_27_11 sky130_fd_pr_reram__reram_cell area_ox=0.0676
XMn_27_11 dn_27_11 WL27 SL11 VSS sky130_fd_pr__nfet_g5v0d10v5 w=1 l=0.5
XRn_27_11 BLN11 dn_27_11 sky130_fd_pr_reram__reram_cell area_ox=0.0676
XMp_27_12 dp_27_12 WL27 SL12 VSS sky130_fd_pr__nfet_g5v0d10v5 w=1 l=0.5
XRp_27_12 BLP12 dp_27_12 sky130_fd_pr_reram__reram_cell area_ox=0.0676
XMn_27_12 dn_27_12 WL27 SL12 VSS sky130_fd_pr__nfet_g5v0d10v5 w=1 l=0.5
XRn_27_12 BLN12 dn_27_12 sky130_fd_pr_reram__reram_cell area_ox=0.0676
XMp_27_13 dp_27_13 WL27 SL13 VSS sky130_fd_pr__nfet_g5v0d10v5 w=1 l=0.5
XRp_27_13 BLP13 dp_27_13 sky130_fd_pr_reram__reram_cell area_ox=0.0676
XMn_27_13 dn_27_13 WL27 SL13 VSS sky130_fd_pr__nfet_g5v0d10v5 w=1 l=0.5
XRn_27_13 BLN13 dn_27_13 sky130_fd_pr_reram__reram_cell area_ox=0.0676
XMp_27_14 dp_27_14 WL27 SL14 VSS sky130_fd_pr__nfet_g5v0d10v5 w=1 l=0.5
XRp_27_14 BLP14 dp_27_14 sky130_fd_pr_reram__reram_cell area_ox=0.0676
XMn_27_14 dn_27_14 WL27 SL14 VSS sky130_fd_pr__nfet_g5v0d10v5 w=1 l=0.5
XRn_27_14 BLN14 dn_27_14 sky130_fd_pr_reram__reram_cell area_ox=0.0676
XMp_27_15 dp_27_15 WL27 SL15 VSS sky130_fd_pr__nfet_g5v0d10v5 w=1 l=0.5
XRp_27_15 BLP15 dp_27_15 sky130_fd_pr_reram__reram_cell area_ox=0.0676
XMn_27_15 dn_27_15 WL27 SL15 VSS sky130_fd_pr__nfet_g5v0d10v5 w=1 l=0.5
XRn_27_15 BLN15 dn_27_15 sky130_fd_pr_reram__reram_cell area_ox=0.0676
XMp_27_16 dp_27_16 WL27 SL16 VSS sky130_fd_pr__nfet_g5v0d10v5 w=1 l=0.5
XRp_27_16 BLP16 dp_27_16 sky130_fd_pr_reram__reram_cell area_ox=0.0676
XMn_27_16 dn_27_16 WL27 SL16 VSS sky130_fd_pr__nfet_g5v0d10v5 w=1 l=0.5
XRn_27_16 BLN16 dn_27_16 sky130_fd_pr_reram__reram_cell area_ox=0.0676
XMp_27_17 dp_27_17 WL27 SL17 VSS sky130_fd_pr__nfet_g5v0d10v5 w=1 l=0.5
XRp_27_17 BLP17 dp_27_17 sky130_fd_pr_reram__reram_cell area_ox=0.0676
XMn_27_17 dn_27_17 WL27 SL17 VSS sky130_fd_pr__nfet_g5v0d10v5 w=1 l=0.5
XRn_27_17 BLN17 dn_27_17 sky130_fd_pr_reram__reram_cell area_ox=0.0676
XMp_27_18 dp_27_18 WL27 SL18 VSS sky130_fd_pr__nfet_g5v0d10v5 w=1 l=0.5
XRp_27_18 BLP18 dp_27_18 sky130_fd_pr_reram__reram_cell area_ox=0.0676
XMn_27_18 dn_27_18 WL27 SL18 VSS sky130_fd_pr__nfet_g5v0d10v5 w=1 l=0.5
XRn_27_18 BLN18 dn_27_18 sky130_fd_pr_reram__reram_cell area_ox=0.0676
XMp_27_19 dp_27_19 WL27 SL19 VSS sky130_fd_pr__nfet_g5v0d10v5 w=1 l=0.5
XRp_27_19 BLP19 dp_27_19 sky130_fd_pr_reram__reram_cell area_ox=0.0676
XMn_27_19 dn_27_19 WL27 SL19 VSS sky130_fd_pr__nfet_g5v0d10v5 w=1 l=0.5
XRn_27_19 BLN19 dn_27_19 sky130_fd_pr_reram__reram_cell area_ox=0.0676
XMp_27_20 dp_27_20 WL27 SL20 VSS sky130_fd_pr__nfet_g5v0d10v5 w=1 l=0.5
XRp_27_20 BLP20 dp_27_20 sky130_fd_pr_reram__reram_cell area_ox=0.0676
XMn_27_20 dn_27_20 WL27 SL20 VSS sky130_fd_pr__nfet_g5v0d10v5 w=1 l=0.5
XRn_27_20 BLN20 dn_27_20 sky130_fd_pr_reram__reram_cell area_ox=0.0676
XMp_27_21 dp_27_21 WL27 SL21 VSS sky130_fd_pr__nfet_g5v0d10v5 w=1 l=0.5
XRp_27_21 BLP21 dp_27_21 sky130_fd_pr_reram__reram_cell area_ox=0.0676
XMn_27_21 dn_27_21 WL27 SL21 VSS sky130_fd_pr__nfet_g5v0d10v5 w=1 l=0.5
XRn_27_21 BLN21 dn_27_21 sky130_fd_pr_reram__reram_cell area_ox=0.0676
XMp_27_22 dp_27_22 WL27 SL22 VSS sky130_fd_pr__nfet_g5v0d10v5 w=1 l=0.5
XRp_27_22 BLP22 dp_27_22 sky130_fd_pr_reram__reram_cell area_ox=0.0676
XMn_27_22 dn_27_22 WL27 SL22 VSS sky130_fd_pr__nfet_g5v0d10v5 w=1 l=0.5
XRn_27_22 BLN22 dn_27_22 sky130_fd_pr_reram__reram_cell area_ox=0.0676
XMp_27_23 dp_27_23 WL27 SL23 VSS sky130_fd_pr__nfet_g5v0d10v5 w=1 l=0.5
XRp_27_23 BLP23 dp_27_23 sky130_fd_pr_reram__reram_cell area_ox=0.0676
XMn_27_23 dn_27_23 WL27 SL23 VSS sky130_fd_pr__nfet_g5v0d10v5 w=1 l=0.5
XRn_27_23 BLN23 dn_27_23 sky130_fd_pr_reram__reram_cell area_ox=0.0676
XMp_28_0 dp_28_0 WL28 SL0 VSS sky130_fd_pr__nfet_g5v0d10v5 w=1 l=0.5
XRp_28_0 BLP0 dp_28_0 sky130_fd_pr_reram__reram_cell area_ox=0.0676
XMn_28_0 dn_28_0 WL28 SL0 VSS sky130_fd_pr__nfet_g5v0d10v5 w=1 l=0.5
XRn_28_0 BLN0 dn_28_0 sky130_fd_pr_reram__reram_cell area_ox=0.0676
XMp_28_1 dp_28_1 WL28 SL1 VSS sky130_fd_pr__nfet_g5v0d10v5 w=1 l=0.5
XRp_28_1 BLP1 dp_28_1 sky130_fd_pr_reram__reram_cell area_ox=0.0676
XMn_28_1 dn_28_1 WL28 SL1 VSS sky130_fd_pr__nfet_g5v0d10v5 w=1 l=0.5
XRn_28_1 BLN1 dn_28_1 sky130_fd_pr_reram__reram_cell area_ox=0.0676
XMp_28_2 dp_28_2 WL28 SL2 VSS sky130_fd_pr__nfet_g5v0d10v5 w=1 l=0.5
XRp_28_2 BLP2 dp_28_2 sky130_fd_pr_reram__reram_cell area_ox=0.0676
XMn_28_2 dn_28_2 WL28 SL2 VSS sky130_fd_pr__nfet_g5v0d10v5 w=1 l=0.5
XRn_28_2 BLN2 dn_28_2 sky130_fd_pr_reram__reram_cell area_ox=0.0676
XMp_28_3 dp_28_3 WL28 SL3 VSS sky130_fd_pr__nfet_g5v0d10v5 w=1 l=0.5
XRp_28_3 BLP3 dp_28_3 sky130_fd_pr_reram__reram_cell area_ox=0.0676
XMn_28_3 dn_28_3 WL28 SL3 VSS sky130_fd_pr__nfet_g5v0d10v5 w=1 l=0.5
XRn_28_3 BLN3 dn_28_3 sky130_fd_pr_reram__reram_cell area_ox=0.0676
XMp_28_4 dp_28_4 WL28 SL4 VSS sky130_fd_pr__nfet_g5v0d10v5 w=1 l=0.5
XRp_28_4 BLP4 dp_28_4 sky130_fd_pr_reram__reram_cell area_ox=0.0676
XMn_28_4 dn_28_4 WL28 SL4 VSS sky130_fd_pr__nfet_g5v0d10v5 w=1 l=0.5
XRn_28_4 BLN4 dn_28_4 sky130_fd_pr_reram__reram_cell area_ox=0.0676
XMp_28_5 dp_28_5 WL28 SL5 VSS sky130_fd_pr__nfet_g5v0d10v5 w=1 l=0.5
XRp_28_5 BLP5 dp_28_5 sky130_fd_pr_reram__reram_cell area_ox=0.0676
XMn_28_5 dn_28_5 WL28 SL5 VSS sky130_fd_pr__nfet_g5v0d10v5 w=1 l=0.5
XRn_28_5 BLN5 dn_28_5 sky130_fd_pr_reram__reram_cell area_ox=0.0676
XMp_28_6 dp_28_6 WL28 SL6 VSS sky130_fd_pr__nfet_g5v0d10v5 w=1 l=0.5
XRp_28_6 BLP6 dp_28_6 sky130_fd_pr_reram__reram_cell area_ox=0.0676
XMn_28_6 dn_28_6 WL28 SL6 VSS sky130_fd_pr__nfet_g5v0d10v5 w=1 l=0.5
XRn_28_6 BLN6 dn_28_6 sky130_fd_pr_reram__reram_cell area_ox=0.0676
XMp_28_7 dp_28_7 WL28 SL7 VSS sky130_fd_pr__nfet_g5v0d10v5 w=1 l=0.5
XRp_28_7 BLP7 dp_28_7 sky130_fd_pr_reram__reram_cell area_ox=0.0676
XMn_28_7 dn_28_7 WL28 SL7 VSS sky130_fd_pr__nfet_g5v0d10v5 w=1 l=0.5
XRn_28_7 BLN7 dn_28_7 sky130_fd_pr_reram__reram_cell area_ox=0.0676
XMp_28_8 dp_28_8 WL28 SL8 VSS sky130_fd_pr__nfet_g5v0d10v5 w=1 l=0.5
XRp_28_8 BLP8 dp_28_8 sky130_fd_pr_reram__reram_cell area_ox=0.0676
XMn_28_8 dn_28_8 WL28 SL8 VSS sky130_fd_pr__nfet_g5v0d10v5 w=1 l=0.5
XRn_28_8 BLN8 dn_28_8 sky130_fd_pr_reram__reram_cell area_ox=0.0676
XMp_28_9 dp_28_9 WL28 SL9 VSS sky130_fd_pr__nfet_g5v0d10v5 w=1 l=0.5
XRp_28_9 BLP9 dp_28_9 sky130_fd_pr_reram__reram_cell area_ox=0.0676
XMn_28_9 dn_28_9 WL28 SL9 VSS sky130_fd_pr__nfet_g5v0d10v5 w=1 l=0.5
XRn_28_9 BLN9 dn_28_9 sky130_fd_pr_reram__reram_cell area_ox=0.0676
XMp_28_10 dp_28_10 WL28 SL10 VSS sky130_fd_pr__nfet_g5v0d10v5 w=1 l=0.5
XRp_28_10 BLP10 dp_28_10 sky130_fd_pr_reram__reram_cell area_ox=0.0676
XMn_28_10 dn_28_10 WL28 SL10 VSS sky130_fd_pr__nfet_g5v0d10v5 w=1 l=0.5
XRn_28_10 BLN10 dn_28_10 sky130_fd_pr_reram__reram_cell area_ox=0.0676
XMp_28_11 dp_28_11 WL28 SL11 VSS sky130_fd_pr__nfet_g5v0d10v5 w=1 l=0.5
XRp_28_11 BLP11 dp_28_11 sky130_fd_pr_reram__reram_cell area_ox=0.0676
XMn_28_11 dn_28_11 WL28 SL11 VSS sky130_fd_pr__nfet_g5v0d10v5 w=1 l=0.5
XRn_28_11 BLN11 dn_28_11 sky130_fd_pr_reram__reram_cell area_ox=0.0676
XMp_28_12 dp_28_12 WL28 SL12 VSS sky130_fd_pr__nfet_g5v0d10v5 w=1 l=0.5
XRp_28_12 BLP12 dp_28_12 sky130_fd_pr_reram__reram_cell area_ox=0.0676
XMn_28_12 dn_28_12 WL28 SL12 VSS sky130_fd_pr__nfet_g5v0d10v5 w=1 l=0.5
XRn_28_12 BLN12 dn_28_12 sky130_fd_pr_reram__reram_cell area_ox=0.0676
XMp_28_13 dp_28_13 WL28 SL13 VSS sky130_fd_pr__nfet_g5v0d10v5 w=1 l=0.5
XRp_28_13 BLP13 dp_28_13 sky130_fd_pr_reram__reram_cell area_ox=0.0676
XMn_28_13 dn_28_13 WL28 SL13 VSS sky130_fd_pr__nfet_g5v0d10v5 w=1 l=0.5
XRn_28_13 BLN13 dn_28_13 sky130_fd_pr_reram__reram_cell area_ox=0.0676
XMp_28_14 dp_28_14 WL28 SL14 VSS sky130_fd_pr__nfet_g5v0d10v5 w=1 l=0.5
XRp_28_14 BLP14 dp_28_14 sky130_fd_pr_reram__reram_cell area_ox=0.0676
XMn_28_14 dn_28_14 WL28 SL14 VSS sky130_fd_pr__nfet_g5v0d10v5 w=1 l=0.5
XRn_28_14 BLN14 dn_28_14 sky130_fd_pr_reram__reram_cell area_ox=0.0676
XMp_28_15 dp_28_15 WL28 SL15 VSS sky130_fd_pr__nfet_g5v0d10v5 w=1 l=0.5
XRp_28_15 BLP15 dp_28_15 sky130_fd_pr_reram__reram_cell area_ox=0.0676
XMn_28_15 dn_28_15 WL28 SL15 VSS sky130_fd_pr__nfet_g5v0d10v5 w=1 l=0.5
XRn_28_15 BLN15 dn_28_15 sky130_fd_pr_reram__reram_cell area_ox=0.0676
XMp_28_16 dp_28_16 WL28 SL16 VSS sky130_fd_pr__nfet_g5v0d10v5 w=1 l=0.5
XRp_28_16 BLP16 dp_28_16 sky130_fd_pr_reram__reram_cell area_ox=0.0676
XMn_28_16 dn_28_16 WL28 SL16 VSS sky130_fd_pr__nfet_g5v0d10v5 w=1 l=0.5
XRn_28_16 BLN16 dn_28_16 sky130_fd_pr_reram__reram_cell area_ox=0.0676
XMp_28_17 dp_28_17 WL28 SL17 VSS sky130_fd_pr__nfet_g5v0d10v5 w=1 l=0.5
XRp_28_17 BLP17 dp_28_17 sky130_fd_pr_reram__reram_cell area_ox=0.0676
XMn_28_17 dn_28_17 WL28 SL17 VSS sky130_fd_pr__nfet_g5v0d10v5 w=1 l=0.5
XRn_28_17 BLN17 dn_28_17 sky130_fd_pr_reram__reram_cell area_ox=0.0676
XMp_28_18 dp_28_18 WL28 SL18 VSS sky130_fd_pr__nfet_g5v0d10v5 w=1 l=0.5
XRp_28_18 BLP18 dp_28_18 sky130_fd_pr_reram__reram_cell area_ox=0.0676
XMn_28_18 dn_28_18 WL28 SL18 VSS sky130_fd_pr__nfet_g5v0d10v5 w=1 l=0.5
XRn_28_18 BLN18 dn_28_18 sky130_fd_pr_reram__reram_cell area_ox=0.0676
XMp_28_19 dp_28_19 WL28 SL19 VSS sky130_fd_pr__nfet_g5v0d10v5 w=1 l=0.5
XRp_28_19 BLP19 dp_28_19 sky130_fd_pr_reram__reram_cell area_ox=0.0676
XMn_28_19 dn_28_19 WL28 SL19 VSS sky130_fd_pr__nfet_g5v0d10v5 w=1 l=0.5
XRn_28_19 BLN19 dn_28_19 sky130_fd_pr_reram__reram_cell area_ox=0.0676
XMp_28_20 dp_28_20 WL28 SL20 VSS sky130_fd_pr__nfet_g5v0d10v5 w=1 l=0.5
XRp_28_20 BLP20 dp_28_20 sky130_fd_pr_reram__reram_cell area_ox=0.0676
XMn_28_20 dn_28_20 WL28 SL20 VSS sky130_fd_pr__nfet_g5v0d10v5 w=1 l=0.5
XRn_28_20 BLN20 dn_28_20 sky130_fd_pr_reram__reram_cell area_ox=0.0676
XMp_28_21 dp_28_21 WL28 SL21 VSS sky130_fd_pr__nfet_g5v0d10v5 w=1 l=0.5
XRp_28_21 BLP21 dp_28_21 sky130_fd_pr_reram__reram_cell area_ox=0.0676
XMn_28_21 dn_28_21 WL28 SL21 VSS sky130_fd_pr__nfet_g5v0d10v5 w=1 l=0.5
XRn_28_21 BLN21 dn_28_21 sky130_fd_pr_reram__reram_cell area_ox=0.0676
XMp_28_22 dp_28_22 WL28 SL22 VSS sky130_fd_pr__nfet_g5v0d10v5 w=1 l=0.5
XRp_28_22 BLP22 dp_28_22 sky130_fd_pr_reram__reram_cell area_ox=0.0676
XMn_28_22 dn_28_22 WL28 SL22 VSS sky130_fd_pr__nfet_g5v0d10v5 w=1 l=0.5
XRn_28_22 BLN22 dn_28_22 sky130_fd_pr_reram__reram_cell area_ox=0.0676
XMp_28_23 dp_28_23 WL28 SL23 VSS sky130_fd_pr__nfet_g5v0d10v5 w=1 l=0.5
XRp_28_23 BLP23 dp_28_23 sky130_fd_pr_reram__reram_cell area_ox=0.0676
XMn_28_23 dn_28_23 WL28 SL23 VSS sky130_fd_pr__nfet_g5v0d10v5 w=1 l=0.5
XRn_28_23 BLN23 dn_28_23 sky130_fd_pr_reram__reram_cell area_ox=0.0676
XMp_29_0 dp_29_0 WL29 SL0 VSS sky130_fd_pr__nfet_g5v0d10v5 w=1 l=0.5
XRp_29_0 BLP0 dp_29_0 sky130_fd_pr_reram__reram_cell area_ox=0.0676
XMn_29_0 dn_29_0 WL29 SL0 VSS sky130_fd_pr__nfet_g5v0d10v5 w=1 l=0.5
XRn_29_0 BLN0 dn_29_0 sky130_fd_pr_reram__reram_cell area_ox=0.0676
XMp_29_1 dp_29_1 WL29 SL1 VSS sky130_fd_pr__nfet_g5v0d10v5 w=1 l=0.5
XRp_29_1 BLP1 dp_29_1 sky130_fd_pr_reram__reram_cell area_ox=0.0676
XMn_29_1 dn_29_1 WL29 SL1 VSS sky130_fd_pr__nfet_g5v0d10v5 w=1 l=0.5
XRn_29_1 BLN1 dn_29_1 sky130_fd_pr_reram__reram_cell area_ox=0.0676
XMp_29_2 dp_29_2 WL29 SL2 VSS sky130_fd_pr__nfet_g5v0d10v5 w=1 l=0.5
XRp_29_2 BLP2 dp_29_2 sky130_fd_pr_reram__reram_cell area_ox=0.0676
XMn_29_2 dn_29_2 WL29 SL2 VSS sky130_fd_pr__nfet_g5v0d10v5 w=1 l=0.5
XRn_29_2 BLN2 dn_29_2 sky130_fd_pr_reram__reram_cell area_ox=0.0676
XMp_29_3 dp_29_3 WL29 SL3 VSS sky130_fd_pr__nfet_g5v0d10v5 w=1 l=0.5
XRp_29_3 BLP3 dp_29_3 sky130_fd_pr_reram__reram_cell area_ox=0.0676
XMn_29_3 dn_29_3 WL29 SL3 VSS sky130_fd_pr__nfet_g5v0d10v5 w=1 l=0.5
XRn_29_3 BLN3 dn_29_3 sky130_fd_pr_reram__reram_cell area_ox=0.0676
XMp_29_4 dp_29_4 WL29 SL4 VSS sky130_fd_pr__nfet_g5v0d10v5 w=1 l=0.5
XRp_29_4 BLP4 dp_29_4 sky130_fd_pr_reram__reram_cell area_ox=0.0676
XMn_29_4 dn_29_4 WL29 SL4 VSS sky130_fd_pr__nfet_g5v0d10v5 w=1 l=0.5
XRn_29_4 BLN4 dn_29_4 sky130_fd_pr_reram__reram_cell area_ox=0.0676
XMp_29_5 dp_29_5 WL29 SL5 VSS sky130_fd_pr__nfet_g5v0d10v5 w=1 l=0.5
XRp_29_5 BLP5 dp_29_5 sky130_fd_pr_reram__reram_cell area_ox=0.0676
XMn_29_5 dn_29_5 WL29 SL5 VSS sky130_fd_pr__nfet_g5v0d10v5 w=1 l=0.5
XRn_29_5 BLN5 dn_29_5 sky130_fd_pr_reram__reram_cell area_ox=0.0676
XMp_29_6 dp_29_6 WL29 SL6 VSS sky130_fd_pr__nfet_g5v0d10v5 w=1 l=0.5
XRp_29_6 BLP6 dp_29_6 sky130_fd_pr_reram__reram_cell area_ox=0.0676
XMn_29_6 dn_29_6 WL29 SL6 VSS sky130_fd_pr__nfet_g5v0d10v5 w=1 l=0.5
XRn_29_6 BLN6 dn_29_6 sky130_fd_pr_reram__reram_cell area_ox=0.0676
XMp_29_7 dp_29_7 WL29 SL7 VSS sky130_fd_pr__nfet_g5v0d10v5 w=1 l=0.5
XRp_29_7 BLP7 dp_29_7 sky130_fd_pr_reram__reram_cell area_ox=0.0676
XMn_29_7 dn_29_7 WL29 SL7 VSS sky130_fd_pr__nfet_g5v0d10v5 w=1 l=0.5
XRn_29_7 BLN7 dn_29_7 sky130_fd_pr_reram__reram_cell area_ox=0.0676
XMp_29_8 dp_29_8 WL29 SL8 VSS sky130_fd_pr__nfet_g5v0d10v5 w=1 l=0.5
XRp_29_8 BLP8 dp_29_8 sky130_fd_pr_reram__reram_cell area_ox=0.0676
XMn_29_8 dn_29_8 WL29 SL8 VSS sky130_fd_pr__nfet_g5v0d10v5 w=1 l=0.5
XRn_29_8 BLN8 dn_29_8 sky130_fd_pr_reram__reram_cell area_ox=0.0676
XMp_29_9 dp_29_9 WL29 SL9 VSS sky130_fd_pr__nfet_g5v0d10v5 w=1 l=0.5
XRp_29_9 BLP9 dp_29_9 sky130_fd_pr_reram__reram_cell area_ox=0.0676
XMn_29_9 dn_29_9 WL29 SL9 VSS sky130_fd_pr__nfet_g5v0d10v5 w=1 l=0.5
XRn_29_9 BLN9 dn_29_9 sky130_fd_pr_reram__reram_cell area_ox=0.0676
XMp_29_10 dp_29_10 WL29 SL10 VSS sky130_fd_pr__nfet_g5v0d10v5 w=1 l=0.5
XRp_29_10 BLP10 dp_29_10 sky130_fd_pr_reram__reram_cell area_ox=0.0676
XMn_29_10 dn_29_10 WL29 SL10 VSS sky130_fd_pr__nfet_g5v0d10v5 w=1 l=0.5
XRn_29_10 BLN10 dn_29_10 sky130_fd_pr_reram__reram_cell area_ox=0.0676
XMp_29_11 dp_29_11 WL29 SL11 VSS sky130_fd_pr__nfet_g5v0d10v5 w=1 l=0.5
XRp_29_11 BLP11 dp_29_11 sky130_fd_pr_reram__reram_cell area_ox=0.0676
XMn_29_11 dn_29_11 WL29 SL11 VSS sky130_fd_pr__nfet_g5v0d10v5 w=1 l=0.5
XRn_29_11 BLN11 dn_29_11 sky130_fd_pr_reram__reram_cell area_ox=0.0676
XMp_29_12 dp_29_12 WL29 SL12 VSS sky130_fd_pr__nfet_g5v0d10v5 w=1 l=0.5
XRp_29_12 BLP12 dp_29_12 sky130_fd_pr_reram__reram_cell area_ox=0.0676
XMn_29_12 dn_29_12 WL29 SL12 VSS sky130_fd_pr__nfet_g5v0d10v5 w=1 l=0.5
XRn_29_12 BLN12 dn_29_12 sky130_fd_pr_reram__reram_cell area_ox=0.0676
XMp_29_13 dp_29_13 WL29 SL13 VSS sky130_fd_pr__nfet_g5v0d10v5 w=1 l=0.5
XRp_29_13 BLP13 dp_29_13 sky130_fd_pr_reram__reram_cell area_ox=0.0676
XMn_29_13 dn_29_13 WL29 SL13 VSS sky130_fd_pr__nfet_g5v0d10v5 w=1 l=0.5
XRn_29_13 BLN13 dn_29_13 sky130_fd_pr_reram__reram_cell area_ox=0.0676
XMp_29_14 dp_29_14 WL29 SL14 VSS sky130_fd_pr__nfet_g5v0d10v5 w=1 l=0.5
XRp_29_14 BLP14 dp_29_14 sky130_fd_pr_reram__reram_cell area_ox=0.0676
XMn_29_14 dn_29_14 WL29 SL14 VSS sky130_fd_pr__nfet_g5v0d10v5 w=1 l=0.5
XRn_29_14 BLN14 dn_29_14 sky130_fd_pr_reram__reram_cell area_ox=0.0676
XMp_29_15 dp_29_15 WL29 SL15 VSS sky130_fd_pr__nfet_g5v0d10v5 w=1 l=0.5
XRp_29_15 BLP15 dp_29_15 sky130_fd_pr_reram__reram_cell area_ox=0.0676
XMn_29_15 dn_29_15 WL29 SL15 VSS sky130_fd_pr__nfet_g5v0d10v5 w=1 l=0.5
XRn_29_15 BLN15 dn_29_15 sky130_fd_pr_reram__reram_cell area_ox=0.0676
XMp_29_16 dp_29_16 WL29 SL16 VSS sky130_fd_pr__nfet_g5v0d10v5 w=1 l=0.5
XRp_29_16 BLP16 dp_29_16 sky130_fd_pr_reram__reram_cell area_ox=0.0676
XMn_29_16 dn_29_16 WL29 SL16 VSS sky130_fd_pr__nfet_g5v0d10v5 w=1 l=0.5
XRn_29_16 BLN16 dn_29_16 sky130_fd_pr_reram__reram_cell area_ox=0.0676
XMp_29_17 dp_29_17 WL29 SL17 VSS sky130_fd_pr__nfet_g5v0d10v5 w=1 l=0.5
XRp_29_17 BLP17 dp_29_17 sky130_fd_pr_reram__reram_cell area_ox=0.0676
XMn_29_17 dn_29_17 WL29 SL17 VSS sky130_fd_pr__nfet_g5v0d10v5 w=1 l=0.5
XRn_29_17 BLN17 dn_29_17 sky130_fd_pr_reram__reram_cell area_ox=0.0676
XMp_29_18 dp_29_18 WL29 SL18 VSS sky130_fd_pr__nfet_g5v0d10v5 w=1 l=0.5
XRp_29_18 BLP18 dp_29_18 sky130_fd_pr_reram__reram_cell area_ox=0.0676
XMn_29_18 dn_29_18 WL29 SL18 VSS sky130_fd_pr__nfet_g5v0d10v5 w=1 l=0.5
XRn_29_18 BLN18 dn_29_18 sky130_fd_pr_reram__reram_cell area_ox=0.0676
XMp_29_19 dp_29_19 WL29 SL19 VSS sky130_fd_pr__nfet_g5v0d10v5 w=1 l=0.5
XRp_29_19 BLP19 dp_29_19 sky130_fd_pr_reram__reram_cell area_ox=0.0676
XMn_29_19 dn_29_19 WL29 SL19 VSS sky130_fd_pr__nfet_g5v0d10v5 w=1 l=0.5
XRn_29_19 BLN19 dn_29_19 sky130_fd_pr_reram__reram_cell area_ox=0.0676
XMp_29_20 dp_29_20 WL29 SL20 VSS sky130_fd_pr__nfet_g5v0d10v5 w=1 l=0.5
XRp_29_20 BLP20 dp_29_20 sky130_fd_pr_reram__reram_cell area_ox=0.0676
XMn_29_20 dn_29_20 WL29 SL20 VSS sky130_fd_pr__nfet_g5v0d10v5 w=1 l=0.5
XRn_29_20 BLN20 dn_29_20 sky130_fd_pr_reram__reram_cell area_ox=0.0676
XMp_29_21 dp_29_21 WL29 SL21 VSS sky130_fd_pr__nfet_g5v0d10v5 w=1 l=0.5
XRp_29_21 BLP21 dp_29_21 sky130_fd_pr_reram__reram_cell area_ox=0.0676
XMn_29_21 dn_29_21 WL29 SL21 VSS sky130_fd_pr__nfet_g5v0d10v5 w=1 l=0.5
XRn_29_21 BLN21 dn_29_21 sky130_fd_pr_reram__reram_cell area_ox=0.0676
XMp_29_22 dp_29_22 WL29 SL22 VSS sky130_fd_pr__nfet_g5v0d10v5 w=1 l=0.5
XRp_29_22 BLP22 dp_29_22 sky130_fd_pr_reram__reram_cell area_ox=0.0676
XMn_29_22 dn_29_22 WL29 SL22 VSS sky130_fd_pr__nfet_g5v0d10v5 w=1 l=0.5
XRn_29_22 BLN22 dn_29_22 sky130_fd_pr_reram__reram_cell area_ox=0.0676
XMp_29_23 dp_29_23 WL29 SL23 VSS sky130_fd_pr__nfet_g5v0d10v5 w=1 l=0.5
XRp_29_23 BLP23 dp_29_23 sky130_fd_pr_reram__reram_cell area_ox=0.0676
XMn_29_23 dn_29_23 WL29 SL23 VSS sky130_fd_pr__nfet_g5v0d10v5 w=1 l=0.5
XRn_29_23 BLN23 dn_29_23 sky130_fd_pr_reram__reram_cell area_ox=0.0676
XMp_30_0 dp_30_0 WL30 SL0 VSS sky130_fd_pr__nfet_g5v0d10v5 w=1 l=0.5
XRp_30_0 BLP0 dp_30_0 sky130_fd_pr_reram__reram_cell area_ox=0.0676
XMn_30_0 dn_30_0 WL30 SL0 VSS sky130_fd_pr__nfet_g5v0d10v5 w=1 l=0.5
XRn_30_0 BLN0 dn_30_0 sky130_fd_pr_reram__reram_cell area_ox=0.0676
XMp_30_1 dp_30_1 WL30 SL1 VSS sky130_fd_pr__nfet_g5v0d10v5 w=1 l=0.5
XRp_30_1 BLP1 dp_30_1 sky130_fd_pr_reram__reram_cell area_ox=0.0676
XMn_30_1 dn_30_1 WL30 SL1 VSS sky130_fd_pr__nfet_g5v0d10v5 w=1 l=0.5
XRn_30_1 BLN1 dn_30_1 sky130_fd_pr_reram__reram_cell area_ox=0.0676
XMp_30_2 dp_30_2 WL30 SL2 VSS sky130_fd_pr__nfet_g5v0d10v5 w=1 l=0.5
XRp_30_2 BLP2 dp_30_2 sky130_fd_pr_reram__reram_cell area_ox=0.0676
XMn_30_2 dn_30_2 WL30 SL2 VSS sky130_fd_pr__nfet_g5v0d10v5 w=1 l=0.5
XRn_30_2 BLN2 dn_30_2 sky130_fd_pr_reram__reram_cell area_ox=0.0676
XMp_30_3 dp_30_3 WL30 SL3 VSS sky130_fd_pr__nfet_g5v0d10v5 w=1 l=0.5
XRp_30_3 BLP3 dp_30_3 sky130_fd_pr_reram__reram_cell area_ox=0.0676
XMn_30_3 dn_30_3 WL30 SL3 VSS sky130_fd_pr__nfet_g5v0d10v5 w=1 l=0.5
XRn_30_3 BLN3 dn_30_3 sky130_fd_pr_reram__reram_cell area_ox=0.0676
XMp_30_4 dp_30_4 WL30 SL4 VSS sky130_fd_pr__nfet_g5v0d10v5 w=1 l=0.5
XRp_30_4 BLP4 dp_30_4 sky130_fd_pr_reram__reram_cell area_ox=0.0676
XMn_30_4 dn_30_4 WL30 SL4 VSS sky130_fd_pr__nfet_g5v0d10v5 w=1 l=0.5
XRn_30_4 BLN4 dn_30_4 sky130_fd_pr_reram__reram_cell area_ox=0.0676
XMp_30_5 dp_30_5 WL30 SL5 VSS sky130_fd_pr__nfet_g5v0d10v5 w=1 l=0.5
XRp_30_5 BLP5 dp_30_5 sky130_fd_pr_reram__reram_cell area_ox=0.0676
XMn_30_5 dn_30_5 WL30 SL5 VSS sky130_fd_pr__nfet_g5v0d10v5 w=1 l=0.5
XRn_30_5 BLN5 dn_30_5 sky130_fd_pr_reram__reram_cell area_ox=0.0676
XMp_30_6 dp_30_6 WL30 SL6 VSS sky130_fd_pr__nfet_g5v0d10v5 w=1 l=0.5
XRp_30_6 BLP6 dp_30_6 sky130_fd_pr_reram__reram_cell area_ox=0.0676
XMn_30_6 dn_30_6 WL30 SL6 VSS sky130_fd_pr__nfet_g5v0d10v5 w=1 l=0.5
XRn_30_6 BLN6 dn_30_6 sky130_fd_pr_reram__reram_cell area_ox=0.0676
XMp_30_7 dp_30_7 WL30 SL7 VSS sky130_fd_pr__nfet_g5v0d10v5 w=1 l=0.5
XRp_30_7 BLP7 dp_30_7 sky130_fd_pr_reram__reram_cell area_ox=0.0676
XMn_30_7 dn_30_7 WL30 SL7 VSS sky130_fd_pr__nfet_g5v0d10v5 w=1 l=0.5
XRn_30_7 BLN7 dn_30_7 sky130_fd_pr_reram__reram_cell area_ox=0.0676
XMp_30_8 dp_30_8 WL30 SL8 VSS sky130_fd_pr__nfet_g5v0d10v5 w=1 l=0.5
XRp_30_8 BLP8 dp_30_8 sky130_fd_pr_reram__reram_cell area_ox=0.0676
XMn_30_8 dn_30_8 WL30 SL8 VSS sky130_fd_pr__nfet_g5v0d10v5 w=1 l=0.5
XRn_30_8 BLN8 dn_30_8 sky130_fd_pr_reram__reram_cell area_ox=0.0676
XMp_30_9 dp_30_9 WL30 SL9 VSS sky130_fd_pr__nfet_g5v0d10v5 w=1 l=0.5
XRp_30_9 BLP9 dp_30_9 sky130_fd_pr_reram__reram_cell area_ox=0.0676
XMn_30_9 dn_30_9 WL30 SL9 VSS sky130_fd_pr__nfet_g5v0d10v5 w=1 l=0.5
XRn_30_9 BLN9 dn_30_9 sky130_fd_pr_reram__reram_cell area_ox=0.0676
XMp_30_10 dp_30_10 WL30 SL10 VSS sky130_fd_pr__nfet_g5v0d10v5 w=1 l=0.5
XRp_30_10 BLP10 dp_30_10 sky130_fd_pr_reram__reram_cell area_ox=0.0676
XMn_30_10 dn_30_10 WL30 SL10 VSS sky130_fd_pr__nfet_g5v0d10v5 w=1 l=0.5
XRn_30_10 BLN10 dn_30_10 sky130_fd_pr_reram__reram_cell area_ox=0.0676
XMp_30_11 dp_30_11 WL30 SL11 VSS sky130_fd_pr__nfet_g5v0d10v5 w=1 l=0.5
XRp_30_11 BLP11 dp_30_11 sky130_fd_pr_reram__reram_cell area_ox=0.0676
XMn_30_11 dn_30_11 WL30 SL11 VSS sky130_fd_pr__nfet_g5v0d10v5 w=1 l=0.5
XRn_30_11 BLN11 dn_30_11 sky130_fd_pr_reram__reram_cell area_ox=0.0676
XMp_30_12 dp_30_12 WL30 SL12 VSS sky130_fd_pr__nfet_g5v0d10v5 w=1 l=0.5
XRp_30_12 BLP12 dp_30_12 sky130_fd_pr_reram__reram_cell area_ox=0.0676
XMn_30_12 dn_30_12 WL30 SL12 VSS sky130_fd_pr__nfet_g5v0d10v5 w=1 l=0.5
XRn_30_12 BLN12 dn_30_12 sky130_fd_pr_reram__reram_cell area_ox=0.0676
XMp_30_13 dp_30_13 WL30 SL13 VSS sky130_fd_pr__nfet_g5v0d10v5 w=1 l=0.5
XRp_30_13 BLP13 dp_30_13 sky130_fd_pr_reram__reram_cell area_ox=0.0676
XMn_30_13 dn_30_13 WL30 SL13 VSS sky130_fd_pr__nfet_g5v0d10v5 w=1 l=0.5
XRn_30_13 BLN13 dn_30_13 sky130_fd_pr_reram__reram_cell area_ox=0.0676
XMp_30_14 dp_30_14 WL30 SL14 VSS sky130_fd_pr__nfet_g5v0d10v5 w=1 l=0.5
XRp_30_14 BLP14 dp_30_14 sky130_fd_pr_reram__reram_cell area_ox=0.0676
XMn_30_14 dn_30_14 WL30 SL14 VSS sky130_fd_pr__nfet_g5v0d10v5 w=1 l=0.5
XRn_30_14 BLN14 dn_30_14 sky130_fd_pr_reram__reram_cell area_ox=0.0676
XMp_30_15 dp_30_15 WL30 SL15 VSS sky130_fd_pr__nfet_g5v0d10v5 w=1 l=0.5
XRp_30_15 BLP15 dp_30_15 sky130_fd_pr_reram__reram_cell area_ox=0.0676
XMn_30_15 dn_30_15 WL30 SL15 VSS sky130_fd_pr__nfet_g5v0d10v5 w=1 l=0.5
XRn_30_15 BLN15 dn_30_15 sky130_fd_pr_reram__reram_cell area_ox=0.0676
XMp_30_16 dp_30_16 WL30 SL16 VSS sky130_fd_pr__nfet_g5v0d10v5 w=1 l=0.5
XRp_30_16 BLP16 dp_30_16 sky130_fd_pr_reram__reram_cell area_ox=0.0676
XMn_30_16 dn_30_16 WL30 SL16 VSS sky130_fd_pr__nfet_g5v0d10v5 w=1 l=0.5
XRn_30_16 BLN16 dn_30_16 sky130_fd_pr_reram__reram_cell area_ox=0.0676
XMp_30_17 dp_30_17 WL30 SL17 VSS sky130_fd_pr__nfet_g5v0d10v5 w=1 l=0.5
XRp_30_17 BLP17 dp_30_17 sky130_fd_pr_reram__reram_cell area_ox=0.0676
XMn_30_17 dn_30_17 WL30 SL17 VSS sky130_fd_pr__nfet_g5v0d10v5 w=1 l=0.5
XRn_30_17 BLN17 dn_30_17 sky130_fd_pr_reram__reram_cell area_ox=0.0676
XMp_30_18 dp_30_18 WL30 SL18 VSS sky130_fd_pr__nfet_g5v0d10v5 w=1 l=0.5
XRp_30_18 BLP18 dp_30_18 sky130_fd_pr_reram__reram_cell area_ox=0.0676
XMn_30_18 dn_30_18 WL30 SL18 VSS sky130_fd_pr__nfet_g5v0d10v5 w=1 l=0.5
XRn_30_18 BLN18 dn_30_18 sky130_fd_pr_reram__reram_cell area_ox=0.0676
XMp_30_19 dp_30_19 WL30 SL19 VSS sky130_fd_pr__nfet_g5v0d10v5 w=1 l=0.5
XRp_30_19 BLP19 dp_30_19 sky130_fd_pr_reram__reram_cell area_ox=0.0676
XMn_30_19 dn_30_19 WL30 SL19 VSS sky130_fd_pr__nfet_g5v0d10v5 w=1 l=0.5
XRn_30_19 BLN19 dn_30_19 sky130_fd_pr_reram__reram_cell area_ox=0.0676
XMp_30_20 dp_30_20 WL30 SL20 VSS sky130_fd_pr__nfet_g5v0d10v5 w=1 l=0.5
XRp_30_20 BLP20 dp_30_20 sky130_fd_pr_reram__reram_cell area_ox=0.0676
XMn_30_20 dn_30_20 WL30 SL20 VSS sky130_fd_pr__nfet_g5v0d10v5 w=1 l=0.5
XRn_30_20 BLN20 dn_30_20 sky130_fd_pr_reram__reram_cell area_ox=0.0676
XMp_30_21 dp_30_21 WL30 SL21 VSS sky130_fd_pr__nfet_g5v0d10v5 w=1 l=0.5
XRp_30_21 BLP21 dp_30_21 sky130_fd_pr_reram__reram_cell area_ox=0.0676
XMn_30_21 dn_30_21 WL30 SL21 VSS sky130_fd_pr__nfet_g5v0d10v5 w=1 l=0.5
XRn_30_21 BLN21 dn_30_21 sky130_fd_pr_reram__reram_cell area_ox=0.0676
XMp_30_22 dp_30_22 WL30 SL22 VSS sky130_fd_pr__nfet_g5v0d10v5 w=1 l=0.5
XRp_30_22 BLP22 dp_30_22 sky130_fd_pr_reram__reram_cell area_ox=0.0676
XMn_30_22 dn_30_22 WL30 SL22 VSS sky130_fd_pr__nfet_g5v0d10v5 w=1 l=0.5
XRn_30_22 BLN22 dn_30_22 sky130_fd_pr_reram__reram_cell area_ox=0.0676
XMp_30_23 dp_30_23 WL30 SL23 VSS sky130_fd_pr__nfet_g5v0d10v5 w=1 l=0.5
XRp_30_23 BLP23 dp_30_23 sky130_fd_pr_reram__reram_cell area_ox=0.0676
XMn_30_23 dn_30_23 WL30 SL23 VSS sky130_fd_pr__nfet_g5v0d10v5 w=1 l=0.5
XRn_30_23 BLN23 dn_30_23 sky130_fd_pr_reram__reram_cell area_ox=0.0676
XMp_31_0 dp_31_0 WL31 SL0 VSS sky130_fd_pr__nfet_g5v0d10v5 w=1 l=0.5
XRp_31_0 BLP0 dp_31_0 sky130_fd_pr_reram__reram_cell area_ox=0.0676
XMn_31_0 dn_31_0 WL31 SL0 VSS sky130_fd_pr__nfet_g5v0d10v5 w=1 l=0.5
XRn_31_0 BLN0 dn_31_0 sky130_fd_pr_reram__reram_cell area_ox=0.0676
XMp_31_1 dp_31_1 WL31 SL1 VSS sky130_fd_pr__nfet_g5v0d10v5 w=1 l=0.5
XRp_31_1 BLP1 dp_31_1 sky130_fd_pr_reram__reram_cell area_ox=0.0676
XMn_31_1 dn_31_1 WL31 SL1 VSS sky130_fd_pr__nfet_g5v0d10v5 w=1 l=0.5
XRn_31_1 BLN1 dn_31_1 sky130_fd_pr_reram__reram_cell area_ox=0.0676
XMp_31_2 dp_31_2 WL31 SL2 VSS sky130_fd_pr__nfet_g5v0d10v5 w=1 l=0.5
XRp_31_2 BLP2 dp_31_2 sky130_fd_pr_reram__reram_cell area_ox=0.0676
XMn_31_2 dn_31_2 WL31 SL2 VSS sky130_fd_pr__nfet_g5v0d10v5 w=1 l=0.5
XRn_31_2 BLN2 dn_31_2 sky130_fd_pr_reram__reram_cell area_ox=0.0676
XMp_31_3 dp_31_3 WL31 SL3 VSS sky130_fd_pr__nfet_g5v0d10v5 w=1 l=0.5
XRp_31_3 BLP3 dp_31_3 sky130_fd_pr_reram__reram_cell area_ox=0.0676
XMn_31_3 dn_31_3 WL31 SL3 VSS sky130_fd_pr__nfet_g5v0d10v5 w=1 l=0.5
XRn_31_3 BLN3 dn_31_3 sky130_fd_pr_reram__reram_cell area_ox=0.0676
XMp_31_4 dp_31_4 WL31 SL4 VSS sky130_fd_pr__nfet_g5v0d10v5 w=1 l=0.5
XRp_31_4 BLP4 dp_31_4 sky130_fd_pr_reram__reram_cell area_ox=0.0676
XMn_31_4 dn_31_4 WL31 SL4 VSS sky130_fd_pr__nfet_g5v0d10v5 w=1 l=0.5
XRn_31_4 BLN4 dn_31_4 sky130_fd_pr_reram__reram_cell area_ox=0.0676
XMp_31_5 dp_31_5 WL31 SL5 VSS sky130_fd_pr__nfet_g5v0d10v5 w=1 l=0.5
XRp_31_5 BLP5 dp_31_5 sky130_fd_pr_reram__reram_cell area_ox=0.0676
XMn_31_5 dn_31_5 WL31 SL5 VSS sky130_fd_pr__nfet_g5v0d10v5 w=1 l=0.5
XRn_31_5 BLN5 dn_31_5 sky130_fd_pr_reram__reram_cell area_ox=0.0676
XMp_31_6 dp_31_6 WL31 SL6 VSS sky130_fd_pr__nfet_g5v0d10v5 w=1 l=0.5
XRp_31_6 BLP6 dp_31_6 sky130_fd_pr_reram__reram_cell area_ox=0.0676
XMn_31_6 dn_31_6 WL31 SL6 VSS sky130_fd_pr__nfet_g5v0d10v5 w=1 l=0.5
XRn_31_6 BLN6 dn_31_6 sky130_fd_pr_reram__reram_cell area_ox=0.0676
XMp_31_7 dp_31_7 WL31 SL7 VSS sky130_fd_pr__nfet_g5v0d10v5 w=1 l=0.5
XRp_31_7 BLP7 dp_31_7 sky130_fd_pr_reram__reram_cell area_ox=0.0676
XMn_31_7 dn_31_7 WL31 SL7 VSS sky130_fd_pr__nfet_g5v0d10v5 w=1 l=0.5
XRn_31_7 BLN7 dn_31_7 sky130_fd_pr_reram__reram_cell area_ox=0.0676
XMp_31_8 dp_31_8 WL31 SL8 VSS sky130_fd_pr__nfet_g5v0d10v5 w=1 l=0.5
XRp_31_8 BLP8 dp_31_8 sky130_fd_pr_reram__reram_cell area_ox=0.0676
XMn_31_8 dn_31_8 WL31 SL8 VSS sky130_fd_pr__nfet_g5v0d10v5 w=1 l=0.5
XRn_31_8 BLN8 dn_31_8 sky130_fd_pr_reram__reram_cell area_ox=0.0676
XMp_31_9 dp_31_9 WL31 SL9 VSS sky130_fd_pr__nfet_g5v0d10v5 w=1 l=0.5
XRp_31_9 BLP9 dp_31_9 sky130_fd_pr_reram__reram_cell area_ox=0.0676
XMn_31_9 dn_31_9 WL31 SL9 VSS sky130_fd_pr__nfet_g5v0d10v5 w=1 l=0.5
XRn_31_9 BLN9 dn_31_9 sky130_fd_pr_reram__reram_cell area_ox=0.0676
XMp_31_10 dp_31_10 WL31 SL10 VSS sky130_fd_pr__nfet_g5v0d10v5 w=1 l=0.5
XRp_31_10 BLP10 dp_31_10 sky130_fd_pr_reram__reram_cell area_ox=0.0676
XMn_31_10 dn_31_10 WL31 SL10 VSS sky130_fd_pr__nfet_g5v0d10v5 w=1 l=0.5
XRn_31_10 BLN10 dn_31_10 sky130_fd_pr_reram__reram_cell area_ox=0.0676
XMp_31_11 dp_31_11 WL31 SL11 VSS sky130_fd_pr__nfet_g5v0d10v5 w=1 l=0.5
XRp_31_11 BLP11 dp_31_11 sky130_fd_pr_reram__reram_cell area_ox=0.0676
XMn_31_11 dn_31_11 WL31 SL11 VSS sky130_fd_pr__nfet_g5v0d10v5 w=1 l=0.5
XRn_31_11 BLN11 dn_31_11 sky130_fd_pr_reram__reram_cell area_ox=0.0676
XMp_31_12 dp_31_12 WL31 SL12 VSS sky130_fd_pr__nfet_g5v0d10v5 w=1 l=0.5
XRp_31_12 BLP12 dp_31_12 sky130_fd_pr_reram__reram_cell area_ox=0.0676
XMn_31_12 dn_31_12 WL31 SL12 VSS sky130_fd_pr__nfet_g5v0d10v5 w=1 l=0.5
XRn_31_12 BLN12 dn_31_12 sky130_fd_pr_reram__reram_cell area_ox=0.0676
XMp_31_13 dp_31_13 WL31 SL13 VSS sky130_fd_pr__nfet_g5v0d10v5 w=1 l=0.5
XRp_31_13 BLP13 dp_31_13 sky130_fd_pr_reram__reram_cell area_ox=0.0676
XMn_31_13 dn_31_13 WL31 SL13 VSS sky130_fd_pr__nfet_g5v0d10v5 w=1 l=0.5
XRn_31_13 BLN13 dn_31_13 sky130_fd_pr_reram__reram_cell area_ox=0.0676
XMp_31_14 dp_31_14 WL31 SL14 VSS sky130_fd_pr__nfet_g5v0d10v5 w=1 l=0.5
XRp_31_14 BLP14 dp_31_14 sky130_fd_pr_reram__reram_cell area_ox=0.0676
XMn_31_14 dn_31_14 WL31 SL14 VSS sky130_fd_pr__nfet_g5v0d10v5 w=1 l=0.5
XRn_31_14 BLN14 dn_31_14 sky130_fd_pr_reram__reram_cell area_ox=0.0676
XMp_31_15 dp_31_15 WL31 SL15 VSS sky130_fd_pr__nfet_g5v0d10v5 w=1 l=0.5
XRp_31_15 BLP15 dp_31_15 sky130_fd_pr_reram__reram_cell area_ox=0.0676
XMn_31_15 dn_31_15 WL31 SL15 VSS sky130_fd_pr__nfet_g5v0d10v5 w=1 l=0.5
XRn_31_15 BLN15 dn_31_15 sky130_fd_pr_reram__reram_cell area_ox=0.0676
XMp_31_16 dp_31_16 WL31 SL16 VSS sky130_fd_pr__nfet_g5v0d10v5 w=1 l=0.5
XRp_31_16 BLP16 dp_31_16 sky130_fd_pr_reram__reram_cell area_ox=0.0676
XMn_31_16 dn_31_16 WL31 SL16 VSS sky130_fd_pr__nfet_g5v0d10v5 w=1 l=0.5
XRn_31_16 BLN16 dn_31_16 sky130_fd_pr_reram__reram_cell area_ox=0.0676
XMp_31_17 dp_31_17 WL31 SL17 VSS sky130_fd_pr__nfet_g5v0d10v5 w=1 l=0.5
XRp_31_17 BLP17 dp_31_17 sky130_fd_pr_reram__reram_cell area_ox=0.0676
XMn_31_17 dn_31_17 WL31 SL17 VSS sky130_fd_pr__nfet_g5v0d10v5 w=1 l=0.5
XRn_31_17 BLN17 dn_31_17 sky130_fd_pr_reram__reram_cell area_ox=0.0676
XMp_31_18 dp_31_18 WL31 SL18 VSS sky130_fd_pr__nfet_g5v0d10v5 w=1 l=0.5
XRp_31_18 BLP18 dp_31_18 sky130_fd_pr_reram__reram_cell area_ox=0.0676
XMn_31_18 dn_31_18 WL31 SL18 VSS sky130_fd_pr__nfet_g5v0d10v5 w=1 l=0.5
XRn_31_18 BLN18 dn_31_18 sky130_fd_pr_reram__reram_cell area_ox=0.0676
XMp_31_19 dp_31_19 WL31 SL19 VSS sky130_fd_pr__nfet_g5v0d10v5 w=1 l=0.5
XRp_31_19 BLP19 dp_31_19 sky130_fd_pr_reram__reram_cell area_ox=0.0676
XMn_31_19 dn_31_19 WL31 SL19 VSS sky130_fd_pr__nfet_g5v0d10v5 w=1 l=0.5
XRn_31_19 BLN19 dn_31_19 sky130_fd_pr_reram__reram_cell area_ox=0.0676
XMp_31_20 dp_31_20 WL31 SL20 VSS sky130_fd_pr__nfet_g5v0d10v5 w=1 l=0.5
XRp_31_20 BLP20 dp_31_20 sky130_fd_pr_reram__reram_cell area_ox=0.0676
XMn_31_20 dn_31_20 WL31 SL20 VSS sky130_fd_pr__nfet_g5v0d10v5 w=1 l=0.5
XRn_31_20 BLN20 dn_31_20 sky130_fd_pr_reram__reram_cell area_ox=0.0676
XMp_31_21 dp_31_21 WL31 SL21 VSS sky130_fd_pr__nfet_g5v0d10v5 w=1 l=0.5
XRp_31_21 BLP21 dp_31_21 sky130_fd_pr_reram__reram_cell area_ox=0.0676
XMn_31_21 dn_31_21 WL31 SL21 VSS sky130_fd_pr__nfet_g5v0d10v5 w=1 l=0.5
XRn_31_21 BLN21 dn_31_21 sky130_fd_pr_reram__reram_cell area_ox=0.0676
XMp_31_22 dp_31_22 WL31 SL22 VSS sky130_fd_pr__nfet_g5v0d10v5 w=1 l=0.5
XRp_31_22 BLP22 dp_31_22 sky130_fd_pr_reram__reram_cell area_ox=0.0676
XMn_31_22 dn_31_22 WL31 SL22 VSS sky130_fd_pr__nfet_g5v0d10v5 w=1 l=0.5
XRn_31_22 BLN22 dn_31_22 sky130_fd_pr_reram__reram_cell area_ox=0.0676
XMp_31_23 dp_31_23 WL31 SL23 VSS sky130_fd_pr__nfet_g5v0d10v5 w=1 l=0.5
XRp_31_23 BLP23 dp_31_23 sky130_fd_pr_reram__reram_cell area_ox=0.0676
XMn_31_23 dn_31_23 WL31 SL23 VSS sky130_fd_pr__nfet_g5v0d10v5 w=1 l=0.5
XRn_31_23 BLN23 dn_31_23 sky130_fd_pr_reram__reram_cell area_ox=0.0676
XMp_32_0 dp_32_0 WL32 SL0 VSS sky130_fd_pr__nfet_g5v0d10v5 w=1 l=0.5
XRp_32_0 BLP0 dp_32_0 sky130_fd_pr_reram__reram_cell area_ox=0.0676
XMn_32_0 dn_32_0 WL32 SL0 VSS sky130_fd_pr__nfet_g5v0d10v5 w=1 l=0.5
XRn_32_0 BLN0 dn_32_0 sky130_fd_pr_reram__reram_cell area_ox=0.0676
XMp_32_1 dp_32_1 WL32 SL1 VSS sky130_fd_pr__nfet_g5v0d10v5 w=1 l=0.5
XRp_32_1 BLP1 dp_32_1 sky130_fd_pr_reram__reram_cell area_ox=0.0676
XMn_32_1 dn_32_1 WL32 SL1 VSS sky130_fd_pr__nfet_g5v0d10v5 w=1 l=0.5
XRn_32_1 BLN1 dn_32_1 sky130_fd_pr_reram__reram_cell area_ox=0.0676
XMp_32_2 dp_32_2 WL32 SL2 VSS sky130_fd_pr__nfet_g5v0d10v5 w=1 l=0.5
XRp_32_2 BLP2 dp_32_2 sky130_fd_pr_reram__reram_cell area_ox=0.0676
XMn_32_2 dn_32_2 WL32 SL2 VSS sky130_fd_pr__nfet_g5v0d10v5 w=1 l=0.5
XRn_32_2 BLN2 dn_32_2 sky130_fd_pr_reram__reram_cell area_ox=0.0676
XMp_32_3 dp_32_3 WL32 SL3 VSS sky130_fd_pr__nfet_g5v0d10v5 w=1 l=0.5
XRp_32_3 BLP3 dp_32_3 sky130_fd_pr_reram__reram_cell area_ox=0.0676
XMn_32_3 dn_32_3 WL32 SL3 VSS sky130_fd_pr__nfet_g5v0d10v5 w=1 l=0.5
XRn_32_3 BLN3 dn_32_3 sky130_fd_pr_reram__reram_cell area_ox=0.0676
XMp_32_4 dp_32_4 WL32 SL4 VSS sky130_fd_pr__nfet_g5v0d10v5 w=1 l=0.5
XRp_32_4 BLP4 dp_32_4 sky130_fd_pr_reram__reram_cell area_ox=0.0676
XMn_32_4 dn_32_4 WL32 SL4 VSS sky130_fd_pr__nfet_g5v0d10v5 w=1 l=0.5
XRn_32_4 BLN4 dn_32_4 sky130_fd_pr_reram__reram_cell area_ox=0.0676
XMp_32_5 dp_32_5 WL32 SL5 VSS sky130_fd_pr__nfet_g5v0d10v5 w=1 l=0.5
XRp_32_5 BLP5 dp_32_5 sky130_fd_pr_reram__reram_cell area_ox=0.0676
XMn_32_5 dn_32_5 WL32 SL5 VSS sky130_fd_pr__nfet_g5v0d10v5 w=1 l=0.5
XRn_32_5 BLN5 dn_32_5 sky130_fd_pr_reram__reram_cell area_ox=0.0676
XMp_32_6 dp_32_6 WL32 SL6 VSS sky130_fd_pr__nfet_g5v0d10v5 w=1 l=0.5
XRp_32_6 BLP6 dp_32_6 sky130_fd_pr_reram__reram_cell area_ox=0.0676
XMn_32_6 dn_32_6 WL32 SL6 VSS sky130_fd_pr__nfet_g5v0d10v5 w=1 l=0.5
XRn_32_6 BLN6 dn_32_6 sky130_fd_pr_reram__reram_cell area_ox=0.0676
XMp_32_7 dp_32_7 WL32 SL7 VSS sky130_fd_pr__nfet_g5v0d10v5 w=1 l=0.5
XRp_32_7 BLP7 dp_32_7 sky130_fd_pr_reram__reram_cell area_ox=0.0676
XMn_32_7 dn_32_7 WL32 SL7 VSS sky130_fd_pr__nfet_g5v0d10v5 w=1 l=0.5
XRn_32_7 BLN7 dn_32_7 sky130_fd_pr_reram__reram_cell area_ox=0.0676
XMp_32_8 dp_32_8 WL32 SL8 VSS sky130_fd_pr__nfet_g5v0d10v5 w=1 l=0.5
XRp_32_8 BLP8 dp_32_8 sky130_fd_pr_reram__reram_cell area_ox=0.0676
XMn_32_8 dn_32_8 WL32 SL8 VSS sky130_fd_pr__nfet_g5v0d10v5 w=1 l=0.5
XRn_32_8 BLN8 dn_32_8 sky130_fd_pr_reram__reram_cell area_ox=0.0676
XMp_32_9 dp_32_9 WL32 SL9 VSS sky130_fd_pr__nfet_g5v0d10v5 w=1 l=0.5
XRp_32_9 BLP9 dp_32_9 sky130_fd_pr_reram__reram_cell area_ox=0.0676
XMn_32_9 dn_32_9 WL32 SL9 VSS sky130_fd_pr__nfet_g5v0d10v5 w=1 l=0.5
XRn_32_9 BLN9 dn_32_9 sky130_fd_pr_reram__reram_cell area_ox=0.0676
XMp_32_10 dp_32_10 WL32 SL10 VSS sky130_fd_pr__nfet_g5v0d10v5 w=1 l=0.5
XRp_32_10 BLP10 dp_32_10 sky130_fd_pr_reram__reram_cell area_ox=0.0676
XMn_32_10 dn_32_10 WL32 SL10 VSS sky130_fd_pr__nfet_g5v0d10v5 w=1 l=0.5
XRn_32_10 BLN10 dn_32_10 sky130_fd_pr_reram__reram_cell area_ox=0.0676
XMp_32_11 dp_32_11 WL32 SL11 VSS sky130_fd_pr__nfet_g5v0d10v5 w=1 l=0.5
XRp_32_11 BLP11 dp_32_11 sky130_fd_pr_reram__reram_cell area_ox=0.0676
XMn_32_11 dn_32_11 WL32 SL11 VSS sky130_fd_pr__nfet_g5v0d10v5 w=1 l=0.5
XRn_32_11 BLN11 dn_32_11 sky130_fd_pr_reram__reram_cell area_ox=0.0676
XMp_32_12 dp_32_12 WL32 SL12 VSS sky130_fd_pr__nfet_g5v0d10v5 w=1 l=0.5
XRp_32_12 BLP12 dp_32_12 sky130_fd_pr_reram__reram_cell area_ox=0.0676
XMn_32_12 dn_32_12 WL32 SL12 VSS sky130_fd_pr__nfet_g5v0d10v5 w=1 l=0.5
XRn_32_12 BLN12 dn_32_12 sky130_fd_pr_reram__reram_cell area_ox=0.0676
XMp_32_13 dp_32_13 WL32 SL13 VSS sky130_fd_pr__nfet_g5v0d10v5 w=1 l=0.5
XRp_32_13 BLP13 dp_32_13 sky130_fd_pr_reram__reram_cell area_ox=0.0676
XMn_32_13 dn_32_13 WL32 SL13 VSS sky130_fd_pr__nfet_g5v0d10v5 w=1 l=0.5
XRn_32_13 BLN13 dn_32_13 sky130_fd_pr_reram__reram_cell area_ox=0.0676
XMp_32_14 dp_32_14 WL32 SL14 VSS sky130_fd_pr__nfet_g5v0d10v5 w=1 l=0.5
XRp_32_14 BLP14 dp_32_14 sky130_fd_pr_reram__reram_cell area_ox=0.0676
XMn_32_14 dn_32_14 WL32 SL14 VSS sky130_fd_pr__nfet_g5v0d10v5 w=1 l=0.5
XRn_32_14 BLN14 dn_32_14 sky130_fd_pr_reram__reram_cell area_ox=0.0676
XMp_32_15 dp_32_15 WL32 SL15 VSS sky130_fd_pr__nfet_g5v0d10v5 w=1 l=0.5
XRp_32_15 BLP15 dp_32_15 sky130_fd_pr_reram__reram_cell area_ox=0.0676
XMn_32_15 dn_32_15 WL32 SL15 VSS sky130_fd_pr__nfet_g5v0d10v5 w=1 l=0.5
XRn_32_15 BLN15 dn_32_15 sky130_fd_pr_reram__reram_cell area_ox=0.0676
XMp_32_16 dp_32_16 WL32 SL16 VSS sky130_fd_pr__nfet_g5v0d10v5 w=1 l=0.5
XRp_32_16 BLP16 dp_32_16 sky130_fd_pr_reram__reram_cell area_ox=0.0676
XMn_32_16 dn_32_16 WL32 SL16 VSS sky130_fd_pr__nfet_g5v0d10v5 w=1 l=0.5
XRn_32_16 BLN16 dn_32_16 sky130_fd_pr_reram__reram_cell area_ox=0.0676
XMp_32_17 dp_32_17 WL32 SL17 VSS sky130_fd_pr__nfet_g5v0d10v5 w=1 l=0.5
XRp_32_17 BLP17 dp_32_17 sky130_fd_pr_reram__reram_cell area_ox=0.0676
XMn_32_17 dn_32_17 WL32 SL17 VSS sky130_fd_pr__nfet_g5v0d10v5 w=1 l=0.5
XRn_32_17 BLN17 dn_32_17 sky130_fd_pr_reram__reram_cell area_ox=0.0676
XMp_32_18 dp_32_18 WL32 SL18 VSS sky130_fd_pr__nfet_g5v0d10v5 w=1 l=0.5
XRp_32_18 BLP18 dp_32_18 sky130_fd_pr_reram__reram_cell area_ox=0.0676
XMn_32_18 dn_32_18 WL32 SL18 VSS sky130_fd_pr__nfet_g5v0d10v5 w=1 l=0.5
XRn_32_18 BLN18 dn_32_18 sky130_fd_pr_reram__reram_cell area_ox=0.0676
XMp_32_19 dp_32_19 WL32 SL19 VSS sky130_fd_pr__nfet_g5v0d10v5 w=1 l=0.5
XRp_32_19 BLP19 dp_32_19 sky130_fd_pr_reram__reram_cell area_ox=0.0676
XMn_32_19 dn_32_19 WL32 SL19 VSS sky130_fd_pr__nfet_g5v0d10v5 w=1 l=0.5
XRn_32_19 BLN19 dn_32_19 sky130_fd_pr_reram__reram_cell area_ox=0.0676
XMp_32_20 dp_32_20 WL32 SL20 VSS sky130_fd_pr__nfet_g5v0d10v5 w=1 l=0.5
XRp_32_20 BLP20 dp_32_20 sky130_fd_pr_reram__reram_cell area_ox=0.0676
XMn_32_20 dn_32_20 WL32 SL20 VSS sky130_fd_pr__nfet_g5v0d10v5 w=1 l=0.5
XRn_32_20 BLN20 dn_32_20 sky130_fd_pr_reram__reram_cell area_ox=0.0676
XMp_32_21 dp_32_21 WL32 SL21 VSS sky130_fd_pr__nfet_g5v0d10v5 w=1 l=0.5
XRp_32_21 BLP21 dp_32_21 sky130_fd_pr_reram__reram_cell area_ox=0.0676
XMn_32_21 dn_32_21 WL32 SL21 VSS sky130_fd_pr__nfet_g5v0d10v5 w=1 l=0.5
XRn_32_21 BLN21 dn_32_21 sky130_fd_pr_reram__reram_cell area_ox=0.0676
XMp_32_22 dp_32_22 WL32 SL22 VSS sky130_fd_pr__nfet_g5v0d10v5 w=1 l=0.5
XRp_32_22 BLP22 dp_32_22 sky130_fd_pr_reram__reram_cell area_ox=0.0676
XMn_32_22 dn_32_22 WL32 SL22 VSS sky130_fd_pr__nfet_g5v0d10v5 w=1 l=0.5
XRn_32_22 BLN22 dn_32_22 sky130_fd_pr_reram__reram_cell area_ox=0.0676
XMp_32_23 dp_32_23 WL32 SL23 VSS sky130_fd_pr__nfet_g5v0d10v5 w=1 l=0.5
XRp_32_23 BLP23 dp_32_23 sky130_fd_pr_reram__reram_cell area_ox=0.0676
XMn_32_23 dn_32_23 WL32 SL23 VSS sky130_fd_pr__nfet_g5v0d10v5 w=1 l=0.5
XRn_32_23 BLN23 dn_32_23 sky130_fd_pr_reram__reram_cell area_ox=0.0676
XMp_33_0 dp_33_0 WL33 SL0 VSS sky130_fd_pr__nfet_g5v0d10v5 w=1 l=0.5
XRp_33_0 BLP0 dp_33_0 sky130_fd_pr_reram__reram_cell area_ox=0.0676
XMn_33_0 dn_33_0 WL33 SL0 VSS sky130_fd_pr__nfet_g5v0d10v5 w=1 l=0.5
XRn_33_0 BLN0 dn_33_0 sky130_fd_pr_reram__reram_cell area_ox=0.0676
XMp_33_1 dp_33_1 WL33 SL1 VSS sky130_fd_pr__nfet_g5v0d10v5 w=1 l=0.5
XRp_33_1 BLP1 dp_33_1 sky130_fd_pr_reram__reram_cell area_ox=0.0676
XMn_33_1 dn_33_1 WL33 SL1 VSS sky130_fd_pr__nfet_g5v0d10v5 w=1 l=0.5
XRn_33_1 BLN1 dn_33_1 sky130_fd_pr_reram__reram_cell area_ox=0.0676
XMp_33_2 dp_33_2 WL33 SL2 VSS sky130_fd_pr__nfet_g5v0d10v5 w=1 l=0.5
XRp_33_2 BLP2 dp_33_2 sky130_fd_pr_reram__reram_cell area_ox=0.0676
XMn_33_2 dn_33_2 WL33 SL2 VSS sky130_fd_pr__nfet_g5v0d10v5 w=1 l=0.5
XRn_33_2 BLN2 dn_33_2 sky130_fd_pr_reram__reram_cell area_ox=0.0676
XMp_33_3 dp_33_3 WL33 SL3 VSS sky130_fd_pr__nfet_g5v0d10v5 w=1 l=0.5
XRp_33_3 BLP3 dp_33_3 sky130_fd_pr_reram__reram_cell area_ox=0.0676
XMn_33_3 dn_33_3 WL33 SL3 VSS sky130_fd_pr__nfet_g5v0d10v5 w=1 l=0.5
XRn_33_3 BLN3 dn_33_3 sky130_fd_pr_reram__reram_cell area_ox=0.0676
XMp_33_4 dp_33_4 WL33 SL4 VSS sky130_fd_pr__nfet_g5v0d10v5 w=1 l=0.5
XRp_33_4 BLP4 dp_33_4 sky130_fd_pr_reram__reram_cell area_ox=0.0676
XMn_33_4 dn_33_4 WL33 SL4 VSS sky130_fd_pr__nfet_g5v0d10v5 w=1 l=0.5
XRn_33_4 BLN4 dn_33_4 sky130_fd_pr_reram__reram_cell area_ox=0.0676
XMp_33_5 dp_33_5 WL33 SL5 VSS sky130_fd_pr__nfet_g5v0d10v5 w=1 l=0.5
XRp_33_5 BLP5 dp_33_5 sky130_fd_pr_reram__reram_cell area_ox=0.0676
XMn_33_5 dn_33_5 WL33 SL5 VSS sky130_fd_pr__nfet_g5v0d10v5 w=1 l=0.5
XRn_33_5 BLN5 dn_33_5 sky130_fd_pr_reram__reram_cell area_ox=0.0676
XMp_33_6 dp_33_6 WL33 SL6 VSS sky130_fd_pr__nfet_g5v0d10v5 w=1 l=0.5
XRp_33_6 BLP6 dp_33_6 sky130_fd_pr_reram__reram_cell area_ox=0.0676
XMn_33_6 dn_33_6 WL33 SL6 VSS sky130_fd_pr__nfet_g5v0d10v5 w=1 l=0.5
XRn_33_6 BLN6 dn_33_6 sky130_fd_pr_reram__reram_cell area_ox=0.0676
XMp_33_7 dp_33_7 WL33 SL7 VSS sky130_fd_pr__nfet_g5v0d10v5 w=1 l=0.5
XRp_33_7 BLP7 dp_33_7 sky130_fd_pr_reram__reram_cell area_ox=0.0676
XMn_33_7 dn_33_7 WL33 SL7 VSS sky130_fd_pr__nfet_g5v0d10v5 w=1 l=0.5
XRn_33_7 BLN7 dn_33_7 sky130_fd_pr_reram__reram_cell area_ox=0.0676
XMp_33_8 dp_33_8 WL33 SL8 VSS sky130_fd_pr__nfet_g5v0d10v5 w=1 l=0.5
XRp_33_8 BLP8 dp_33_8 sky130_fd_pr_reram__reram_cell area_ox=0.0676
XMn_33_8 dn_33_8 WL33 SL8 VSS sky130_fd_pr__nfet_g5v0d10v5 w=1 l=0.5
XRn_33_8 BLN8 dn_33_8 sky130_fd_pr_reram__reram_cell area_ox=0.0676
XMp_33_9 dp_33_9 WL33 SL9 VSS sky130_fd_pr__nfet_g5v0d10v5 w=1 l=0.5
XRp_33_9 BLP9 dp_33_9 sky130_fd_pr_reram__reram_cell area_ox=0.0676
XMn_33_9 dn_33_9 WL33 SL9 VSS sky130_fd_pr__nfet_g5v0d10v5 w=1 l=0.5
XRn_33_9 BLN9 dn_33_9 sky130_fd_pr_reram__reram_cell area_ox=0.0676
XMp_33_10 dp_33_10 WL33 SL10 VSS sky130_fd_pr__nfet_g5v0d10v5 w=1 l=0.5
XRp_33_10 BLP10 dp_33_10 sky130_fd_pr_reram__reram_cell area_ox=0.0676
XMn_33_10 dn_33_10 WL33 SL10 VSS sky130_fd_pr__nfet_g5v0d10v5 w=1 l=0.5
XRn_33_10 BLN10 dn_33_10 sky130_fd_pr_reram__reram_cell area_ox=0.0676
XMp_33_11 dp_33_11 WL33 SL11 VSS sky130_fd_pr__nfet_g5v0d10v5 w=1 l=0.5
XRp_33_11 BLP11 dp_33_11 sky130_fd_pr_reram__reram_cell area_ox=0.0676
XMn_33_11 dn_33_11 WL33 SL11 VSS sky130_fd_pr__nfet_g5v0d10v5 w=1 l=0.5
XRn_33_11 BLN11 dn_33_11 sky130_fd_pr_reram__reram_cell area_ox=0.0676
XMp_33_12 dp_33_12 WL33 SL12 VSS sky130_fd_pr__nfet_g5v0d10v5 w=1 l=0.5
XRp_33_12 BLP12 dp_33_12 sky130_fd_pr_reram__reram_cell area_ox=0.0676
XMn_33_12 dn_33_12 WL33 SL12 VSS sky130_fd_pr__nfet_g5v0d10v5 w=1 l=0.5
XRn_33_12 BLN12 dn_33_12 sky130_fd_pr_reram__reram_cell area_ox=0.0676
XMp_33_13 dp_33_13 WL33 SL13 VSS sky130_fd_pr__nfet_g5v0d10v5 w=1 l=0.5
XRp_33_13 BLP13 dp_33_13 sky130_fd_pr_reram__reram_cell area_ox=0.0676
XMn_33_13 dn_33_13 WL33 SL13 VSS sky130_fd_pr__nfet_g5v0d10v5 w=1 l=0.5
XRn_33_13 BLN13 dn_33_13 sky130_fd_pr_reram__reram_cell area_ox=0.0676
XMp_33_14 dp_33_14 WL33 SL14 VSS sky130_fd_pr__nfet_g5v0d10v5 w=1 l=0.5
XRp_33_14 BLP14 dp_33_14 sky130_fd_pr_reram__reram_cell area_ox=0.0676
XMn_33_14 dn_33_14 WL33 SL14 VSS sky130_fd_pr__nfet_g5v0d10v5 w=1 l=0.5
XRn_33_14 BLN14 dn_33_14 sky130_fd_pr_reram__reram_cell area_ox=0.0676
XMp_33_15 dp_33_15 WL33 SL15 VSS sky130_fd_pr__nfet_g5v0d10v5 w=1 l=0.5
XRp_33_15 BLP15 dp_33_15 sky130_fd_pr_reram__reram_cell area_ox=0.0676
XMn_33_15 dn_33_15 WL33 SL15 VSS sky130_fd_pr__nfet_g5v0d10v5 w=1 l=0.5
XRn_33_15 BLN15 dn_33_15 sky130_fd_pr_reram__reram_cell area_ox=0.0676
XMp_33_16 dp_33_16 WL33 SL16 VSS sky130_fd_pr__nfet_g5v0d10v5 w=1 l=0.5
XRp_33_16 BLP16 dp_33_16 sky130_fd_pr_reram__reram_cell area_ox=0.0676
XMn_33_16 dn_33_16 WL33 SL16 VSS sky130_fd_pr__nfet_g5v0d10v5 w=1 l=0.5
XRn_33_16 BLN16 dn_33_16 sky130_fd_pr_reram__reram_cell area_ox=0.0676
XMp_33_17 dp_33_17 WL33 SL17 VSS sky130_fd_pr__nfet_g5v0d10v5 w=1 l=0.5
XRp_33_17 BLP17 dp_33_17 sky130_fd_pr_reram__reram_cell area_ox=0.0676
XMn_33_17 dn_33_17 WL33 SL17 VSS sky130_fd_pr__nfet_g5v0d10v5 w=1 l=0.5
XRn_33_17 BLN17 dn_33_17 sky130_fd_pr_reram__reram_cell area_ox=0.0676
XMp_33_18 dp_33_18 WL33 SL18 VSS sky130_fd_pr__nfet_g5v0d10v5 w=1 l=0.5
XRp_33_18 BLP18 dp_33_18 sky130_fd_pr_reram__reram_cell area_ox=0.0676
XMn_33_18 dn_33_18 WL33 SL18 VSS sky130_fd_pr__nfet_g5v0d10v5 w=1 l=0.5
XRn_33_18 BLN18 dn_33_18 sky130_fd_pr_reram__reram_cell area_ox=0.0676
XMp_33_19 dp_33_19 WL33 SL19 VSS sky130_fd_pr__nfet_g5v0d10v5 w=1 l=0.5
XRp_33_19 BLP19 dp_33_19 sky130_fd_pr_reram__reram_cell area_ox=0.0676
XMn_33_19 dn_33_19 WL33 SL19 VSS sky130_fd_pr__nfet_g5v0d10v5 w=1 l=0.5
XRn_33_19 BLN19 dn_33_19 sky130_fd_pr_reram__reram_cell area_ox=0.0676
XMp_33_20 dp_33_20 WL33 SL20 VSS sky130_fd_pr__nfet_g5v0d10v5 w=1 l=0.5
XRp_33_20 BLP20 dp_33_20 sky130_fd_pr_reram__reram_cell area_ox=0.0676
XMn_33_20 dn_33_20 WL33 SL20 VSS sky130_fd_pr__nfet_g5v0d10v5 w=1 l=0.5
XRn_33_20 BLN20 dn_33_20 sky130_fd_pr_reram__reram_cell area_ox=0.0676
XMp_33_21 dp_33_21 WL33 SL21 VSS sky130_fd_pr__nfet_g5v0d10v5 w=1 l=0.5
XRp_33_21 BLP21 dp_33_21 sky130_fd_pr_reram__reram_cell area_ox=0.0676
XMn_33_21 dn_33_21 WL33 SL21 VSS sky130_fd_pr__nfet_g5v0d10v5 w=1 l=0.5
XRn_33_21 BLN21 dn_33_21 sky130_fd_pr_reram__reram_cell area_ox=0.0676
XMp_33_22 dp_33_22 WL33 SL22 VSS sky130_fd_pr__nfet_g5v0d10v5 w=1 l=0.5
XRp_33_22 BLP22 dp_33_22 sky130_fd_pr_reram__reram_cell area_ox=0.0676
XMn_33_22 dn_33_22 WL33 SL22 VSS sky130_fd_pr__nfet_g5v0d10v5 w=1 l=0.5
XRn_33_22 BLN22 dn_33_22 sky130_fd_pr_reram__reram_cell area_ox=0.0676
XMp_33_23 dp_33_23 WL33 SL23 VSS sky130_fd_pr__nfet_g5v0d10v5 w=1 l=0.5
XRp_33_23 BLP23 dp_33_23 sky130_fd_pr_reram__reram_cell area_ox=0.0676
XMn_33_23 dn_33_23 WL33 SL23 VSS sky130_fd_pr__nfet_g5v0d10v5 w=1 l=0.5
XRn_33_23 BLN23 dn_33_23 sky130_fd_pr_reram__reram_cell area_ox=0.0676
XMp_34_0 dp_34_0 WL34 SL0 VSS sky130_fd_pr__nfet_g5v0d10v5 w=1 l=0.5
XRp_34_0 BLP0 dp_34_0 sky130_fd_pr_reram__reram_cell area_ox=0.0676
XMn_34_0 dn_34_0 WL34 SL0 VSS sky130_fd_pr__nfet_g5v0d10v5 w=1 l=0.5
XRn_34_0 BLN0 dn_34_0 sky130_fd_pr_reram__reram_cell area_ox=0.0676
XMp_34_1 dp_34_1 WL34 SL1 VSS sky130_fd_pr__nfet_g5v0d10v5 w=1 l=0.5
XRp_34_1 BLP1 dp_34_1 sky130_fd_pr_reram__reram_cell area_ox=0.0676
XMn_34_1 dn_34_1 WL34 SL1 VSS sky130_fd_pr__nfet_g5v0d10v5 w=1 l=0.5
XRn_34_1 BLN1 dn_34_1 sky130_fd_pr_reram__reram_cell area_ox=0.0676
XMp_34_2 dp_34_2 WL34 SL2 VSS sky130_fd_pr__nfet_g5v0d10v5 w=1 l=0.5
XRp_34_2 BLP2 dp_34_2 sky130_fd_pr_reram__reram_cell area_ox=0.0676
XMn_34_2 dn_34_2 WL34 SL2 VSS sky130_fd_pr__nfet_g5v0d10v5 w=1 l=0.5
XRn_34_2 BLN2 dn_34_2 sky130_fd_pr_reram__reram_cell area_ox=0.0676
XMp_34_3 dp_34_3 WL34 SL3 VSS sky130_fd_pr__nfet_g5v0d10v5 w=1 l=0.5
XRp_34_3 BLP3 dp_34_3 sky130_fd_pr_reram__reram_cell area_ox=0.0676
XMn_34_3 dn_34_3 WL34 SL3 VSS sky130_fd_pr__nfet_g5v0d10v5 w=1 l=0.5
XRn_34_3 BLN3 dn_34_3 sky130_fd_pr_reram__reram_cell area_ox=0.0676
XMp_34_4 dp_34_4 WL34 SL4 VSS sky130_fd_pr__nfet_g5v0d10v5 w=1 l=0.5
XRp_34_4 BLP4 dp_34_4 sky130_fd_pr_reram__reram_cell area_ox=0.0676
XMn_34_4 dn_34_4 WL34 SL4 VSS sky130_fd_pr__nfet_g5v0d10v5 w=1 l=0.5
XRn_34_4 BLN4 dn_34_4 sky130_fd_pr_reram__reram_cell area_ox=0.0676
XMp_34_5 dp_34_5 WL34 SL5 VSS sky130_fd_pr__nfet_g5v0d10v5 w=1 l=0.5
XRp_34_5 BLP5 dp_34_5 sky130_fd_pr_reram__reram_cell area_ox=0.0676
XMn_34_5 dn_34_5 WL34 SL5 VSS sky130_fd_pr__nfet_g5v0d10v5 w=1 l=0.5
XRn_34_5 BLN5 dn_34_5 sky130_fd_pr_reram__reram_cell area_ox=0.0676
XMp_34_6 dp_34_6 WL34 SL6 VSS sky130_fd_pr__nfet_g5v0d10v5 w=1 l=0.5
XRp_34_6 BLP6 dp_34_6 sky130_fd_pr_reram__reram_cell area_ox=0.0676
XMn_34_6 dn_34_6 WL34 SL6 VSS sky130_fd_pr__nfet_g5v0d10v5 w=1 l=0.5
XRn_34_6 BLN6 dn_34_6 sky130_fd_pr_reram__reram_cell area_ox=0.0676
XMp_34_7 dp_34_7 WL34 SL7 VSS sky130_fd_pr__nfet_g5v0d10v5 w=1 l=0.5
XRp_34_7 BLP7 dp_34_7 sky130_fd_pr_reram__reram_cell area_ox=0.0676
XMn_34_7 dn_34_7 WL34 SL7 VSS sky130_fd_pr__nfet_g5v0d10v5 w=1 l=0.5
XRn_34_7 BLN7 dn_34_7 sky130_fd_pr_reram__reram_cell area_ox=0.0676
XMp_34_8 dp_34_8 WL34 SL8 VSS sky130_fd_pr__nfet_g5v0d10v5 w=1 l=0.5
XRp_34_8 BLP8 dp_34_8 sky130_fd_pr_reram__reram_cell area_ox=0.0676
XMn_34_8 dn_34_8 WL34 SL8 VSS sky130_fd_pr__nfet_g5v0d10v5 w=1 l=0.5
XRn_34_8 BLN8 dn_34_8 sky130_fd_pr_reram__reram_cell area_ox=0.0676
XMp_34_9 dp_34_9 WL34 SL9 VSS sky130_fd_pr__nfet_g5v0d10v5 w=1 l=0.5
XRp_34_9 BLP9 dp_34_9 sky130_fd_pr_reram__reram_cell area_ox=0.0676
XMn_34_9 dn_34_9 WL34 SL9 VSS sky130_fd_pr__nfet_g5v0d10v5 w=1 l=0.5
XRn_34_9 BLN9 dn_34_9 sky130_fd_pr_reram__reram_cell area_ox=0.0676
XMp_34_10 dp_34_10 WL34 SL10 VSS sky130_fd_pr__nfet_g5v0d10v5 w=1 l=0.5
XRp_34_10 BLP10 dp_34_10 sky130_fd_pr_reram__reram_cell area_ox=0.0676
XMn_34_10 dn_34_10 WL34 SL10 VSS sky130_fd_pr__nfet_g5v0d10v5 w=1 l=0.5
XRn_34_10 BLN10 dn_34_10 sky130_fd_pr_reram__reram_cell area_ox=0.0676
XMp_34_11 dp_34_11 WL34 SL11 VSS sky130_fd_pr__nfet_g5v0d10v5 w=1 l=0.5
XRp_34_11 BLP11 dp_34_11 sky130_fd_pr_reram__reram_cell area_ox=0.0676
XMn_34_11 dn_34_11 WL34 SL11 VSS sky130_fd_pr__nfet_g5v0d10v5 w=1 l=0.5
XRn_34_11 BLN11 dn_34_11 sky130_fd_pr_reram__reram_cell area_ox=0.0676
XMp_34_12 dp_34_12 WL34 SL12 VSS sky130_fd_pr__nfet_g5v0d10v5 w=1 l=0.5
XRp_34_12 BLP12 dp_34_12 sky130_fd_pr_reram__reram_cell area_ox=0.0676
XMn_34_12 dn_34_12 WL34 SL12 VSS sky130_fd_pr__nfet_g5v0d10v5 w=1 l=0.5
XRn_34_12 BLN12 dn_34_12 sky130_fd_pr_reram__reram_cell area_ox=0.0676
XMp_34_13 dp_34_13 WL34 SL13 VSS sky130_fd_pr__nfet_g5v0d10v5 w=1 l=0.5
XRp_34_13 BLP13 dp_34_13 sky130_fd_pr_reram__reram_cell area_ox=0.0676
XMn_34_13 dn_34_13 WL34 SL13 VSS sky130_fd_pr__nfet_g5v0d10v5 w=1 l=0.5
XRn_34_13 BLN13 dn_34_13 sky130_fd_pr_reram__reram_cell area_ox=0.0676
XMp_34_14 dp_34_14 WL34 SL14 VSS sky130_fd_pr__nfet_g5v0d10v5 w=1 l=0.5
XRp_34_14 BLP14 dp_34_14 sky130_fd_pr_reram__reram_cell area_ox=0.0676
XMn_34_14 dn_34_14 WL34 SL14 VSS sky130_fd_pr__nfet_g5v0d10v5 w=1 l=0.5
XRn_34_14 BLN14 dn_34_14 sky130_fd_pr_reram__reram_cell area_ox=0.0676
XMp_34_15 dp_34_15 WL34 SL15 VSS sky130_fd_pr__nfet_g5v0d10v5 w=1 l=0.5
XRp_34_15 BLP15 dp_34_15 sky130_fd_pr_reram__reram_cell area_ox=0.0676
XMn_34_15 dn_34_15 WL34 SL15 VSS sky130_fd_pr__nfet_g5v0d10v5 w=1 l=0.5
XRn_34_15 BLN15 dn_34_15 sky130_fd_pr_reram__reram_cell area_ox=0.0676
XMp_34_16 dp_34_16 WL34 SL16 VSS sky130_fd_pr__nfet_g5v0d10v5 w=1 l=0.5
XRp_34_16 BLP16 dp_34_16 sky130_fd_pr_reram__reram_cell area_ox=0.0676
XMn_34_16 dn_34_16 WL34 SL16 VSS sky130_fd_pr__nfet_g5v0d10v5 w=1 l=0.5
XRn_34_16 BLN16 dn_34_16 sky130_fd_pr_reram__reram_cell area_ox=0.0676
XMp_34_17 dp_34_17 WL34 SL17 VSS sky130_fd_pr__nfet_g5v0d10v5 w=1 l=0.5
XRp_34_17 BLP17 dp_34_17 sky130_fd_pr_reram__reram_cell area_ox=0.0676
XMn_34_17 dn_34_17 WL34 SL17 VSS sky130_fd_pr__nfet_g5v0d10v5 w=1 l=0.5
XRn_34_17 BLN17 dn_34_17 sky130_fd_pr_reram__reram_cell area_ox=0.0676
XMp_34_18 dp_34_18 WL34 SL18 VSS sky130_fd_pr__nfet_g5v0d10v5 w=1 l=0.5
XRp_34_18 BLP18 dp_34_18 sky130_fd_pr_reram__reram_cell area_ox=0.0676
XMn_34_18 dn_34_18 WL34 SL18 VSS sky130_fd_pr__nfet_g5v0d10v5 w=1 l=0.5
XRn_34_18 BLN18 dn_34_18 sky130_fd_pr_reram__reram_cell area_ox=0.0676
XMp_34_19 dp_34_19 WL34 SL19 VSS sky130_fd_pr__nfet_g5v0d10v5 w=1 l=0.5
XRp_34_19 BLP19 dp_34_19 sky130_fd_pr_reram__reram_cell area_ox=0.0676
XMn_34_19 dn_34_19 WL34 SL19 VSS sky130_fd_pr__nfet_g5v0d10v5 w=1 l=0.5
XRn_34_19 BLN19 dn_34_19 sky130_fd_pr_reram__reram_cell area_ox=0.0676
XMp_34_20 dp_34_20 WL34 SL20 VSS sky130_fd_pr__nfet_g5v0d10v5 w=1 l=0.5
XRp_34_20 BLP20 dp_34_20 sky130_fd_pr_reram__reram_cell area_ox=0.0676
XMn_34_20 dn_34_20 WL34 SL20 VSS sky130_fd_pr__nfet_g5v0d10v5 w=1 l=0.5
XRn_34_20 BLN20 dn_34_20 sky130_fd_pr_reram__reram_cell area_ox=0.0676
XMp_34_21 dp_34_21 WL34 SL21 VSS sky130_fd_pr__nfet_g5v0d10v5 w=1 l=0.5
XRp_34_21 BLP21 dp_34_21 sky130_fd_pr_reram__reram_cell area_ox=0.0676
XMn_34_21 dn_34_21 WL34 SL21 VSS sky130_fd_pr__nfet_g5v0d10v5 w=1 l=0.5
XRn_34_21 BLN21 dn_34_21 sky130_fd_pr_reram__reram_cell area_ox=0.0676
XMp_34_22 dp_34_22 WL34 SL22 VSS sky130_fd_pr__nfet_g5v0d10v5 w=1 l=0.5
XRp_34_22 BLP22 dp_34_22 sky130_fd_pr_reram__reram_cell area_ox=0.0676
XMn_34_22 dn_34_22 WL34 SL22 VSS sky130_fd_pr__nfet_g5v0d10v5 w=1 l=0.5
XRn_34_22 BLN22 dn_34_22 sky130_fd_pr_reram__reram_cell area_ox=0.0676
XMp_34_23 dp_34_23 WL34 SL23 VSS sky130_fd_pr__nfet_g5v0d10v5 w=1 l=0.5
XRp_34_23 BLP23 dp_34_23 sky130_fd_pr_reram__reram_cell area_ox=0.0676
XMn_34_23 dn_34_23 WL34 SL23 VSS sky130_fd_pr__nfet_g5v0d10v5 w=1 l=0.5
XRn_34_23 BLN23 dn_34_23 sky130_fd_pr_reram__reram_cell area_ox=0.0676
XMp_35_0 dp_35_0 WL35 SL0 VSS sky130_fd_pr__nfet_g5v0d10v5 w=1 l=0.5
XRp_35_0 BLP0 dp_35_0 sky130_fd_pr_reram__reram_cell area_ox=0.0676
XMn_35_0 dn_35_0 WL35 SL0 VSS sky130_fd_pr__nfet_g5v0d10v5 w=1 l=0.5
XRn_35_0 BLN0 dn_35_0 sky130_fd_pr_reram__reram_cell area_ox=0.0676
XMp_35_1 dp_35_1 WL35 SL1 VSS sky130_fd_pr__nfet_g5v0d10v5 w=1 l=0.5
XRp_35_1 BLP1 dp_35_1 sky130_fd_pr_reram__reram_cell area_ox=0.0676
XMn_35_1 dn_35_1 WL35 SL1 VSS sky130_fd_pr__nfet_g5v0d10v5 w=1 l=0.5
XRn_35_1 BLN1 dn_35_1 sky130_fd_pr_reram__reram_cell area_ox=0.0676
XMp_35_2 dp_35_2 WL35 SL2 VSS sky130_fd_pr__nfet_g5v0d10v5 w=1 l=0.5
XRp_35_2 BLP2 dp_35_2 sky130_fd_pr_reram__reram_cell area_ox=0.0676
XMn_35_2 dn_35_2 WL35 SL2 VSS sky130_fd_pr__nfet_g5v0d10v5 w=1 l=0.5
XRn_35_2 BLN2 dn_35_2 sky130_fd_pr_reram__reram_cell area_ox=0.0676
XMp_35_3 dp_35_3 WL35 SL3 VSS sky130_fd_pr__nfet_g5v0d10v5 w=1 l=0.5
XRp_35_3 BLP3 dp_35_3 sky130_fd_pr_reram__reram_cell area_ox=0.0676
XMn_35_3 dn_35_3 WL35 SL3 VSS sky130_fd_pr__nfet_g5v0d10v5 w=1 l=0.5
XRn_35_3 BLN3 dn_35_3 sky130_fd_pr_reram__reram_cell area_ox=0.0676
XMp_35_4 dp_35_4 WL35 SL4 VSS sky130_fd_pr__nfet_g5v0d10v5 w=1 l=0.5
XRp_35_4 BLP4 dp_35_4 sky130_fd_pr_reram__reram_cell area_ox=0.0676
XMn_35_4 dn_35_4 WL35 SL4 VSS sky130_fd_pr__nfet_g5v0d10v5 w=1 l=0.5
XRn_35_4 BLN4 dn_35_4 sky130_fd_pr_reram__reram_cell area_ox=0.0676
XMp_35_5 dp_35_5 WL35 SL5 VSS sky130_fd_pr__nfet_g5v0d10v5 w=1 l=0.5
XRp_35_5 BLP5 dp_35_5 sky130_fd_pr_reram__reram_cell area_ox=0.0676
XMn_35_5 dn_35_5 WL35 SL5 VSS sky130_fd_pr__nfet_g5v0d10v5 w=1 l=0.5
XRn_35_5 BLN5 dn_35_5 sky130_fd_pr_reram__reram_cell area_ox=0.0676
XMp_35_6 dp_35_6 WL35 SL6 VSS sky130_fd_pr__nfet_g5v0d10v5 w=1 l=0.5
XRp_35_6 BLP6 dp_35_6 sky130_fd_pr_reram__reram_cell area_ox=0.0676
XMn_35_6 dn_35_6 WL35 SL6 VSS sky130_fd_pr__nfet_g5v0d10v5 w=1 l=0.5
XRn_35_6 BLN6 dn_35_6 sky130_fd_pr_reram__reram_cell area_ox=0.0676
XMp_35_7 dp_35_7 WL35 SL7 VSS sky130_fd_pr__nfet_g5v0d10v5 w=1 l=0.5
XRp_35_7 BLP7 dp_35_7 sky130_fd_pr_reram__reram_cell area_ox=0.0676
XMn_35_7 dn_35_7 WL35 SL7 VSS sky130_fd_pr__nfet_g5v0d10v5 w=1 l=0.5
XRn_35_7 BLN7 dn_35_7 sky130_fd_pr_reram__reram_cell area_ox=0.0676
XMp_35_8 dp_35_8 WL35 SL8 VSS sky130_fd_pr__nfet_g5v0d10v5 w=1 l=0.5
XRp_35_8 BLP8 dp_35_8 sky130_fd_pr_reram__reram_cell area_ox=0.0676
XMn_35_8 dn_35_8 WL35 SL8 VSS sky130_fd_pr__nfet_g5v0d10v5 w=1 l=0.5
XRn_35_8 BLN8 dn_35_8 sky130_fd_pr_reram__reram_cell area_ox=0.0676
XMp_35_9 dp_35_9 WL35 SL9 VSS sky130_fd_pr__nfet_g5v0d10v5 w=1 l=0.5
XRp_35_9 BLP9 dp_35_9 sky130_fd_pr_reram__reram_cell area_ox=0.0676
XMn_35_9 dn_35_9 WL35 SL9 VSS sky130_fd_pr__nfet_g5v0d10v5 w=1 l=0.5
XRn_35_9 BLN9 dn_35_9 sky130_fd_pr_reram__reram_cell area_ox=0.0676
XMp_35_10 dp_35_10 WL35 SL10 VSS sky130_fd_pr__nfet_g5v0d10v5 w=1 l=0.5
XRp_35_10 BLP10 dp_35_10 sky130_fd_pr_reram__reram_cell area_ox=0.0676
XMn_35_10 dn_35_10 WL35 SL10 VSS sky130_fd_pr__nfet_g5v0d10v5 w=1 l=0.5
XRn_35_10 BLN10 dn_35_10 sky130_fd_pr_reram__reram_cell area_ox=0.0676
XMp_35_11 dp_35_11 WL35 SL11 VSS sky130_fd_pr__nfet_g5v0d10v5 w=1 l=0.5
XRp_35_11 BLP11 dp_35_11 sky130_fd_pr_reram__reram_cell area_ox=0.0676
XMn_35_11 dn_35_11 WL35 SL11 VSS sky130_fd_pr__nfet_g5v0d10v5 w=1 l=0.5
XRn_35_11 BLN11 dn_35_11 sky130_fd_pr_reram__reram_cell area_ox=0.0676
XMp_35_12 dp_35_12 WL35 SL12 VSS sky130_fd_pr__nfet_g5v0d10v5 w=1 l=0.5
XRp_35_12 BLP12 dp_35_12 sky130_fd_pr_reram__reram_cell area_ox=0.0676
XMn_35_12 dn_35_12 WL35 SL12 VSS sky130_fd_pr__nfet_g5v0d10v5 w=1 l=0.5
XRn_35_12 BLN12 dn_35_12 sky130_fd_pr_reram__reram_cell area_ox=0.0676
XMp_35_13 dp_35_13 WL35 SL13 VSS sky130_fd_pr__nfet_g5v0d10v5 w=1 l=0.5
XRp_35_13 BLP13 dp_35_13 sky130_fd_pr_reram__reram_cell area_ox=0.0676
XMn_35_13 dn_35_13 WL35 SL13 VSS sky130_fd_pr__nfet_g5v0d10v5 w=1 l=0.5
XRn_35_13 BLN13 dn_35_13 sky130_fd_pr_reram__reram_cell area_ox=0.0676
XMp_35_14 dp_35_14 WL35 SL14 VSS sky130_fd_pr__nfet_g5v0d10v5 w=1 l=0.5
XRp_35_14 BLP14 dp_35_14 sky130_fd_pr_reram__reram_cell area_ox=0.0676
XMn_35_14 dn_35_14 WL35 SL14 VSS sky130_fd_pr__nfet_g5v0d10v5 w=1 l=0.5
XRn_35_14 BLN14 dn_35_14 sky130_fd_pr_reram__reram_cell area_ox=0.0676
XMp_35_15 dp_35_15 WL35 SL15 VSS sky130_fd_pr__nfet_g5v0d10v5 w=1 l=0.5
XRp_35_15 BLP15 dp_35_15 sky130_fd_pr_reram__reram_cell area_ox=0.0676
XMn_35_15 dn_35_15 WL35 SL15 VSS sky130_fd_pr__nfet_g5v0d10v5 w=1 l=0.5
XRn_35_15 BLN15 dn_35_15 sky130_fd_pr_reram__reram_cell area_ox=0.0676
XMp_35_16 dp_35_16 WL35 SL16 VSS sky130_fd_pr__nfet_g5v0d10v5 w=1 l=0.5
XRp_35_16 BLP16 dp_35_16 sky130_fd_pr_reram__reram_cell area_ox=0.0676
XMn_35_16 dn_35_16 WL35 SL16 VSS sky130_fd_pr__nfet_g5v0d10v5 w=1 l=0.5
XRn_35_16 BLN16 dn_35_16 sky130_fd_pr_reram__reram_cell area_ox=0.0676
XMp_35_17 dp_35_17 WL35 SL17 VSS sky130_fd_pr__nfet_g5v0d10v5 w=1 l=0.5
XRp_35_17 BLP17 dp_35_17 sky130_fd_pr_reram__reram_cell area_ox=0.0676
XMn_35_17 dn_35_17 WL35 SL17 VSS sky130_fd_pr__nfet_g5v0d10v5 w=1 l=0.5
XRn_35_17 BLN17 dn_35_17 sky130_fd_pr_reram__reram_cell area_ox=0.0676
XMp_35_18 dp_35_18 WL35 SL18 VSS sky130_fd_pr__nfet_g5v0d10v5 w=1 l=0.5
XRp_35_18 BLP18 dp_35_18 sky130_fd_pr_reram__reram_cell area_ox=0.0676
XMn_35_18 dn_35_18 WL35 SL18 VSS sky130_fd_pr__nfet_g5v0d10v5 w=1 l=0.5
XRn_35_18 BLN18 dn_35_18 sky130_fd_pr_reram__reram_cell area_ox=0.0676
XMp_35_19 dp_35_19 WL35 SL19 VSS sky130_fd_pr__nfet_g5v0d10v5 w=1 l=0.5
XRp_35_19 BLP19 dp_35_19 sky130_fd_pr_reram__reram_cell area_ox=0.0676
XMn_35_19 dn_35_19 WL35 SL19 VSS sky130_fd_pr__nfet_g5v0d10v5 w=1 l=0.5
XRn_35_19 BLN19 dn_35_19 sky130_fd_pr_reram__reram_cell area_ox=0.0676
XMp_35_20 dp_35_20 WL35 SL20 VSS sky130_fd_pr__nfet_g5v0d10v5 w=1 l=0.5
XRp_35_20 BLP20 dp_35_20 sky130_fd_pr_reram__reram_cell area_ox=0.0676
XMn_35_20 dn_35_20 WL35 SL20 VSS sky130_fd_pr__nfet_g5v0d10v5 w=1 l=0.5
XRn_35_20 BLN20 dn_35_20 sky130_fd_pr_reram__reram_cell area_ox=0.0676
XMp_35_21 dp_35_21 WL35 SL21 VSS sky130_fd_pr__nfet_g5v0d10v5 w=1 l=0.5
XRp_35_21 BLP21 dp_35_21 sky130_fd_pr_reram__reram_cell area_ox=0.0676
XMn_35_21 dn_35_21 WL35 SL21 VSS sky130_fd_pr__nfet_g5v0d10v5 w=1 l=0.5
XRn_35_21 BLN21 dn_35_21 sky130_fd_pr_reram__reram_cell area_ox=0.0676
XMp_35_22 dp_35_22 WL35 SL22 VSS sky130_fd_pr__nfet_g5v0d10v5 w=1 l=0.5
XRp_35_22 BLP22 dp_35_22 sky130_fd_pr_reram__reram_cell area_ox=0.0676
XMn_35_22 dn_35_22 WL35 SL22 VSS sky130_fd_pr__nfet_g5v0d10v5 w=1 l=0.5
XRn_35_22 BLN22 dn_35_22 sky130_fd_pr_reram__reram_cell area_ox=0.0676
XMp_35_23 dp_35_23 WL35 SL23 VSS sky130_fd_pr__nfet_g5v0d10v5 w=1 l=0.5
XRp_35_23 BLP23 dp_35_23 sky130_fd_pr_reram__reram_cell area_ox=0.0676
XMn_35_23 dn_35_23 WL35 SL23 VSS sky130_fd_pr__nfet_g5v0d10v5 w=1 l=0.5
XRn_35_23 BLN23 dn_35_23 sky130_fd_pr_reram__reram_cell area_ox=0.0676
XMp_36_0 dp_36_0 WL36 SL0 VSS sky130_fd_pr__nfet_g5v0d10v5 w=1 l=0.5
XRp_36_0 BLP0 dp_36_0 sky130_fd_pr_reram__reram_cell area_ox=0.0676
XMn_36_0 dn_36_0 WL36 SL0 VSS sky130_fd_pr__nfet_g5v0d10v5 w=1 l=0.5
XRn_36_0 BLN0 dn_36_0 sky130_fd_pr_reram__reram_cell area_ox=0.0676
XMp_36_1 dp_36_1 WL36 SL1 VSS sky130_fd_pr__nfet_g5v0d10v5 w=1 l=0.5
XRp_36_1 BLP1 dp_36_1 sky130_fd_pr_reram__reram_cell area_ox=0.0676
XMn_36_1 dn_36_1 WL36 SL1 VSS sky130_fd_pr__nfet_g5v0d10v5 w=1 l=0.5
XRn_36_1 BLN1 dn_36_1 sky130_fd_pr_reram__reram_cell area_ox=0.0676
XMp_36_2 dp_36_2 WL36 SL2 VSS sky130_fd_pr__nfet_g5v0d10v5 w=1 l=0.5
XRp_36_2 BLP2 dp_36_2 sky130_fd_pr_reram__reram_cell area_ox=0.0676
XMn_36_2 dn_36_2 WL36 SL2 VSS sky130_fd_pr__nfet_g5v0d10v5 w=1 l=0.5
XRn_36_2 BLN2 dn_36_2 sky130_fd_pr_reram__reram_cell area_ox=0.0676
XMp_36_3 dp_36_3 WL36 SL3 VSS sky130_fd_pr__nfet_g5v0d10v5 w=1 l=0.5
XRp_36_3 BLP3 dp_36_3 sky130_fd_pr_reram__reram_cell area_ox=0.0676
XMn_36_3 dn_36_3 WL36 SL3 VSS sky130_fd_pr__nfet_g5v0d10v5 w=1 l=0.5
XRn_36_3 BLN3 dn_36_3 sky130_fd_pr_reram__reram_cell area_ox=0.0676
XMp_36_4 dp_36_4 WL36 SL4 VSS sky130_fd_pr__nfet_g5v0d10v5 w=1 l=0.5
XRp_36_4 BLP4 dp_36_4 sky130_fd_pr_reram__reram_cell area_ox=0.0676
XMn_36_4 dn_36_4 WL36 SL4 VSS sky130_fd_pr__nfet_g5v0d10v5 w=1 l=0.5
XRn_36_4 BLN4 dn_36_4 sky130_fd_pr_reram__reram_cell area_ox=0.0676
XMp_36_5 dp_36_5 WL36 SL5 VSS sky130_fd_pr__nfet_g5v0d10v5 w=1 l=0.5
XRp_36_5 BLP5 dp_36_5 sky130_fd_pr_reram__reram_cell area_ox=0.0676
XMn_36_5 dn_36_5 WL36 SL5 VSS sky130_fd_pr__nfet_g5v0d10v5 w=1 l=0.5
XRn_36_5 BLN5 dn_36_5 sky130_fd_pr_reram__reram_cell area_ox=0.0676
XMp_36_6 dp_36_6 WL36 SL6 VSS sky130_fd_pr__nfet_g5v0d10v5 w=1 l=0.5
XRp_36_6 BLP6 dp_36_6 sky130_fd_pr_reram__reram_cell area_ox=0.0676
XMn_36_6 dn_36_6 WL36 SL6 VSS sky130_fd_pr__nfet_g5v0d10v5 w=1 l=0.5
XRn_36_6 BLN6 dn_36_6 sky130_fd_pr_reram__reram_cell area_ox=0.0676
XMp_36_7 dp_36_7 WL36 SL7 VSS sky130_fd_pr__nfet_g5v0d10v5 w=1 l=0.5
XRp_36_7 BLP7 dp_36_7 sky130_fd_pr_reram__reram_cell area_ox=0.0676
XMn_36_7 dn_36_7 WL36 SL7 VSS sky130_fd_pr__nfet_g5v0d10v5 w=1 l=0.5
XRn_36_7 BLN7 dn_36_7 sky130_fd_pr_reram__reram_cell area_ox=0.0676
XMp_36_8 dp_36_8 WL36 SL8 VSS sky130_fd_pr__nfet_g5v0d10v5 w=1 l=0.5
XRp_36_8 BLP8 dp_36_8 sky130_fd_pr_reram__reram_cell area_ox=0.0676
XMn_36_8 dn_36_8 WL36 SL8 VSS sky130_fd_pr__nfet_g5v0d10v5 w=1 l=0.5
XRn_36_8 BLN8 dn_36_8 sky130_fd_pr_reram__reram_cell area_ox=0.0676
XMp_36_9 dp_36_9 WL36 SL9 VSS sky130_fd_pr__nfet_g5v0d10v5 w=1 l=0.5
XRp_36_9 BLP9 dp_36_9 sky130_fd_pr_reram__reram_cell area_ox=0.0676
XMn_36_9 dn_36_9 WL36 SL9 VSS sky130_fd_pr__nfet_g5v0d10v5 w=1 l=0.5
XRn_36_9 BLN9 dn_36_9 sky130_fd_pr_reram__reram_cell area_ox=0.0676
XMp_36_10 dp_36_10 WL36 SL10 VSS sky130_fd_pr__nfet_g5v0d10v5 w=1 l=0.5
XRp_36_10 BLP10 dp_36_10 sky130_fd_pr_reram__reram_cell area_ox=0.0676
XMn_36_10 dn_36_10 WL36 SL10 VSS sky130_fd_pr__nfet_g5v0d10v5 w=1 l=0.5
XRn_36_10 BLN10 dn_36_10 sky130_fd_pr_reram__reram_cell area_ox=0.0676
XMp_36_11 dp_36_11 WL36 SL11 VSS sky130_fd_pr__nfet_g5v0d10v5 w=1 l=0.5
XRp_36_11 BLP11 dp_36_11 sky130_fd_pr_reram__reram_cell area_ox=0.0676
XMn_36_11 dn_36_11 WL36 SL11 VSS sky130_fd_pr__nfet_g5v0d10v5 w=1 l=0.5
XRn_36_11 BLN11 dn_36_11 sky130_fd_pr_reram__reram_cell area_ox=0.0676
XMp_36_12 dp_36_12 WL36 SL12 VSS sky130_fd_pr__nfet_g5v0d10v5 w=1 l=0.5
XRp_36_12 BLP12 dp_36_12 sky130_fd_pr_reram__reram_cell area_ox=0.0676
XMn_36_12 dn_36_12 WL36 SL12 VSS sky130_fd_pr__nfet_g5v0d10v5 w=1 l=0.5
XRn_36_12 BLN12 dn_36_12 sky130_fd_pr_reram__reram_cell area_ox=0.0676
XMp_36_13 dp_36_13 WL36 SL13 VSS sky130_fd_pr__nfet_g5v0d10v5 w=1 l=0.5
XRp_36_13 BLP13 dp_36_13 sky130_fd_pr_reram__reram_cell area_ox=0.0676
XMn_36_13 dn_36_13 WL36 SL13 VSS sky130_fd_pr__nfet_g5v0d10v5 w=1 l=0.5
XRn_36_13 BLN13 dn_36_13 sky130_fd_pr_reram__reram_cell area_ox=0.0676
XMp_36_14 dp_36_14 WL36 SL14 VSS sky130_fd_pr__nfet_g5v0d10v5 w=1 l=0.5
XRp_36_14 BLP14 dp_36_14 sky130_fd_pr_reram__reram_cell area_ox=0.0676
XMn_36_14 dn_36_14 WL36 SL14 VSS sky130_fd_pr__nfet_g5v0d10v5 w=1 l=0.5
XRn_36_14 BLN14 dn_36_14 sky130_fd_pr_reram__reram_cell area_ox=0.0676
XMp_36_15 dp_36_15 WL36 SL15 VSS sky130_fd_pr__nfet_g5v0d10v5 w=1 l=0.5
XRp_36_15 BLP15 dp_36_15 sky130_fd_pr_reram__reram_cell area_ox=0.0676
XMn_36_15 dn_36_15 WL36 SL15 VSS sky130_fd_pr__nfet_g5v0d10v5 w=1 l=0.5
XRn_36_15 BLN15 dn_36_15 sky130_fd_pr_reram__reram_cell area_ox=0.0676
XMp_36_16 dp_36_16 WL36 SL16 VSS sky130_fd_pr__nfet_g5v0d10v5 w=1 l=0.5
XRp_36_16 BLP16 dp_36_16 sky130_fd_pr_reram__reram_cell area_ox=0.0676
XMn_36_16 dn_36_16 WL36 SL16 VSS sky130_fd_pr__nfet_g5v0d10v5 w=1 l=0.5
XRn_36_16 BLN16 dn_36_16 sky130_fd_pr_reram__reram_cell area_ox=0.0676
XMp_36_17 dp_36_17 WL36 SL17 VSS sky130_fd_pr__nfet_g5v0d10v5 w=1 l=0.5
XRp_36_17 BLP17 dp_36_17 sky130_fd_pr_reram__reram_cell area_ox=0.0676
XMn_36_17 dn_36_17 WL36 SL17 VSS sky130_fd_pr__nfet_g5v0d10v5 w=1 l=0.5
XRn_36_17 BLN17 dn_36_17 sky130_fd_pr_reram__reram_cell area_ox=0.0676
XMp_36_18 dp_36_18 WL36 SL18 VSS sky130_fd_pr__nfet_g5v0d10v5 w=1 l=0.5
XRp_36_18 BLP18 dp_36_18 sky130_fd_pr_reram__reram_cell area_ox=0.0676
XMn_36_18 dn_36_18 WL36 SL18 VSS sky130_fd_pr__nfet_g5v0d10v5 w=1 l=0.5
XRn_36_18 BLN18 dn_36_18 sky130_fd_pr_reram__reram_cell area_ox=0.0676
XMp_36_19 dp_36_19 WL36 SL19 VSS sky130_fd_pr__nfet_g5v0d10v5 w=1 l=0.5
XRp_36_19 BLP19 dp_36_19 sky130_fd_pr_reram__reram_cell area_ox=0.0676
XMn_36_19 dn_36_19 WL36 SL19 VSS sky130_fd_pr__nfet_g5v0d10v5 w=1 l=0.5
XRn_36_19 BLN19 dn_36_19 sky130_fd_pr_reram__reram_cell area_ox=0.0676
XMp_36_20 dp_36_20 WL36 SL20 VSS sky130_fd_pr__nfet_g5v0d10v5 w=1 l=0.5
XRp_36_20 BLP20 dp_36_20 sky130_fd_pr_reram__reram_cell area_ox=0.0676
XMn_36_20 dn_36_20 WL36 SL20 VSS sky130_fd_pr__nfet_g5v0d10v5 w=1 l=0.5
XRn_36_20 BLN20 dn_36_20 sky130_fd_pr_reram__reram_cell area_ox=0.0676
XMp_36_21 dp_36_21 WL36 SL21 VSS sky130_fd_pr__nfet_g5v0d10v5 w=1 l=0.5
XRp_36_21 BLP21 dp_36_21 sky130_fd_pr_reram__reram_cell area_ox=0.0676
XMn_36_21 dn_36_21 WL36 SL21 VSS sky130_fd_pr__nfet_g5v0d10v5 w=1 l=0.5
XRn_36_21 BLN21 dn_36_21 sky130_fd_pr_reram__reram_cell area_ox=0.0676
XMp_36_22 dp_36_22 WL36 SL22 VSS sky130_fd_pr__nfet_g5v0d10v5 w=1 l=0.5
XRp_36_22 BLP22 dp_36_22 sky130_fd_pr_reram__reram_cell area_ox=0.0676
XMn_36_22 dn_36_22 WL36 SL22 VSS sky130_fd_pr__nfet_g5v0d10v5 w=1 l=0.5
XRn_36_22 BLN22 dn_36_22 sky130_fd_pr_reram__reram_cell area_ox=0.0676
XMp_36_23 dp_36_23 WL36 SL23 VSS sky130_fd_pr__nfet_g5v0d10v5 w=1 l=0.5
XRp_36_23 BLP23 dp_36_23 sky130_fd_pr_reram__reram_cell area_ox=0.0676
XMn_36_23 dn_36_23 WL36 SL23 VSS sky130_fd_pr__nfet_g5v0d10v5 w=1 l=0.5
XRn_36_23 BLN23 dn_36_23 sky130_fd_pr_reram__reram_cell area_ox=0.0676
XMp_37_0 dp_37_0 WL37 SL0 VSS sky130_fd_pr__nfet_g5v0d10v5 w=1 l=0.5
XRp_37_0 BLP0 dp_37_0 sky130_fd_pr_reram__reram_cell area_ox=0.0676
XMn_37_0 dn_37_0 WL37 SL0 VSS sky130_fd_pr__nfet_g5v0d10v5 w=1 l=0.5
XRn_37_0 BLN0 dn_37_0 sky130_fd_pr_reram__reram_cell area_ox=0.0676
XMp_37_1 dp_37_1 WL37 SL1 VSS sky130_fd_pr__nfet_g5v0d10v5 w=1 l=0.5
XRp_37_1 BLP1 dp_37_1 sky130_fd_pr_reram__reram_cell area_ox=0.0676
XMn_37_1 dn_37_1 WL37 SL1 VSS sky130_fd_pr__nfet_g5v0d10v5 w=1 l=0.5
XRn_37_1 BLN1 dn_37_1 sky130_fd_pr_reram__reram_cell area_ox=0.0676
XMp_37_2 dp_37_2 WL37 SL2 VSS sky130_fd_pr__nfet_g5v0d10v5 w=1 l=0.5
XRp_37_2 BLP2 dp_37_2 sky130_fd_pr_reram__reram_cell area_ox=0.0676
XMn_37_2 dn_37_2 WL37 SL2 VSS sky130_fd_pr__nfet_g5v0d10v5 w=1 l=0.5
XRn_37_2 BLN2 dn_37_2 sky130_fd_pr_reram__reram_cell area_ox=0.0676
XMp_37_3 dp_37_3 WL37 SL3 VSS sky130_fd_pr__nfet_g5v0d10v5 w=1 l=0.5
XRp_37_3 BLP3 dp_37_3 sky130_fd_pr_reram__reram_cell area_ox=0.0676
XMn_37_3 dn_37_3 WL37 SL3 VSS sky130_fd_pr__nfet_g5v0d10v5 w=1 l=0.5
XRn_37_3 BLN3 dn_37_3 sky130_fd_pr_reram__reram_cell area_ox=0.0676
XMp_37_4 dp_37_4 WL37 SL4 VSS sky130_fd_pr__nfet_g5v0d10v5 w=1 l=0.5
XRp_37_4 BLP4 dp_37_4 sky130_fd_pr_reram__reram_cell area_ox=0.0676
XMn_37_4 dn_37_4 WL37 SL4 VSS sky130_fd_pr__nfet_g5v0d10v5 w=1 l=0.5
XRn_37_4 BLN4 dn_37_4 sky130_fd_pr_reram__reram_cell area_ox=0.0676
XMp_37_5 dp_37_5 WL37 SL5 VSS sky130_fd_pr__nfet_g5v0d10v5 w=1 l=0.5
XRp_37_5 BLP5 dp_37_5 sky130_fd_pr_reram__reram_cell area_ox=0.0676
XMn_37_5 dn_37_5 WL37 SL5 VSS sky130_fd_pr__nfet_g5v0d10v5 w=1 l=0.5
XRn_37_5 BLN5 dn_37_5 sky130_fd_pr_reram__reram_cell area_ox=0.0676
XMp_37_6 dp_37_6 WL37 SL6 VSS sky130_fd_pr__nfet_g5v0d10v5 w=1 l=0.5
XRp_37_6 BLP6 dp_37_6 sky130_fd_pr_reram__reram_cell area_ox=0.0676
XMn_37_6 dn_37_6 WL37 SL6 VSS sky130_fd_pr__nfet_g5v0d10v5 w=1 l=0.5
XRn_37_6 BLN6 dn_37_6 sky130_fd_pr_reram__reram_cell area_ox=0.0676
XMp_37_7 dp_37_7 WL37 SL7 VSS sky130_fd_pr__nfet_g5v0d10v5 w=1 l=0.5
XRp_37_7 BLP7 dp_37_7 sky130_fd_pr_reram__reram_cell area_ox=0.0676
XMn_37_7 dn_37_7 WL37 SL7 VSS sky130_fd_pr__nfet_g5v0d10v5 w=1 l=0.5
XRn_37_7 BLN7 dn_37_7 sky130_fd_pr_reram__reram_cell area_ox=0.0676
XMp_37_8 dp_37_8 WL37 SL8 VSS sky130_fd_pr__nfet_g5v0d10v5 w=1 l=0.5
XRp_37_8 BLP8 dp_37_8 sky130_fd_pr_reram__reram_cell area_ox=0.0676
XMn_37_8 dn_37_8 WL37 SL8 VSS sky130_fd_pr__nfet_g5v0d10v5 w=1 l=0.5
XRn_37_8 BLN8 dn_37_8 sky130_fd_pr_reram__reram_cell area_ox=0.0676
XMp_37_9 dp_37_9 WL37 SL9 VSS sky130_fd_pr__nfet_g5v0d10v5 w=1 l=0.5
XRp_37_9 BLP9 dp_37_9 sky130_fd_pr_reram__reram_cell area_ox=0.0676
XMn_37_9 dn_37_9 WL37 SL9 VSS sky130_fd_pr__nfet_g5v0d10v5 w=1 l=0.5
XRn_37_9 BLN9 dn_37_9 sky130_fd_pr_reram__reram_cell area_ox=0.0676
XMp_37_10 dp_37_10 WL37 SL10 VSS sky130_fd_pr__nfet_g5v0d10v5 w=1 l=0.5
XRp_37_10 BLP10 dp_37_10 sky130_fd_pr_reram__reram_cell area_ox=0.0676
XMn_37_10 dn_37_10 WL37 SL10 VSS sky130_fd_pr__nfet_g5v0d10v5 w=1 l=0.5
XRn_37_10 BLN10 dn_37_10 sky130_fd_pr_reram__reram_cell area_ox=0.0676
XMp_37_11 dp_37_11 WL37 SL11 VSS sky130_fd_pr__nfet_g5v0d10v5 w=1 l=0.5
XRp_37_11 BLP11 dp_37_11 sky130_fd_pr_reram__reram_cell area_ox=0.0676
XMn_37_11 dn_37_11 WL37 SL11 VSS sky130_fd_pr__nfet_g5v0d10v5 w=1 l=0.5
XRn_37_11 BLN11 dn_37_11 sky130_fd_pr_reram__reram_cell area_ox=0.0676
XMp_37_12 dp_37_12 WL37 SL12 VSS sky130_fd_pr__nfet_g5v0d10v5 w=1 l=0.5
XRp_37_12 BLP12 dp_37_12 sky130_fd_pr_reram__reram_cell area_ox=0.0676
XMn_37_12 dn_37_12 WL37 SL12 VSS sky130_fd_pr__nfet_g5v0d10v5 w=1 l=0.5
XRn_37_12 BLN12 dn_37_12 sky130_fd_pr_reram__reram_cell area_ox=0.0676
XMp_37_13 dp_37_13 WL37 SL13 VSS sky130_fd_pr__nfet_g5v0d10v5 w=1 l=0.5
XRp_37_13 BLP13 dp_37_13 sky130_fd_pr_reram__reram_cell area_ox=0.0676
XMn_37_13 dn_37_13 WL37 SL13 VSS sky130_fd_pr__nfet_g5v0d10v5 w=1 l=0.5
XRn_37_13 BLN13 dn_37_13 sky130_fd_pr_reram__reram_cell area_ox=0.0676
XMp_37_14 dp_37_14 WL37 SL14 VSS sky130_fd_pr__nfet_g5v0d10v5 w=1 l=0.5
XRp_37_14 BLP14 dp_37_14 sky130_fd_pr_reram__reram_cell area_ox=0.0676
XMn_37_14 dn_37_14 WL37 SL14 VSS sky130_fd_pr__nfet_g5v0d10v5 w=1 l=0.5
XRn_37_14 BLN14 dn_37_14 sky130_fd_pr_reram__reram_cell area_ox=0.0676
XMp_37_15 dp_37_15 WL37 SL15 VSS sky130_fd_pr__nfet_g5v0d10v5 w=1 l=0.5
XRp_37_15 BLP15 dp_37_15 sky130_fd_pr_reram__reram_cell area_ox=0.0676
XMn_37_15 dn_37_15 WL37 SL15 VSS sky130_fd_pr__nfet_g5v0d10v5 w=1 l=0.5
XRn_37_15 BLN15 dn_37_15 sky130_fd_pr_reram__reram_cell area_ox=0.0676
XMp_37_16 dp_37_16 WL37 SL16 VSS sky130_fd_pr__nfet_g5v0d10v5 w=1 l=0.5
XRp_37_16 BLP16 dp_37_16 sky130_fd_pr_reram__reram_cell area_ox=0.0676
XMn_37_16 dn_37_16 WL37 SL16 VSS sky130_fd_pr__nfet_g5v0d10v5 w=1 l=0.5
XRn_37_16 BLN16 dn_37_16 sky130_fd_pr_reram__reram_cell area_ox=0.0676
XMp_37_17 dp_37_17 WL37 SL17 VSS sky130_fd_pr__nfet_g5v0d10v5 w=1 l=0.5
XRp_37_17 BLP17 dp_37_17 sky130_fd_pr_reram__reram_cell area_ox=0.0676
XMn_37_17 dn_37_17 WL37 SL17 VSS sky130_fd_pr__nfet_g5v0d10v5 w=1 l=0.5
XRn_37_17 BLN17 dn_37_17 sky130_fd_pr_reram__reram_cell area_ox=0.0676
XMp_37_18 dp_37_18 WL37 SL18 VSS sky130_fd_pr__nfet_g5v0d10v5 w=1 l=0.5
XRp_37_18 BLP18 dp_37_18 sky130_fd_pr_reram__reram_cell area_ox=0.0676
XMn_37_18 dn_37_18 WL37 SL18 VSS sky130_fd_pr__nfet_g5v0d10v5 w=1 l=0.5
XRn_37_18 BLN18 dn_37_18 sky130_fd_pr_reram__reram_cell area_ox=0.0676
XMp_37_19 dp_37_19 WL37 SL19 VSS sky130_fd_pr__nfet_g5v0d10v5 w=1 l=0.5
XRp_37_19 BLP19 dp_37_19 sky130_fd_pr_reram__reram_cell area_ox=0.0676
XMn_37_19 dn_37_19 WL37 SL19 VSS sky130_fd_pr__nfet_g5v0d10v5 w=1 l=0.5
XRn_37_19 BLN19 dn_37_19 sky130_fd_pr_reram__reram_cell area_ox=0.0676
XMp_37_20 dp_37_20 WL37 SL20 VSS sky130_fd_pr__nfet_g5v0d10v5 w=1 l=0.5
XRp_37_20 BLP20 dp_37_20 sky130_fd_pr_reram__reram_cell area_ox=0.0676
XMn_37_20 dn_37_20 WL37 SL20 VSS sky130_fd_pr__nfet_g5v0d10v5 w=1 l=0.5
XRn_37_20 BLN20 dn_37_20 sky130_fd_pr_reram__reram_cell area_ox=0.0676
XMp_37_21 dp_37_21 WL37 SL21 VSS sky130_fd_pr__nfet_g5v0d10v5 w=1 l=0.5
XRp_37_21 BLP21 dp_37_21 sky130_fd_pr_reram__reram_cell area_ox=0.0676
XMn_37_21 dn_37_21 WL37 SL21 VSS sky130_fd_pr__nfet_g5v0d10v5 w=1 l=0.5
XRn_37_21 BLN21 dn_37_21 sky130_fd_pr_reram__reram_cell area_ox=0.0676
XMp_37_22 dp_37_22 WL37 SL22 VSS sky130_fd_pr__nfet_g5v0d10v5 w=1 l=0.5
XRp_37_22 BLP22 dp_37_22 sky130_fd_pr_reram__reram_cell area_ox=0.0676
XMn_37_22 dn_37_22 WL37 SL22 VSS sky130_fd_pr__nfet_g5v0d10v5 w=1 l=0.5
XRn_37_22 BLN22 dn_37_22 sky130_fd_pr_reram__reram_cell area_ox=0.0676
XMp_37_23 dp_37_23 WL37 SL23 VSS sky130_fd_pr__nfet_g5v0d10v5 w=1 l=0.5
XRp_37_23 BLP23 dp_37_23 sky130_fd_pr_reram__reram_cell area_ox=0.0676
XMn_37_23 dn_37_23 WL37 SL23 VSS sky130_fd_pr__nfet_g5v0d10v5 w=1 l=0.5
XRn_37_23 BLN23 dn_37_23 sky130_fd_pr_reram__reram_cell area_ox=0.0676
XMp_38_0 dp_38_0 WL38 SL0 VSS sky130_fd_pr__nfet_g5v0d10v5 w=1 l=0.5
XRp_38_0 BLP0 dp_38_0 sky130_fd_pr_reram__reram_cell area_ox=0.0676
XMn_38_0 dn_38_0 WL38 SL0 VSS sky130_fd_pr__nfet_g5v0d10v5 w=1 l=0.5
XRn_38_0 BLN0 dn_38_0 sky130_fd_pr_reram__reram_cell area_ox=0.0676
XMp_38_1 dp_38_1 WL38 SL1 VSS sky130_fd_pr__nfet_g5v0d10v5 w=1 l=0.5
XRp_38_1 BLP1 dp_38_1 sky130_fd_pr_reram__reram_cell area_ox=0.0676
XMn_38_1 dn_38_1 WL38 SL1 VSS sky130_fd_pr__nfet_g5v0d10v5 w=1 l=0.5
XRn_38_1 BLN1 dn_38_1 sky130_fd_pr_reram__reram_cell area_ox=0.0676
XMp_38_2 dp_38_2 WL38 SL2 VSS sky130_fd_pr__nfet_g5v0d10v5 w=1 l=0.5
XRp_38_2 BLP2 dp_38_2 sky130_fd_pr_reram__reram_cell area_ox=0.0676
XMn_38_2 dn_38_2 WL38 SL2 VSS sky130_fd_pr__nfet_g5v0d10v5 w=1 l=0.5
XRn_38_2 BLN2 dn_38_2 sky130_fd_pr_reram__reram_cell area_ox=0.0676
XMp_38_3 dp_38_3 WL38 SL3 VSS sky130_fd_pr__nfet_g5v0d10v5 w=1 l=0.5
XRp_38_3 BLP3 dp_38_3 sky130_fd_pr_reram__reram_cell area_ox=0.0676
XMn_38_3 dn_38_3 WL38 SL3 VSS sky130_fd_pr__nfet_g5v0d10v5 w=1 l=0.5
XRn_38_3 BLN3 dn_38_3 sky130_fd_pr_reram__reram_cell area_ox=0.0676
XMp_38_4 dp_38_4 WL38 SL4 VSS sky130_fd_pr__nfet_g5v0d10v5 w=1 l=0.5
XRp_38_4 BLP4 dp_38_4 sky130_fd_pr_reram__reram_cell area_ox=0.0676
XMn_38_4 dn_38_4 WL38 SL4 VSS sky130_fd_pr__nfet_g5v0d10v5 w=1 l=0.5
XRn_38_4 BLN4 dn_38_4 sky130_fd_pr_reram__reram_cell area_ox=0.0676
XMp_38_5 dp_38_5 WL38 SL5 VSS sky130_fd_pr__nfet_g5v0d10v5 w=1 l=0.5
XRp_38_5 BLP5 dp_38_5 sky130_fd_pr_reram__reram_cell area_ox=0.0676
XMn_38_5 dn_38_5 WL38 SL5 VSS sky130_fd_pr__nfet_g5v0d10v5 w=1 l=0.5
XRn_38_5 BLN5 dn_38_5 sky130_fd_pr_reram__reram_cell area_ox=0.0676
XMp_38_6 dp_38_6 WL38 SL6 VSS sky130_fd_pr__nfet_g5v0d10v5 w=1 l=0.5
XRp_38_6 BLP6 dp_38_6 sky130_fd_pr_reram__reram_cell area_ox=0.0676
XMn_38_6 dn_38_6 WL38 SL6 VSS sky130_fd_pr__nfet_g5v0d10v5 w=1 l=0.5
XRn_38_6 BLN6 dn_38_6 sky130_fd_pr_reram__reram_cell area_ox=0.0676
XMp_38_7 dp_38_7 WL38 SL7 VSS sky130_fd_pr__nfet_g5v0d10v5 w=1 l=0.5
XRp_38_7 BLP7 dp_38_7 sky130_fd_pr_reram__reram_cell area_ox=0.0676
XMn_38_7 dn_38_7 WL38 SL7 VSS sky130_fd_pr__nfet_g5v0d10v5 w=1 l=0.5
XRn_38_7 BLN7 dn_38_7 sky130_fd_pr_reram__reram_cell area_ox=0.0676
XMp_38_8 dp_38_8 WL38 SL8 VSS sky130_fd_pr__nfet_g5v0d10v5 w=1 l=0.5
XRp_38_8 BLP8 dp_38_8 sky130_fd_pr_reram__reram_cell area_ox=0.0676
XMn_38_8 dn_38_8 WL38 SL8 VSS sky130_fd_pr__nfet_g5v0d10v5 w=1 l=0.5
XRn_38_8 BLN8 dn_38_8 sky130_fd_pr_reram__reram_cell area_ox=0.0676
XMp_38_9 dp_38_9 WL38 SL9 VSS sky130_fd_pr__nfet_g5v0d10v5 w=1 l=0.5
XRp_38_9 BLP9 dp_38_9 sky130_fd_pr_reram__reram_cell area_ox=0.0676
XMn_38_9 dn_38_9 WL38 SL9 VSS sky130_fd_pr__nfet_g5v0d10v5 w=1 l=0.5
XRn_38_9 BLN9 dn_38_9 sky130_fd_pr_reram__reram_cell area_ox=0.0676
XMp_38_10 dp_38_10 WL38 SL10 VSS sky130_fd_pr__nfet_g5v0d10v5 w=1 l=0.5
XRp_38_10 BLP10 dp_38_10 sky130_fd_pr_reram__reram_cell area_ox=0.0676
XMn_38_10 dn_38_10 WL38 SL10 VSS sky130_fd_pr__nfet_g5v0d10v5 w=1 l=0.5
XRn_38_10 BLN10 dn_38_10 sky130_fd_pr_reram__reram_cell area_ox=0.0676
XMp_38_11 dp_38_11 WL38 SL11 VSS sky130_fd_pr__nfet_g5v0d10v5 w=1 l=0.5
XRp_38_11 BLP11 dp_38_11 sky130_fd_pr_reram__reram_cell area_ox=0.0676
XMn_38_11 dn_38_11 WL38 SL11 VSS sky130_fd_pr__nfet_g5v0d10v5 w=1 l=0.5
XRn_38_11 BLN11 dn_38_11 sky130_fd_pr_reram__reram_cell area_ox=0.0676
XMp_38_12 dp_38_12 WL38 SL12 VSS sky130_fd_pr__nfet_g5v0d10v5 w=1 l=0.5
XRp_38_12 BLP12 dp_38_12 sky130_fd_pr_reram__reram_cell area_ox=0.0676
XMn_38_12 dn_38_12 WL38 SL12 VSS sky130_fd_pr__nfet_g5v0d10v5 w=1 l=0.5
XRn_38_12 BLN12 dn_38_12 sky130_fd_pr_reram__reram_cell area_ox=0.0676
XMp_38_13 dp_38_13 WL38 SL13 VSS sky130_fd_pr__nfet_g5v0d10v5 w=1 l=0.5
XRp_38_13 BLP13 dp_38_13 sky130_fd_pr_reram__reram_cell area_ox=0.0676
XMn_38_13 dn_38_13 WL38 SL13 VSS sky130_fd_pr__nfet_g5v0d10v5 w=1 l=0.5
XRn_38_13 BLN13 dn_38_13 sky130_fd_pr_reram__reram_cell area_ox=0.0676
XMp_38_14 dp_38_14 WL38 SL14 VSS sky130_fd_pr__nfet_g5v0d10v5 w=1 l=0.5
XRp_38_14 BLP14 dp_38_14 sky130_fd_pr_reram__reram_cell area_ox=0.0676
XMn_38_14 dn_38_14 WL38 SL14 VSS sky130_fd_pr__nfet_g5v0d10v5 w=1 l=0.5
XRn_38_14 BLN14 dn_38_14 sky130_fd_pr_reram__reram_cell area_ox=0.0676
XMp_38_15 dp_38_15 WL38 SL15 VSS sky130_fd_pr__nfet_g5v0d10v5 w=1 l=0.5
XRp_38_15 BLP15 dp_38_15 sky130_fd_pr_reram__reram_cell area_ox=0.0676
XMn_38_15 dn_38_15 WL38 SL15 VSS sky130_fd_pr__nfet_g5v0d10v5 w=1 l=0.5
XRn_38_15 BLN15 dn_38_15 sky130_fd_pr_reram__reram_cell area_ox=0.0676
XMp_38_16 dp_38_16 WL38 SL16 VSS sky130_fd_pr__nfet_g5v0d10v5 w=1 l=0.5
XRp_38_16 BLP16 dp_38_16 sky130_fd_pr_reram__reram_cell area_ox=0.0676
XMn_38_16 dn_38_16 WL38 SL16 VSS sky130_fd_pr__nfet_g5v0d10v5 w=1 l=0.5
XRn_38_16 BLN16 dn_38_16 sky130_fd_pr_reram__reram_cell area_ox=0.0676
XMp_38_17 dp_38_17 WL38 SL17 VSS sky130_fd_pr__nfet_g5v0d10v5 w=1 l=0.5
XRp_38_17 BLP17 dp_38_17 sky130_fd_pr_reram__reram_cell area_ox=0.0676
XMn_38_17 dn_38_17 WL38 SL17 VSS sky130_fd_pr__nfet_g5v0d10v5 w=1 l=0.5
XRn_38_17 BLN17 dn_38_17 sky130_fd_pr_reram__reram_cell area_ox=0.0676
XMp_38_18 dp_38_18 WL38 SL18 VSS sky130_fd_pr__nfet_g5v0d10v5 w=1 l=0.5
XRp_38_18 BLP18 dp_38_18 sky130_fd_pr_reram__reram_cell area_ox=0.0676
XMn_38_18 dn_38_18 WL38 SL18 VSS sky130_fd_pr__nfet_g5v0d10v5 w=1 l=0.5
XRn_38_18 BLN18 dn_38_18 sky130_fd_pr_reram__reram_cell area_ox=0.0676
XMp_38_19 dp_38_19 WL38 SL19 VSS sky130_fd_pr__nfet_g5v0d10v5 w=1 l=0.5
XRp_38_19 BLP19 dp_38_19 sky130_fd_pr_reram__reram_cell area_ox=0.0676
XMn_38_19 dn_38_19 WL38 SL19 VSS sky130_fd_pr__nfet_g5v0d10v5 w=1 l=0.5
XRn_38_19 BLN19 dn_38_19 sky130_fd_pr_reram__reram_cell area_ox=0.0676
XMp_38_20 dp_38_20 WL38 SL20 VSS sky130_fd_pr__nfet_g5v0d10v5 w=1 l=0.5
XRp_38_20 BLP20 dp_38_20 sky130_fd_pr_reram__reram_cell area_ox=0.0676
XMn_38_20 dn_38_20 WL38 SL20 VSS sky130_fd_pr__nfet_g5v0d10v5 w=1 l=0.5
XRn_38_20 BLN20 dn_38_20 sky130_fd_pr_reram__reram_cell area_ox=0.0676
XMp_38_21 dp_38_21 WL38 SL21 VSS sky130_fd_pr__nfet_g5v0d10v5 w=1 l=0.5
XRp_38_21 BLP21 dp_38_21 sky130_fd_pr_reram__reram_cell area_ox=0.0676
XMn_38_21 dn_38_21 WL38 SL21 VSS sky130_fd_pr__nfet_g5v0d10v5 w=1 l=0.5
XRn_38_21 BLN21 dn_38_21 sky130_fd_pr_reram__reram_cell area_ox=0.0676
XMp_38_22 dp_38_22 WL38 SL22 VSS sky130_fd_pr__nfet_g5v0d10v5 w=1 l=0.5
XRp_38_22 BLP22 dp_38_22 sky130_fd_pr_reram__reram_cell area_ox=0.0676
XMn_38_22 dn_38_22 WL38 SL22 VSS sky130_fd_pr__nfet_g5v0d10v5 w=1 l=0.5
XRn_38_22 BLN22 dn_38_22 sky130_fd_pr_reram__reram_cell area_ox=0.0676
XMp_38_23 dp_38_23 WL38 SL23 VSS sky130_fd_pr__nfet_g5v0d10v5 w=1 l=0.5
XRp_38_23 BLP23 dp_38_23 sky130_fd_pr_reram__reram_cell area_ox=0.0676
XMn_38_23 dn_38_23 WL38 SL23 VSS sky130_fd_pr__nfet_g5v0d10v5 w=1 l=0.5
XRn_38_23 BLN23 dn_38_23 sky130_fd_pr_reram__reram_cell area_ox=0.0676
XMp_39_0 dp_39_0 WL39 SL0 VSS sky130_fd_pr__nfet_g5v0d10v5 w=1 l=0.5
XRp_39_0 BLP0 dp_39_0 sky130_fd_pr_reram__reram_cell area_ox=0.0676
XMn_39_0 dn_39_0 WL39 SL0 VSS sky130_fd_pr__nfet_g5v0d10v5 w=1 l=0.5
XRn_39_0 BLN0 dn_39_0 sky130_fd_pr_reram__reram_cell area_ox=0.0676
XMp_39_1 dp_39_1 WL39 SL1 VSS sky130_fd_pr__nfet_g5v0d10v5 w=1 l=0.5
XRp_39_1 BLP1 dp_39_1 sky130_fd_pr_reram__reram_cell area_ox=0.0676
XMn_39_1 dn_39_1 WL39 SL1 VSS sky130_fd_pr__nfet_g5v0d10v5 w=1 l=0.5
XRn_39_1 BLN1 dn_39_1 sky130_fd_pr_reram__reram_cell area_ox=0.0676
XMp_39_2 dp_39_2 WL39 SL2 VSS sky130_fd_pr__nfet_g5v0d10v5 w=1 l=0.5
XRp_39_2 BLP2 dp_39_2 sky130_fd_pr_reram__reram_cell area_ox=0.0676
XMn_39_2 dn_39_2 WL39 SL2 VSS sky130_fd_pr__nfet_g5v0d10v5 w=1 l=0.5
XRn_39_2 BLN2 dn_39_2 sky130_fd_pr_reram__reram_cell area_ox=0.0676
XMp_39_3 dp_39_3 WL39 SL3 VSS sky130_fd_pr__nfet_g5v0d10v5 w=1 l=0.5
XRp_39_3 BLP3 dp_39_3 sky130_fd_pr_reram__reram_cell area_ox=0.0676
XMn_39_3 dn_39_3 WL39 SL3 VSS sky130_fd_pr__nfet_g5v0d10v5 w=1 l=0.5
XRn_39_3 BLN3 dn_39_3 sky130_fd_pr_reram__reram_cell area_ox=0.0676
XMp_39_4 dp_39_4 WL39 SL4 VSS sky130_fd_pr__nfet_g5v0d10v5 w=1 l=0.5
XRp_39_4 BLP4 dp_39_4 sky130_fd_pr_reram__reram_cell area_ox=0.0676
XMn_39_4 dn_39_4 WL39 SL4 VSS sky130_fd_pr__nfet_g5v0d10v5 w=1 l=0.5
XRn_39_4 BLN4 dn_39_4 sky130_fd_pr_reram__reram_cell area_ox=0.0676
XMp_39_5 dp_39_5 WL39 SL5 VSS sky130_fd_pr__nfet_g5v0d10v5 w=1 l=0.5
XRp_39_5 BLP5 dp_39_5 sky130_fd_pr_reram__reram_cell area_ox=0.0676
XMn_39_5 dn_39_5 WL39 SL5 VSS sky130_fd_pr__nfet_g5v0d10v5 w=1 l=0.5
XRn_39_5 BLN5 dn_39_5 sky130_fd_pr_reram__reram_cell area_ox=0.0676
XMp_39_6 dp_39_6 WL39 SL6 VSS sky130_fd_pr__nfet_g5v0d10v5 w=1 l=0.5
XRp_39_6 BLP6 dp_39_6 sky130_fd_pr_reram__reram_cell area_ox=0.0676
XMn_39_6 dn_39_6 WL39 SL6 VSS sky130_fd_pr__nfet_g5v0d10v5 w=1 l=0.5
XRn_39_6 BLN6 dn_39_6 sky130_fd_pr_reram__reram_cell area_ox=0.0676
XMp_39_7 dp_39_7 WL39 SL7 VSS sky130_fd_pr__nfet_g5v0d10v5 w=1 l=0.5
XRp_39_7 BLP7 dp_39_7 sky130_fd_pr_reram__reram_cell area_ox=0.0676
XMn_39_7 dn_39_7 WL39 SL7 VSS sky130_fd_pr__nfet_g5v0d10v5 w=1 l=0.5
XRn_39_7 BLN7 dn_39_7 sky130_fd_pr_reram__reram_cell area_ox=0.0676
XMp_39_8 dp_39_8 WL39 SL8 VSS sky130_fd_pr__nfet_g5v0d10v5 w=1 l=0.5
XRp_39_8 BLP8 dp_39_8 sky130_fd_pr_reram__reram_cell area_ox=0.0676
XMn_39_8 dn_39_8 WL39 SL8 VSS sky130_fd_pr__nfet_g5v0d10v5 w=1 l=0.5
XRn_39_8 BLN8 dn_39_8 sky130_fd_pr_reram__reram_cell area_ox=0.0676
XMp_39_9 dp_39_9 WL39 SL9 VSS sky130_fd_pr__nfet_g5v0d10v5 w=1 l=0.5
XRp_39_9 BLP9 dp_39_9 sky130_fd_pr_reram__reram_cell area_ox=0.0676
XMn_39_9 dn_39_9 WL39 SL9 VSS sky130_fd_pr__nfet_g5v0d10v5 w=1 l=0.5
XRn_39_9 BLN9 dn_39_9 sky130_fd_pr_reram__reram_cell area_ox=0.0676
XMp_39_10 dp_39_10 WL39 SL10 VSS sky130_fd_pr__nfet_g5v0d10v5 w=1 l=0.5
XRp_39_10 BLP10 dp_39_10 sky130_fd_pr_reram__reram_cell area_ox=0.0676
XMn_39_10 dn_39_10 WL39 SL10 VSS sky130_fd_pr__nfet_g5v0d10v5 w=1 l=0.5
XRn_39_10 BLN10 dn_39_10 sky130_fd_pr_reram__reram_cell area_ox=0.0676
XMp_39_11 dp_39_11 WL39 SL11 VSS sky130_fd_pr__nfet_g5v0d10v5 w=1 l=0.5
XRp_39_11 BLP11 dp_39_11 sky130_fd_pr_reram__reram_cell area_ox=0.0676
XMn_39_11 dn_39_11 WL39 SL11 VSS sky130_fd_pr__nfet_g5v0d10v5 w=1 l=0.5
XRn_39_11 BLN11 dn_39_11 sky130_fd_pr_reram__reram_cell area_ox=0.0676
XMp_39_12 dp_39_12 WL39 SL12 VSS sky130_fd_pr__nfet_g5v0d10v5 w=1 l=0.5
XRp_39_12 BLP12 dp_39_12 sky130_fd_pr_reram__reram_cell area_ox=0.0676
XMn_39_12 dn_39_12 WL39 SL12 VSS sky130_fd_pr__nfet_g5v0d10v5 w=1 l=0.5
XRn_39_12 BLN12 dn_39_12 sky130_fd_pr_reram__reram_cell area_ox=0.0676
XMp_39_13 dp_39_13 WL39 SL13 VSS sky130_fd_pr__nfet_g5v0d10v5 w=1 l=0.5
XRp_39_13 BLP13 dp_39_13 sky130_fd_pr_reram__reram_cell area_ox=0.0676
XMn_39_13 dn_39_13 WL39 SL13 VSS sky130_fd_pr__nfet_g5v0d10v5 w=1 l=0.5
XRn_39_13 BLN13 dn_39_13 sky130_fd_pr_reram__reram_cell area_ox=0.0676
XMp_39_14 dp_39_14 WL39 SL14 VSS sky130_fd_pr__nfet_g5v0d10v5 w=1 l=0.5
XRp_39_14 BLP14 dp_39_14 sky130_fd_pr_reram__reram_cell area_ox=0.0676
XMn_39_14 dn_39_14 WL39 SL14 VSS sky130_fd_pr__nfet_g5v0d10v5 w=1 l=0.5
XRn_39_14 BLN14 dn_39_14 sky130_fd_pr_reram__reram_cell area_ox=0.0676
XMp_39_15 dp_39_15 WL39 SL15 VSS sky130_fd_pr__nfet_g5v0d10v5 w=1 l=0.5
XRp_39_15 BLP15 dp_39_15 sky130_fd_pr_reram__reram_cell area_ox=0.0676
XMn_39_15 dn_39_15 WL39 SL15 VSS sky130_fd_pr__nfet_g5v0d10v5 w=1 l=0.5
XRn_39_15 BLN15 dn_39_15 sky130_fd_pr_reram__reram_cell area_ox=0.0676
XMp_39_16 dp_39_16 WL39 SL16 VSS sky130_fd_pr__nfet_g5v0d10v5 w=1 l=0.5
XRp_39_16 BLP16 dp_39_16 sky130_fd_pr_reram__reram_cell area_ox=0.0676
XMn_39_16 dn_39_16 WL39 SL16 VSS sky130_fd_pr__nfet_g5v0d10v5 w=1 l=0.5
XRn_39_16 BLN16 dn_39_16 sky130_fd_pr_reram__reram_cell area_ox=0.0676
XMp_39_17 dp_39_17 WL39 SL17 VSS sky130_fd_pr__nfet_g5v0d10v5 w=1 l=0.5
XRp_39_17 BLP17 dp_39_17 sky130_fd_pr_reram__reram_cell area_ox=0.0676
XMn_39_17 dn_39_17 WL39 SL17 VSS sky130_fd_pr__nfet_g5v0d10v5 w=1 l=0.5
XRn_39_17 BLN17 dn_39_17 sky130_fd_pr_reram__reram_cell area_ox=0.0676
XMp_39_18 dp_39_18 WL39 SL18 VSS sky130_fd_pr__nfet_g5v0d10v5 w=1 l=0.5
XRp_39_18 BLP18 dp_39_18 sky130_fd_pr_reram__reram_cell area_ox=0.0676
XMn_39_18 dn_39_18 WL39 SL18 VSS sky130_fd_pr__nfet_g5v0d10v5 w=1 l=0.5
XRn_39_18 BLN18 dn_39_18 sky130_fd_pr_reram__reram_cell area_ox=0.0676
XMp_39_19 dp_39_19 WL39 SL19 VSS sky130_fd_pr__nfet_g5v0d10v5 w=1 l=0.5
XRp_39_19 BLP19 dp_39_19 sky130_fd_pr_reram__reram_cell area_ox=0.0676
XMn_39_19 dn_39_19 WL39 SL19 VSS sky130_fd_pr__nfet_g5v0d10v5 w=1 l=0.5
XRn_39_19 BLN19 dn_39_19 sky130_fd_pr_reram__reram_cell area_ox=0.0676
XMp_39_20 dp_39_20 WL39 SL20 VSS sky130_fd_pr__nfet_g5v0d10v5 w=1 l=0.5
XRp_39_20 BLP20 dp_39_20 sky130_fd_pr_reram__reram_cell area_ox=0.0676
XMn_39_20 dn_39_20 WL39 SL20 VSS sky130_fd_pr__nfet_g5v0d10v5 w=1 l=0.5
XRn_39_20 BLN20 dn_39_20 sky130_fd_pr_reram__reram_cell area_ox=0.0676
XMp_39_21 dp_39_21 WL39 SL21 VSS sky130_fd_pr__nfet_g5v0d10v5 w=1 l=0.5
XRp_39_21 BLP21 dp_39_21 sky130_fd_pr_reram__reram_cell area_ox=0.0676
XMn_39_21 dn_39_21 WL39 SL21 VSS sky130_fd_pr__nfet_g5v0d10v5 w=1 l=0.5
XRn_39_21 BLN21 dn_39_21 sky130_fd_pr_reram__reram_cell area_ox=0.0676
XMp_39_22 dp_39_22 WL39 SL22 VSS sky130_fd_pr__nfet_g5v0d10v5 w=1 l=0.5
XRp_39_22 BLP22 dp_39_22 sky130_fd_pr_reram__reram_cell area_ox=0.0676
XMn_39_22 dn_39_22 WL39 SL22 VSS sky130_fd_pr__nfet_g5v0d10v5 w=1 l=0.5
XRn_39_22 BLN22 dn_39_22 sky130_fd_pr_reram__reram_cell area_ox=0.0676
XMp_39_23 dp_39_23 WL39 SL23 VSS sky130_fd_pr__nfet_g5v0d10v5 w=1 l=0.5
XRp_39_23 BLP23 dp_39_23 sky130_fd_pr_reram__reram_cell area_ox=0.0676
XMn_39_23 dn_39_23 WL39 SL23 VSS sky130_fd_pr__nfet_g5v0d10v5 w=1 l=0.5
XRn_39_23 BLN23 dn_39_23 sky130_fd_pr_reram__reram_cell area_ox=0.0676
XMp_40_0 dp_40_0 WL40 SL0 VSS sky130_fd_pr__nfet_g5v0d10v5 w=1 l=0.5
XRp_40_0 BLP0 dp_40_0 sky130_fd_pr_reram__reram_cell area_ox=0.0676
XMn_40_0 dn_40_0 WL40 SL0 VSS sky130_fd_pr__nfet_g5v0d10v5 w=1 l=0.5
XRn_40_0 BLN0 dn_40_0 sky130_fd_pr_reram__reram_cell area_ox=0.0676
XMp_40_1 dp_40_1 WL40 SL1 VSS sky130_fd_pr__nfet_g5v0d10v5 w=1 l=0.5
XRp_40_1 BLP1 dp_40_1 sky130_fd_pr_reram__reram_cell area_ox=0.0676
XMn_40_1 dn_40_1 WL40 SL1 VSS sky130_fd_pr__nfet_g5v0d10v5 w=1 l=0.5
XRn_40_1 BLN1 dn_40_1 sky130_fd_pr_reram__reram_cell area_ox=0.0676
XMp_40_2 dp_40_2 WL40 SL2 VSS sky130_fd_pr__nfet_g5v0d10v5 w=1 l=0.5
XRp_40_2 BLP2 dp_40_2 sky130_fd_pr_reram__reram_cell area_ox=0.0676
XMn_40_2 dn_40_2 WL40 SL2 VSS sky130_fd_pr__nfet_g5v0d10v5 w=1 l=0.5
XRn_40_2 BLN2 dn_40_2 sky130_fd_pr_reram__reram_cell area_ox=0.0676
XMp_40_3 dp_40_3 WL40 SL3 VSS sky130_fd_pr__nfet_g5v0d10v5 w=1 l=0.5
XRp_40_3 BLP3 dp_40_3 sky130_fd_pr_reram__reram_cell area_ox=0.0676
XMn_40_3 dn_40_3 WL40 SL3 VSS sky130_fd_pr__nfet_g5v0d10v5 w=1 l=0.5
XRn_40_3 BLN3 dn_40_3 sky130_fd_pr_reram__reram_cell area_ox=0.0676
XMp_40_4 dp_40_4 WL40 SL4 VSS sky130_fd_pr__nfet_g5v0d10v5 w=1 l=0.5
XRp_40_4 BLP4 dp_40_4 sky130_fd_pr_reram__reram_cell area_ox=0.0676
XMn_40_4 dn_40_4 WL40 SL4 VSS sky130_fd_pr__nfet_g5v0d10v5 w=1 l=0.5
XRn_40_4 BLN4 dn_40_4 sky130_fd_pr_reram__reram_cell area_ox=0.0676
XMp_40_5 dp_40_5 WL40 SL5 VSS sky130_fd_pr__nfet_g5v0d10v5 w=1 l=0.5
XRp_40_5 BLP5 dp_40_5 sky130_fd_pr_reram__reram_cell area_ox=0.0676
XMn_40_5 dn_40_5 WL40 SL5 VSS sky130_fd_pr__nfet_g5v0d10v5 w=1 l=0.5
XRn_40_5 BLN5 dn_40_5 sky130_fd_pr_reram__reram_cell area_ox=0.0676
XMp_40_6 dp_40_6 WL40 SL6 VSS sky130_fd_pr__nfet_g5v0d10v5 w=1 l=0.5
XRp_40_6 BLP6 dp_40_6 sky130_fd_pr_reram__reram_cell area_ox=0.0676
XMn_40_6 dn_40_6 WL40 SL6 VSS sky130_fd_pr__nfet_g5v0d10v5 w=1 l=0.5
XRn_40_6 BLN6 dn_40_6 sky130_fd_pr_reram__reram_cell area_ox=0.0676
XMp_40_7 dp_40_7 WL40 SL7 VSS sky130_fd_pr__nfet_g5v0d10v5 w=1 l=0.5
XRp_40_7 BLP7 dp_40_7 sky130_fd_pr_reram__reram_cell area_ox=0.0676
XMn_40_7 dn_40_7 WL40 SL7 VSS sky130_fd_pr__nfet_g5v0d10v5 w=1 l=0.5
XRn_40_7 BLN7 dn_40_7 sky130_fd_pr_reram__reram_cell area_ox=0.0676
XMp_40_8 dp_40_8 WL40 SL8 VSS sky130_fd_pr__nfet_g5v0d10v5 w=1 l=0.5
XRp_40_8 BLP8 dp_40_8 sky130_fd_pr_reram__reram_cell area_ox=0.0676
XMn_40_8 dn_40_8 WL40 SL8 VSS sky130_fd_pr__nfet_g5v0d10v5 w=1 l=0.5
XRn_40_8 BLN8 dn_40_8 sky130_fd_pr_reram__reram_cell area_ox=0.0676
XMp_40_9 dp_40_9 WL40 SL9 VSS sky130_fd_pr__nfet_g5v0d10v5 w=1 l=0.5
XRp_40_9 BLP9 dp_40_9 sky130_fd_pr_reram__reram_cell area_ox=0.0676
XMn_40_9 dn_40_9 WL40 SL9 VSS sky130_fd_pr__nfet_g5v0d10v5 w=1 l=0.5
XRn_40_9 BLN9 dn_40_9 sky130_fd_pr_reram__reram_cell area_ox=0.0676
XMp_40_10 dp_40_10 WL40 SL10 VSS sky130_fd_pr__nfet_g5v0d10v5 w=1 l=0.5
XRp_40_10 BLP10 dp_40_10 sky130_fd_pr_reram__reram_cell area_ox=0.0676
XMn_40_10 dn_40_10 WL40 SL10 VSS sky130_fd_pr__nfet_g5v0d10v5 w=1 l=0.5
XRn_40_10 BLN10 dn_40_10 sky130_fd_pr_reram__reram_cell area_ox=0.0676
XMp_40_11 dp_40_11 WL40 SL11 VSS sky130_fd_pr__nfet_g5v0d10v5 w=1 l=0.5
XRp_40_11 BLP11 dp_40_11 sky130_fd_pr_reram__reram_cell area_ox=0.0676
XMn_40_11 dn_40_11 WL40 SL11 VSS sky130_fd_pr__nfet_g5v0d10v5 w=1 l=0.5
XRn_40_11 BLN11 dn_40_11 sky130_fd_pr_reram__reram_cell area_ox=0.0676
XMp_40_12 dp_40_12 WL40 SL12 VSS sky130_fd_pr__nfet_g5v0d10v5 w=1 l=0.5
XRp_40_12 BLP12 dp_40_12 sky130_fd_pr_reram__reram_cell area_ox=0.0676
XMn_40_12 dn_40_12 WL40 SL12 VSS sky130_fd_pr__nfet_g5v0d10v5 w=1 l=0.5
XRn_40_12 BLN12 dn_40_12 sky130_fd_pr_reram__reram_cell area_ox=0.0676
XMp_40_13 dp_40_13 WL40 SL13 VSS sky130_fd_pr__nfet_g5v0d10v5 w=1 l=0.5
XRp_40_13 BLP13 dp_40_13 sky130_fd_pr_reram__reram_cell area_ox=0.0676
XMn_40_13 dn_40_13 WL40 SL13 VSS sky130_fd_pr__nfet_g5v0d10v5 w=1 l=0.5
XRn_40_13 BLN13 dn_40_13 sky130_fd_pr_reram__reram_cell area_ox=0.0676
XMp_40_14 dp_40_14 WL40 SL14 VSS sky130_fd_pr__nfet_g5v0d10v5 w=1 l=0.5
XRp_40_14 BLP14 dp_40_14 sky130_fd_pr_reram__reram_cell area_ox=0.0676
XMn_40_14 dn_40_14 WL40 SL14 VSS sky130_fd_pr__nfet_g5v0d10v5 w=1 l=0.5
XRn_40_14 BLN14 dn_40_14 sky130_fd_pr_reram__reram_cell area_ox=0.0676
XMp_40_15 dp_40_15 WL40 SL15 VSS sky130_fd_pr__nfet_g5v0d10v5 w=1 l=0.5
XRp_40_15 BLP15 dp_40_15 sky130_fd_pr_reram__reram_cell area_ox=0.0676
XMn_40_15 dn_40_15 WL40 SL15 VSS sky130_fd_pr__nfet_g5v0d10v5 w=1 l=0.5
XRn_40_15 BLN15 dn_40_15 sky130_fd_pr_reram__reram_cell area_ox=0.0676
XMp_40_16 dp_40_16 WL40 SL16 VSS sky130_fd_pr__nfet_g5v0d10v5 w=1 l=0.5
XRp_40_16 BLP16 dp_40_16 sky130_fd_pr_reram__reram_cell area_ox=0.0676
XMn_40_16 dn_40_16 WL40 SL16 VSS sky130_fd_pr__nfet_g5v0d10v5 w=1 l=0.5
XRn_40_16 BLN16 dn_40_16 sky130_fd_pr_reram__reram_cell area_ox=0.0676
XMp_40_17 dp_40_17 WL40 SL17 VSS sky130_fd_pr__nfet_g5v0d10v5 w=1 l=0.5
XRp_40_17 BLP17 dp_40_17 sky130_fd_pr_reram__reram_cell area_ox=0.0676
XMn_40_17 dn_40_17 WL40 SL17 VSS sky130_fd_pr__nfet_g5v0d10v5 w=1 l=0.5
XRn_40_17 BLN17 dn_40_17 sky130_fd_pr_reram__reram_cell area_ox=0.0676
XMp_40_18 dp_40_18 WL40 SL18 VSS sky130_fd_pr__nfet_g5v0d10v5 w=1 l=0.5
XRp_40_18 BLP18 dp_40_18 sky130_fd_pr_reram__reram_cell area_ox=0.0676
XMn_40_18 dn_40_18 WL40 SL18 VSS sky130_fd_pr__nfet_g5v0d10v5 w=1 l=0.5
XRn_40_18 BLN18 dn_40_18 sky130_fd_pr_reram__reram_cell area_ox=0.0676
XMp_40_19 dp_40_19 WL40 SL19 VSS sky130_fd_pr__nfet_g5v0d10v5 w=1 l=0.5
XRp_40_19 BLP19 dp_40_19 sky130_fd_pr_reram__reram_cell area_ox=0.0676
XMn_40_19 dn_40_19 WL40 SL19 VSS sky130_fd_pr__nfet_g5v0d10v5 w=1 l=0.5
XRn_40_19 BLN19 dn_40_19 sky130_fd_pr_reram__reram_cell area_ox=0.0676
XMp_40_20 dp_40_20 WL40 SL20 VSS sky130_fd_pr__nfet_g5v0d10v5 w=1 l=0.5
XRp_40_20 BLP20 dp_40_20 sky130_fd_pr_reram__reram_cell area_ox=0.0676
XMn_40_20 dn_40_20 WL40 SL20 VSS sky130_fd_pr__nfet_g5v0d10v5 w=1 l=0.5
XRn_40_20 BLN20 dn_40_20 sky130_fd_pr_reram__reram_cell area_ox=0.0676
XMp_40_21 dp_40_21 WL40 SL21 VSS sky130_fd_pr__nfet_g5v0d10v5 w=1 l=0.5
XRp_40_21 BLP21 dp_40_21 sky130_fd_pr_reram__reram_cell area_ox=0.0676
XMn_40_21 dn_40_21 WL40 SL21 VSS sky130_fd_pr__nfet_g5v0d10v5 w=1 l=0.5
XRn_40_21 BLN21 dn_40_21 sky130_fd_pr_reram__reram_cell area_ox=0.0676
XMp_40_22 dp_40_22 WL40 SL22 VSS sky130_fd_pr__nfet_g5v0d10v5 w=1 l=0.5
XRp_40_22 BLP22 dp_40_22 sky130_fd_pr_reram__reram_cell area_ox=0.0676
XMn_40_22 dn_40_22 WL40 SL22 VSS sky130_fd_pr__nfet_g5v0d10v5 w=1 l=0.5
XRn_40_22 BLN22 dn_40_22 sky130_fd_pr_reram__reram_cell area_ox=0.0676
XMp_40_23 dp_40_23 WL40 SL23 VSS sky130_fd_pr__nfet_g5v0d10v5 w=1 l=0.5
XRp_40_23 BLP23 dp_40_23 sky130_fd_pr_reram__reram_cell area_ox=0.0676
XMn_40_23 dn_40_23 WL40 SL23 VSS sky130_fd_pr__nfet_g5v0d10v5 w=1 l=0.5
XRn_40_23 BLN23 dn_40_23 sky130_fd_pr_reram__reram_cell area_ox=0.0676
XMp_41_0 dp_41_0 WL41 SL0 VSS sky130_fd_pr__nfet_g5v0d10v5 w=1 l=0.5
XRp_41_0 BLP0 dp_41_0 sky130_fd_pr_reram__reram_cell area_ox=0.0676
XMn_41_0 dn_41_0 WL41 SL0 VSS sky130_fd_pr__nfet_g5v0d10v5 w=1 l=0.5
XRn_41_0 BLN0 dn_41_0 sky130_fd_pr_reram__reram_cell area_ox=0.0676
XMp_41_1 dp_41_1 WL41 SL1 VSS sky130_fd_pr__nfet_g5v0d10v5 w=1 l=0.5
XRp_41_1 BLP1 dp_41_1 sky130_fd_pr_reram__reram_cell area_ox=0.0676
XMn_41_1 dn_41_1 WL41 SL1 VSS sky130_fd_pr__nfet_g5v0d10v5 w=1 l=0.5
XRn_41_1 BLN1 dn_41_1 sky130_fd_pr_reram__reram_cell area_ox=0.0676
XMp_41_2 dp_41_2 WL41 SL2 VSS sky130_fd_pr__nfet_g5v0d10v5 w=1 l=0.5
XRp_41_2 BLP2 dp_41_2 sky130_fd_pr_reram__reram_cell area_ox=0.0676
XMn_41_2 dn_41_2 WL41 SL2 VSS sky130_fd_pr__nfet_g5v0d10v5 w=1 l=0.5
XRn_41_2 BLN2 dn_41_2 sky130_fd_pr_reram__reram_cell area_ox=0.0676
XMp_41_3 dp_41_3 WL41 SL3 VSS sky130_fd_pr__nfet_g5v0d10v5 w=1 l=0.5
XRp_41_3 BLP3 dp_41_3 sky130_fd_pr_reram__reram_cell area_ox=0.0676
XMn_41_3 dn_41_3 WL41 SL3 VSS sky130_fd_pr__nfet_g5v0d10v5 w=1 l=0.5
XRn_41_3 BLN3 dn_41_3 sky130_fd_pr_reram__reram_cell area_ox=0.0676
XMp_41_4 dp_41_4 WL41 SL4 VSS sky130_fd_pr__nfet_g5v0d10v5 w=1 l=0.5
XRp_41_4 BLP4 dp_41_4 sky130_fd_pr_reram__reram_cell area_ox=0.0676
XMn_41_4 dn_41_4 WL41 SL4 VSS sky130_fd_pr__nfet_g5v0d10v5 w=1 l=0.5
XRn_41_4 BLN4 dn_41_4 sky130_fd_pr_reram__reram_cell area_ox=0.0676
XMp_41_5 dp_41_5 WL41 SL5 VSS sky130_fd_pr__nfet_g5v0d10v5 w=1 l=0.5
XRp_41_5 BLP5 dp_41_5 sky130_fd_pr_reram__reram_cell area_ox=0.0676
XMn_41_5 dn_41_5 WL41 SL5 VSS sky130_fd_pr__nfet_g5v0d10v5 w=1 l=0.5
XRn_41_5 BLN5 dn_41_5 sky130_fd_pr_reram__reram_cell area_ox=0.0676
XMp_41_6 dp_41_6 WL41 SL6 VSS sky130_fd_pr__nfet_g5v0d10v5 w=1 l=0.5
XRp_41_6 BLP6 dp_41_6 sky130_fd_pr_reram__reram_cell area_ox=0.0676
XMn_41_6 dn_41_6 WL41 SL6 VSS sky130_fd_pr__nfet_g5v0d10v5 w=1 l=0.5
XRn_41_6 BLN6 dn_41_6 sky130_fd_pr_reram__reram_cell area_ox=0.0676
XMp_41_7 dp_41_7 WL41 SL7 VSS sky130_fd_pr__nfet_g5v0d10v5 w=1 l=0.5
XRp_41_7 BLP7 dp_41_7 sky130_fd_pr_reram__reram_cell area_ox=0.0676
XMn_41_7 dn_41_7 WL41 SL7 VSS sky130_fd_pr__nfet_g5v0d10v5 w=1 l=0.5
XRn_41_7 BLN7 dn_41_7 sky130_fd_pr_reram__reram_cell area_ox=0.0676
XMp_41_8 dp_41_8 WL41 SL8 VSS sky130_fd_pr__nfet_g5v0d10v5 w=1 l=0.5
XRp_41_8 BLP8 dp_41_8 sky130_fd_pr_reram__reram_cell area_ox=0.0676
XMn_41_8 dn_41_8 WL41 SL8 VSS sky130_fd_pr__nfet_g5v0d10v5 w=1 l=0.5
XRn_41_8 BLN8 dn_41_8 sky130_fd_pr_reram__reram_cell area_ox=0.0676
XMp_41_9 dp_41_9 WL41 SL9 VSS sky130_fd_pr__nfet_g5v0d10v5 w=1 l=0.5
XRp_41_9 BLP9 dp_41_9 sky130_fd_pr_reram__reram_cell area_ox=0.0676
XMn_41_9 dn_41_9 WL41 SL9 VSS sky130_fd_pr__nfet_g5v0d10v5 w=1 l=0.5
XRn_41_9 BLN9 dn_41_9 sky130_fd_pr_reram__reram_cell area_ox=0.0676
XMp_41_10 dp_41_10 WL41 SL10 VSS sky130_fd_pr__nfet_g5v0d10v5 w=1 l=0.5
XRp_41_10 BLP10 dp_41_10 sky130_fd_pr_reram__reram_cell area_ox=0.0676
XMn_41_10 dn_41_10 WL41 SL10 VSS sky130_fd_pr__nfet_g5v0d10v5 w=1 l=0.5
XRn_41_10 BLN10 dn_41_10 sky130_fd_pr_reram__reram_cell area_ox=0.0676
XMp_41_11 dp_41_11 WL41 SL11 VSS sky130_fd_pr__nfet_g5v0d10v5 w=1 l=0.5
XRp_41_11 BLP11 dp_41_11 sky130_fd_pr_reram__reram_cell area_ox=0.0676
XMn_41_11 dn_41_11 WL41 SL11 VSS sky130_fd_pr__nfet_g5v0d10v5 w=1 l=0.5
XRn_41_11 BLN11 dn_41_11 sky130_fd_pr_reram__reram_cell area_ox=0.0676
XMp_41_12 dp_41_12 WL41 SL12 VSS sky130_fd_pr__nfet_g5v0d10v5 w=1 l=0.5
XRp_41_12 BLP12 dp_41_12 sky130_fd_pr_reram__reram_cell area_ox=0.0676
XMn_41_12 dn_41_12 WL41 SL12 VSS sky130_fd_pr__nfet_g5v0d10v5 w=1 l=0.5
XRn_41_12 BLN12 dn_41_12 sky130_fd_pr_reram__reram_cell area_ox=0.0676
XMp_41_13 dp_41_13 WL41 SL13 VSS sky130_fd_pr__nfet_g5v0d10v5 w=1 l=0.5
XRp_41_13 BLP13 dp_41_13 sky130_fd_pr_reram__reram_cell area_ox=0.0676
XMn_41_13 dn_41_13 WL41 SL13 VSS sky130_fd_pr__nfet_g5v0d10v5 w=1 l=0.5
XRn_41_13 BLN13 dn_41_13 sky130_fd_pr_reram__reram_cell area_ox=0.0676
XMp_41_14 dp_41_14 WL41 SL14 VSS sky130_fd_pr__nfet_g5v0d10v5 w=1 l=0.5
XRp_41_14 BLP14 dp_41_14 sky130_fd_pr_reram__reram_cell area_ox=0.0676
XMn_41_14 dn_41_14 WL41 SL14 VSS sky130_fd_pr__nfet_g5v0d10v5 w=1 l=0.5
XRn_41_14 BLN14 dn_41_14 sky130_fd_pr_reram__reram_cell area_ox=0.0676
XMp_41_15 dp_41_15 WL41 SL15 VSS sky130_fd_pr__nfet_g5v0d10v5 w=1 l=0.5
XRp_41_15 BLP15 dp_41_15 sky130_fd_pr_reram__reram_cell area_ox=0.0676
XMn_41_15 dn_41_15 WL41 SL15 VSS sky130_fd_pr__nfet_g5v0d10v5 w=1 l=0.5
XRn_41_15 BLN15 dn_41_15 sky130_fd_pr_reram__reram_cell area_ox=0.0676
XMp_41_16 dp_41_16 WL41 SL16 VSS sky130_fd_pr__nfet_g5v0d10v5 w=1 l=0.5
XRp_41_16 BLP16 dp_41_16 sky130_fd_pr_reram__reram_cell area_ox=0.0676
XMn_41_16 dn_41_16 WL41 SL16 VSS sky130_fd_pr__nfet_g5v0d10v5 w=1 l=0.5
XRn_41_16 BLN16 dn_41_16 sky130_fd_pr_reram__reram_cell area_ox=0.0676
XMp_41_17 dp_41_17 WL41 SL17 VSS sky130_fd_pr__nfet_g5v0d10v5 w=1 l=0.5
XRp_41_17 BLP17 dp_41_17 sky130_fd_pr_reram__reram_cell area_ox=0.0676
XMn_41_17 dn_41_17 WL41 SL17 VSS sky130_fd_pr__nfet_g5v0d10v5 w=1 l=0.5
XRn_41_17 BLN17 dn_41_17 sky130_fd_pr_reram__reram_cell area_ox=0.0676
XMp_41_18 dp_41_18 WL41 SL18 VSS sky130_fd_pr__nfet_g5v0d10v5 w=1 l=0.5
XRp_41_18 BLP18 dp_41_18 sky130_fd_pr_reram__reram_cell area_ox=0.0676
XMn_41_18 dn_41_18 WL41 SL18 VSS sky130_fd_pr__nfet_g5v0d10v5 w=1 l=0.5
XRn_41_18 BLN18 dn_41_18 sky130_fd_pr_reram__reram_cell area_ox=0.0676
XMp_41_19 dp_41_19 WL41 SL19 VSS sky130_fd_pr__nfet_g5v0d10v5 w=1 l=0.5
XRp_41_19 BLP19 dp_41_19 sky130_fd_pr_reram__reram_cell area_ox=0.0676
XMn_41_19 dn_41_19 WL41 SL19 VSS sky130_fd_pr__nfet_g5v0d10v5 w=1 l=0.5
XRn_41_19 BLN19 dn_41_19 sky130_fd_pr_reram__reram_cell area_ox=0.0676
XMp_41_20 dp_41_20 WL41 SL20 VSS sky130_fd_pr__nfet_g5v0d10v5 w=1 l=0.5
XRp_41_20 BLP20 dp_41_20 sky130_fd_pr_reram__reram_cell area_ox=0.0676
XMn_41_20 dn_41_20 WL41 SL20 VSS sky130_fd_pr__nfet_g5v0d10v5 w=1 l=0.5
XRn_41_20 BLN20 dn_41_20 sky130_fd_pr_reram__reram_cell area_ox=0.0676
XMp_41_21 dp_41_21 WL41 SL21 VSS sky130_fd_pr__nfet_g5v0d10v5 w=1 l=0.5
XRp_41_21 BLP21 dp_41_21 sky130_fd_pr_reram__reram_cell area_ox=0.0676
XMn_41_21 dn_41_21 WL41 SL21 VSS sky130_fd_pr__nfet_g5v0d10v5 w=1 l=0.5
XRn_41_21 BLN21 dn_41_21 sky130_fd_pr_reram__reram_cell area_ox=0.0676
XMp_41_22 dp_41_22 WL41 SL22 VSS sky130_fd_pr__nfet_g5v0d10v5 w=1 l=0.5
XRp_41_22 BLP22 dp_41_22 sky130_fd_pr_reram__reram_cell area_ox=0.0676
XMn_41_22 dn_41_22 WL41 SL22 VSS sky130_fd_pr__nfet_g5v0d10v5 w=1 l=0.5
XRn_41_22 BLN22 dn_41_22 sky130_fd_pr_reram__reram_cell area_ox=0.0676
XMp_41_23 dp_41_23 WL41 SL23 VSS sky130_fd_pr__nfet_g5v0d10v5 w=1 l=0.5
XRp_41_23 BLP23 dp_41_23 sky130_fd_pr_reram__reram_cell area_ox=0.0676
XMn_41_23 dn_41_23 WL41 SL23 VSS sky130_fd_pr__nfet_g5v0d10v5 w=1 l=0.5
XRn_41_23 BLN23 dn_41_23 sky130_fd_pr_reram__reram_cell area_ox=0.0676
XMp_42_0 dp_42_0 WL42 SL0 VSS sky130_fd_pr__nfet_g5v0d10v5 w=1 l=0.5
XRp_42_0 BLP0 dp_42_0 sky130_fd_pr_reram__reram_cell area_ox=0.0676
XMn_42_0 dn_42_0 WL42 SL0 VSS sky130_fd_pr__nfet_g5v0d10v5 w=1 l=0.5
XRn_42_0 BLN0 dn_42_0 sky130_fd_pr_reram__reram_cell area_ox=0.0676
XMp_42_1 dp_42_1 WL42 SL1 VSS sky130_fd_pr__nfet_g5v0d10v5 w=1 l=0.5
XRp_42_1 BLP1 dp_42_1 sky130_fd_pr_reram__reram_cell area_ox=0.0676
XMn_42_1 dn_42_1 WL42 SL1 VSS sky130_fd_pr__nfet_g5v0d10v5 w=1 l=0.5
XRn_42_1 BLN1 dn_42_1 sky130_fd_pr_reram__reram_cell area_ox=0.0676
XMp_42_2 dp_42_2 WL42 SL2 VSS sky130_fd_pr__nfet_g5v0d10v5 w=1 l=0.5
XRp_42_2 BLP2 dp_42_2 sky130_fd_pr_reram__reram_cell area_ox=0.0676
XMn_42_2 dn_42_2 WL42 SL2 VSS sky130_fd_pr__nfet_g5v0d10v5 w=1 l=0.5
XRn_42_2 BLN2 dn_42_2 sky130_fd_pr_reram__reram_cell area_ox=0.0676
XMp_42_3 dp_42_3 WL42 SL3 VSS sky130_fd_pr__nfet_g5v0d10v5 w=1 l=0.5
XRp_42_3 BLP3 dp_42_3 sky130_fd_pr_reram__reram_cell area_ox=0.0676
XMn_42_3 dn_42_3 WL42 SL3 VSS sky130_fd_pr__nfet_g5v0d10v5 w=1 l=0.5
XRn_42_3 BLN3 dn_42_3 sky130_fd_pr_reram__reram_cell area_ox=0.0676
XMp_42_4 dp_42_4 WL42 SL4 VSS sky130_fd_pr__nfet_g5v0d10v5 w=1 l=0.5
XRp_42_4 BLP4 dp_42_4 sky130_fd_pr_reram__reram_cell area_ox=0.0676
XMn_42_4 dn_42_4 WL42 SL4 VSS sky130_fd_pr__nfet_g5v0d10v5 w=1 l=0.5
XRn_42_4 BLN4 dn_42_4 sky130_fd_pr_reram__reram_cell area_ox=0.0676
XMp_42_5 dp_42_5 WL42 SL5 VSS sky130_fd_pr__nfet_g5v0d10v5 w=1 l=0.5
XRp_42_5 BLP5 dp_42_5 sky130_fd_pr_reram__reram_cell area_ox=0.0676
XMn_42_5 dn_42_5 WL42 SL5 VSS sky130_fd_pr__nfet_g5v0d10v5 w=1 l=0.5
XRn_42_5 BLN5 dn_42_5 sky130_fd_pr_reram__reram_cell area_ox=0.0676
XMp_42_6 dp_42_6 WL42 SL6 VSS sky130_fd_pr__nfet_g5v0d10v5 w=1 l=0.5
XRp_42_6 BLP6 dp_42_6 sky130_fd_pr_reram__reram_cell area_ox=0.0676
XMn_42_6 dn_42_6 WL42 SL6 VSS sky130_fd_pr__nfet_g5v0d10v5 w=1 l=0.5
XRn_42_6 BLN6 dn_42_6 sky130_fd_pr_reram__reram_cell area_ox=0.0676
XMp_42_7 dp_42_7 WL42 SL7 VSS sky130_fd_pr__nfet_g5v0d10v5 w=1 l=0.5
XRp_42_7 BLP7 dp_42_7 sky130_fd_pr_reram__reram_cell area_ox=0.0676
XMn_42_7 dn_42_7 WL42 SL7 VSS sky130_fd_pr__nfet_g5v0d10v5 w=1 l=0.5
XRn_42_7 BLN7 dn_42_7 sky130_fd_pr_reram__reram_cell area_ox=0.0676
XMp_42_8 dp_42_8 WL42 SL8 VSS sky130_fd_pr__nfet_g5v0d10v5 w=1 l=0.5
XRp_42_8 BLP8 dp_42_8 sky130_fd_pr_reram__reram_cell area_ox=0.0676
XMn_42_8 dn_42_8 WL42 SL8 VSS sky130_fd_pr__nfet_g5v0d10v5 w=1 l=0.5
XRn_42_8 BLN8 dn_42_8 sky130_fd_pr_reram__reram_cell area_ox=0.0676
XMp_42_9 dp_42_9 WL42 SL9 VSS sky130_fd_pr__nfet_g5v0d10v5 w=1 l=0.5
XRp_42_9 BLP9 dp_42_9 sky130_fd_pr_reram__reram_cell area_ox=0.0676
XMn_42_9 dn_42_9 WL42 SL9 VSS sky130_fd_pr__nfet_g5v0d10v5 w=1 l=0.5
XRn_42_9 BLN9 dn_42_9 sky130_fd_pr_reram__reram_cell area_ox=0.0676
XMp_42_10 dp_42_10 WL42 SL10 VSS sky130_fd_pr__nfet_g5v0d10v5 w=1 l=0.5
XRp_42_10 BLP10 dp_42_10 sky130_fd_pr_reram__reram_cell area_ox=0.0676
XMn_42_10 dn_42_10 WL42 SL10 VSS sky130_fd_pr__nfet_g5v0d10v5 w=1 l=0.5
XRn_42_10 BLN10 dn_42_10 sky130_fd_pr_reram__reram_cell area_ox=0.0676
XMp_42_11 dp_42_11 WL42 SL11 VSS sky130_fd_pr__nfet_g5v0d10v5 w=1 l=0.5
XRp_42_11 BLP11 dp_42_11 sky130_fd_pr_reram__reram_cell area_ox=0.0676
XMn_42_11 dn_42_11 WL42 SL11 VSS sky130_fd_pr__nfet_g5v0d10v5 w=1 l=0.5
XRn_42_11 BLN11 dn_42_11 sky130_fd_pr_reram__reram_cell area_ox=0.0676
XMp_42_12 dp_42_12 WL42 SL12 VSS sky130_fd_pr__nfet_g5v0d10v5 w=1 l=0.5
XRp_42_12 BLP12 dp_42_12 sky130_fd_pr_reram__reram_cell area_ox=0.0676
XMn_42_12 dn_42_12 WL42 SL12 VSS sky130_fd_pr__nfet_g5v0d10v5 w=1 l=0.5
XRn_42_12 BLN12 dn_42_12 sky130_fd_pr_reram__reram_cell area_ox=0.0676
XMp_42_13 dp_42_13 WL42 SL13 VSS sky130_fd_pr__nfet_g5v0d10v5 w=1 l=0.5
XRp_42_13 BLP13 dp_42_13 sky130_fd_pr_reram__reram_cell area_ox=0.0676
XMn_42_13 dn_42_13 WL42 SL13 VSS sky130_fd_pr__nfet_g5v0d10v5 w=1 l=0.5
XRn_42_13 BLN13 dn_42_13 sky130_fd_pr_reram__reram_cell area_ox=0.0676
XMp_42_14 dp_42_14 WL42 SL14 VSS sky130_fd_pr__nfet_g5v0d10v5 w=1 l=0.5
XRp_42_14 BLP14 dp_42_14 sky130_fd_pr_reram__reram_cell area_ox=0.0676
XMn_42_14 dn_42_14 WL42 SL14 VSS sky130_fd_pr__nfet_g5v0d10v5 w=1 l=0.5
XRn_42_14 BLN14 dn_42_14 sky130_fd_pr_reram__reram_cell area_ox=0.0676
XMp_42_15 dp_42_15 WL42 SL15 VSS sky130_fd_pr__nfet_g5v0d10v5 w=1 l=0.5
XRp_42_15 BLP15 dp_42_15 sky130_fd_pr_reram__reram_cell area_ox=0.0676
XMn_42_15 dn_42_15 WL42 SL15 VSS sky130_fd_pr__nfet_g5v0d10v5 w=1 l=0.5
XRn_42_15 BLN15 dn_42_15 sky130_fd_pr_reram__reram_cell area_ox=0.0676
XMp_42_16 dp_42_16 WL42 SL16 VSS sky130_fd_pr__nfet_g5v0d10v5 w=1 l=0.5
XRp_42_16 BLP16 dp_42_16 sky130_fd_pr_reram__reram_cell area_ox=0.0676
XMn_42_16 dn_42_16 WL42 SL16 VSS sky130_fd_pr__nfet_g5v0d10v5 w=1 l=0.5
XRn_42_16 BLN16 dn_42_16 sky130_fd_pr_reram__reram_cell area_ox=0.0676
XMp_42_17 dp_42_17 WL42 SL17 VSS sky130_fd_pr__nfet_g5v0d10v5 w=1 l=0.5
XRp_42_17 BLP17 dp_42_17 sky130_fd_pr_reram__reram_cell area_ox=0.0676
XMn_42_17 dn_42_17 WL42 SL17 VSS sky130_fd_pr__nfet_g5v0d10v5 w=1 l=0.5
XRn_42_17 BLN17 dn_42_17 sky130_fd_pr_reram__reram_cell area_ox=0.0676
XMp_42_18 dp_42_18 WL42 SL18 VSS sky130_fd_pr__nfet_g5v0d10v5 w=1 l=0.5
XRp_42_18 BLP18 dp_42_18 sky130_fd_pr_reram__reram_cell area_ox=0.0676
XMn_42_18 dn_42_18 WL42 SL18 VSS sky130_fd_pr__nfet_g5v0d10v5 w=1 l=0.5
XRn_42_18 BLN18 dn_42_18 sky130_fd_pr_reram__reram_cell area_ox=0.0676
XMp_42_19 dp_42_19 WL42 SL19 VSS sky130_fd_pr__nfet_g5v0d10v5 w=1 l=0.5
XRp_42_19 BLP19 dp_42_19 sky130_fd_pr_reram__reram_cell area_ox=0.0676
XMn_42_19 dn_42_19 WL42 SL19 VSS sky130_fd_pr__nfet_g5v0d10v5 w=1 l=0.5
XRn_42_19 BLN19 dn_42_19 sky130_fd_pr_reram__reram_cell area_ox=0.0676
XMp_42_20 dp_42_20 WL42 SL20 VSS sky130_fd_pr__nfet_g5v0d10v5 w=1 l=0.5
XRp_42_20 BLP20 dp_42_20 sky130_fd_pr_reram__reram_cell area_ox=0.0676
XMn_42_20 dn_42_20 WL42 SL20 VSS sky130_fd_pr__nfet_g5v0d10v5 w=1 l=0.5
XRn_42_20 BLN20 dn_42_20 sky130_fd_pr_reram__reram_cell area_ox=0.0676
XMp_42_21 dp_42_21 WL42 SL21 VSS sky130_fd_pr__nfet_g5v0d10v5 w=1 l=0.5
XRp_42_21 BLP21 dp_42_21 sky130_fd_pr_reram__reram_cell area_ox=0.0676
XMn_42_21 dn_42_21 WL42 SL21 VSS sky130_fd_pr__nfet_g5v0d10v5 w=1 l=0.5
XRn_42_21 BLN21 dn_42_21 sky130_fd_pr_reram__reram_cell area_ox=0.0676
XMp_42_22 dp_42_22 WL42 SL22 VSS sky130_fd_pr__nfet_g5v0d10v5 w=1 l=0.5
XRp_42_22 BLP22 dp_42_22 sky130_fd_pr_reram__reram_cell area_ox=0.0676
XMn_42_22 dn_42_22 WL42 SL22 VSS sky130_fd_pr__nfet_g5v0d10v5 w=1 l=0.5
XRn_42_22 BLN22 dn_42_22 sky130_fd_pr_reram__reram_cell area_ox=0.0676
XMp_42_23 dp_42_23 WL42 SL23 VSS sky130_fd_pr__nfet_g5v0d10v5 w=1 l=0.5
XRp_42_23 BLP23 dp_42_23 sky130_fd_pr_reram__reram_cell area_ox=0.0676
XMn_42_23 dn_42_23 WL42 SL23 VSS sky130_fd_pr__nfet_g5v0d10v5 w=1 l=0.5
XRn_42_23 BLN23 dn_42_23 sky130_fd_pr_reram__reram_cell area_ox=0.0676
XMp_43_0 dp_43_0 WL43 SL0 VSS sky130_fd_pr__nfet_g5v0d10v5 w=1 l=0.5
XRp_43_0 BLP0 dp_43_0 sky130_fd_pr_reram__reram_cell area_ox=0.0676
XMn_43_0 dn_43_0 WL43 SL0 VSS sky130_fd_pr__nfet_g5v0d10v5 w=1 l=0.5
XRn_43_0 BLN0 dn_43_0 sky130_fd_pr_reram__reram_cell area_ox=0.0676
XMp_43_1 dp_43_1 WL43 SL1 VSS sky130_fd_pr__nfet_g5v0d10v5 w=1 l=0.5
XRp_43_1 BLP1 dp_43_1 sky130_fd_pr_reram__reram_cell area_ox=0.0676
XMn_43_1 dn_43_1 WL43 SL1 VSS sky130_fd_pr__nfet_g5v0d10v5 w=1 l=0.5
XRn_43_1 BLN1 dn_43_1 sky130_fd_pr_reram__reram_cell area_ox=0.0676
XMp_43_2 dp_43_2 WL43 SL2 VSS sky130_fd_pr__nfet_g5v0d10v5 w=1 l=0.5
XRp_43_2 BLP2 dp_43_2 sky130_fd_pr_reram__reram_cell area_ox=0.0676
XMn_43_2 dn_43_2 WL43 SL2 VSS sky130_fd_pr__nfet_g5v0d10v5 w=1 l=0.5
XRn_43_2 BLN2 dn_43_2 sky130_fd_pr_reram__reram_cell area_ox=0.0676
XMp_43_3 dp_43_3 WL43 SL3 VSS sky130_fd_pr__nfet_g5v0d10v5 w=1 l=0.5
XRp_43_3 BLP3 dp_43_3 sky130_fd_pr_reram__reram_cell area_ox=0.0676
XMn_43_3 dn_43_3 WL43 SL3 VSS sky130_fd_pr__nfet_g5v0d10v5 w=1 l=0.5
XRn_43_3 BLN3 dn_43_3 sky130_fd_pr_reram__reram_cell area_ox=0.0676
XMp_43_4 dp_43_4 WL43 SL4 VSS sky130_fd_pr__nfet_g5v0d10v5 w=1 l=0.5
XRp_43_4 BLP4 dp_43_4 sky130_fd_pr_reram__reram_cell area_ox=0.0676
XMn_43_4 dn_43_4 WL43 SL4 VSS sky130_fd_pr__nfet_g5v0d10v5 w=1 l=0.5
XRn_43_4 BLN4 dn_43_4 sky130_fd_pr_reram__reram_cell area_ox=0.0676
XMp_43_5 dp_43_5 WL43 SL5 VSS sky130_fd_pr__nfet_g5v0d10v5 w=1 l=0.5
XRp_43_5 BLP5 dp_43_5 sky130_fd_pr_reram__reram_cell area_ox=0.0676
XMn_43_5 dn_43_5 WL43 SL5 VSS sky130_fd_pr__nfet_g5v0d10v5 w=1 l=0.5
XRn_43_5 BLN5 dn_43_5 sky130_fd_pr_reram__reram_cell area_ox=0.0676
XMp_43_6 dp_43_6 WL43 SL6 VSS sky130_fd_pr__nfet_g5v0d10v5 w=1 l=0.5
XRp_43_6 BLP6 dp_43_6 sky130_fd_pr_reram__reram_cell area_ox=0.0676
XMn_43_6 dn_43_6 WL43 SL6 VSS sky130_fd_pr__nfet_g5v0d10v5 w=1 l=0.5
XRn_43_6 BLN6 dn_43_6 sky130_fd_pr_reram__reram_cell area_ox=0.0676
XMp_43_7 dp_43_7 WL43 SL7 VSS sky130_fd_pr__nfet_g5v0d10v5 w=1 l=0.5
XRp_43_7 BLP7 dp_43_7 sky130_fd_pr_reram__reram_cell area_ox=0.0676
XMn_43_7 dn_43_7 WL43 SL7 VSS sky130_fd_pr__nfet_g5v0d10v5 w=1 l=0.5
XRn_43_7 BLN7 dn_43_7 sky130_fd_pr_reram__reram_cell area_ox=0.0676
XMp_43_8 dp_43_8 WL43 SL8 VSS sky130_fd_pr__nfet_g5v0d10v5 w=1 l=0.5
XRp_43_8 BLP8 dp_43_8 sky130_fd_pr_reram__reram_cell area_ox=0.0676
XMn_43_8 dn_43_8 WL43 SL8 VSS sky130_fd_pr__nfet_g5v0d10v5 w=1 l=0.5
XRn_43_8 BLN8 dn_43_8 sky130_fd_pr_reram__reram_cell area_ox=0.0676
XMp_43_9 dp_43_9 WL43 SL9 VSS sky130_fd_pr__nfet_g5v0d10v5 w=1 l=0.5
XRp_43_9 BLP9 dp_43_9 sky130_fd_pr_reram__reram_cell area_ox=0.0676
XMn_43_9 dn_43_9 WL43 SL9 VSS sky130_fd_pr__nfet_g5v0d10v5 w=1 l=0.5
XRn_43_9 BLN9 dn_43_9 sky130_fd_pr_reram__reram_cell area_ox=0.0676
XMp_43_10 dp_43_10 WL43 SL10 VSS sky130_fd_pr__nfet_g5v0d10v5 w=1 l=0.5
XRp_43_10 BLP10 dp_43_10 sky130_fd_pr_reram__reram_cell area_ox=0.0676
XMn_43_10 dn_43_10 WL43 SL10 VSS sky130_fd_pr__nfet_g5v0d10v5 w=1 l=0.5
XRn_43_10 BLN10 dn_43_10 sky130_fd_pr_reram__reram_cell area_ox=0.0676
XMp_43_11 dp_43_11 WL43 SL11 VSS sky130_fd_pr__nfet_g5v0d10v5 w=1 l=0.5
XRp_43_11 BLP11 dp_43_11 sky130_fd_pr_reram__reram_cell area_ox=0.0676
XMn_43_11 dn_43_11 WL43 SL11 VSS sky130_fd_pr__nfet_g5v0d10v5 w=1 l=0.5
XRn_43_11 BLN11 dn_43_11 sky130_fd_pr_reram__reram_cell area_ox=0.0676
XMp_43_12 dp_43_12 WL43 SL12 VSS sky130_fd_pr__nfet_g5v0d10v5 w=1 l=0.5
XRp_43_12 BLP12 dp_43_12 sky130_fd_pr_reram__reram_cell area_ox=0.0676
XMn_43_12 dn_43_12 WL43 SL12 VSS sky130_fd_pr__nfet_g5v0d10v5 w=1 l=0.5
XRn_43_12 BLN12 dn_43_12 sky130_fd_pr_reram__reram_cell area_ox=0.0676
XMp_43_13 dp_43_13 WL43 SL13 VSS sky130_fd_pr__nfet_g5v0d10v5 w=1 l=0.5
XRp_43_13 BLP13 dp_43_13 sky130_fd_pr_reram__reram_cell area_ox=0.0676
XMn_43_13 dn_43_13 WL43 SL13 VSS sky130_fd_pr__nfet_g5v0d10v5 w=1 l=0.5
XRn_43_13 BLN13 dn_43_13 sky130_fd_pr_reram__reram_cell area_ox=0.0676
XMp_43_14 dp_43_14 WL43 SL14 VSS sky130_fd_pr__nfet_g5v0d10v5 w=1 l=0.5
XRp_43_14 BLP14 dp_43_14 sky130_fd_pr_reram__reram_cell area_ox=0.0676
XMn_43_14 dn_43_14 WL43 SL14 VSS sky130_fd_pr__nfet_g5v0d10v5 w=1 l=0.5
XRn_43_14 BLN14 dn_43_14 sky130_fd_pr_reram__reram_cell area_ox=0.0676
XMp_43_15 dp_43_15 WL43 SL15 VSS sky130_fd_pr__nfet_g5v0d10v5 w=1 l=0.5
XRp_43_15 BLP15 dp_43_15 sky130_fd_pr_reram__reram_cell area_ox=0.0676
XMn_43_15 dn_43_15 WL43 SL15 VSS sky130_fd_pr__nfet_g5v0d10v5 w=1 l=0.5
XRn_43_15 BLN15 dn_43_15 sky130_fd_pr_reram__reram_cell area_ox=0.0676
XMp_43_16 dp_43_16 WL43 SL16 VSS sky130_fd_pr__nfet_g5v0d10v5 w=1 l=0.5
XRp_43_16 BLP16 dp_43_16 sky130_fd_pr_reram__reram_cell area_ox=0.0676
XMn_43_16 dn_43_16 WL43 SL16 VSS sky130_fd_pr__nfet_g5v0d10v5 w=1 l=0.5
XRn_43_16 BLN16 dn_43_16 sky130_fd_pr_reram__reram_cell area_ox=0.0676
XMp_43_17 dp_43_17 WL43 SL17 VSS sky130_fd_pr__nfet_g5v0d10v5 w=1 l=0.5
XRp_43_17 BLP17 dp_43_17 sky130_fd_pr_reram__reram_cell area_ox=0.0676
XMn_43_17 dn_43_17 WL43 SL17 VSS sky130_fd_pr__nfet_g5v0d10v5 w=1 l=0.5
XRn_43_17 BLN17 dn_43_17 sky130_fd_pr_reram__reram_cell area_ox=0.0676
XMp_43_18 dp_43_18 WL43 SL18 VSS sky130_fd_pr__nfet_g5v0d10v5 w=1 l=0.5
XRp_43_18 BLP18 dp_43_18 sky130_fd_pr_reram__reram_cell area_ox=0.0676
XMn_43_18 dn_43_18 WL43 SL18 VSS sky130_fd_pr__nfet_g5v0d10v5 w=1 l=0.5
XRn_43_18 BLN18 dn_43_18 sky130_fd_pr_reram__reram_cell area_ox=0.0676
XMp_43_19 dp_43_19 WL43 SL19 VSS sky130_fd_pr__nfet_g5v0d10v5 w=1 l=0.5
XRp_43_19 BLP19 dp_43_19 sky130_fd_pr_reram__reram_cell area_ox=0.0676
XMn_43_19 dn_43_19 WL43 SL19 VSS sky130_fd_pr__nfet_g5v0d10v5 w=1 l=0.5
XRn_43_19 BLN19 dn_43_19 sky130_fd_pr_reram__reram_cell area_ox=0.0676
XMp_43_20 dp_43_20 WL43 SL20 VSS sky130_fd_pr__nfet_g5v0d10v5 w=1 l=0.5
XRp_43_20 BLP20 dp_43_20 sky130_fd_pr_reram__reram_cell area_ox=0.0676
XMn_43_20 dn_43_20 WL43 SL20 VSS sky130_fd_pr__nfet_g5v0d10v5 w=1 l=0.5
XRn_43_20 BLN20 dn_43_20 sky130_fd_pr_reram__reram_cell area_ox=0.0676
XMp_43_21 dp_43_21 WL43 SL21 VSS sky130_fd_pr__nfet_g5v0d10v5 w=1 l=0.5
XRp_43_21 BLP21 dp_43_21 sky130_fd_pr_reram__reram_cell area_ox=0.0676
XMn_43_21 dn_43_21 WL43 SL21 VSS sky130_fd_pr__nfet_g5v0d10v5 w=1 l=0.5
XRn_43_21 BLN21 dn_43_21 sky130_fd_pr_reram__reram_cell area_ox=0.0676
XMp_43_22 dp_43_22 WL43 SL22 VSS sky130_fd_pr__nfet_g5v0d10v5 w=1 l=0.5
XRp_43_22 BLP22 dp_43_22 sky130_fd_pr_reram__reram_cell area_ox=0.0676
XMn_43_22 dn_43_22 WL43 SL22 VSS sky130_fd_pr__nfet_g5v0d10v5 w=1 l=0.5
XRn_43_22 BLN22 dn_43_22 sky130_fd_pr_reram__reram_cell area_ox=0.0676
XMp_43_23 dp_43_23 WL43 SL23 VSS sky130_fd_pr__nfet_g5v0d10v5 w=1 l=0.5
XRp_43_23 BLP23 dp_43_23 sky130_fd_pr_reram__reram_cell area_ox=0.0676
XMn_43_23 dn_43_23 WL43 SL23 VSS sky130_fd_pr__nfet_g5v0d10v5 w=1 l=0.5
XRn_43_23 BLN23 dn_43_23 sky130_fd_pr_reram__reram_cell area_ox=0.0676
XMp_44_0 dp_44_0 WL44 SL0 VSS sky130_fd_pr__nfet_g5v0d10v5 w=1 l=0.5
XRp_44_0 BLP0 dp_44_0 sky130_fd_pr_reram__reram_cell area_ox=0.0676
XMn_44_0 dn_44_0 WL44 SL0 VSS sky130_fd_pr__nfet_g5v0d10v5 w=1 l=0.5
XRn_44_0 BLN0 dn_44_0 sky130_fd_pr_reram__reram_cell area_ox=0.0676
XMp_44_1 dp_44_1 WL44 SL1 VSS sky130_fd_pr__nfet_g5v0d10v5 w=1 l=0.5
XRp_44_1 BLP1 dp_44_1 sky130_fd_pr_reram__reram_cell area_ox=0.0676
XMn_44_1 dn_44_1 WL44 SL1 VSS sky130_fd_pr__nfet_g5v0d10v5 w=1 l=0.5
XRn_44_1 BLN1 dn_44_1 sky130_fd_pr_reram__reram_cell area_ox=0.0676
XMp_44_2 dp_44_2 WL44 SL2 VSS sky130_fd_pr__nfet_g5v0d10v5 w=1 l=0.5
XRp_44_2 BLP2 dp_44_2 sky130_fd_pr_reram__reram_cell area_ox=0.0676
XMn_44_2 dn_44_2 WL44 SL2 VSS sky130_fd_pr__nfet_g5v0d10v5 w=1 l=0.5
XRn_44_2 BLN2 dn_44_2 sky130_fd_pr_reram__reram_cell area_ox=0.0676
XMp_44_3 dp_44_3 WL44 SL3 VSS sky130_fd_pr__nfet_g5v0d10v5 w=1 l=0.5
XRp_44_3 BLP3 dp_44_3 sky130_fd_pr_reram__reram_cell area_ox=0.0676
XMn_44_3 dn_44_3 WL44 SL3 VSS sky130_fd_pr__nfet_g5v0d10v5 w=1 l=0.5
XRn_44_3 BLN3 dn_44_3 sky130_fd_pr_reram__reram_cell area_ox=0.0676
XMp_44_4 dp_44_4 WL44 SL4 VSS sky130_fd_pr__nfet_g5v0d10v5 w=1 l=0.5
XRp_44_4 BLP4 dp_44_4 sky130_fd_pr_reram__reram_cell area_ox=0.0676
XMn_44_4 dn_44_4 WL44 SL4 VSS sky130_fd_pr__nfet_g5v0d10v5 w=1 l=0.5
XRn_44_4 BLN4 dn_44_4 sky130_fd_pr_reram__reram_cell area_ox=0.0676
XMp_44_5 dp_44_5 WL44 SL5 VSS sky130_fd_pr__nfet_g5v0d10v5 w=1 l=0.5
XRp_44_5 BLP5 dp_44_5 sky130_fd_pr_reram__reram_cell area_ox=0.0676
XMn_44_5 dn_44_5 WL44 SL5 VSS sky130_fd_pr__nfet_g5v0d10v5 w=1 l=0.5
XRn_44_5 BLN5 dn_44_5 sky130_fd_pr_reram__reram_cell area_ox=0.0676
XMp_44_6 dp_44_6 WL44 SL6 VSS sky130_fd_pr__nfet_g5v0d10v5 w=1 l=0.5
XRp_44_6 BLP6 dp_44_6 sky130_fd_pr_reram__reram_cell area_ox=0.0676
XMn_44_6 dn_44_6 WL44 SL6 VSS sky130_fd_pr__nfet_g5v0d10v5 w=1 l=0.5
XRn_44_6 BLN6 dn_44_6 sky130_fd_pr_reram__reram_cell area_ox=0.0676
XMp_44_7 dp_44_7 WL44 SL7 VSS sky130_fd_pr__nfet_g5v0d10v5 w=1 l=0.5
XRp_44_7 BLP7 dp_44_7 sky130_fd_pr_reram__reram_cell area_ox=0.0676
XMn_44_7 dn_44_7 WL44 SL7 VSS sky130_fd_pr__nfet_g5v0d10v5 w=1 l=0.5
XRn_44_7 BLN7 dn_44_7 sky130_fd_pr_reram__reram_cell area_ox=0.0676
XMp_44_8 dp_44_8 WL44 SL8 VSS sky130_fd_pr__nfet_g5v0d10v5 w=1 l=0.5
XRp_44_8 BLP8 dp_44_8 sky130_fd_pr_reram__reram_cell area_ox=0.0676
XMn_44_8 dn_44_8 WL44 SL8 VSS sky130_fd_pr__nfet_g5v0d10v5 w=1 l=0.5
XRn_44_8 BLN8 dn_44_8 sky130_fd_pr_reram__reram_cell area_ox=0.0676
XMp_44_9 dp_44_9 WL44 SL9 VSS sky130_fd_pr__nfet_g5v0d10v5 w=1 l=0.5
XRp_44_9 BLP9 dp_44_9 sky130_fd_pr_reram__reram_cell area_ox=0.0676
XMn_44_9 dn_44_9 WL44 SL9 VSS sky130_fd_pr__nfet_g5v0d10v5 w=1 l=0.5
XRn_44_9 BLN9 dn_44_9 sky130_fd_pr_reram__reram_cell area_ox=0.0676
XMp_44_10 dp_44_10 WL44 SL10 VSS sky130_fd_pr__nfet_g5v0d10v5 w=1 l=0.5
XRp_44_10 BLP10 dp_44_10 sky130_fd_pr_reram__reram_cell area_ox=0.0676
XMn_44_10 dn_44_10 WL44 SL10 VSS sky130_fd_pr__nfet_g5v0d10v5 w=1 l=0.5
XRn_44_10 BLN10 dn_44_10 sky130_fd_pr_reram__reram_cell area_ox=0.0676
XMp_44_11 dp_44_11 WL44 SL11 VSS sky130_fd_pr__nfet_g5v0d10v5 w=1 l=0.5
XRp_44_11 BLP11 dp_44_11 sky130_fd_pr_reram__reram_cell area_ox=0.0676
XMn_44_11 dn_44_11 WL44 SL11 VSS sky130_fd_pr__nfet_g5v0d10v5 w=1 l=0.5
XRn_44_11 BLN11 dn_44_11 sky130_fd_pr_reram__reram_cell area_ox=0.0676
XMp_44_12 dp_44_12 WL44 SL12 VSS sky130_fd_pr__nfet_g5v0d10v5 w=1 l=0.5
XRp_44_12 BLP12 dp_44_12 sky130_fd_pr_reram__reram_cell area_ox=0.0676
XMn_44_12 dn_44_12 WL44 SL12 VSS sky130_fd_pr__nfet_g5v0d10v5 w=1 l=0.5
XRn_44_12 BLN12 dn_44_12 sky130_fd_pr_reram__reram_cell area_ox=0.0676
XMp_44_13 dp_44_13 WL44 SL13 VSS sky130_fd_pr__nfet_g5v0d10v5 w=1 l=0.5
XRp_44_13 BLP13 dp_44_13 sky130_fd_pr_reram__reram_cell area_ox=0.0676
XMn_44_13 dn_44_13 WL44 SL13 VSS sky130_fd_pr__nfet_g5v0d10v5 w=1 l=0.5
XRn_44_13 BLN13 dn_44_13 sky130_fd_pr_reram__reram_cell area_ox=0.0676
XMp_44_14 dp_44_14 WL44 SL14 VSS sky130_fd_pr__nfet_g5v0d10v5 w=1 l=0.5
XRp_44_14 BLP14 dp_44_14 sky130_fd_pr_reram__reram_cell area_ox=0.0676
XMn_44_14 dn_44_14 WL44 SL14 VSS sky130_fd_pr__nfet_g5v0d10v5 w=1 l=0.5
XRn_44_14 BLN14 dn_44_14 sky130_fd_pr_reram__reram_cell area_ox=0.0676
XMp_44_15 dp_44_15 WL44 SL15 VSS sky130_fd_pr__nfet_g5v0d10v5 w=1 l=0.5
XRp_44_15 BLP15 dp_44_15 sky130_fd_pr_reram__reram_cell area_ox=0.0676
XMn_44_15 dn_44_15 WL44 SL15 VSS sky130_fd_pr__nfet_g5v0d10v5 w=1 l=0.5
XRn_44_15 BLN15 dn_44_15 sky130_fd_pr_reram__reram_cell area_ox=0.0676
XMp_44_16 dp_44_16 WL44 SL16 VSS sky130_fd_pr__nfet_g5v0d10v5 w=1 l=0.5
XRp_44_16 BLP16 dp_44_16 sky130_fd_pr_reram__reram_cell area_ox=0.0676
XMn_44_16 dn_44_16 WL44 SL16 VSS sky130_fd_pr__nfet_g5v0d10v5 w=1 l=0.5
XRn_44_16 BLN16 dn_44_16 sky130_fd_pr_reram__reram_cell area_ox=0.0676
XMp_44_17 dp_44_17 WL44 SL17 VSS sky130_fd_pr__nfet_g5v0d10v5 w=1 l=0.5
XRp_44_17 BLP17 dp_44_17 sky130_fd_pr_reram__reram_cell area_ox=0.0676
XMn_44_17 dn_44_17 WL44 SL17 VSS sky130_fd_pr__nfet_g5v0d10v5 w=1 l=0.5
XRn_44_17 BLN17 dn_44_17 sky130_fd_pr_reram__reram_cell area_ox=0.0676
XMp_44_18 dp_44_18 WL44 SL18 VSS sky130_fd_pr__nfet_g5v0d10v5 w=1 l=0.5
XRp_44_18 BLP18 dp_44_18 sky130_fd_pr_reram__reram_cell area_ox=0.0676
XMn_44_18 dn_44_18 WL44 SL18 VSS sky130_fd_pr__nfet_g5v0d10v5 w=1 l=0.5
XRn_44_18 BLN18 dn_44_18 sky130_fd_pr_reram__reram_cell area_ox=0.0676
XMp_44_19 dp_44_19 WL44 SL19 VSS sky130_fd_pr__nfet_g5v0d10v5 w=1 l=0.5
XRp_44_19 BLP19 dp_44_19 sky130_fd_pr_reram__reram_cell area_ox=0.0676
XMn_44_19 dn_44_19 WL44 SL19 VSS sky130_fd_pr__nfet_g5v0d10v5 w=1 l=0.5
XRn_44_19 BLN19 dn_44_19 sky130_fd_pr_reram__reram_cell area_ox=0.0676
XMp_44_20 dp_44_20 WL44 SL20 VSS sky130_fd_pr__nfet_g5v0d10v5 w=1 l=0.5
XRp_44_20 BLP20 dp_44_20 sky130_fd_pr_reram__reram_cell area_ox=0.0676
XMn_44_20 dn_44_20 WL44 SL20 VSS sky130_fd_pr__nfet_g5v0d10v5 w=1 l=0.5
XRn_44_20 BLN20 dn_44_20 sky130_fd_pr_reram__reram_cell area_ox=0.0676
XMp_44_21 dp_44_21 WL44 SL21 VSS sky130_fd_pr__nfet_g5v0d10v5 w=1 l=0.5
XRp_44_21 BLP21 dp_44_21 sky130_fd_pr_reram__reram_cell area_ox=0.0676
XMn_44_21 dn_44_21 WL44 SL21 VSS sky130_fd_pr__nfet_g5v0d10v5 w=1 l=0.5
XRn_44_21 BLN21 dn_44_21 sky130_fd_pr_reram__reram_cell area_ox=0.0676
XMp_44_22 dp_44_22 WL44 SL22 VSS sky130_fd_pr__nfet_g5v0d10v5 w=1 l=0.5
XRp_44_22 BLP22 dp_44_22 sky130_fd_pr_reram__reram_cell area_ox=0.0676
XMn_44_22 dn_44_22 WL44 SL22 VSS sky130_fd_pr__nfet_g5v0d10v5 w=1 l=0.5
XRn_44_22 BLN22 dn_44_22 sky130_fd_pr_reram__reram_cell area_ox=0.0676
XMp_44_23 dp_44_23 WL44 SL23 VSS sky130_fd_pr__nfet_g5v0d10v5 w=1 l=0.5
XRp_44_23 BLP23 dp_44_23 sky130_fd_pr_reram__reram_cell area_ox=0.0676
XMn_44_23 dn_44_23 WL44 SL23 VSS sky130_fd_pr__nfet_g5v0d10v5 w=1 l=0.5
XRn_44_23 BLN23 dn_44_23 sky130_fd_pr_reram__reram_cell area_ox=0.0676
XMp_45_0 dp_45_0 WL45 SL0 VSS sky130_fd_pr__nfet_g5v0d10v5 w=1 l=0.5
XRp_45_0 BLP0 dp_45_0 sky130_fd_pr_reram__reram_cell area_ox=0.0676
XMn_45_0 dn_45_0 WL45 SL0 VSS sky130_fd_pr__nfet_g5v0d10v5 w=1 l=0.5
XRn_45_0 BLN0 dn_45_0 sky130_fd_pr_reram__reram_cell area_ox=0.0676
XMp_45_1 dp_45_1 WL45 SL1 VSS sky130_fd_pr__nfet_g5v0d10v5 w=1 l=0.5
XRp_45_1 BLP1 dp_45_1 sky130_fd_pr_reram__reram_cell area_ox=0.0676
XMn_45_1 dn_45_1 WL45 SL1 VSS sky130_fd_pr__nfet_g5v0d10v5 w=1 l=0.5
XRn_45_1 BLN1 dn_45_1 sky130_fd_pr_reram__reram_cell area_ox=0.0676
XMp_45_2 dp_45_2 WL45 SL2 VSS sky130_fd_pr__nfet_g5v0d10v5 w=1 l=0.5
XRp_45_2 BLP2 dp_45_2 sky130_fd_pr_reram__reram_cell area_ox=0.0676
XMn_45_2 dn_45_2 WL45 SL2 VSS sky130_fd_pr__nfet_g5v0d10v5 w=1 l=0.5
XRn_45_2 BLN2 dn_45_2 sky130_fd_pr_reram__reram_cell area_ox=0.0676
XMp_45_3 dp_45_3 WL45 SL3 VSS sky130_fd_pr__nfet_g5v0d10v5 w=1 l=0.5
XRp_45_3 BLP3 dp_45_3 sky130_fd_pr_reram__reram_cell area_ox=0.0676
XMn_45_3 dn_45_3 WL45 SL3 VSS sky130_fd_pr__nfet_g5v0d10v5 w=1 l=0.5
XRn_45_3 BLN3 dn_45_3 sky130_fd_pr_reram__reram_cell area_ox=0.0676
XMp_45_4 dp_45_4 WL45 SL4 VSS sky130_fd_pr__nfet_g5v0d10v5 w=1 l=0.5
XRp_45_4 BLP4 dp_45_4 sky130_fd_pr_reram__reram_cell area_ox=0.0676
XMn_45_4 dn_45_4 WL45 SL4 VSS sky130_fd_pr__nfet_g5v0d10v5 w=1 l=0.5
XRn_45_4 BLN4 dn_45_4 sky130_fd_pr_reram__reram_cell area_ox=0.0676
XMp_45_5 dp_45_5 WL45 SL5 VSS sky130_fd_pr__nfet_g5v0d10v5 w=1 l=0.5
XRp_45_5 BLP5 dp_45_5 sky130_fd_pr_reram__reram_cell area_ox=0.0676
XMn_45_5 dn_45_5 WL45 SL5 VSS sky130_fd_pr__nfet_g5v0d10v5 w=1 l=0.5
XRn_45_5 BLN5 dn_45_5 sky130_fd_pr_reram__reram_cell area_ox=0.0676
XMp_45_6 dp_45_6 WL45 SL6 VSS sky130_fd_pr__nfet_g5v0d10v5 w=1 l=0.5
XRp_45_6 BLP6 dp_45_6 sky130_fd_pr_reram__reram_cell area_ox=0.0676
XMn_45_6 dn_45_6 WL45 SL6 VSS sky130_fd_pr__nfet_g5v0d10v5 w=1 l=0.5
XRn_45_6 BLN6 dn_45_6 sky130_fd_pr_reram__reram_cell area_ox=0.0676
XMp_45_7 dp_45_7 WL45 SL7 VSS sky130_fd_pr__nfet_g5v0d10v5 w=1 l=0.5
XRp_45_7 BLP7 dp_45_7 sky130_fd_pr_reram__reram_cell area_ox=0.0676
XMn_45_7 dn_45_7 WL45 SL7 VSS sky130_fd_pr__nfet_g5v0d10v5 w=1 l=0.5
XRn_45_7 BLN7 dn_45_7 sky130_fd_pr_reram__reram_cell area_ox=0.0676
XMp_45_8 dp_45_8 WL45 SL8 VSS sky130_fd_pr__nfet_g5v0d10v5 w=1 l=0.5
XRp_45_8 BLP8 dp_45_8 sky130_fd_pr_reram__reram_cell area_ox=0.0676
XMn_45_8 dn_45_8 WL45 SL8 VSS sky130_fd_pr__nfet_g5v0d10v5 w=1 l=0.5
XRn_45_8 BLN8 dn_45_8 sky130_fd_pr_reram__reram_cell area_ox=0.0676
XMp_45_9 dp_45_9 WL45 SL9 VSS sky130_fd_pr__nfet_g5v0d10v5 w=1 l=0.5
XRp_45_9 BLP9 dp_45_9 sky130_fd_pr_reram__reram_cell area_ox=0.0676
XMn_45_9 dn_45_9 WL45 SL9 VSS sky130_fd_pr__nfet_g5v0d10v5 w=1 l=0.5
XRn_45_9 BLN9 dn_45_9 sky130_fd_pr_reram__reram_cell area_ox=0.0676
XMp_45_10 dp_45_10 WL45 SL10 VSS sky130_fd_pr__nfet_g5v0d10v5 w=1 l=0.5
XRp_45_10 BLP10 dp_45_10 sky130_fd_pr_reram__reram_cell area_ox=0.0676
XMn_45_10 dn_45_10 WL45 SL10 VSS sky130_fd_pr__nfet_g5v0d10v5 w=1 l=0.5
XRn_45_10 BLN10 dn_45_10 sky130_fd_pr_reram__reram_cell area_ox=0.0676
XMp_45_11 dp_45_11 WL45 SL11 VSS sky130_fd_pr__nfet_g5v0d10v5 w=1 l=0.5
XRp_45_11 BLP11 dp_45_11 sky130_fd_pr_reram__reram_cell area_ox=0.0676
XMn_45_11 dn_45_11 WL45 SL11 VSS sky130_fd_pr__nfet_g5v0d10v5 w=1 l=0.5
XRn_45_11 BLN11 dn_45_11 sky130_fd_pr_reram__reram_cell area_ox=0.0676
XMp_45_12 dp_45_12 WL45 SL12 VSS sky130_fd_pr__nfet_g5v0d10v5 w=1 l=0.5
XRp_45_12 BLP12 dp_45_12 sky130_fd_pr_reram__reram_cell area_ox=0.0676
XMn_45_12 dn_45_12 WL45 SL12 VSS sky130_fd_pr__nfet_g5v0d10v5 w=1 l=0.5
XRn_45_12 BLN12 dn_45_12 sky130_fd_pr_reram__reram_cell area_ox=0.0676
XMp_45_13 dp_45_13 WL45 SL13 VSS sky130_fd_pr__nfet_g5v0d10v5 w=1 l=0.5
XRp_45_13 BLP13 dp_45_13 sky130_fd_pr_reram__reram_cell area_ox=0.0676
XMn_45_13 dn_45_13 WL45 SL13 VSS sky130_fd_pr__nfet_g5v0d10v5 w=1 l=0.5
XRn_45_13 BLN13 dn_45_13 sky130_fd_pr_reram__reram_cell area_ox=0.0676
XMp_45_14 dp_45_14 WL45 SL14 VSS sky130_fd_pr__nfet_g5v0d10v5 w=1 l=0.5
XRp_45_14 BLP14 dp_45_14 sky130_fd_pr_reram__reram_cell area_ox=0.0676
XMn_45_14 dn_45_14 WL45 SL14 VSS sky130_fd_pr__nfet_g5v0d10v5 w=1 l=0.5
XRn_45_14 BLN14 dn_45_14 sky130_fd_pr_reram__reram_cell area_ox=0.0676
XMp_45_15 dp_45_15 WL45 SL15 VSS sky130_fd_pr__nfet_g5v0d10v5 w=1 l=0.5
XRp_45_15 BLP15 dp_45_15 sky130_fd_pr_reram__reram_cell area_ox=0.0676
XMn_45_15 dn_45_15 WL45 SL15 VSS sky130_fd_pr__nfet_g5v0d10v5 w=1 l=0.5
XRn_45_15 BLN15 dn_45_15 sky130_fd_pr_reram__reram_cell area_ox=0.0676
XMp_45_16 dp_45_16 WL45 SL16 VSS sky130_fd_pr__nfet_g5v0d10v5 w=1 l=0.5
XRp_45_16 BLP16 dp_45_16 sky130_fd_pr_reram__reram_cell area_ox=0.0676
XMn_45_16 dn_45_16 WL45 SL16 VSS sky130_fd_pr__nfet_g5v0d10v5 w=1 l=0.5
XRn_45_16 BLN16 dn_45_16 sky130_fd_pr_reram__reram_cell area_ox=0.0676
XMp_45_17 dp_45_17 WL45 SL17 VSS sky130_fd_pr__nfet_g5v0d10v5 w=1 l=0.5
XRp_45_17 BLP17 dp_45_17 sky130_fd_pr_reram__reram_cell area_ox=0.0676
XMn_45_17 dn_45_17 WL45 SL17 VSS sky130_fd_pr__nfet_g5v0d10v5 w=1 l=0.5
XRn_45_17 BLN17 dn_45_17 sky130_fd_pr_reram__reram_cell area_ox=0.0676
XMp_45_18 dp_45_18 WL45 SL18 VSS sky130_fd_pr__nfet_g5v0d10v5 w=1 l=0.5
XRp_45_18 BLP18 dp_45_18 sky130_fd_pr_reram__reram_cell area_ox=0.0676
XMn_45_18 dn_45_18 WL45 SL18 VSS sky130_fd_pr__nfet_g5v0d10v5 w=1 l=0.5
XRn_45_18 BLN18 dn_45_18 sky130_fd_pr_reram__reram_cell area_ox=0.0676
XMp_45_19 dp_45_19 WL45 SL19 VSS sky130_fd_pr__nfet_g5v0d10v5 w=1 l=0.5
XRp_45_19 BLP19 dp_45_19 sky130_fd_pr_reram__reram_cell area_ox=0.0676
XMn_45_19 dn_45_19 WL45 SL19 VSS sky130_fd_pr__nfet_g5v0d10v5 w=1 l=0.5
XRn_45_19 BLN19 dn_45_19 sky130_fd_pr_reram__reram_cell area_ox=0.0676
XMp_45_20 dp_45_20 WL45 SL20 VSS sky130_fd_pr__nfet_g5v0d10v5 w=1 l=0.5
XRp_45_20 BLP20 dp_45_20 sky130_fd_pr_reram__reram_cell area_ox=0.0676
XMn_45_20 dn_45_20 WL45 SL20 VSS sky130_fd_pr__nfet_g5v0d10v5 w=1 l=0.5
XRn_45_20 BLN20 dn_45_20 sky130_fd_pr_reram__reram_cell area_ox=0.0676
XMp_45_21 dp_45_21 WL45 SL21 VSS sky130_fd_pr__nfet_g5v0d10v5 w=1 l=0.5
XRp_45_21 BLP21 dp_45_21 sky130_fd_pr_reram__reram_cell area_ox=0.0676
XMn_45_21 dn_45_21 WL45 SL21 VSS sky130_fd_pr__nfet_g5v0d10v5 w=1 l=0.5
XRn_45_21 BLN21 dn_45_21 sky130_fd_pr_reram__reram_cell area_ox=0.0676
XMp_45_22 dp_45_22 WL45 SL22 VSS sky130_fd_pr__nfet_g5v0d10v5 w=1 l=0.5
XRp_45_22 BLP22 dp_45_22 sky130_fd_pr_reram__reram_cell area_ox=0.0676
XMn_45_22 dn_45_22 WL45 SL22 VSS sky130_fd_pr__nfet_g5v0d10v5 w=1 l=0.5
XRn_45_22 BLN22 dn_45_22 sky130_fd_pr_reram__reram_cell area_ox=0.0676
XMp_45_23 dp_45_23 WL45 SL23 VSS sky130_fd_pr__nfet_g5v0d10v5 w=1 l=0.5
XRp_45_23 BLP23 dp_45_23 sky130_fd_pr_reram__reram_cell area_ox=0.0676
XMn_45_23 dn_45_23 WL45 SL23 VSS sky130_fd_pr__nfet_g5v0d10v5 w=1 l=0.5
XRn_45_23 BLN23 dn_45_23 sky130_fd_pr_reram__reram_cell area_ox=0.0676
XMp_46_0 dp_46_0 WL46 SL0 VSS sky130_fd_pr__nfet_g5v0d10v5 w=1 l=0.5
XRp_46_0 BLP0 dp_46_0 sky130_fd_pr_reram__reram_cell area_ox=0.0676
XMn_46_0 dn_46_0 WL46 SL0 VSS sky130_fd_pr__nfet_g5v0d10v5 w=1 l=0.5
XRn_46_0 BLN0 dn_46_0 sky130_fd_pr_reram__reram_cell area_ox=0.0676
XMp_46_1 dp_46_1 WL46 SL1 VSS sky130_fd_pr__nfet_g5v0d10v5 w=1 l=0.5
XRp_46_1 BLP1 dp_46_1 sky130_fd_pr_reram__reram_cell area_ox=0.0676
XMn_46_1 dn_46_1 WL46 SL1 VSS sky130_fd_pr__nfet_g5v0d10v5 w=1 l=0.5
XRn_46_1 BLN1 dn_46_1 sky130_fd_pr_reram__reram_cell area_ox=0.0676
XMp_46_2 dp_46_2 WL46 SL2 VSS sky130_fd_pr__nfet_g5v0d10v5 w=1 l=0.5
XRp_46_2 BLP2 dp_46_2 sky130_fd_pr_reram__reram_cell area_ox=0.0676
XMn_46_2 dn_46_2 WL46 SL2 VSS sky130_fd_pr__nfet_g5v0d10v5 w=1 l=0.5
XRn_46_2 BLN2 dn_46_2 sky130_fd_pr_reram__reram_cell area_ox=0.0676
XMp_46_3 dp_46_3 WL46 SL3 VSS sky130_fd_pr__nfet_g5v0d10v5 w=1 l=0.5
XRp_46_3 BLP3 dp_46_3 sky130_fd_pr_reram__reram_cell area_ox=0.0676
XMn_46_3 dn_46_3 WL46 SL3 VSS sky130_fd_pr__nfet_g5v0d10v5 w=1 l=0.5
XRn_46_3 BLN3 dn_46_3 sky130_fd_pr_reram__reram_cell area_ox=0.0676
XMp_46_4 dp_46_4 WL46 SL4 VSS sky130_fd_pr__nfet_g5v0d10v5 w=1 l=0.5
XRp_46_4 BLP4 dp_46_4 sky130_fd_pr_reram__reram_cell area_ox=0.0676
XMn_46_4 dn_46_4 WL46 SL4 VSS sky130_fd_pr__nfet_g5v0d10v5 w=1 l=0.5
XRn_46_4 BLN4 dn_46_4 sky130_fd_pr_reram__reram_cell area_ox=0.0676
XMp_46_5 dp_46_5 WL46 SL5 VSS sky130_fd_pr__nfet_g5v0d10v5 w=1 l=0.5
XRp_46_5 BLP5 dp_46_5 sky130_fd_pr_reram__reram_cell area_ox=0.0676
XMn_46_5 dn_46_5 WL46 SL5 VSS sky130_fd_pr__nfet_g5v0d10v5 w=1 l=0.5
XRn_46_5 BLN5 dn_46_5 sky130_fd_pr_reram__reram_cell area_ox=0.0676
XMp_46_6 dp_46_6 WL46 SL6 VSS sky130_fd_pr__nfet_g5v0d10v5 w=1 l=0.5
XRp_46_6 BLP6 dp_46_6 sky130_fd_pr_reram__reram_cell area_ox=0.0676
XMn_46_6 dn_46_6 WL46 SL6 VSS sky130_fd_pr__nfet_g5v0d10v5 w=1 l=0.5
XRn_46_6 BLN6 dn_46_6 sky130_fd_pr_reram__reram_cell area_ox=0.0676
XMp_46_7 dp_46_7 WL46 SL7 VSS sky130_fd_pr__nfet_g5v0d10v5 w=1 l=0.5
XRp_46_7 BLP7 dp_46_7 sky130_fd_pr_reram__reram_cell area_ox=0.0676
XMn_46_7 dn_46_7 WL46 SL7 VSS sky130_fd_pr__nfet_g5v0d10v5 w=1 l=0.5
XRn_46_7 BLN7 dn_46_7 sky130_fd_pr_reram__reram_cell area_ox=0.0676
XMp_46_8 dp_46_8 WL46 SL8 VSS sky130_fd_pr__nfet_g5v0d10v5 w=1 l=0.5
XRp_46_8 BLP8 dp_46_8 sky130_fd_pr_reram__reram_cell area_ox=0.0676
XMn_46_8 dn_46_8 WL46 SL8 VSS sky130_fd_pr__nfet_g5v0d10v5 w=1 l=0.5
XRn_46_8 BLN8 dn_46_8 sky130_fd_pr_reram__reram_cell area_ox=0.0676
XMp_46_9 dp_46_9 WL46 SL9 VSS sky130_fd_pr__nfet_g5v0d10v5 w=1 l=0.5
XRp_46_9 BLP9 dp_46_9 sky130_fd_pr_reram__reram_cell area_ox=0.0676
XMn_46_9 dn_46_9 WL46 SL9 VSS sky130_fd_pr__nfet_g5v0d10v5 w=1 l=0.5
XRn_46_9 BLN9 dn_46_9 sky130_fd_pr_reram__reram_cell area_ox=0.0676
XMp_46_10 dp_46_10 WL46 SL10 VSS sky130_fd_pr__nfet_g5v0d10v5 w=1 l=0.5
XRp_46_10 BLP10 dp_46_10 sky130_fd_pr_reram__reram_cell area_ox=0.0676
XMn_46_10 dn_46_10 WL46 SL10 VSS sky130_fd_pr__nfet_g5v0d10v5 w=1 l=0.5
XRn_46_10 BLN10 dn_46_10 sky130_fd_pr_reram__reram_cell area_ox=0.0676
XMp_46_11 dp_46_11 WL46 SL11 VSS sky130_fd_pr__nfet_g5v0d10v5 w=1 l=0.5
XRp_46_11 BLP11 dp_46_11 sky130_fd_pr_reram__reram_cell area_ox=0.0676
XMn_46_11 dn_46_11 WL46 SL11 VSS sky130_fd_pr__nfet_g5v0d10v5 w=1 l=0.5
XRn_46_11 BLN11 dn_46_11 sky130_fd_pr_reram__reram_cell area_ox=0.0676
XMp_46_12 dp_46_12 WL46 SL12 VSS sky130_fd_pr__nfet_g5v0d10v5 w=1 l=0.5
XRp_46_12 BLP12 dp_46_12 sky130_fd_pr_reram__reram_cell area_ox=0.0676
XMn_46_12 dn_46_12 WL46 SL12 VSS sky130_fd_pr__nfet_g5v0d10v5 w=1 l=0.5
XRn_46_12 BLN12 dn_46_12 sky130_fd_pr_reram__reram_cell area_ox=0.0676
XMp_46_13 dp_46_13 WL46 SL13 VSS sky130_fd_pr__nfet_g5v0d10v5 w=1 l=0.5
XRp_46_13 BLP13 dp_46_13 sky130_fd_pr_reram__reram_cell area_ox=0.0676
XMn_46_13 dn_46_13 WL46 SL13 VSS sky130_fd_pr__nfet_g5v0d10v5 w=1 l=0.5
XRn_46_13 BLN13 dn_46_13 sky130_fd_pr_reram__reram_cell area_ox=0.0676
XMp_46_14 dp_46_14 WL46 SL14 VSS sky130_fd_pr__nfet_g5v0d10v5 w=1 l=0.5
XRp_46_14 BLP14 dp_46_14 sky130_fd_pr_reram__reram_cell area_ox=0.0676
XMn_46_14 dn_46_14 WL46 SL14 VSS sky130_fd_pr__nfet_g5v0d10v5 w=1 l=0.5
XRn_46_14 BLN14 dn_46_14 sky130_fd_pr_reram__reram_cell area_ox=0.0676
XMp_46_15 dp_46_15 WL46 SL15 VSS sky130_fd_pr__nfet_g5v0d10v5 w=1 l=0.5
XRp_46_15 BLP15 dp_46_15 sky130_fd_pr_reram__reram_cell area_ox=0.0676
XMn_46_15 dn_46_15 WL46 SL15 VSS sky130_fd_pr__nfet_g5v0d10v5 w=1 l=0.5
XRn_46_15 BLN15 dn_46_15 sky130_fd_pr_reram__reram_cell area_ox=0.0676
XMp_46_16 dp_46_16 WL46 SL16 VSS sky130_fd_pr__nfet_g5v0d10v5 w=1 l=0.5
XRp_46_16 BLP16 dp_46_16 sky130_fd_pr_reram__reram_cell area_ox=0.0676
XMn_46_16 dn_46_16 WL46 SL16 VSS sky130_fd_pr__nfet_g5v0d10v5 w=1 l=0.5
XRn_46_16 BLN16 dn_46_16 sky130_fd_pr_reram__reram_cell area_ox=0.0676
XMp_46_17 dp_46_17 WL46 SL17 VSS sky130_fd_pr__nfet_g5v0d10v5 w=1 l=0.5
XRp_46_17 BLP17 dp_46_17 sky130_fd_pr_reram__reram_cell area_ox=0.0676
XMn_46_17 dn_46_17 WL46 SL17 VSS sky130_fd_pr__nfet_g5v0d10v5 w=1 l=0.5
XRn_46_17 BLN17 dn_46_17 sky130_fd_pr_reram__reram_cell area_ox=0.0676
XMp_46_18 dp_46_18 WL46 SL18 VSS sky130_fd_pr__nfet_g5v0d10v5 w=1 l=0.5
XRp_46_18 BLP18 dp_46_18 sky130_fd_pr_reram__reram_cell area_ox=0.0676
XMn_46_18 dn_46_18 WL46 SL18 VSS sky130_fd_pr__nfet_g5v0d10v5 w=1 l=0.5
XRn_46_18 BLN18 dn_46_18 sky130_fd_pr_reram__reram_cell area_ox=0.0676
XMp_46_19 dp_46_19 WL46 SL19 VSS sky130_fd_pr__nfet_g5v0d10v5 w=1 l=0.5
XRp_46_19 BLP19 dp_46_19 sky130_fd_pr_reram__reram_cell area_ox=0.0676
XMn_46_19 dn_46_19 WL46 SL19 VSS sky130_fd_pr__nfet_g5v0d10v5 w=1 l=0.5
XRn_46_19 BLN19 dn_46_19 sky130_fd_pr_reram__reram_cell area_ox=0.0676
XMp_46_20 dp_46_20 WL46 SL20 VSS sky130_fd_pr__nfet_g5v0d10v5 w=1 l=0.5
XRp_46_20 BLP20 dp_46_20 sky130_fd_pr_reram__reram_cell area_ox=0.0676
XMn_46_20 dn_46_20 WL46 SL20 VSS sky130_fd_pr__nfet_g5v0d10v5 w=1 l=0.5
XRn_46_20 BLN20 dn_46_20 sky130_fd_pr_reram__reram_cell area_ox=0.0676
XMp_46_21 dp_46_21 WL46 SL21 VSS sky130_fd_pr__nfet_g5v0d10v5 w=1 l=0.5
XRp_46_21 BLP21 dp_46_21 sky130_fd_pr_reram__reram_cell area_ox=0.0676
XMn_46_21 dn_46_21 WL46 SL21 VSS sky130_fd_pr__nfet_g5v0d10v5 w=1 l=0.5
XRn_46_21 BLN21 dn_46_21 sky130_fd_pr_reram__reram_cell area_ox=0.0676
XMp_46_22 dp_46_22 WL46 SL22 VSS sky130_fd_pr__nfet_g5v0d10v5 w=1 l=0.5
XRp_46_22 BLP22 dp_46_22 sky130_fd_pr_reram__reram_cell area_ox=0.0676
XMn_46_22 dn_46_22 WL46 SL22 VSS sky130_fd_pr__nfet_g5v0d10v5 w=1 l=0.5
XRn_46_22 BLN22 dn_46_22 sky130_fd_pr_reram__reram_cell area_ox=0.0676
XMp_46_23 dp_46_23 WL46 SL23 VSS sky130_fd_pr__nfet_g5v0d10v5 w=1 l=0.5
XRp_46_23 BLP23 dp_46_23 sky130_fd_pr_reram__reram_cell area_ox=0.0676
XMn_46_23 dn_46_23 WL46 SL23 VSS sky130_fd_pr__nfet_g5v0d10v5 w=1 l=0.5
XRn_46_23 BLN23 dn_46_23 sky130_fd_pr_reram__reram_cell area_ox=0.0676
XMp_47_0 dp_47_0 WL47 SL0 VSS sky130_fd_pr__nfet_g5v0d10v5 w=1 l=0.5
XRp_47_0 BLP0 dp_47_0 sky130_fd_pr_reram__reram_cell area_ox=0.0676
XMn_47_0 dn_47_0 WL47 SL0 VSS sky130_fd_pr__nfet_g5v0d10v5 w=1 l=0.5
XRn_47_0 BLN0 dn_47_0 sky130_fd_pr_reram__reram_cell area_ox=0.0676
XMp_47_1 dp_47_1 WL47 SL1 VSS sky130_fd_pr__nfet_g5v0d10v5 w=1 l=0.5
XRp_47_1 BLP1 dp_47_1 sky130_fd_pr_reram__reram_cell area_ox=0.0676
XMn_47_1 dn_47_1 WL47 SL1 VSS sky130_fd_pr__nfet_g5v0d10v5 w=1 l=0.5
XRn_47_1 BLN1 dn_47_1 sky130_fd_pr_reram__reram_cell area_ox=0.0676
XMp_47_2 dp_47_2 WL47 SL2 VSS sky130_fd_pr__nfet_g5v0d10v5 w=1 l=0.5
XRp_47_2 BLP2 dp_47_2 sky130_fd_pr_reram__reram_cell area_ox=0.0676
XMn_47_2 dn_47_2 WL47 SL2 VSS sky130_fd_pr__nfet_g5v0d10v5 w=1 l=0.5
XRn_47_2 BLN2 dn_47_2 sky130_fd_pr_reram__reram_cell area_ox=0.0676
XMp_47_3 dp_47_3 WL47 SL3 VSS sky130_fd_pr__nfet_g5v0d10v5 w=1 l=0.5
XRp_47_3 BLP3 dp_47_3 sky130_fd_pr_reram__reram_cell area_ox=0.0676
XMn_47_3 dn_47_3 WL47 SL3 VSS sky130_fd_pr__nfet_g5v0d10v5 w=1 l=0.5
XRn_47_3 BLN3 dn_47_3 sky130_fd_pr_reram__reram_cell area_ox=0.0676
XMp_47_4 dp_47_4 WL47 SL4 VSS sky130_fd_pr__nfet_g5v0d10v5 w=1 l=0.5
XRp_47_4 BLP4 dp_47_4 sky130_fd_pr_reram__reram_cell area_ox=0.0676
XMn_47_4 dn_47_4 WL47 SL4 VSS sky130_fd_pr__nfet_g5v0d10v5 w=1 l=0.5
XRn_47_4 BLN4 dn_47_4 sky130_fd_pr_reram__reram_cell area_ox=0.0676
XMp_47_5 dp_47_5 WL47 SL5 VSS sky130_fd_pr__nfet_g5v0d10v5 w=1 l=0.5
XRp_47_5 BLP5 dp_47_5 sky130_fd_pr_reram__reram_cell area_ox=0.0676
XMn_47_5 dn_47_5 WL47 SL5 VSS sky130_fd_pr__nfet_g5v0d10v5 w=1 l=0.5
XRn_47_5 BLN5 dn_47_5 sky130_fd_pr_reram__reram_cell area_ox=0.0676
XMp_47_6 dp_47_6 WL47 SL6 VSS sky130_fd_pr__nfet_g5v0d10v5 w=1 l=0.5
XRp_47_6 BLP6 dp_47_6 sky130_fd_pr_reram__reram_cell area_ox=0.0676
XMn_47_6 dn_47_6 WL47 SL6 VSS sky130_fd_pr__nfet_g5v0d10v5 w=1 l=0.5
XRn_47_6 BLN6 dn_47_6 sky130_fd_pr_reram__reram_cell area_ox=0.0676
XMp_47_7 dp_47_7 WL47 SL7 VSS sky130_fd_pr__nfet_g5v0d10v5 w=1 l=0.5
XRp_47_7 BLP7 dp_47_7 sky130_fd_pr_reram__reram_cell area_ox=0.0676
XMn_47_7 dn_47_7 WL47 SL7 VSS sky130_fd_pr__nfet_g5v0d10v5 w=1 l=0.5
XRn_47_7 BLN7 dn_47_7 sky130_fd_pr_reram__reram_cell area_ox=0.0676
XMp_47_8 dp_47_8 WL47 SL8 VSS sky130_fd_pr__nfet_g5v0d10v5 w=1 l=0.5
XRp_47_8 BLP8 dp_47_8 sky130_fd_pr_reram__reram_cell area_ox=0.0676
XMn_47_8 dn_47_8 WL47 SL8 VSS sky130_fd_pr__nfet_g5v0d10v5 w=1 l=0.5
XRn_47_8 BLN8 dn_47_8 sky130_fd_pr_reram__reram_cell area_ox=0.0676
XMp_47_9 dp_47_9 WL47 SL9 VSS sky130_fd_pr__nfet_g5v0d10v5 w=1 l=0.5
XRp_47_9 BLP9 dp_47_9 sky130_fd_pr_reram__reram_cell area_ox=0.0676
XMn_47_9 dn_47_9 WL47 SL9 VSS sky130_fd_pr__nfet_g5v0d10v5 w=1 l=0.5
XRn_47_9 BLN9 dn_47_9 sky130_fd_pr_reram__reram_cell area_ox=0.0676
XMp_47_10 dp_47_10 WL47 SL10 VSS sky130_fd_pr__nfet_g5v0d10v5 w=1 l=0.5
XRp_47_10 BLP10 dp_47_10 sky130_fd_pr_reram__reram_cell area_ox=0.0676
XMn_47_10 dn_47_10 WL47 SL10 VSS sky130_fd_pr__nfet_g5v0d10v5 w=1 l=0.5
XRn_47_10 BLN10 dn_47_10 sky130_fd_pr_reram__reram_cell area_ox=0.0676
XMp_47_11 dp_47_11 WL47 SL11 VSS sky130_fd_pr__nfet_g5v0d10v5 w=1 l=0.5
XRp_47_11 BLP11 dp_47_11 sky130_fd_pr_reram__reram_cell area_ox=0.0676
XMn_47_11 dn_47_11 WL47 SL11 VSS sky130_fd_pr__nfet_g5v0d10v5 w=1 l=0.5
XRn_47_11 BLN11 dn_47_11 sky130_fd_pr_reram__reram_cell area_ox=0.0676
XMp_47_12 dp_47_12 WL47 SL12 VSS sky130_fd_pr__nfet_g5v0d10v5 w=1 l=0.5
XRp_47_12 BLP12 dp_47_12 sky130_fd_pr_reram__reram_cell area_ox=0.0676
XMn_47_12 dn_47_12 WL47 SL12 VSS sky130_fd_pr__nfet_g5v0d10v5 w=1 l=0.5
XRn_47_12 BLN12 dn_47_12 sky130_fd_pr_reram__reram_cell area_ox=0.0676
XMp_47_13 dp_47_13 WL47 SL13 VSS sky130_fd_pr__nfet_g5v0d10v5 w=1 l=0.5
XRp_47_13 BLP13 dp_47_13 sky130_fd_pr_reram__reram_cell area_ox=0.0676
XMn_47_13 dn_47_13 WL47 SL13 VSS sky130_fd_pr__nfet_g5v0d10v5 w=1 l=0.5
XRn_47_13 BLN13 dn_47_13 sky130_fd_pr_reram__reram_cell area_ox=0.0676
XMp_47_14 dp_47_14 WL47 SL14 VSS sky130_fd_pr__nfet_g5v0d10v5 w=1 l=0.5
XRp_47_14 BLP14 dp_47_14 sky130_fd_pr_reram__reram_cell area_ox=0.0676
XMn_47_14 dn_47_14 WL47 SL14 VSS sky130_fd_pr__nfet_g5v0d10v5 w=1 l=0.5
XRn_47_14 BLN14 dn_47_14 sky130_fd_pr_reram__reram_cell area_ox=0.0676
XMp_47_15 dp_47_15 WL47 SL15 VSS sky130_fd_pr__nfet_g5v0d10v5 w=1 l=0.5
XRp_47_15 BLP15 dp_47_15 sky130_fd_pr_reram__reram_cell area_ox=0.0676
XMn_47_15 dn_47_15 WL47 SL15 VSS sky130_fd_pr__nfet_g5v0d10v5 w=1 l=0.5
XRn_47_15 BLN15 dn_47_15 sky130_fd_pr_reram__reram_cell area_ox=0.0676
XMp_47_16 dp_47_16 WL47 SL16 VSS sky130_fd_pr__nfet_g5v0d10v5 w=1 l=0.5
XRp_47_16 BLP16 dp_47_16 sky130_fd_pr_reram__reram_cell area_ox=0.0676
XMn_47_16 dn_47_16 WL47 SL16 VSS sky130_fd_pr__nfet_g5v0d10v5 w=1 l=0.5
XRn_47_16 BLN16 dn_47_16 sky130_fd_pr_reram__reram_cell area_ox=0.0676
XMp_47_17 dp_47_17 WL47 SL17 VSS sky130_fd_pr__nfet_g5v0d10v5 w=1 l=0.5
XRp_47_17 BLP17 dp_47_17 sky130_fd_pr_reram__reram_cell area_ox=0.0676
XMn_47_17 dn_47_17 WL47 SL17 VSS sky130_fd_pr__nfet_g5v0d10v5 w=1 l=0.5
XRn_47_17 BLN17 dn_47_17 sky130_fd_pr_reram__reram_cell area_ox=0.0676
XMp_47_18 dp_47_18 WL47 SL18 VSS sky130_fd_pr__nfet_g5v0d10v5 w=1 l=0.5
XRp_47_18 BLP18 dp_47_18 sky130_fd_pr_reram__reram_cell area_ox=0.0676
XMn_47_18 dn_47_18 WL47 SL18 VSS sky130_fd_pr__nfet_g5v0d10v5 w=1 l=0.5
XRn_47_18 BLN18 dn_47_18 sky130_fd_pr_reram__reram_cell area_ox=0.0676
XMp_47_19 dp_47_19 WL47 SL19 VSS sky130_fd_pr__nfet_g5v0d10v5 w=1 l=0.5
XRp_47_19 BLP19 dp_47_19 sky130_fd_pr_reram__reram_cell area_ox=0.0676
XMn_47_19 dn_47_19 WL47 SL19 VSS sky130_fd_pr__nfet_g5v0d10v5 w=1 l=0.5
XRn_47_19 BLN19 dn_47_19 sky130_fd_pr_reram__reram_cell area_ox=0.0676
XMp_47_20 dp_47_20 WL47 SL20 VSS sky130_fd_pr__nfet_g5v0d10v5 w=1 l=0.5
XRp_47_20 BLP20 dp_47_20 sky130_fd_pr_reram__reram_cell area_ox=0.0676
XMn_47_20 dn_47_20 WL47 SL20 VSS sky130_fd_pr__nfet_g5v0d10v5 w=1 l=0.5
XRn_47_20 BLN20 dn_47_20 sky130_fd_pr_reram__reram_cell area_ox=0.0676
XMp_47_21 dp_47_21 WL47 SL21 VSS sky130_fd_pr__nfet_g5v0d10v5 w=1 l=0.5
XRp_47_21 BLP21 dp_47_21 sky130_fd_pr_reram__reram_cell area_ox=0.0676
XMn_47_21 dn_47_21 WL47 SL21 VSS sky130_fd_pr__nfet_g5v0d10v5 w=1 l=0.5
XRn_47_21 BLN21 dn_47_21 sky130_fd_pr_reram__reram_cell area_ox=0.0676
XMp_47_22 dp_47_22 WL47 SL22 VSS sky130_fd_pr__nfet_g5v0d10v5 w=1 l=0.5
XRp_47_22 BLP22 dp_47_22 sky130_fd_pr_reram__reram_cell area_ox=0.0676
XMn_47_22 dn_47_22 WL47 SL22 VSS sky130_fd_pr__nfet_g5v0d10v5 w=1 l=0.5
XRn_47_22 BLN22 dn_47_22 sky130_fd_pr_reram__reram_cell area_ox=0.0676
XMp_47_23 dp_47_23 WL47 SL23 VSS sky130_fd_pr__nfet_g5v0d10v5 w=1 l=0.5
XRp_47_23 BLP23 dp_47_23 sky130_fd_pr_reram__reram_cell area_ox=0.0676
XMn_47_23 dn_47_23 WL47 SL23 VSS sky130_fd_pr__nfet_g5v0d10v5 w=1 l=0.5
XRn_47_23 BLN23 dn_47_23 sky130_fd_pr_reram__reram_cell area_ox=0.0676
XMp_48_0 dp_48_0 WL48 SL0 VSS sky130_fd_pr__nfet_g5v0d10v5 w=1 l=0.5
XRp_48_0 BLP0 dp_48_0 sky130_fd_pr_reram__reram_cell area_ox=0.0676
XMn_48_0 dn_48_0 WL48 SL0 VSS sky130_fd_pr__nfet_g5v0d10v5 w=1 l=0.5
XRn_48_0 BLN0 dn_48_0 sky130_fd_pr_reram__reram_cell area_ox=0.0676
XMp_48_1 dp_48_1 WL48 SL1 VSS sky130_fd_pr__nfet_g5v0d10v5 w=1 l=0.5
XRp_48_1 BLP1 dp_48_1 sky130_fd_pr_reram__reram_cell area_ox=0.0676
XMn_48_1 dn_48_1 WL48 SL1 VSS sky130_fd_pr__nfet_g5v0d10v5 w=1 l=0.5
XRn_48_1 BLN1 dn_48_1 sky130_fd_pr_reram__reram_cell area_ox=0.0676
XMp_48_2 dp_48_2 WL48 SL2 VSS sky130_fd_pr__nfet_g5v0d10v5 w=1 l=0.5
XRp_48_2 BLP2 dp_48_2 sky130_fd_pr_reram__reram_cell area_ox=0.0676
XMn_48_2 dn_48_2 WL48 SL2 VSS sky130_fd_pr__nfet_g5v0d10v5 w=1 l=0.5
XRn_48_2 BLN2 dn_48_2 sky130_fd_pr_reram__reram_cell area_ox=0.0676
XMp_48_3 dp_48_3 WL48 SL3 VSS sky130_fd_pr__nfet_g5v0d10v5 w=1 l=0.5
XRp_48_3 BLP3 dp_48_3 sky130_fd_pr_reram__reram_cell area_ox=0.0676
XMn_48_3 dn_48_3 WL48 SL3 VSS sky130_fd_pr__nfet_g5v0d10v5 w=1 l=0.5
XRn_48_3 BLN3 dn_48_3 sky130_fd_pr_reram__reram_cell area_ox=0.0676
XMp_48_4 dp_48_4 WL48 SL4 VSS sky130_fd_pr__nfet_g5v0d10v5 w=1 l=0.5
XRp_48_4 BLP4 dp_48_4 sky130_fd_pr_reram__reram_cell area_ox=0.0676
XMn_48_4 dn_48_4 WL48 SL4 VSS sky130_fd_pr__nfet_g5v0d10v5 w=1 l=0.5
XRn_48_4 BLN4 dn_48_4 sky130_fd_pr_reram__reram_cell area_ox=0.0676
XMp_48_5 dp_48_5 WL48 SL5 VSS sky130_fd_pr__nfet_g5v0d10v5 w=1 l=0.5
XRp_48_5 BLP5 dp_48_5 sky130_fd_pr_reram__reram_cell area_ox=0.0676
XMn_48_5 dn_48_5 WL48 SL5 VSS sky130_fd_pr__nfet_g5v0d10v5 w=1 l=0.5
XRn_48_5 BLN5 dn_48_5 sky130_fd_pr_reram__reram_cell area_ox=0.0676
XMp_48_6 dp_48_6 WL48 SL6 VSS sky130_fd_pr__nfet_g5v0d10v5 w=1 l=0.5
XRp_48_6 BLP6 dp_48_6 sky130_fd_pr_reram__reram_cell area_ox=0.0676
XMn_48_6 dn_48_6 WL48 SL6 VSS sky130_fd_pr__nfet_g5v0d10v5 w=1 l=0.5
XRn_48_6 BLN6 dn_48_6 sky130_fd_pr_reram__reram_cell area_ox=0.0676
XMp_48_7 dp_48_7 WL48 SL7 VSS sky130_fd_pr__nfet_g5v0d10v5 w=1 l=0.5
XRp_48_7 BLP7 dp_48_7 sky130_fd_pr_reram__reram_cell area_ox=0.0676
XMn_48_7 dn_48_7 WL48 SL7 VSS sky130_fd_pr__nfet_g5v0d10v5 w=1 l=0.5
XRn_48_7 BLN7 dn_48_7 sky130_fd_pr_reram__reram_cell area_ox=0.0676
XMp_48_8 dp_48_8 WL48 SL8 VSS sky130_fd_pr__nfet_g5v0d10v5 w=1 l=0.5
XRp_48_8 BLP8 dp_48_8 sky130_fd_pr_reram__reram_cell area_ox=0.0676
XMn_48_8 dn_48_8 WL48 SL8 VSS sky130_fd_pr__nfet_g5v0d10v5 w=1 l=0.5
XRn_48_8 BLN8 dn_48_8 sky130_fd_pr_reram__reram_cell area_ox=0.0676
XMp_48_9 dp_48_9 WL48 SL9 VSS sky130_fd_pr__nfet_g5v0d10v5 w=1 l=0.5
XRp_48_9 BLP9 dp_48_9 sky130_fd_pr_reram__reram_cell area_ox=0.0676
XMn_48_9 dn_48_9 WL48 SL9 VSS sky130_fd_pr__nfet_g5v0d10v5 w=1 l=0.5
XRn_48_9 BLN9 dn_48_9 sky130_fd_pr_reram__reram_cell area_ox=0.0676
XMp_48_10 dp_48_10 WL48 SL10 VSS sky130_fd_pr__nfet_g5v0d10v5 w=1 l=0.5
XRp_48_10 BLP10 dp_48_10 sky130_fd_pr_reram__reram_cell area_ox=0.0676
XMn_48_10 dn_48_10 WL48 SL10 VSS sky130_fd_pr__nfet_g5v0d10v5 w=1 l=0.5
XRn_48_10 BLN10 dn_48_10 sky130_fd_pr_reram__reram_cell area_ox=0.0676
XMp_48_11 dp_48_11 WL48 SL11 VSS sky130_fd_pr__nfet_g5v0d10v5 w=1 l=0.5
XRp_48_11 BLP11 dp_48_11 sky130_fd_pr_reram__reram_cell area_ox=0.0676
XMn_48_11 dn_48_11 WL48 SL11 VSS sky130_fd_pr__nfet_g5v0d10v5 w=1 l=0.5
XRn_48_11 BLN11 dn_48_11 sky130_fd_pr_reram__reram_cell area_ox=0.0676
XMp_48_12 dp_48_12 WL48 SL12 VSS sky130_fd_pr__nfet_g5v0d10v5 w=1 l=0.5
XRp_48_12 BLP12 dp_48_12 sky130_fd_pr_reram__reram_cell area_ox=0.0676
XMn_48_12 dn_48_12 WL48 SL12 VSS sky130_fd_pr__nfet_g5v0d10v5 w=1 l=0.5
XRn_48_12 BLN12 dn_48_12 sky130_fd_pr_reram__reram_cell area_ox=0.0676
XMp_48_13 dp_48_13 WL48 SL13 VSS sky130_fd_pr__nfet_g5v0d10v5 w=1 l=0.5
XRp_48_13 BLP13 dp_48_13 sky130_fd_pr_reram__reram_cell area_ox=0.0676
XMn_48_13 dn_48_13 WL48 SL13 VSS sky130_fd_pr__nfet_g5v0d10v5 w=1 l=0.5
XRn_48_13 BLN13 dn_48_13 sky130_fd_pr_reram__reram_cell area_ox=0.0676
XMp_48_14 dp_48_14 WL48 SL14 VSS sky130_fd_pr__nfet_g5v0d10v5 w=1 l=0.5
XRp_48_14 BLP14 dp_48_14 sky130_fd_pr_reram__reram_cell area_ox=0.0676
XMn_48_14 dn_48_14 WL48 SL14 VSS sky130_fd_pr__nfet_g5v0d10v5 w=1 l=0.5
XRn_48_14 BLN14 dn_48_14 sky130_fd_pr_reram__reram_cell area_ox=0.0676
XMp_48_15 dp_48_15 WL48 SL15 VSS sky130_fd_pr__nfet_g5v0d10v5 w=1 l=0.5
XRp_48_15 BLP15 dp_48_15 sky130_fd_pr_reram__reram_cell area_ox=0.0676
XMn_48_15 dn_48_15 WL48 SL15 VSS sky130_fd_pr__nfet_g5v0d10v5 w=1 l=0.5
XRn_48_15 BLN15 dn_48_15 sky130_fd_pr_reram__reram_cell area_ox=0.0676
XMp_48_16 dp_48_16 WL48 SL16 VSS sky130_fd_pr__nfet_g5v0d10v5 w=1 l=0.5
XRp_48_16 BLP16 dp_48_16 sky130_fd_pr_reram__reram_cell area_ox=0.0676
XMn_48_16 dn_48_16 WL48 SL16 VSS sky130_fd_pr__nfet_g5v0d10v5 w=1 l=0.5
XRn_48_16 BLN16 dn_48_16 sky130_fd_pr_reram__reram_cell area_ox=0.0676
XMp_48_17 dp_48_17 WL48 SL17 VSS sky130_fd_pr__nfet_g5v0d10v5 w=1 l=0.5
XRp_48_17 BLP17 dp_48_17 sky130_fd_pr_reram__reram_cell area_ox=0.0676
XMn_48_17 dn_48_17 WL48 SL17 VSS sky130_fd_pr__nfet_g5v0d10v5 w=1 l=0.5
XRn_48_17 BLN17 dn_48_17 sky130_fd_pr_reram__reram_cell area_ox=0.0676
XMp_48_18 dp_48_18 WL48 SL18 VSS sky130_fd_pr__nfet_g5v0d10v5 w=1 l=0.5
XRp_48_18 BLP18 dp_48_18 sky130_fd_pr_reram__reram_cell area_ox=0.0676
XMn_48_18 dn_48_18 WL48 SL18 VSS sky130_fd_pr__nfet_g5v0d10v5 w=1 l=0.5
XRn_48_18 BLN18 dn_48_18 sky130_fd_pr_reram__reram_cell area_ox=0.0676
XMp_48_19 dp_48_19 WL48 SL19 VSS sky130_fd_pr__nfet_g5v0d10v5 w=1 l=0.5
XRp_48_19 BLP19 dp_48_19 sky130_fd_pr_reram__reram_cell area_ox=0.0676
XMn_48_19 dn_48_19 WL48 SL19 VSS sky130_fd_pr__nfet_g5v0d10v5 w=1 l=0.5
XRn_48_19 BLN19 dn_48_19 sky130_fd_pr_reram__reram_cell area_ox=0.0676
XMp_48_20 dp_48_20 WL48 SL20 VSS sky130_fd_pr__nfet_g5v0d10v5 w=1 l=0.5
XRp_48_20 BLP20 dp_48_20 sky130_fd_pr_reram__reram_cell area_ox=0.0676
XMn_48_20 dn_48_20 WL48 SL20 VSS sky130_fd_pr__nfet_g5v0d10v5 w=1 l=0.5
XRn_48_20 BLN20 dn_48_20 sky130_fd_pr_reram__reram_cell area_ox=0.0676
XMp_48_21 dp_48_21 WL48 SL21 VSS sky130_fd_pr__nfet_g5v0d10v5 w=1 l=0.5
XRp_48_21 BLP21 dp_48_21 sky130_fd_pr_reram__reram_cell area_ox=0.0676
XMn_48_21 dn_48_21 WL48 SL21 VSS sky130_fd_pr__nfet_g5v0d10v5 w=1 l=0.5
XRn_48_21 BLN21 dn_48_21 sky130_fd_pr_reram__reram_cell area_ox=0.0676
XMp_48_22 dp_48_22 WL48 SL22 VSS sky130_fd_pr__nfet_g5v0d10v5 w=1 l=0.5
XRp_48_22 BLP22 dp_48_22 sky130_fd_pr_reram__reram_cell area_ox=0.0676
XMn_48_22 dn_48_22 WL48 SL22 VSS sky130_fd_pr__nfet_g5v0d10v5 w=1 l=0.5
XRn_48_22 BLN22 dn_48_22 sky130_fd_pr_reram__reram_cell area_ox=0.0676
XMp_48_23 dp_48_23 WL48 SL23 VSS sky130_fd_pr__nfet_g5v0d10v5 w=1 l=0.5
XRp_48_23 BLP23 dp_48_23 sky130_fd_pr_reram__reram_cell area_ox=0.0676
XMn_48_23 dn_48_23 WL48 SL23 VSS sky130_fd_pr__nfet_g5v0d10v5 w=1 l=0.5
XRn_48_23 BLN23 dn_48_23 sky130_fd_pr_reram__reram_cell area_ox=0.0676
XMp_49_0 dp_49_0 WL49 SL0 VSS sky130_fd_pr__nfet_g5v0d10v5 w=1 l=0.5
XRp_49_0 BLP0 dp_49_0 sky130_fd_pr_reram__reram_cell area_ox=0.0676
XMn_49_0 dn_49_0 WL49 SL0 VSS sky130_fd_pr__nfet_g5v0d10v5 w=1 l=0.5
XRn_49_0 BLN0 dn_49_0 sky130_fd_pr_reram__reram_cell area_ox=0.0676
XMp_49_1 dp_49_1 WL49 SL1 VSS sky130_fd_pr__nfet_g5v0d10v5 w=1 l=0.5
XRp_49_1 BLP1 dp_49_1 sky130_fd_pr_reram__reram_cell area_ox=0.0676
XMn_49_1 dn_49_1 WL49 SL1 VSS sky130_fd_pr__nfet_g5v0d10v5 w=1 l=0.5
XRn_49_1 BLN1 dn_49_1 sky130_fd_pr_reram__reram_cell area_ox=0.0676
XMp_49_2 dp_49_2 WL49 SL2 VSS sky130_fd_pr__nfet_g5v0d10v5 w=1 l=0.5
XRp_49_2 BLP2 dp_49_2 sky130_fd_pr_reram__reram_cell area_ox=0.0676
XMn_49_2 dn_49_2 WL49 SL2 VSS sky130_fd_pr__nfet_g5v0d10v5 w=1 l=0.5
XRn_49_2 BLN2 dn_49_2 sky130_fd_pr_reram__reram_cell area_ox=0.0676
XMp_49_3 dp_49_3 WL49 SL3 VSS sky130_fd_pr__nfet_g5v0d10v5 w=1 l=0.5
XRp_49_3 BLP3 dp_49_3 sky130_fd_pr_reram__reram_cell area_ox=0.0676
XMn_49_3 dn_49_3 WL49 SL3 VSS sky130_fd_pr__nfet_g5v0d10v5 w=1 l=0.5
XRn_49_3 BLN3 dn_49_3 sky130_fd_pr_reram__reram_cell area_ox=0.0676
XMp_49_4 dp_49_4 WL49 SL4 VSS sky130_fd_pr__nfet_g5v0d10v5 w=1 l=0.5
XRp_49_4 BLP4 dp_49_4 sky130_fd_pr_reram__reram_cell area_ox=0.0676
XMn_49_4 dn_49_4 WL49 SL4 VSS sky130_fd_pr__nfet_g5v0d10v5 w=1 l=0.5
XRn_49_4 BLN4 dn_49_4 sky130_fd_pr_reram__reram_cell area_ox=0.0676
XMp_49_5 dp_49_5 WL49 SL5 VSS sky130_fd_pr__nfet_g5v0d10v5 w=1 l=0.5
XRp_49_5 BLP5 dp_49_5 sky130_fd_pr_reram__reram_cell area_ox=0.0676
XMn_49_5 dn_49_5 WL49 SL5 VSS sky130_fd_pr__nfet_g5v0d10v5 w=1 l=0.5
XRn_49_5 BLN5 dn_49_5 sky130_fd_pr_reram__reram_cell area_ox=0.0676
XMp_49_6 dp_49_6 WL49 SL6 VSS sky130_fd_pr__nfet_g5v0d10v5 w=1 l=0.5
XRp_49_6 BLP6 dp_49_6 sky130_fd_pr_reram__reram_cell area_ox=0.0676
XMn_49_6 dn_49_6 WL49 SL6 VSS sky130_fd_pr__nfet_g5v0d10v5 w=1 l=0.5
XRn_49_6 BLN6 dn_49_6 sky130_fd_pr_reram__reram_cell area_ox=0.0676
XMp_49_7 dp_49_7 WL49 SL7 VSS sky130_fd_pr__nfet_g5v0d10v5 w=1 l=0.5
XRp_49_7 BLP7 dp_49_7 sky130_fd_pr_reram__reram_cell area_ox=0.0676
XMn_49_7 dn_49_7 WL49 SL7 VSS sky130_fd_pr__nfet_g5v0d10v5 w=1 l=0.5
XRn_49_7 BLN7 dn_49_7 sky130_fd_pr_reram__reram_cell area_ox=0.0676
XMp_49_8 dp_49_8 WL49 SL8 VSS sky130_fd_pr__nfet_g5v0d10v5 w=1 l=0.5
XRp_49_8 BLP8 dp_49_8 sky130_fd_pr_reram__reram_cell area_ox=0.0676
XMn_49_8 dn_49_8 WL49 SL8 VSS sky130_fd_pr__nfet_g5v0d10v5 w=1 l=0.5
XRn_49_8 BLN8 dn_49_8 sky130_fd_pr_reram__reram_cell area_ox=0.0676
XMp_49_9 dp_49_9 WL49 SL9 VSS sky130_fd_pr__nfet_g5v0d10v5 w=1 l=0.5
XRp_49_9 BLP9 dp_49_9 sky130_fd_pr_reram__reram_cell area_ox=0.0676
XMn_49_9 dn_49_9 WL49 SL9 VSS sky130_fd_pr__nfet_g5v0d10v5 w=1 l=0.5
XRn_49_9 BLN9 dn_49_9 sky130_fd_pr_reram__reram_cell area_ox=0.0676
XMp_49_10 dp_49_10 WL49 SL10 VSS sky130_fd_pr__nfet_g5v0d10v5 w=1 l=0.5
XRp_49_10 BLP10 dp_49_10 sky130_fd_pr_reram__reram_cell area_ox=0.0676
XMn_49_10 dn_49_10 WL49 SL10 VSS sky130_fd_pr__nfet_g5v0d10v5 w=1 l=0.5
XRn_49_10 BLN10 dn_49_10 sky130_fd_pr_reram__reram_cell area_ox=0.0676
XMp_49_11 dp_49_11 WL49 SL11 VSS sky130_fd_pr__nfet_g5v0d10v5 w=1 l=0.5
XRp_49_11 BLP11 dp_49_11 sky130_fd_pr_reram__reram_cell area_ox=0.0676
XMn_49_11 dn_49_11 WL49 SL11 VSS sky130_fd_pr__nfet_g5v0d10v5 w=1 l=0.5
XRn_49_11 BLN11 dn_49_11 sky130_fd_pr_reram__reram_cell area_ox=0.0676
XMp_49_12 dp_49_12 WL49 SL12 VSS sky130_fd_pr__nfet_g5v0d10v5 w=1 l=0.5
XRp_49_12 BLP12 dp_49_12 sky130_fd_pr_reram__reram_cell area_ox=0.0676
XMn_49_12 dn_49_12 WL49 SL12 VSS sky130_fd_pr__nfet_g5v0d10v5 w=1 l=0.5
XRn_49_12 BLN12 dn_49_12 sky130_fd_pr_reram__reram_cell area_ox=0.0676
XMp_49_13 dp_49_13 WL49 SL13 VSS sky130_fd_pr__nfet_g5v0d10v5 w=1 l=0.5
XRp_49_13 BLP13 dp_49_13 sky130_fd_pr_reram__reram_cell area_ox=0.0676
XMn_49_13 dn_49_13 WL49 SL13 VSS sky130_fd_pr__nfet_g5v0d10v5 w=1 l=0.5
XRn_49_13 BLN13 dn_49_13 sky130_fd_pr_reram__reram_cell area_ox=0.0676
XMp_49_14 dp_49_14 WL49 SL14 VSS sky130_fd_pr__nfet_g5v0d10v5 w=1 l=0.5
XRp_49_14 BLP14 dp_49_14 sky130_fd_pr_reram__reram_cell area_ox=0.0676
XMn_49_14 dn_49_14 WL49 SL14 VSS sky130_fd_pr__nfet_g5v0d10v5 w=1 l=0.5
XRn_49_14 BLN14 dn_49_14 sky130_fd_pr_reram__reram_cell area_ox=0.0676
XMp_49_15 dp_49_15 WL49 SL15 VSS sky130_fd_pr__nfet_g5v0d10v5 w=1 l=0.5
XRp_49_15 BLP15 dp_49_15 sky130_fd_pr_reram__reram_cell area_ox=0.0676
XMn_49_15 dn_49_15 WL49 SL15 VSS sky130_fd_pr__nfet_g5v0d10v5 w=1 l=0.5
XRn_49_15 BLN15 dn_49_15 sky130_fd_pr_reram__reram_cell area_ox=0.0676
XMp_49_16 dp_49_16 WL49 SL16 VSS sky130_fd_pr__nfet_g5v0d10v5 w=1 l=0.5
XRp_49_16 BLP16 dp_49_16 sky130_fd_pr_reram__reram_cell area_ox=0.0676
XMn_49_16 dn_49_16 WL49 SL16 VSS sky130_fd_pr__nfet_g5v0d10v5 w=1 l=0.5
XRn_49_16 BLN16 dn_49_16 sky130_fd_pr_reram__reram_cell area_ox=0.0676
XMp_49_17 dp_49_17 WL49 SL17 VSS sky130_fd_pr__nfet_g5v0d10v5 w=1 l=0.5
XRp_49_17 BLP17 dp_49_17 sky130_fd_pr_reram__reram_cell area_ox=0.0676
XMn_49_17 dn_49_17 WL49 SL17 VSS sky130_fd_pr__nfet_g5v0d10v5 w=1 l=0.5
XRn_49_17 BLN17 dn_49_17 sky130_fd_pr_reram__reram_cell area_ox=0.0676
XMp_49_18 dp_49_18 WL49 SL18 VSS sky130_fd_pr__nfet_g5v0d10v5 w=1 l=0.5
XRp_49_18 BLP18 dp_49_18 sky130_fd_pr_reram__reram_cell area_ox=0.0676
XMn_49_18 dn_49_18 WL49 SL18 VSS sky130_fd_pr__nfet_g5v0d10v5 w=1 l=0.5
XRn_49_18 BLN18 dn_49_18 sky130_fd_pr_reram__reram_cell area_ox=0.0676
XMp_49_19 dp_49_19 WL49 SL19 VSS sky130_fd_pr__nfet_g5v0d10v5 w=1 l=0.5
XRp_49_19 BLP19 dp_49_19 sky130_fd_pr_reram__reram_cell area_ox=0.0676
XMn_49_19 dn_49_19 WL49 SL19 VSS sky130_fd_pr__nfet_g5v0d10v5 w=1 l=0.5
XRn_49_19 BLN19 dn_49_19 sky130_fd_pr_reram__reram_cell area_ox=0.0676
XMp_49_20 dp_49_20 WL49 SL20 VSS sky130_fd_pr__nfet_g5v0d10v5 w=1 l=0.5
XRp_49_20 BLP20 dp_49_20 sky130_fd_pr_reram__reram_cell area_ox=0.0676
XMn_49_20 dn_49_20 WL49 SL20 VSS sky130_fd_pr__nfet_g5v0d10v5 w=1 l=0.5
XRn_49_20 BLN20 dn_49_20 sky130_fd_pr_reram__reram_cell area_ox=0.0676
XMp_49_21 dp_49_21 WL49 SL21 VSS sky130_fd_pr__nfet_g5v0d10v5 w=1 l=0.5
XRp_49_21 BLP21 dp_49_21 sky130_fd_pr_reram__reram_cell area_ox=0.0676
XMn_49_21 dn_49_21 WL49 SL21 VSS sky130_fd_pr__nfet_g5v0d10v5 w=1 l=0.5
XRn_49_21 BLN21 dn_49_21 sky130_fd_pr_reram__reram_cell area_ox=0.0676
XMp_49_22 dp_49_22 WL49 SL22 VSS sky130_fd_pr__nfet_g5v0d10v5 w=1 l=0.5
XRp_49_22 BLP22 dp_49_22 sky130_fd_pr_reram__reram_cell area_ox=0.0676
XMn_49_22 dn_49_22 WL49 SL22 VSS sky130_fd_pr__nfet_g5v0d10v5 w=1 l=0.5
XRn_49_22 BLN22 dn_49_22 sky130_fd_pr_reram__reram_cell area_ox=0.0676
XMp_49_23 dp_49_23 WL49 SL23 VSS sky130_fd_pr__nfet_g5v0d10v5 w=1 l=0.5
XRp_49_23 BLP23 dp_49_23 sky130_fd_pr_reram__reram_cell area_ox=0.0676
XMn_49_23 dn_49_23 WL49 SL23 VSS sky130_fd_pr__nfet_g5v0d10v5 w=1 l=0.5
XRn_49_23 BLN23 dn_49_23 sky130_fd_pr_reram__reram_cell area_ox=0.0676
XMp_50_0 dp_50_0 WL50 SL0 VSS sky130_fd_pr__nfet_g5v0d10v5 w=1 l=0.5
XRp_50_0 BLP0 dp_50_0 sky130_fd_pr_reram__reram_cell area_ox=0.0676
XMn_50_0 dn_50_0 WL50 SL0 VSS sky130_fd_pr__nfet_g5v0d10v5 w=1 l=0.5
XRn_50_0 BLN0 dn_50_0 sky130_fd_pr_reram__reram_cell area_ox=0.0676
XMp_50_1 dp_50_1 WL50 SL1 VSS sky130_fd_pr__nfet_g5v0d10v5 w=1 l=0.5
XRp_50_1 BLP1 dp_50_1 sky130_fd_pr_reram__reram_cell area_ox=0.0676
XMn_50_1 dn_50_1 WL50 SL1 VSS sky130_fd_pr__nfet_g5v0d10v5 w=1 l=0.5
XRn_50_1 BLN1 dn_50_1 sky130_fd_pr_reram__reram_cell area_ox=0.0676
XMp_50_2 dp_50_2 WL50 SL2 VSS sky130_fd_pr__nfet_g5v0d10v5 w=1 l=0.5
XRp_50_2 BLP2 dp_50_2 sky130_fd_pr_reram__reram_cell area_ox=0.0676
XMn_50_2 dn_50_2 WL50 SL2 VSS sky130_fd_pr__nfet_g5v0d10v5 w=1 l=0.5
XRn_50_2 BLN2 dn_50_2 sky130_fd_pr_reram__reram_cell area_ox=0.0676
XMp_50_3 dp_50_3 WL50 SL3 VSS sky130_fd_pr__nfet_g5v0d10v5 w=1 l=0.5
XRp_50_3 BLP3 dp_50_3 sky130_fd_pr_reram__reram_cell area_ox=0.0676
XMn_50_3 dn_50_3 WL50 SL3 VSS sky130_fd_pr__nfet_g5v0d10v5 w=1 l=0.5
XRn_50_3 BLN3 dn_50_3 sky130_fd_pr_reram__reram_cell area_ox=0.0676
XMp_50_4 dp_50_4 WL50 SL4 VSS sky130_fd_pr__nfet_g5v0d10v5 w=1 l=0.5
XRp_50_4 BLP4 dp_50_4 sky130_fd_pr_reram__reram_cell area_ox=0.0676
XMn_50_4 dn_50_4 WL50 SL4 VSS sky130_fd_pr__nfet_g5v0d10v5 w=1 l=0.5
XRn_50_4 BLN4 dn_50_4 sky130_fd_pr_reram__reram_cell area_ox=0.0676
XMp_50_5 dp_50_5 WL50 SL5 VSS sky130_fd_pr__nfet_g5v0d10v5 w=1 l=0.5
XRp_50_5 BLP5 dp_50_5 sky130_fd_pr_reram__reram_cell area_ox=0.0676
XMn_50_5 dn_50_5 WL50 SL5 VSS sky130_fd_pr__nfet_g5v0d10v5 w=1 l=0.5
XRn_50_5 BLN5 dn_50_5 sky130_fd_pr_reram__reram_cell area_ox=0.0676
XMp_50_6 dp_50_6 WL50 SL6 VSS sky130_fd_pr__nfet_g5v0d10v5 w=1 l=0.5
XRp_50_6 BLP6 dp_50_6 sky130_fd_pr_reram__reram_cell area_ox=0.0676
XMn_50_6 dn_50_6 WL50 SL6 VSS sky130_fd_pr__nfet_g5v0d10v5 w=1 l=0.5
XRn_50_6 BLN6 dn_50_6 sky130_fd_pr_reram__reram_cell area_ox=0.0676
XMp_50_7 dp_50_7 WL50 SL7 VSS sky130_fd_pr__nfet_g5v0d10v5 w=1 l=0.5
XRp_50_7 BLP7 dp_50_7 sky130_fd_pr_reram__reram_cell area_ox=0.0676
XMn_50_7 dn_50_7 WL50 SL7 VSS sky130_fd_pr__nfet_g5v0d10v5 w=1 l=0.5
XRn_50_7 BLN7 dn_50_7 sky130_fd_pr_reram__reram_cell area_ox=0.0676
XMp_50_8 dp_50_8 WL50 SL8 VSS sky130_fd_pr__nfet_g5v0d10v5 w=1 l=0.5
XRp_50_8 BLP8 dp_50_8 sky130_fd_pr_reram__reram_cell area_ox=0.0676
XMn_50_8 dn_50_8 WL50 SL8 VSS sky130_fd_pr__nfet_g5v0d10v5 w=1 l=0.5
XRn_50_8 BLN8 dn_50_8 sky130_fd_pr_reram__reram_cell area_ox=0.0676
XMp_50_9 dp_50_9 WL50 SL9 VSS sky130_fd_pr__nfet_g5v0d10v5 w=1 l=0.5
XRp_50_9 BLP9 dp_50_9 sky130_fd_pr_reram__reram_cell area_ox=0.0676
XMn_50_9 dn_50_9 WL50 SL9 VSS sky130_fd_pr__nfet_g5v0d10v5 w=1 l=0.5
XRn_50_9 BLN9 dn_50_9 sky130_fd_pr_reram__reram_cell area_ox=0.0676
XMp_50_10 dp_50_10 WL50 SL10 VSS sky130_fd_pr__nfet_g5v0d10v5 w=1 l=0.5
XRp_50_10 BLP10 dp_50_10 sky130_fd_pr_reram__reram_cell area_ox=0.0676
XMn_50_10 dn_50_10 WL50 SL10 VSS sky130_fd_pr__nfet_g5v0d10v5 w=1 l=0.5
XRn_50_10 BLN10 dn_50_10 sky130_fd_pr_reram__reram_cell area_ox=0.0676
XMp_50_11 dp_50_11 WL50 SL11 VSS sky130_fd_pr__nfet_g5v0d10v5 w=1 l=0.5
XRp_50_11 BLP11 dp_50_11 sky130_fd_pr_reram__reram_cell area_ox=0.0676
XMn_50_11 dn_50_11 WL50 SL11 VSS sky130_fd_pr__nfet_g5v0d10v5 w=1 l=0.5
XRn_50_11 BLN11 dn_50_11 sky130_fd_pr_reram__reram_cell area_ox=0.0676
XMp_50_12 dp_50_12 WL50 SL12 VSS sky130_fd_pr__nfet_g5v0d10v5 w=1 l=0.5
XRp_50_12 BLP12 dp_50_12 sky130_fd_pr_reram__reram_cell area_ox=0.0676
XMn_50_12 dn_50_12 WL50 SL12 VSS sky130_fd_pr__nfet_g5v0d10v5 w=1 l=0.5
XRn_50_12 BLN12 dn_50_12 sky130_fd_pr_reram__reram_cell area_ox=0.0676
XMp_50_13 dp_50_13 WL50 SL13 VSS sky130_fd_pr__nfet_g5v0d10v5 w=1 l=0.5
XRp_50_13 BLP13 dp_50_13 sky130_fd_pr_reram__reram_cell area_ox=0.0676
XMn_50_13 dn_50_13 WL50 SL13 VSS sky130_fd_pr__nfet_g5v0d10v5 w=1 l=0.5
XRn_50_13 BLN13 dn_50_13 sky130_fd_pr_reram__reram_cell area_ox=0.0676
XMp_50_14 dp_50_14 WL50 SL14 VSS sky130_fd_pr__nfet_g5v0d10v5 w=1 l=0.5
XRp_50_14 BLP14 dp_50_14 sky130_fd_pr_reram__reram_cell area_ox=0.0676
XMn_50_14 dn_50_14 WL50 SL14 VSS sky130_fd_pr__nfet_g5v0d10v5 w=1 l=0.5
XRn_50_14 BLN14 dn_50_14 sky130_fd_pr_reram__reram_cell area_ox=0.0676
XMp_50_15 dp_50_15 WL50 SL15 VSS sky130_fd_pr__nfet_g5v0d10v5 w=1 l=0.5
XRp_50_15 BLP15 dp_50_15 sky130_fd_pr_reram__reram_cell area_ox=0.0676
XMn_50_15 dn_50_15 WL50 SL15 VSS sky130_fd_pr__nfet_g5v0d10v5 w=1 l=0.5
XRn_50_15 BLN15 dn_50_15 sky130_fd_pr_reram__reram_cell area_ox=0.0676
XMp_50_16 dp_50_16 WL50 SL16 VSS sky130_fd_pr__nfet_g5v0d10v5 w=1 l=0.5
XRp_50_16 BLP16 dp_50_16 sky130_fd_pr_reram__reram_cell area_ox=0.0676
XMn_50_16 dn_50_16 WL50 SL16 VSS sky130_fd_pr__nfet_g5v0d10v5 w=1 l=0.5
XRn_50_16 BLN16 dn_50_16 sky130_fd_pr_reram__reram_cell area_ox=0.0676
XMp_50_17 dp_50_17 WL50 SL17 VSS sky130_fd_pr__nfet_g5v0d10v5 w=1 l=0.5
XRp_50_17 BLP17 dp_50_17 sky130_fd_pr_reram__reram_cell area_ox=0.0676
XMn_50_17 dn_50_17 WL50 SL17 VSS sky130_fd_pr__nfet_g5v0d10v5 w=1 l=0.5
XRn_50_17 BLN17 dn_50_17 sky130_fd_pr_reram__reram_cell area_ox=0.0676
XMp_50_18 dp_50_18 WL50 SL18 VSS sky130_fd_pr__nfet_g5v0d10v5 w=1 l=0.5
XRp_50_18 BLP18 dp_50_18 sky130_fd_pr_reram__reram_cell area_ox=0.0676
XMn_50_18 dn_50_18 WL50 SL18 VSS sky130_fd_pr__nfet_g5v0d10v5 w=1 l=0.5
XRn_50_18 BLN18 dn_50_18 sky130_fd_pr_reram__reram_cell area_ox=0.0676
XMp_50_19 dp_50_19 WL50 SL19 VSS sky130_fd_pr__nfet_g5v0d10v5 w=1 l=0.5
XRp_50_19 BLP19 dp_50_19 sky130_fd_pr_reram__reram_cell area_ox=0.0676
XMn_50_19 dn_50_19 WL50 SL19 VSS sky130_fd_pr__nfet_g5v0d10v5 w=1 l=0.5
XRn_50_19 BLN19 dn_50_19 sky130_fd_pr_reram__reram_cell area_ox=0.0676
XMp_50_20 dp_50_20 WL50 SL20 VSS sky130_fd_pr__nfet_g5v0d10v5 w=1 l=0.5
XRp_50_20 BLP20 dp_50_20 sky130_fd_pr_reram__reram_cell area_ox=0.0676
XMn_50_20 dn_50_20 WL50 SL20 VSS sky130_fd_pr__nfet_g5v0d10v5 w=1 l=0.5
XRn_50_20 BLN20 dn_50_20 sky130_fd_pr_reram__reram_cell area_ox=0.0676
XMp_50_21 dp_50_21 WL50 SL21 VSS sky130_fd_pr__nfet_g5v0d10v5 w=1 l=0.5
XRp_50_21 BLP21 dp_50_21 sky130_fd_pr_reram__reram_cell area_ox=0.0676
XMn_50_21 dn_50_21 WL50 SL21 VSS sky130_fd_pr__nfet_g5v0d10v5 w=1 l=0.5
XRn_50_21 BLN21 dn_50_21 sky130_fd_pr_reram__reram_cell area_ox=0.0676
XMp_50_22 dp_50_22 WL50 SL22 VSS sky130_fd_pr__nfet_g5v0d10v5 w=1 l=0.5
XRp_50_22 BLP22 dp_50_22 sky130_fd_pr_reram__reram_cell area_ox=0.0676
XMn_50_22 dn_50_22 WL50 SL22 VSS sky130_fd_pr__nfet_g5v0d10v5 w=1 l=0.5
XRn_50_22 BLN22 dn_50_22 sky130_fd_pr_reram__reram_cell area_ox=0.0676
XMp_50_23 dp_50_23 WL50 SL23 VSS sky130_fd_pr__nfet_g5v0d10v5 w=1 l=0.5
XRp_50_23 BLP23 dp_50_23 sky130_fd_pr_reram__reram_cell area_ox=0.0676
XMn_50_23 dn_50_23 WL50 SL23 VSS sky130_fd_pr__nfet_g5v0d10v5 w=1 l=0.5
XRn_50_23 BLN23 dn_50_23 sky130_fd_pr_reram__reram_cell area_ox=0.0676
XMp_51_0 dp_51_0 WL51 SL0 VSS sky130_fd_pr__nfet_g5v0d10v5 w=1 l=0.5
XRp_51_0 BLP0 dp_51_0 sky130_fd_pr_reram__reram_cell area_ox=0.0676
XMn_51_0 dn_51_0 WL51 SL0 VSS sky130_fd_pr__nfet_g5v0d10v5 w=1 l=0.5
XRn_51_0 BLN0 dn_51_0 sky130_fd_pr_reram__reram_cell area_ox=0.0676
XMp_51_1 dp_51_1 WL51 SL1 VSS sky130_fd_pr__nfet_g5v0d10v5 w=1 l=0.5
XRp_51_1 BLP1 dp_51_1 sky130_fd_pr_reram__reram_cell area_ox=0.0676
XMn_51_1 dn_51_1 WL51 SL1 VSS sky130_fd_pr__nfet_g5v0d10v5 w=1 l=0.5
XRn_51_1 BLN1 dn_51_1 sky130_fd_pr_reram__reram_cell area_ox=0.0676
XMp_51_2 dp_51_2 WL51 SL2 VSS sky130_fd_pr__nfet_g5v0d10v5 w=1 l=0.5
XRp_51_2 BLP2 dp_51_2 sky130_fd_pr_reram__reram_cell area_ox=0.0676
XMn_51_2 dn_51_2 WL51 SL2 VSS sky130_fd_pr__nfet_g5v0d10v5 w=1 l=0.5
XRn_51_2 BLN2 dn_51_2 sky130_fd_pr_reram__reram_cell area_ox=0.0676
XMp_51_3 dp_51_3 WL51 SL3 VSS sky130_fd_pr__nfet_g5v0d10v5 w=1 l=0.5
XRp_51_3 BLP3 dp_51_3 sky130_fd_pr_reram__reram_cell area_ox=0.0676
XMn_51_3 dn_51_3 WL51 SL3 VSS sky130_fd_pr__nfet_g5v0d10v5 w=1 l=0.5
XRn_51_3 BLN3 dn_51_3 sky130_fd_pr_reram__reram_cell area_ox=0.0676
XMp_51_4 dp_51_4 WL51 SL4 VSS sky130_fd_pr__nfet_g5v0d10v5 w=1 l=0.5
XRp_51_4 BLP4 dp_51_4 sky130_fd_pr_reram__reram_cell area_ox=0.0676
XMn_51_4 dn_51_4 WL51 SL4 VSS sky130_fd_pr__nfet_g5v0d10v5 w=1 l=0.5
XRn_51_4 BLN4 dn_51_4 sky130_fd_pr_reram__reram_cell area_ox=0.0676
XMp_51_5 dp_51_5 WL51 SL5 VSS sky130_fd_pr__nfet_g5v0d10v5 w=1 l=0.5
XRp_51_5 BLP5 dp_51_5 sky130_fd_pr_reram__reram_cell area_ox=0.0676
XMn_51_5 dn_51_5 WL51 SL5 VSS sky130_fd_pr__nfet_g5v0d10v5 w=1 l=0.5
XRn_51_5 BLN5 dn_51_5 sky130_fd_pr_reram__reram_cell area_ox=0.0676
XMp_51_6 dp_51_6 WL51 SL6 VSS sky130_fd_pr__nfet_g5v0d10v5 w=1 l=0.5
XRp_51_6 BLP6 dp_51_6 sky130_fd_pr_reram__reram_cell area_ox=0.0676
XMn_51_6 dn_51_6 WL51 SL6 VSS sky130_fd_pr__nfet_g5v0d10v5 w=1 l=0.5
XRn_51_6 BLN6 dn_51_6 sky130_fd_pr_reram__reram_cell area_ox=0.0676
XMp_51_7 dp_51_7 WL51 SL7 VSS sky130_fd_pr__nfet_g5v0d10v5 w=1 l=0.5
XRp_51_7 BLP7 dp_51_7 sky130_fd_pr_reram__reram_cell area_ox=0.0676
XMn_51_7 dn_51_7 WL51 SL7 VSS sky130_fd_pr__nfet_g5v0d10v5 w=1 l=0.5
XRn_51_7 BLN7 dn_51_7 sky130_fd_pr_reram__reram_cell area_ox=0.0676
XMp_51_8 dp_51_8 WL51 SL8 VSS sky130_fd_pr__nfet_g5v0d10v5 w=1 l=0.5
XRp_51_8 BLP8 dp_51_8 sky130_fd_pr_reram__reram_cell area_ox=0.0676
XMn_51_8 dn_51_8 WL51 SL8 VSS sky130_fd_pr__nfet_g5v0d10v5 w=1 l=0.5
XRn_51_8 BLN8 dn_51_8 sky130_fd_pr_reram__reram_cell area_ox=0.0676
XMp_51_9 dp_51_9 WL51 SL9 VSS sky130_fd_pr__nfet_g5v0d10v5 w=1 l=0.5
XRp_51_9 BLP9 dp_51_9 sky130_fd_pr_reram__reram_cell area_ox=0.0676
XMn_51_9 dn_51_9 WL51 SL9 VSS sky130_fd_pr__nfet_g5v0d10v5 w=1 l=0.5
XRn_51_9 BLN9 dn_51_9 sky130_fd_pr_reram__reram_cell area_ox=0.0676
XMp_51_10 dp_51_10 WL51 SL10 VSS sky130_fd_pr__nfet_g5v0d10v5 w=1 l=0.5
XRp_51_10 BLP10 dp_51_10 sky130_fd_pr_reram__reram_cell area_ox=0.0676
XMn_51_10 dn_51_10 WL51 SL10 VSS sky130_fd_pr__nfet_g5v0d10v5 w=1 l=0.5
XRn_51_10 BLN10 dn_51_10 sky130_fd_pr_reram__reram_cell area_ox=0.0676
XMp_51_11 dp_51_11 WL51 SL11 VSS sky130_fd_pr__nfet_g5v0d10v5 w=1 l=0.5
XRp_51_11 BLP11 dp_51_11 sky130_fd_pr_reram__reram_cell area_ox=0.0676
XMn_51_11 dn_51_11 WL51 SL11 VSS sky130_fd_pr__nfet_g5v0d10v5 w=1 l=0.5
XRn_51_11 BLN11 dn_51_11 sky130_fd_pr_reram__reram_cell area_ox=0.0676
XMp_51_12 dp_51_12 WL51 SL12 VSS sky130_fd_pr__nfet_g5v0d10v5 w=1 l=0.5
XRp_51_12 BLP12 dp_51_12 sky130_fd_pr_reram__reram_cell area_ox=0.0676
XMn_51_12 dn_51_12 WL51 SL12 VSS sky130_fd_pr__nfet_g5v0d10v5 w=1 l=0.5
XRn_51_12 BLN12 dn_51_12 sky130_fd_pr_reram__reram_cell area_ox=0.0676
XMp_51_13 dp_51_13 WL51 SL13 VSS sky130_fd_pr__nfet_g5v0d10v5 w=1 l=0.5
XRp_51_13 BLP13 dp_51_13 sky130_fd_pr_reram__reram_cell area_ox=0.0676
XMn_51_13 dn_51_13 WL51 SL13 VSS sky130_fd_pr__nfet_g5v0d10v5 w=1 l=0.5
XRn_51_13 BLN13 dn_51_13 sky130_fd_pr_reram__reram_cell area_ox=0.0676
XMp_51_14 dp_51_14 WL51 SL14 VSS sky130_fd_pr__nfet_g5v0d10v5 w=1 l=0.5
XRp_51_14 BLP14 dp_51_14 sky130_fd_pr_reram__reram_cell area_ox=0.0676
XMn_51_14 dn_51_14 WL51 SL14 VSS sky130_fd_pr__nfet_g5v0d10v5 w=1 l=0.5
XRn_51_14 BLN14 dn_51_14 sky130_fd_pr_reram__reram_cell area_ox=0.0676
XMp_51_15 dp_51_15 WL51 SL15 VSS sky130_fd_pr__nfet_g5v0d10v5 w=1 l=0.5
XRp_51_15 BLP15 dp_51_15 sky130_fd_pr_reram__reram_cell area_ox=0.0676
XMn_51_15 dn_51_15 WL51 SL15 VSS sky130_fd_pr__nfet_g5v0d10v5 w=1 l=0.5
XRn_51_15 BLN15 dn_51_15 sky130_fd_pr_reram__reram_cell area_ox=0.0676
XMp_51_16 dp_51_16 WL51 SL16 VSS sky130_fd_pr__nfet_g5v0d10v5 w=1 l=0.5
XRp_51_16 BLP16 dp_51_16 sky130_fd_pr_reram__reram_cell area_ox=0.0676
XMn_51_16 dn_51_16 WL51 SL16 VSS sky130_fd_pr__nfet_g5v0d10v5 w=1 l=0.5
XRn_51_16 BLN16 dn_51_16 sky130_fd_pr_reram__reram_cell area_ox=0.0676
XMp_51_17 dp_51_17 WL51 SL17 VSS sky130_fd_pr__nfet_g5v0d10v5 w=1 l=0.5
XRp_51_17 BLP17 dp_51_17 sky130_fd_pr_reram__reram_cell area_ox=0.0676
XMn_51_17 dn_51_17 WL51 SL17 VSS sky130_fd_pr__nfet_g5v0d10v5 w=1 l=0.5
XRn_51_17 BLN17 dn_51_17 sky130_fd_pr_reram__reram_cell area_ox=0.0676
XMp_51_18 dp_51_18 WL51 SL18 VSS sky130_fd_pr__nfet_g5v0d10v5 w=1 l=0.5
XRp_51_18 BLP18 dp_51_18 sky130_fd_pr_reram__reram_cell area_ox=0.0676
XMn_51_18 dn_51_18 WL51 SL18 VSS sky130_fd_pr__nfet_g5v0d10v5 w=1 l=0.5
XRn_51_18 BLN18 dn_51_18 sky130_fd_pr_reram__reram_cell area_ox=0.0676
XMp_51_19 dp_51_19 WL51 SL19 VSS sky130_fd_pr__nfet_g5v0d10v5 w=1 l=0.5
XRp_51_19 BLP19 dp_51_19 sky130_fd_pr_reram__reram_cell area_ox=0.0676
XMn_51_19 dn_51_19 WL51 SL19 VSS sky130_fd_pr__nfet_g5v0d10v5 w=1 l=0.5
XRn_51_19 BLN19 dn_51_19 sky130_fd_pr_reram__reram_cell area_ox=0.0676
XMp_51_20 dp_51_20 WL51 SL20 VSS sky130_fd_pr__nfet_g5v0d10v5 w=1 l=0.5
XRp_51_20 BLP20 dp_51_20 sky130_fd_pr_reram__reram_cell area_ox=0.0676
XMn_51_20 dn_51_20 WL51 SL20 VSS sky130_fd_pr__nfet_g5v0d10v5 w=1 l=0.5
XRn_51_20 BLN20 dn_51_20 sky130_fd_pr_reram__reram_cell area_ox=0.0676
XMp_51_21 dp_51_21 WL51 SL21 VSS sky130_fd_pr__nfet_g5v0d10v5 w=1 l=0.5
XRp_51_21 BLP21 dp_51_21 sky130_fd_pr_reram__reram_cell area_ox=0.0676
XMn_51_21 dn_51_21 WL51 SL21 VSS sky130_fd_pr__nfet_g5v0d10v5 w=1 l=0.5
XRn_51_21 BLN21 dn_51_21 sky130_fd_pr_reram__reram_cell area_ox=0.0676
XMp_51_22 dp_51_22 WL51 SL22 VSS sky130_fd_pr__nfet_g5v0d10v5 w=1 l=0.5
XRp_51_22 BLP22 dp_51_22 sky130_fd_pr_reram__reram_cell area_ox=0.0676
XMn_51_22 dn_51_22 WL51 SL22 VSS sky130_fd_pr__nfet_g5v0d10v5 w=1 l=0.5
XRn_51_22 BLN22 dn_51_22 sky130_fd_pr_reram__reram_cell area_ox=0.0676
XMp_51_23 dp_51_23 WL51 SL23 VSS sky130_fd_pr__nfet_g5v0d10v5 w=1 l=0.5
XRp_51_23 BLP23 dp_51_23 sky130_fd_pr_reram__reram_cell area_ox=0.0676
XMn_51_23 dn_51_23 WL51 SL23 VSS sky130_fd_pr__nfet_g5v0d10v5 w=1 l=0.5
XRn_51_23 BLN23 dn_51_23 sky130_fd_pr_reram__reram_cell area_ox=0.0676
XMp_52_0 dp_52_0 WL52 SL0 VSS sky130_fd_pr__nfet_g5v0d10v5 w=1 l=0.5
XRp_52_0 BLP0 dp_52_0 sky130_fd_pr_reram__reram_cell area_ox=0.0676
XMn_52_0 dn_52_0 WL52 SL0 VSS sky130_fd_pr__nfet_g5v0d10v5 w=1 l=0.5
XRn_52_0 BLN0 dn_52_0 sky130_fd_pr_reram__reram_cell area_ox=0.0676
XMp_52_1 dp_52_1 WL52 SL1 VSS sky130_fd_pr__nfet_g5v0d10v5 w=1 l=0.5
XRp_52_1 BLP1 dp_52_1 sky130_fd_pr_reram__reram_cell area_ox=0.0676
XMn_52_1 dn_52_1 WL52 SL1 VSS sky130_fd_pr__nfet_g5v0d10v5 w=1 l=0.5
XRn_52_1 BLN1 dn_52_1 sky130_fd_pr_reram__reram_cell area_ox=0.0676
XMp_52_2 dp_52_2 WL52 SL2 VSS sky130_fd_pr__nfet_g5v0d10v5 w=1 l=0.5
XRp_52_2 BLP2 dp_52_2 sky130_fd_pr_reram__reram_cell area_ox=0.0676
XMn_52_2 dn_52_2 WL52 SL2 VSS sky130_fd_pr__nfet_g5v0d10v5 w=1 l=0.5
XRn_52_2 BLN2 dn_52_2 sky130_fd_pr_reram__reram_cell area_ox=0.0676
XMp_52_3 dp_52_3 WL52 SL3 VSS sky130_fd_pr__nfet_g5v0d10v5 w=1 l=0.5
XRp_52_3 BLP3 dp_52_3 sky130_fd_pr_reram__reram_cell area_ox=0.0676
XMn_52_3 dn_52_3 WL52 SL3 VSS sky130_fd_pr__nfet_g5v0d10v5 w=1 l=0.5
XRn_52_3 BLN3 dn_52_3 sky130_fd_pr_reram__reram_cell area_ox=0.0676
XMp_52_4 dp_52_4 WL52 SL4 VSS sky130_fd_pr__nfet_g5v0d10v5 w=1 l=0.5
XRp_52_4 BLP4 dp_52_4 sky130_fd_pr_reram__reram_cell area_ox=0.0676
XMn_52_4 dn_52_4 WL52 SL4 VSS sky130_fd_pr__nfet_g5v0d10v5 w=1 l=0.5
XRn_52_4 BLN4 dn_52_4 sky130_fd_pr_reram__reram_cell area_ox=0.0676
XMp_52_5 dp_52_5 WL52 SL5 VSS sky130_fd_pr__nfet_g5v0d10v5 w=1 l=0.5
XRp_52_5 BLP5 dp_52_5 sky130_fd_pr_reram__reram_cell area_ox=0.0676
XMn_52_5 dn_52_5 WL52 SL5 VSS sky130_fd_pr__nfet_g5v0d10v5 w=1 l=0.5
XRn_52_5 BLN5 dn_52_5 sky130_fd_pr_reram__reram_cell area_ox=0.0676
XMp_52_6 dp_52_6 WL52 SL6 VSS sky130_fd_pr__nfet_g5v0d10v5 w=1 l=0.5
XRp_52_6 BLP6 dp_52_6 sky130_fd_pr_reram__reram_cell area_ox=0.0676
XMn_52_6 dn_52_6 WL52 SL6 VSS sky130_fd_pr__nfet_g5v0d10v5 w=1 l=0.5
XRn_52_6 BLN6 dn_52_6 sky130_fd_pr_reram__reram_cell area_ox=0.0676
XMp_52_7 dp_52_7 WL52 SL7 VSS sky130_fd_pr__nfet_g5v0d10v5 w=1 l=0.5
XRp_52_7 BLP7 dp_52_7 sky130_fd_pr_reram__reram_cell area_ox=0.0676
XMn_52_7 dn_52_7 WL52 SL7 VSS sky130_fd_pr__nfet_g5v0d10v5 w=1 l=0.5
XRn_52_7 BLN7 dn_52_7 sky130_fd_pr_reram__reram_cell area_ox=0.0676
XMp_52_8 dp_52_8 WL52 SL8 VSS sky130_fd_pr__nfet_g5v0d10v5 w=1 l=0.5
XRp_52_8 BLP8 dp_52_8 sky130_fd_pr_reram__reram_cell area_ox=0.0676
XMn_52_8 dn_52_8 WL52 SL8 VSS sky130_fd_pr__nfet_g5v0d10v5 w=1 l=0.5
XRn_52_8 BLN8 dn_52_8 sky130_fd_pr_reram__reram_cell area_ox=0.0676
XMp_52_9 dp_52_9 WL52 SL9 VSS sky130_fd_pr__nfet_g5v0d10v5 w=1 l=0.5
XRp_52_9 BLP9 dp_52_9 sky130_fd_pr_reram__reram_cell area_ox=0.0676
XMn_52_9 dn_52_9 WL52 SL9 VSS sky130_fd_pr__nfet_g5v0d10v5 w=1 l=0.5
XRn_52_9 BLN9 dn_52_9 sky130_fd_pr_reram__reram_cell area_ox=0.0676
XMp_52_10 dp_52_10 WL52 SL10 VSS sky130_fd_pr__nfet_g5v0d10v5 w=1 l=0.5
XRp_52_10 BLP10 dp_52_10 sky130_fd_pr_reram__reram_cell area_ox=0.0676
XMn_52_10 dn_52_10 WL52 SL10 VSS sky130_fd_pr__nfet_g5v0d10v5 w=1 l=0.5
XRn_52_10 BLN10 dn_52_10 sky130_fd_pr_reram__reram_cell area_ox=0.0676
XMp_52_11 dp_52_11 WL52 SL11 VSS sky130_fd_pr__nfet_g5v0d10v5 w=1 l=0.5
XRp_52_11 BLP11 dp_52_11 sky130_fd_pr_reram__reram_cell area_ox=0.0676
XMn_52_11 dn_52_11 WL52 SL11 VSS sky130_fd_pr__nfet_g5v0d10v5 w=1 l=0.5
XRn_52_11 BLN11 dn_52_11 sky130_fd_pr_reram__reram_cell area_ox=0.0676
XMp_52_12 dp_52_12 WL52 SL12 VSS sky130_fd_pr__nfet_g5v0d10v5 w=1 l=0.5
XRp_52_12 BLP12 dp_52_12 sky130_fd_pr_reram__reram_cell area_ox=0.0676
XMn_52_12 dn_52_12 WL52 SL12 VSS sky130_fd_pr__nfet_g5v0d10v5 w=1 l=0.5
XRn_52_12 BLN12 dn_52_12 sky130_fd_pr_reram__reram_cell area_ox=0.0676
XMp_52_13 dp_52_13 WL52 SL13 VSS sky130_fd_pr__nfet_g5v0d10v5 w=1 l=0.5
XRp_52_13 BLP13 dp_52_13 sky130_fd_pr_reram__reram_cell area_ox=0.0676
XMn_52_13 dn_52_13 WL52 SL13 VSS sky130_fd_pr__nfet_g5v0d10v5 w=1 l=0.5
XRn_52_13 BLN13 dn_52_13 sky130_fd_pr_reram__reram_cell area_ox=0.0676
XMp_52_14 dp_52_14 WL52 SL14 VSS sky130_fd_pr__nfet_g5v0d10v5 w=1 l=0.5
XRp_52_14 BLP14 dp_52_14 sky130_fd_pr_reram__reram_cell area_ox=0.0676
XMn_52_14 dn_52_14 WL52 SL14 VSS sky130_fd_pr__nfet_g5v0d10v5 w=1 l=0.5
XRn_52_14 BLN14 dn_52_14 sky130_fd_pr_reram__reram_cell area_ox=0.0676
XMp_52_15 dp_52_15 WL52 SL15 VSS sky130_fd_pr__nfet_g5v0d10v5 w=1 l=0.5
XRp_52_15 BLP15 dp_52_15 sky130_fd_pr_reram__reram_cell area_ox=0.0676
XMn_52_15 dn_52_15 WL52 SL15 VSS sky130_fd_pr__nfet_g5v0d10v5 w=1 l=0.5
XRn_52_15 BLN15 dn_52_15 sky130_fd_pr_reram__reram_cell area_ox=0.0676
XMp_52_16 dp_52_16 WL52 SL16 VSS sky130_fd_pr__nfet_g5v0d10v5 w=1 l=0.5
XRp_52_16 BLP16 dp_52_16 sky130_fd_pr_reram__reram_cell area_ox=0.0676
XMn_52_16 dn_52_16 WL52 SL16 VSS sky130_fd_pr__nfet_g5v0d10v5 w=1 l=0.5
XRn_52_16 BLN16 dn_52_16 sky130_fd_pr_reram__reram_cell area_ox=0.0676
XMp_52_17 dp_52_17 WL52 SL17 VSS sky130_fd_pr__nfet_g5v0d10v5 w=1 l=0.5
XRp_52_17 BLP17 dp_52_17 sky130_fd_pr_reram__reram_cell area_ox=0.0676
XMn_52_17 dn_52_17 WL52 SL17 VSS sky130_fd_pr__nfet_g5v0d10v5 w=1 l=0.5
XRn_52_17 BLN17 dn_52_17 sky130_fd_pr_reram__reram_cell area_ox=0.0676
XMp_52_18 dp_52_18 WL52 SL18 VSS sky130_fd_pr__nfet_g5v0d10v5 w=1 l=0.5
XRp_52_18 BLP18 dp_52_18 sky130_fd_pr_reram__reram_cell area_ox=0.0676
XMn_52_18 dn_52_18 WL52 SL18 VSS sky130_fd_pr__nfet_g5v0d10v5 w=1 l=0.5
XRn_52_18 BLN18 dn_52_18 sky130_fd_pr_reram__reram_cell area_ox=0.0676
XMp_52_19 dp_52_19 WL52 SL19 VSS sky130_fd_pr__nfet_g5v0d10v5 w=1 l=0.5
XRp_52_19 BLP19 dp_52_19 sky130_fd_pr_reram__reram_cell area_ox=0.0676
XMn_52_19 dn_52_19 WL52 SL19 VSS sky130_fd_pr__nfet_g5v0d10v5 w=1 l=0.5
XRn_52_19 BLN19 dn_52_19 sky130_fd_pr_reram__reram_cell area_ox=0.0676
XMp_52_20 dp_52_20 WL52 SL20 VSS sky130_fd_pr__nfet_g5v0d10v5 w=1 l=0.5
XRp_52_20 BLP20 dp_52_20 sky130_fd_pr_reram__reram_cell area_ox=0.0676
XMn_52_20 dn_52_20 WL52 SL20 VSS sky130_fd_pr__nfet_g5v0d10v5 w=1 l=0.5
XRn_52_20 BLN20 dn_52_20 sky130_fd_pr_reram__reram_cell area_ox=0.0676
XMp_52_21 dp_52_21 WL52 SL21 VSS sky130_fd_pr__nfet_g5v0d10v5 w=1 l=0.5
XRp_52_21 BLP21 dp_52_21 sky130_fd_pr_reram__reram_cell area_ox=0.0676
XMn_52_21 dn_52_21 WL52 SL21 VSS sky130_fd_pr__nfet_g5v0d10v5 w=1 l=0.5
XRn_52_21 BLN21 dn_52_21 sky130_fd_pr_reram__reram_cell area_ox=0.0676
XMp_52_22 dp_52_22 WL52 SL22 VSS sky130_fd_pr__nfet_g5v0d10v5 w=1 l=0.5
XRp_52_22 BLP22 dp_52_22 sky130_fd_pr_reram__reram_cell area_ox=0.0676
XMn_52_22 dn_52_22 WL52 SL22 VSS sky130_fd_pr__nfet_g5v0d10v5 w=1 l=0.5
XRn_52_22 BLN22 dn_52_22 sky130_fd_pr_reram__reram_cell area_ox=0.0676
XMp_52_23 dp_52_23 WL52 SL23 VSS sky130_fd_pr__nfet_g5v0d10v5 w=1 l=0.5
XRp_52_23 BLP23 dp_52_23 sky130_fd_pr_reram__reram_cell area_ox=0.0676
XMn_52_23 dn_52_23 WL52 SL23 VSS sky130_fd_pr__nfet_g5v0d10v5 w=1 l=0.5
XRn_52_23 BLN23 dn_52_23 sky130_fd_pr_reram__reram_cell area_ox=0.0676
XMp_53_0 dp_53_0 WL53 SL0 VSS sky130_fd_pr__nfet_g5v0d10v5 w=1 l=0.5
XRp_53_0 BLP0 dp_53_0 sky130_fd_pr_reram__reram_cell area_ox=0.0676
XMn_53_0 dn_53_0 WL53 SL0 VSS sky130_fd_pr__nfet_g5v0d10v5 w=1 l=0.5
XRn_53_0 BLN0 dn_53_0 sky130_fd_pr_reram__reram_cell area_ox=0.0676
XMp_53_1 dp_53_1 WL53 SL1 VSS sky130_fd_pr__nfet_g5v0d10v5 w=1 l=0.5
XRp_53_1 BLP1 dp_53_1 sky130_fd_pr_reram__reram_cell area_ox=0.0676
XMn_53_1 dn_53_1 WL53 SL1 VSS sky130_fd_pr__nfet_g5v0d10v5 w=1 l=0.5
XRn_53_1 BLN1 dn_53_1 sky130_fd_pr_reram__reram_cell area_ox=0.0676
XMp_53_2 dp_53_2 WL53 SL2 VSS sky130_fd_pr__nfet_g5v0d10v5 w=1 l=0.5
XRp_53_2 BLP2 dp_53_2 sky130_fd_pr_reram__reram_cell area_ox=0.0676
XMn_53_2 dn_53_2 WL53 SL2 VSS sky130_fd_pr__nfet_g5v0d10v5 w=1 l=0.5
XRn_53_2 BLN2 dn_53_2 sky130_fd_pr_reram__reram_cell area_ox=0.0676
XMp_53_3 dp_53_3 WL53 SL3 VSS sky130_fd_pr__nfet_g5v0d10v5 w=1 l=0.5
XRp_53_3 BLP3 dp_53_3 sky130_fd_pr_reram__reram_cell area_ox=0.0676
XMn_53_3 dn_53_3 WL53 SL3 VSS sky130_fd_pr__nfet_g5v0d10v5 w=1 l=0.5
XRn_53_3 BLN3 dn_53_3 sky130_fd_pr_reram__reram_cell area_ox=0.0676
XMp_53_4 dp_53_4 WL53 SL4 VSS sky130_fd_pr__nfet_g5v0d10v5 w=1 l=0.5
XRp_53_4 BLP4 dp_53_4 sky130_fd_pr_reram__reram_cell area_ox=0.0676
XMn_53_4 dn_53_4 WL53 SL4 VSS sky130_fd_pr__nfet_g5v0d10v5 w=1 l=0.5
XRn_53_4 BLN4 dn_53_4 sky130_fd_pr_reram__reram_cell area_ox=0.0676
XMp_53_5 dp_53_5 WL53 SL5 VSS sky130_fd_pr__nfet_g5v0d10v5 w=1 l=0.5
XRp_53_5 BLP5 dp_53_5 sky130_fd_pr_reram__reram_cell area_ox=0.0676
XMn_53_5 dn_53_5 WL53 SL5 VSS sky130_fd_pr__nfet_g5v0d10v5 w=1 l=0.5
XRn_53_5 BLN5 dn_53_5 sky130_fd_pr_reram__reram_cell area_ox=0.0676
XMp_53_6 dp_53_6 WL53 SL6 VSS sky130_fd_pr__nfet_g5v0d10v5 w=1 l=0.5
XRp_53_6 BLP6 dp_53_6 sky130_fd_pr_reram__reram_cell area_ox=0.0676
XMn_53_6 dn_53_6 WL53 SL6 VSS sky130_fd_pr__nfet_g5v0d10v5 w=1 l=0.5
XRn_53_6 BLN6 dn_53_6 sky130_fd_pr_reram__reram_cell area_ox=0.0676
XMp_53_7 dp_53_7 WL53 SL7 VSS sky130_fd_pr__nfet_g5v0d10v5 w=1 l=0.5
XRp_53_7 BLP7 dp_53_7 sky130_fd_pr_reram__reram_cell area_ox=0.0676
XMn_53_7 dn_53_7 WL53 SL7 VSS sky130_fd_pr__nfet_g5v0d10v5 w=1 l=0.5
XRn_53_7 BLN7 dn_53_7 sky130_fd_pr_reram__reram_cell area_ox=0.0676
XMp_53_8 dp_53_8 WL53 SL8 VSS sky130_fd_pr__nfet_g5v0d10v5 w=1 l=0.5
XRp_53_8 BLP8 dp_53_8 sky130_fd_pr_reram__reram_cell area_ox=0.0676
XMn_53_8 dn_53_8 WL53 SL8 VSS sky130_fd_pr__nfet_g5v0d10v5 w=1 l=0.5
XRn_53_8 BLN8 dn_53_8 sky130_fd_pr_reram__reram_cell area_ox=0.0676
XMp_53_9 dp_53_9 WL53 SL9 VSS sky130_fd_pr__nfet_g5v0d10v5 w=1 l=0.5
XRp_53_9 BLP9 dp_53_9 sky130_fd_pr_reram__reram_cell area_ox=0.0676
XMn_53_9 dn_53_9 WL53 SL9 VSS sky130_fd_pr__nfet_g5v0d10v5 w=1 l=0.5
XRn_53_9 BLN9 dn_53_9 sky130_fd_pr_reram__reram_cell area_ox=0.0676
XMp_53_10 dp_53_10 WL53 SL10 VSS sky130_fd_pr__nfet_g5v0d10v5 w=1 l=0.5
XRp_53_10 BLP10 dp_53_10 sky130_fd_pr_reram__reram_cell area_ox=0.0676
XMn_53_10 dn_53_10 WL53 SL10 VSS sky130_fd_pr__nfet_g5v0d10v5 w=1 l=0.5
XRn_53_10 BLN10 dn_53_10 sky130_fd_pr_reram__reram_cell area_ox=0.0676
XMp_53_11 dp_53_11 WL53 SL11 VSS sky130_fd_pr__nfet_g5v0d10v5 w=1 l=0.5
XRp_53_11 BLP11 dp_53_11 sky130_fd_pr_reram__reram_cell area_ox=0.0676
XMn_53_11 dn_53_11 WL53 SL11 VSS sky130_fd_pr__nfet_g5v0d10v5 w=1 l=0.5
XRn_53_11 BLN11 dn_53_11 sky130_fd_pr_reram__reram_cell area_ox=0.0676
XMp_53_12 dp_53_12 WL53 SL12 VSS sky130_fd_pr__nfet_g5v0d10v5 w=1 l=0.5
XRp_53_12 BLP12 dp_53_12 sky130_fd_pr_reram__reram_cell area_ox=0.0676
XMn_53_12 dn_53_12 WL53 SL12 VSS sky130_fd_pr__nfet_g5v0d10v5 w=1 l=0.5
XRn_53_12 BLN12 dn_53_12 sky130_fd_pr_reram__reram_cell area_ox=0.0676
XMp_53_13 dp_53_13 WL53 SL13 VSS sky130_fd_pr__nfet_g5v0d10v5 w=1 l=0.5
XRp_53_13 BLP13 dp_53_13 sky130_fd_pr_reram__reram_cell area_ox=0.0676
XMn_53_13 dn_53_13 WL53 SL13 VSS sky130_fd_pr__nfet_g5v0d10v5 w=1 l=0.5
XRn_53_13 BLN13 dn_53_13 sky130_fd_pr_reram__reram_cell area_ox=0.0676
XMp_53_14 dp_53_14 WL53 SL14 VSS sky130_fd_pr__nfet_g5v0d10v5 w=1 l=0.5
XRp_53_14 BLP14 dp_53_14 sky130_fd_pr_reram__reram_cell area_ox=0.0676
XMn_53_14 dn_53_14 WL53 SL14 VSS sky130_fd_pr__nfet_g5v0d10v5 w=1 l=0.5
XRn_53_14 BLN14 dn_53_14 sky130_fd_pr_reram__reram_cell area_ox=0.0676
XMp_53_15 dp_53_15 WL53 SL15 VSS sky130_fd_pr__nfet_g5v0d10v5 w=1 l=0.5
XRp_53_15 BLP15 dp_53_15 sky130_fd_pr_reram__reram_cell area_ox=0.0676
XMn_53_15 dn_53_15 WL53 SL15 VSS sky130_fd_pr__nfet_g5v0d10v5 w=1 l=0.5
XRn_53_15 BLN15 dn_53_15 sky130_fd_pr_reram__reram_cell area_ox=0.0676
XMp_53_16 dp_53_16 WL53 SL16 VSS sky130_fd_pr__nfet_g5v0d10v5 w=1 l=0.5
XRp_53_16 BLP16 dp_53_16 sky130_fd_pr_reram__reram_cell area_ox=0.0676
XMn_53_16 dn_53_16 WL53 SL16 VSS sky130_fd_pr__nfet_g5v0d10v5 w=1 l=0.5
XRn_53_16 BLN16 dn_53_16 sky130_fd_pr_reram__reram_cell area_ox=0.0676
XMp_53_17 dp_53_17 WL53 SL17 VSS sky130_fd_pr__nfet_g5v0d10v5 w=1 l=0.5
XRp_53_17 BLP17 dp_53_17 sky130_fd_pr_reram__reram_cell area_ox=0.0676
XMn_53_17 dn_53_17 WL53 SL17 VSS sky130_fd_pr__nfet_g5v0d10v5 w=1 l=0.5
XRn_53_17 BLN17 dn_53_17 sky130_fd_pr_reram__reram_cell area_ox=0.0676
XMp_53_18 dp_53_18 WL53 SL18 VSS sky130_fd_pr__nfet_g5v0d10v5 w=1 l=0.5
XRp_53_18 BLP18 dp_53_18 sky130_fd_pr_reram__reram_cell area_ox=0.0676
XMn_53_18 dn_53_18 WL53 SL18 VSS sky130_fd_pr__nfet_g5v0d10v5 w=1 l=0.5
XRn_53_18 BLN18 dn_53_18 sky130_fd_pr_reram__reram_cell area_ox=0.0676
XMp_53_19 dp_53_19 WL53 SL19 VSS sky130_fd_pr__nfet_g5v0d10v5 w=1 l=0.5
XRp_53_19 BLP19 dp_53_19 sky130_fd_pr_reram__reram_cell area_ox=0.0676
XMn_53_19 dn_53_19 WL53 SL19 VSS sky130_fd_pr__nfet_g5v0d10v5 w=1 l=0.5
XRn_53_19 BLN19 dn_53_19 sky130_fd_pr_reram__reram_cell area_ox=0.0676
XMp_53_20 dp_53_20 WL53 SL20 VSS sky130_fd_pr__nfet_g5v0d10v5 w=1 l=0.5
XRp_53_20 BLP20 dp_53_20 sky130_fd_pr_reram__reram_cell area_ox=0.0676
XMn_53_20 dn_53_20 WL53 SL20 VSS sky130_fd_pr__nfet_g5v0d10v5 w=1 l=0.5
XRn_53_20 BLN20 dn_53_20 sky130_fd_pr_reram__reram_cell area_ox=0.0676
XMp_53_21 dp_53_21 WL53 SL21 VSS sky130_fd_pr__nfet_g5v0d10v5 w=1 l=0.5
XRp_53_21 BLP21 dp_53_21 sky130_fd_pr_reram__reram_cell area_ox=0.0676
XMn_53_21 dn_53_21 WL53 SL21 VSS sky130_fd_pr__nfet_g5v0d10v5 w=1 l=0.5
XRn_53_21 BLN21 dn_53_21 sky130_fd_pr_reram__reram_cell area_ox=0.0676
XMp_53_22 dp_53_22 WL53 SL22 VSS sky130_fd_pr__nfet_g5v0d10v5 w=1 l=0.5
XRp_53_22 BLP22 dp_53_22 sky130_fd_pr_reram__reram_cell area_ox=0.0676
XMn_53_22 dn_53_22 WL53 SL22 VSS sky130_fd_pr__nfet_g5v0d10v5 w=1 l=0.5
XRn_53_22 BLN22 dn_53_22 sky130_fd_pr_reram__reram_cell area_ox=0.0676
XMp_53_23 dp_53_23 WL53 SL23 VSS sky130_fd_pr__nfet_g5v0d10v5 w=1 l=0.5
XRp_53_23 BLP23 dp_53_23 sky130_fd_pr_reram__reram_cell area_ox=0.0676
XMn_53_23 dn_53_23 WL53 SL23 VSS sky130_fd_pr__nfet_g5v0d10v5 w=1 l=0.5
XRn_53_23 BLN23 dn_53_23 sky130_fd_pr_reram__reram_cell area_ox=0.0676
XMp_54_0 dp_54_0 WL54 SL0 VSS sky130_fd_pr__nfet_g5v0d10v5 w=1 l=0.5
XRp_54_0 BLP0 dp_54_0 sky130_fd_pr_reram__reram_cell area_ox=0.0676
XMn_54_0 dn_54_0 WL54 SL0 VSS sky130_fd_pr__nfet_g5v0d10v5 w=1 l=0.5
XRn_54_0 BLN0 dn_54_0 sky130_fd_pr_reram__reram_cell area_ox=0.0676
XMp_54_1 dp_54_1 WL54 SL1 VSS sky130_fd_pr__nfet_g5v0d10v5 w=1 l=0.5
XRp_54_1 BLP1 dp_54_1 sky130_fd_pr_reram__reram_cell area_ox=0.0676
XMn_54_1 dn_54_1 WL54 SL1 VSS sky130_fd_pr__nfet_g5v0d10v5 w=1 l=0.5
XRn_54_1 BLN1 dn_54_1 sky130_fd_pr_reram__reram_cell area_ox=0.0676
XMp_54_2 dp_54_2 WL54 SL2 VSS sky130_fd_pr__nfet_g5v0d10v5 w=1 l=0.5
XRp_54_2 BLP2 dp_54_2 sky130_fd_pr_reram__reram_cell area_ox=0.0676
XMn_54_2 dn_54_2 WL54 SL2 VSS sky130_fd_pr__nfet_g5v0d10v5 w=1 l=0.5
XRn_54_2 BLN2 dn_54_2 sky130_fd_pr_reram__reram_cell area_ox=0.0676
XMp_54_3 dp_54_3 WL54 SL3 VSS sky130_fd_pr__nfet_g5v0d10v5 w=1 l=0.5
XRp_54_3 BLP3 dp_54_3 sky130_fd_pr_reram__reram_cell area_ox=0.0676
XMn_54_3 dn_54_3 WL54 SL3 VSS sky130_fd_pr__nfet_g5v0d10v5 w=1 l=0.5
XRn_54_3 BLN3 dn_54_3 sky130_fd_pr_reram__reram_cell area_ox=0.0676
XMp_54_4 dp_54_4 WL54 SL4 VSS sky130_fd_pr__nfet_g5v0d10v5 w=1 l=0.5
XRp_54_4 BLP4 dp_54_4 sky130_fd_pr_reram__reram_cell area_ox=0.0676
XMn_54_4 dn_54_4 WL54 SL4 VSS sky130_fd_pr__nfet_g5v0d10v5 w=1 l=0.5
XRn_54_4 BLN4 dn_54_4 sky130_fd_pr_reram__reram_cell area_ox=0.0676
XMp_54_5 dp_54_5 WL54 SL5 VSS sky130_fd_pr__nfet_g5v0d10v5 w=1 l=0.5
XRp_54_5 BLP5 dp_54_5 sky130_fd_pr_reram__reram_cell area_ox=0.0676
XMn_54_5 dn_54_5 WL54 SL5 VSS sky130_fd_pr__nfet_g5v0d10v5 w=1 l=0.5
XRn_54_5 BLN5 dn_54_5 sky130_fd_pr_reram__reram_cell area_ox=0.0676
XMp_54_6 dp_54_6 WL54 SL6 VSS sky130_fd_pr__nfet_g5v0d10v5 w=1 l=0.5
XRp_54_6 BLP6 dp_54_6 sky130_fd_pr_reram__reram_cell area_ox=0.0676
XMn_54_6 dn_54_6 WL54 SL6 VSS sky130_fd_pr__nfet_g5v0d10v5 w=1 l=0.5
XRn_54_6 BLN6 dn_54_6 sky130_fd_pr_reram__reram_cell area_ox=0.0676
XMp_54_7 dp_54_7 WL54 SL7 VSS sky130_fd_pr__nfet_g5v0d10v5 w=1 l=0.5
XRp_54_7 BLP7 dp_54_7 sky130_fd_pr_reram__reram_cell area_ox=0.0676
XMn_54_7 dn_54_7 WL54 SL7 VSS sky130_fd_pr__nfet_g5v0d10v5 w=1 l=0.5
XRn_54_7 BLN7 dn_54_7 sky130_fd_pr_reram__reram_cell area_ox=0.0676
XMp_54_8 dp_54_8 WL54 SL8 VSS sky130_fd_pr__nfet_g5v0d10v5 w=1 l=0.5
XRp_54_8 BLP8 dp_54_8 sky130_fd_pr_reram__reram_cell area_ox=0.0676
XMn_54_8 dn_54_8 WL54 SL8 VSS sky130_fd_pr__nfet_g5v0d10v5 w=1 l=0.5
XRn_54_8 BLN8 dn_54_8 sky130_fd_pr_reram__reram_cell area_ox=0.0676
XMp_54_9 dp_54_9 WL54 SL9 VSS sky130_fd_pr__nfet_g5v0d10v5 w=1 l=0.5
XRp_54_9 BLP9 dp_54_9 sky130_fd_pr_reram__reram_cell area_ox=0.0676
XMn_54_9 dn_54_9 WL54 SL9 VSS sky130_fd_pr__nfet_g5v0d10v5 w=1 l=0.5
XRn_54_9 BLN9 dn_54_9 sky130_fd_pr_reram__reram_cell area_ox=0.0676
XMp_54_10 dp_54_10 WL54 SL10 VSS sky130_fd_pr__nfet_g5v0d10v5 w=1 l=0.5
XRp_54_10 BLP10 dp_54_10 sky130_fd_pr_reram__reram_cell area_ox=0.0676
XMn_54_10 dn_54_10 WL54 SL10 VSS sky130_fd_pr__nfet_g5v0d10v5 w=1 l=0.5
XRn_54_10 BLN10 dn_54_10 sky130_fd_pr_reram__reram_cell area_ox=0.0676
XMp_54_11 dp_54_11 WL54 SL11 VSS sky130_fd_pr__nfet_g5v0d10v5 w=1 l=0.5
XRp_54_11 BLP11 dp_54_11 sky130_fd_pr_reram__reram_cell area_ox=0.0676
XMn_54_11 dn_54_11 WL54 SL11 VSS sky130_fd_pr__nfet_g5v0d10v5 w=1 l=0.5
XRn_54_11 BLN11 dn_54_11 sky130_fd_pr_reram__reram_cell area_ox=0.0676
XMp_54_12 dp_54_12 WL54 SL12 VSS sky130_fd_pr__nfet_g5v0d10v5 w=1 l=0.5
XRp_54_12 BLP12 dp_54_12 sky130_fd_pr_reram__reram_cell area_ox=0.0676
XMn_54_12 dn_54_12 WL54 SL12 VSS sky130_fd_pr__nfet_g5v0d10v5 w=1 l=0.5
XRn_54_12 BLN12 dn_54_12 sky130_fd_pr_reram__reram_cell area_ox=0.0676
XMp_54_13 dp_54_13 WL54 SL13 VSS sky130_fd_pr__nfet_g5v0d10v5 w=1 l=0.5
XRp_54_13 BLP13 dp_54_13 sky130_fd_pr_reram__reram_cell area_ox=0.0676
XMn_54_13 dn_54_13 WL54 SL13 VSS sky130_fd_pr__nfet_g5v0d10v5 w=1 l=0.5
XRn_54_13 BLN13 dn_54_13 sky130_fd_pr_reram__reram_cell area_ox=0.0676
XMp_54_14 dp_54_14 WL54 SL14 VSS sky130_fd_pr__nfet_g5v0d10v5 w=1 l=0.5
XRp_54_14 BLP14 dp_54_14 sky130_fd_pr_reram__reram_cell area_ox=0.0676
XMn_54_14 dn_54_14 WL54 SL14 VSS sky130_fd_pr__nfet_g5v0d10v5 w=1 l=0.5
XRn_54_14 BLN14 dn_54_14 sky130_fd_pr_reram__reram_cell area_ox=0.0676
XMp_54_15 dp_54_15 WL54 SL15 VSS sky130_fd_pr__nfet_g5v0d10v5 w=1 l=0.5
XRp_54_15 BLP15 dp_54_15 sky130_fd_pr_reram__reram_cell area_ox=0.0676
XMn_54_15 dn_54_15 WL54 SL15 VSS sky130_fd_pr__nfet_g5v0d10v5 w=1 l=0.5
XRn_54_15 BLN15 dn_54_15 sky130_fd_pr_reram__reram_cell area_ox=0.0676
XMp_54_16 dp_54_16 WL54 SL16 VSS sky130_fd_pr__nfet_g5v0d10v5 w=1 l=0.5
XRp_54_16 BLP16 dp_54_16 sky130_fd_pr_reram__reram_cell area_ox=0.0676
XMn_54_16 dn_54_16 WL54 SL16 VSS sky130_fd_pr__nfet_g5v0d10v5 w=1 l=0.5
XRn_54_16 BLN16 dn_54_16 sky130_fd_pr_reram__reram_cell area_ox=0.0676
XMp_54_17 dp_54_17 WL54 SL17 VSS sky130_fd_pr__nfet_g5v0d10v5 w=1 l=0.5
XRp_54_17 BLP17 dp_54_17 sky130_fd_pr_reram__reram_cell area_ox=0.0676
XMn_54_17 dn_54_17 WL54 SL17 VSS sky130_fd_pr__nfet_g5v0d10v5 w=1 l=0.5
XRn_54_17 BLN17 dn_54_17 sky130_fd_pr_reram__reram_cell area_ox=0.0676
XMp_54_18 dp_54_18 WL54 SL18 VSS sky130_fd_pr__nfet_g5v0d10v5 w=1 l=0.5
XRp_54_18 BLP18 dp_54_18 sky130_fd_pr_reram__reram_cell area_ox=0.0676
XMn_54_18 dn_54_18 WL54 SL18 VSS sky130_fd_pr__nfet_g5v0d10v5 w=1 l=0.5
XRn_54_18 BLN18 dn_54_18 sky130_fd_pr_reram__reram_cell area_ox=0.0676
XMp_54_19 dp_54_19 WL54 SL19 VSS sky130_fd_pr__nfet_g5v0d10v5 w=1 l=0.5
XRp_54_19 BLP19 dp_54_19 sky130_fd_pr_reram__reram_cell area_ox=0.0676
XMn_54_19 dn_54_19 WL54 SL19 VSS sky130_fd_pr__nfet_g5v0d10v5 w=1 l=0.5
XRn_54_19 BLN19 dn_54_19 sky130_fd_pr_reram__reram_cell area_ox=0.0676
XMp_54_20 dp_54_20 WL54 SL20 VSS sky130_fd_pr__nfet_g5v0d10v5 w=1 l=0.5
XRp_54_20 BLP20 dp_54_20 sky130_fd_pr_reram__reram_cell area_ox=0.0676
XMn_54_20 dn_54_20 WL54 SL20 VSS sky130_fd_pr__nfet_g5v0d10v5 w=1 l=0.5
XRn_54_20 BLN20 dn_54_20 sky130_fd_pr_reram__reram_cell area_ox=0.0676
XMp_54_21 dp_54_21 WL54 SL21 VSS sky130_fd_pr__nfet_g5v0d10v5 w=1 l=0.5
XRp_54_21 BLP21 dp_54_21 sky130_fd_pr_reram__reram_cell area_ox=0.0676
XMn_54_21 dn_54_21 WL54 SL21 VSS sky130_fd_pr__nfet_g5v0d10v5 w=1 l=0.5
XRn_54_21 BLN21 dn_54_21 sky130_fd_pr_reram__reram_cell area_ox=0.0676
XMp_54_22 dp_54_22 WL54 SL22 VSS sky130_fd_pr__nfet_g5v0d10v5 w=1 l=0.5
XRp_54_22 BLP22 dp_54_22 sky130_fd_pr_reram__reram_cell area_ox=0.0676
XMn_54_22 dn_54_22 WL54 SL22 VSS sky130_fd_pr__nfet_g5v0d10v5 w=1 l=0.5
XRn_54_22 BLN22 dn_54_22 sky130_fd_pr_reram__reram_cell area_ox=0.0676
XMp_54_23 dp_54_23 WL54 SL23 VSS sky130_fd_pr__nfet_g5v0d10v5 w=1 l=0.5
XRp_54_23 BLP23 dp_54_23 sky130_fd_pr_reram__reram_cell area_ox=0.0676
XMn_54_23 dn_54_23 WL54 SL23 VSS sky130_fd_pr__nfet_g5v0d10v5 w=1 l=0.5
XRn_54_23 BLN23 dn_54_23 sky130_fd_pr_reram__reram_cell area_ox=0.0676
XMp_55_0 dp_55_0 WL55 SL0 VSS sky130_fd_pr__nfet_g5v0d10v5 w=1 l=0.5
XRp_55_0 BLP0 dp_55_0 sky130_fd_pr_reram__reram_cell area_ox=0.0676
XMn_55_0 dn_55_0 WL55 SL0 VSS sky130_fd_pr__nfet_g5v0d10v5 w=1 l=0.5
XRn_55_0 BLN0 dn_55_0 sky130_fd_pr_reram__reram_cell area_ox=0.0676
XMp_55_1 dp_55_1 WL55 SL1 VSS sky130_fd_pr__nfet_g5v0d10v5 w=1 l=0.5
XRp_55_1 BLP1 dp_55_1 sky130_fd_pr_reram__reram_cell area_ox=0.0676
XMn_55_1 dn_55_1 WL55 SL1 VSS sky130_fd_pr__nfet_g5v0d10v5 w=1 l=0.5
XRn_55_1 BLN1 dn_55_1 sky130_fd_pr_reram__reram_cell area_ox=0.0676
XMp_55_2 dp_55_2 WL55 SL2 VSS sky130_fd_pr__nfet_g5v0d10v5 w=1 l=0.5
XRp_55_2 BLP2 dp_55_2 sky130_fd_pr_reram__reram_cell area_ox=0.0676
XMn_55_2 dn_55_2 WL55 SL2 VSS sky130_fd_pr__nfet_g5v0d10v5 w=1 l=0.5
XRn_55_2 BLN2 dn_55_2 sky130_fd_pr_reram__reram_cell area_ox=0.0676
XMp_55_3 dp_55_3 WL55 SL3 VSS sky130_fd_pr__nfet_g5v0d10v5 w=1 l=0.5
XRp_55_3 BLP3 dp_55_3 sky130_fd_pr_reram__reram_cell area_ox=0.0676
XMn_55_3 dn_55_3 WL55 SL3 VSS sky130_fd_pr__nfet_g5v0d10v5 w=1 l=0.5
XRn_55_3 BLN3 dn_55_3 sky130_fd_pr_reram__reram_cell area_ox=0.0676
XMp_55_4 dp_55_4 WL55 SL4 VSS sky130_fd_pr__nfet_g5v0d10v5 w=1 l=0.5
XRp_55_4 BLP4 dp_55_4 sky130_fd_pr_reram__reram_cell area_ox=0.0676
XMn_55_4 dn_55_4 WL55 SL4 VSS sky130_fd_pr__nfet_g5v0d10v5 w=1 l=0.5
XRn_55_4 BLN4 dn_55_4 sky130_fd_pr_reram__reram_cell area_ox=0.0676
XMp_55_5 dp_55_5 WL55 SL5 VSS sky130_fd_pr__nfet_g5v0d10v5 w=1 l=0.5
XRp_55_5 BLP5 dp_55_5 sky130_fd_pr_reram__reram_cell area_ox=0.0676
XMn_55_5 dn_55_5 WL55 SL5 VSS sky130_fd_pr__nfet_g5v0d10v5 w=1 l=0.5
XRn_55_5 BLN5 dn_55_5 sky130_fd_pr_reram__reram_cell area_ox=0.0676
XMp_55_6 dp_55_6 WL55 SL6 VSS sky130_fd_pr__nfet_g5v0d10v5 w=1 l=0.5
XRp_55_6 BLP6 dp_55_6 sky130_fd_pr_reram__reram_cell area_ox=0.0676
XMn_55_6 dn_55_6 WL55 SL6 VSS sky130_fd_pr__nfet_g5v0d10v5 w=1 l=0.5
XRn_55_6 BLN6 dn_55_6 sky130_fd_pr_reram__reram_cell area_ox=0.0676
XMp_55_7 dp_55_7 WL55 SL7 VSS sky130_fd_pr__nfet_g5v0d10v5 w=1 l=0.5
XRp_55_7 BLP7 dp_55_7 sky130_fd_pr_reram__reram_cell area_ox=0.0676
XMn_55_7 dn_55_7 WL55 SL7 VSS sky130_fd_pr__nfet_g5v0d10v5 w=1 l=0.5
XRn_55_7 BLN7 dn_55_7 sky130_fd_pr_reram__reram_cell area_ox=0.0676
XMp_55_8 dp_55_8 WL55 SL8 VSS sky130_fd_pr__nfet_g5v0d10v5 w=1 l=0.5
XRp_55_8 BLP8 dp_55_8 sky130_fd_pr_reram__reram_cell area_ox=0.0676
XMn_55_8 dn_55_8 WL55 SL8 VSS sky130_fd_pr__nfet_g5v0d10v5 w=1 l=0.5
XRn_55_8 BLN8 dn_55_8 sky130_fd_pr_reram__reram_cell area_ox=0.0676
XMp_55_9 dp_55_9 WL55 SL9 VSS sky130_fd_pr__nfet_g5v0d10v5 w=1 l=0.5
XRp_55_9 BLP9 dp_55_9 sky130_fd_pr_reram__reram_cell area_ox=0.0676
XMn_55_9 dn_55_9 WL55 SL9 VSS sky130_fd_pr__nfet_g5v0d10v5 w=1 l=0.5
XRn_55_9 BLN9 dn_55_9 sky130_fd_pr_reram__reram_cell area_ox=0.0676
XMp_55_10 dp_55_10 WL55 SL10 VSS sky130_fd_pr__nfet_g5v0d10v5 w=1 l=0.5
XRp_55_10 BLP10 dp_55_10 sky130_fd_pr_reram__reram_cell area_ox=0.0676
XMn_55_10 dn_55_10 WL55 SL10 VSS sky130_fd_pr__nfet_g5v0d10v5 w=1 l=0.5
XRn_55_10 BLN10 dn_55_10 sky130_fd_pr_reram__reram_cell area_ox=0.0676
XMp_55_11 dp_55_11 WL55 SL11 VSS sky130_fd_pr__nfet_g5v0d10v5 w=1 l=0.5
XRp_55_11 BLP11 dp_55_11 sky130_fd_pr_reram__reram_cell area_ox=0.0676
XMn_55_11 dn_55_11 WL55 SL11 VSS sky130_fd_pr__nfet_g5v0d10v5 w=1 l=0.5
XRn_55_11 BLN11 dn_55_11 sky130_fd_pr_reram__reram_cell area_ox=0.0676
XMp_55_12 dp_55_12 WL55 SL12 VSS sky130_fd_pr__nfet_g5v0d10v5 w=1 l=0.5
XRp_55_12 BLP12 dp_55_12 sky130_fd_pr_reram__reram_cell area_ox=0.0676
XMn_55_12 dn_55_12 WL55 SL12 VSS sky130_fd_pr__nfet_g5v0d10v5 w=1 l=0.5
XRn_55_12 BLN12 dn_55_12 sky130_fd_pr_reram__reram_cell area_ox=0.0676
XMp_55_13 dp_55_13 WL55 SL13 VSS sky130_fd_pr__nfet_g5v0d10v5 w=1 l=0.5
XRp_55_13 BLP13 dp_55_13 sky130_fd_pr_reram__reram_cell area_ox=0.0676
XMn_55_13 dn_55_13 WL55 SL13 VSS sky130_fd_pr__nfet_g5v0d10v5 w=1 l=0.5
XRn_55_13 BLN13 dn_55_13 sky130_fd_pr_reram__reram_cell area_ox=0.0676
XMp_55_14 dp_55_14 WL55 SL14 VSS sky130_fd_pr__nfet_g5v0d10v5 w=1 l=0.5
XRp_55_14 BLP14 dp_55_14 sky130_fd_pr_reram__reram_cell area_ox=0.0676
XMn_55_14 dn_55_14 WL55 SL14 VSS sky130_fd_pr__nfet_g5v0d10v5 w=1 l=0.5
XRn_55_14 BLN14 dn_55_14 sky130_fd_pr_reram__reram_cell area_ox=0.0676
XMp_55_15 dp_55_15 WL55 SL15 VSS sky130_fd_pr__nfet_g5v0d10v5 w=1 l=0.5
XRp_55_15 BLP15 dp_55_15 sky130_fd_pr_reram__reram_cell area_ox=0.0676
XMn_55_15 dn_55_15 WL55 SL15 VSS sky130_fd_pr__nfet_g5v0d10v5 w=1 l=0.5
XRn_55_15 BLN15 dn_55_15 sky130_fd_pr_reram__reram_cell area_ox=0.0676
XMp_55_16 dp_55_16 WL55 SL16 VSS sky130_fd_pr__nfet_g5v0d10v5 w=1 l=0.5
XRp_55_16 BLP16 dp_55_16 sky130_fd_pr_reram__reram_cell area_ox=0.0676
XMn_55_16 dn_55_16 WL55 SL16 VSS sky130_fd_pr__nfet_g5v0d10v5 w=1 l=0.5
XRn_55_16 BLN16 dn_55_16 sky130_fd_pr_reram__reram_cell area_ox=0.0676
XMp_55_17 dp_55_17 WL55 SL17 VSS sky130_fd_pr__nfet_g5v0d10v5 w=1 l=0.5
XRp_55_17 BLP17 dp_55_17 sky130_fd_pr_reram__reram_cell area_ox=0.0676
XMn_55_17 dn_55_17 WL55 SL17 VSS sky130_fd_pr__nfet_g5v0d10v5 w=1 l=0.5
XRn_55_17 BLN17 dn_55_17 sky130_fd_pr_reram__reram_cell area_ox=0.0676
XMp_55_18 dp_55_18 WL55 SL18 VSS sky130_fd_pr__nfet_g5v0d10v5 w=1 l=0.5
XRp_55_18 BLP18 dp_55_18 sky130_fd_pr_reram__reram_cell area_ox=0.0676
XMn_55_18 dn_55_18 WL55 SL18 VSS sky130_fd_pr__nfet_g5v0d10v5 w=1 l=0.5
XRn_55_18 BLN18 dn_55_18 sky130_fd_pr_reram__reram_cell area_ox=0.0676
XMp_55_19 dp_55_19 WL55 SL19 VSS sky130_fd_pr__nfet_g5v0d10v5 w=1 l=0.5
XRp_55_19 BLP19 dp_55_19 sky130_fd_pr_reram__reram_cell area_ox=0.0676
XMn_55_19 dn_55_19 WL55 SL19 VSS sky130_fd_pr__nfet_g5v0d10v5 w=1 l=0.5
XRn_55_19 BLN19 dn_55_19 sky130_fd_pr_reram__reram_cell area_ox=0.0676
XMp_55_20 dp_55_20 WL55 SL20 VSS sky130_fd_pr__nfet_g5v0d10v5 w=1 l=0.5
XRp_55_20 BLP20 dp_55_20 sky130_fd_pr_reram__reram_cell area_ox=0.0676
XMn_55_20 dn_55_20 WL55 SL20 VSS sky130_fd_pr__nfet_g5v0d10v5 w=1 l=0.5
XRn_55_20 BLN20 dn_55_20 sky130_fd_pr_reram__reram_cell area_ox=0.0676
XMp_55_21 dp_55_21 WL55 SL21 VSS sky130_fd_pr__nfet_g5v0d10v5 w=1 l=0.5
XRp_55_21 BLP21 dp_55_21 sky130_fd_pr_reram__reram_cell area_ox=0.0676
XMn_55_21 dn_55_21 WL55 SL21 VSS sky130_fd_pr__nfet_g5v0d10v5 w=1 l=0.5
XRn_55_21 BLN21 dn_55_21 sky130_fd_pr_reram__reram_cell area_ox=0.0676
XMp_55_22 dp_55_22 WL55 SL22 VSS sky130_fd_pr__nfet_g5v0d10v5 w=1 l=0.5
XRp_55_22 BLP22 dp_55_22 sky130_fd_pr_reram__reram_cell area_ox=0.0676
XMn_55_22 dn_55_22 WL55 SL22 VSS sky130_fd_pr__nfet_g5v0d10v5 w=1 l=0.5
XRn_55_22 BLN22 dn_55_22 sky130_fd_pr_reram__reram_cell area_ox=0.0676
XMp_55_23 dp_55_23 WL55 SL23 VSS sky130_fd_pr__nfet_g5v0d10v5 w=1 l=0.5
XRp_55_23 BLP23 dp_55_23 sky130_fd_pr_reram__reram_cell area_ox=0.0676
XMn_55_23 dn_55_23 WL55 SL23 VSS sky130_fd_pr__nfet_g5v0d10v5 w=1 l=0.5
XRn_55_23 BLN23 dn_55_23 sky130_fd_pr_reram__reram_cell area_ox=0.0676
XMp_56_0 dp_56_0 WL56 SL0 VSS sky130_fd_pr__nfet_g5v0d10v5 w=1 l=0.5
XRp_56_0 BLP0 dp_56_0 sky130_fd_pr_reram__reram_cell area_ox=0.0676
XMn_56_0 dn_56_0 WL56 SL0 VSS sky130_fd_pr__nfet_g5v0d10v5 w=1 l=0.5
XRn_56_0 BLN0 dn_56_0 sky130_fd_pr_reram__reram_cell area_ox=0.0676
XMp_56_1 dp_56_1 WL56 SL1 VSS sky130_fd_pr__nfet_g5v0d10v5 w=1 l=0.5
XRp_56_1 BLP1 dp_56_1 sky130_fd_pr_reram__reram_cell area_ox=0.0676
XMn_56_1 dn_56_1 WL56 SL1 VSS sky130_fd_pr__nfet_g5v0d10v5 w=1 l=0.5
XRn_56_1 BLN1 dn_56_1 sky130_fd_pr_reram__reram_cell area_ox=0.0676
XMp_56_2 dp_56_2 WL56 SL2 VSS sky130_fd_pr__nfet_g5v0d10v5 w=1 l=0.5
XRp_56_2 BLP2 dp_56_2 sky130_fd_pr_reram__reram_cell area_ox=0.0676
XMn_56_2 dn_56_2 WL56 SL2 VSS sky130_fd_pr__nfet_g5v0d10v5 w=1 l=0.5
XRn_56_2 BLN2 dn_56_2 sky130_fd_pr_reram__reram_cell area_ox=0.0676
XMp_56_3 dp_56_3 WL56 SL3 VSS sky130_fd_pr__nfet_g5v0d10v5 w=1 l=0.5
XRp_56_3 BLP3 dp_56_3 sky130_fd_pr_reram__reram_cell area_ox=0.0676
XMn_56_3 dn_56_3 WL56 SL3 VSS sky130_fd_pr__nfet_g5v0d10v5 w=1 l=0.5
XRn_56_3 BLN3 dn_56_3 sky130_fd_pr_reram__reram_cell area_ox=0.0676
XMp_56_4 dp_56_4 WL56 SL4 VSS sky130_fd_pr__nfet_g5v0d10v5 w=1 l=0.5
XRp_56_4 BLP4 dp_56_4 sky130_fd_pr_reram__reram_cell area_ox=0.0676
XMn_56_4 dn_56_4 WL56 SL4 VSS sky130_fd_pr__nfet_g5v0d10v5 w=1 l=0.5
XRn_56_4 BLN4 dn_56_4 sky130_fd_pr_reram__reram_cell area_ox=0.0676
XMp_56_5 dp_56_5 WL56 SL5 VSS sky130_fd_pr__nfet_g5v0d10v5 w=1 l=0.5
XRp_56_5 BLP5 dp_56_5 sky130_fd_pr_reram__reram_cell area_ox=0.0676
XMn_56_5 dn_56_5 WL56 SL5 VSS sky130_fd_pr__nfet_g5v0d10v5 w=1 l=0.5
XRn_56_5 BLN5 dn_56_5 sky130_fd_pr_reram__reram_cell area_ox=0.0676
XMp_56_6 dp_56_6 WL56 SL6 VSS sky130_fd_pr__nfet_g5v0d10v5 w=1 l=0.5
XRp_56_6 BLP6 dp_56_6 sky130_fd_pr_reram__reram_cell area_ox=0.0676
XMn_56_6 dn_56_6 WL56 SL6 VSS sky130_fd_pr__nfet_g5v0d10v5 w=1 l=0.5
XRn_56_6 BLN6 dn_56_6 sky130_fd_pr_reram__reram_cell area_ox=0.0676
XMp_56_7 dp_56_7 WL56 SL7 VSS sky130_fd_pr__nfet_g5v0d10v5 w=1 l=0.5
XRp_56_7 BLP7 dp_56_7 sky130_fd_pr_reram__reram_cell area_ox=0.0676
XMn_56_7 dn_56_7 WL56 SL7 VSS sky130_fd_pr__nfet_g5v0d10v5 w=1 l=0.5
XRn_56_7 BLN7 dn_56_7 sky130_fd_pr_reram__reram_cell area_ox=0.0676
XMp_56_8 dp_56_8 WL56 SL8 VSS sky130_fd_pr__nfet_g5v0d10v5 w=1 l=0.5
XRp_56_8 BLP8 dp_56_8 sky130_fd_pr_reram__reram_cell area_ox=0.0676
XMn_56_8 dn_56_8 WL56 SL8 VSS sky130_fd_pr__nfet_g5v0d10v5 w=1 l=0.5
XRn_56_8 BLN8 dn_56_8 sky130_fd_pr_reram__reram_cell area_ox=0.0676
XMp_56_9 dp_56_9 WL56 SL9 VSS sky130_fd_pr__nfet_g5v0d10v5 w=1 l=0.5
XRp_56_9 BLP9 dp_56_9 sky130_fd_pr_reram__reram_cell area_ox=0.0676
XMn_56_9 dn_56_9 WL56 SL9 VSS sky130_fd_pr__nfet_g5v0d10v5 w=1 l=0.5
XRn_56_9 BLN9 dn_56_9 sky130_fd_pr_reram__reram_cell area_ox=0.0676
XMp_56_10 dp_56_10 WL56 SL10 VSS sky130_fd_pr__nfet_g5v0d10v5 w=1 l=0.5
XRp_56_10 BLP10 dp_56_10 sky130_fd_pr_reram__reram_cell area_ox=0.0676
XMn_56_10 dn_56_10 WL56 SL10 VSS sky130_fd_pr__nfet_g5v0d10v5 w=1 l=0.5
XRn_56_10 BLN10 dn_56_10 sky130_fd_pr_reram__reram_cell area_ox=0.0676
XMp_56_11 dp_56_11 WL56 SL11 VSS sky130_fd_pr__nfet_g5v0d10v5 w=1 l=0.5
XRp_56_11 BLP11 dp_56_11 sky130_fd_pr_reram__reram_cell area_ox=0.0676
XMn_56_11 dn_56_11 WL56 SL11 VSS sky130_fd_pr__nfet_g5v0d10v5 w=1 l=0.5
XRn_56_11 BLN11 dn_56_11 sky130_fd_pr_reram__reram_cell area_ox=0.0676
XMp_56_12 dp_56_12 WL56 SL12 VSS sky130_fd_pr__nfet_g5v0d10v5 w=1 l=0.5
XRp_56_12 BLP12 dp_56_12 sky130_fd_pr_reram__reram_cell area_ox=0.0676
XMn_56_12 dn_56_12 WL56 SL12 VSS sky130_fd_pr__nfet_g5v0d10v5 w=1 l=0.5
XRn_56_12 BLN12 dn_56_12 sky130_fd_pr_reram__reram_cell area_ox=0.0676
XMp_56_13 dp_56_13 WL56 SL13 VSS sky130_fd_pr__nfet_g5v0d10v5 w=1 l=0.5
XRp_56_13 BLP13 dp_56_13 sky130_fd_pr_reram__reram_cell area_ox=0.0676
XMn_56_13 dn_56_13 WL56 SL13 VSS sky130_fd_pr__nfet_g5v0d10v5 w=1 l=0.5
XRn_56_13 BLN13 dn_56_13 sky130_fd_pr_reram__reram_cell area_ox=0.0676
XMp_56_14 dp_56_14 WL56 SL14 VSS sky130_fd_pr__nfet_g5v0d10v5 w=1 l=0.5
XRp_56_14 BLP14 dp_56_14 sky130_fd_pr_reram__reram_cell area_ox=0.0676
XMn_56_14 dn_56_14 WL56 SL14 VSS sky130_fd_pr__nfet_g5v0d10v5 w=1 l=0.5
XRn_56_14 BLN14 dn_56_14 sky130_fd_pr_reram__reram_cell area_ox=0.0676
XMp_56_15 dp_56_15 WL56 SL15 VSS sky130_fd_pr__nfet_g5v0d10v5 w=1 l=0.5
XRp_56_15 BLP15 dp_56_15 sky130_fd_pr_reram__reram_cell area_ox=0.0676
XMn_56_15 dn_56_15 WL56 SL15 VSS sky130_fd_pr__nfet_g5v0d10v5 w=1 l=0.5
XRn_56_15 BLN15 dn_56_15 sky130_fd_pr_reram__reram_cell area_ox=0.0676
XMp_56_16 dp_56_16 WL56 SL16 VSS sky130_fd_pr__nfet_g5v0d10v5 w=1 l=0.5
XRp_56_16 BLP16 dp_56_16 sky130_fd_pr_reram__reram_cell area_ox=0.0676
XMn_56_16 dn_56_16 WL56 SL16 VSS sky130_fd_pr__nfet_g5v0d10v5 w=1 l=0.5
XRn_56_16 BLN16 dn_56_16 sky130_fd_pr_reram__reram_cell area_ox=0.0676
XMp_56_17 dp_56_17 WL56 SL17 VSS sky130_fd_pr__nfet_g5v0d10v5 w=1 l=0.5
XRp_56_17 BLP17 dp_56_17 sky130_fd_pr_reram__reram_cell area_ox=0.0676
XMn_56_17 dn_56_17 WL56 SL17 VSS sky130_fd_pr__nfet_g5v0d10v5 w=1 l=0.5
XRn_56_17 BLN17 dn_56_17 sky130_fd_pr_reram__reram_cell area_ox=0.0676
XMp_56_18 dp_56_18 WL56 SL18 VSS sky130_fd_pr__nfet_g5v0d10v5 w=1 l=0.5
XRp_56_18 BLP18 dp_56_18 sky130_fd_pr_reram__reram_cell area_ox=0.0676
XMn_56_18 dn_56_18 WL56 SL18 VSS sky130_fd_pr__nfet_g5v0d10v5 w=1 l=0.5
XRn_56_18 BLN18 dn_56_18 sky130_fd_pr_reram__reram_cell area_ox=0.0676
XMp_56_19 dp_56_19 WL56 SL19 VSS sky130_fd_pr__nfet_g5v0d10v5 w=1 l=0.5
XRp_56_19 BLP19 dp_56_19 sky130_fd_pr_reram__reram_cell area_ox=0.0676
XMn_56_19 dn_56_19 WL56 SL19 VSS sky130_fd_pr__nfet_g5v0d10v5 w=1 l=0.5
XRn_56_19 BLN19 dn_56_19 sky130_fd_pr_reram__reram_cell area_ox=0.0676
XMp_56_20 dp_56_20 WL56 SL20 VSS sky130_fd_pr__nfet_g5v0d10v5 w=1 l=0.5
XRp_56_20 BLP20 dp_56_20 sky130_fd_pr_reram__reram_cell area_ox=0.0676
XMn_56_20 dn_56_20 WL56 SL20 VSS sky130_fd_pr__nfet_g5v0d10v5 w=1 l=0.5
XRn_56_20 BLN20 dn_56_20 sky130_fd_pr_reram__reram_cell area_ox=0.0676
XMp_56_21 dp_56_21 WL56 SL21 VSS sky130_fd_pr__nfet_g5v0d10v5 w=1 l=0.5
XRp_56_21 BLP21 dp_56_21 sky130_fd_pr_reram__reram_cell area_ox=0.0676
XMn_56_21 dn_56_21 WL56 SL21 VSS sky130_fd_pr__nfet_g5v0d10v5 w=1 l=0.5
XRn_56_21 BLN21 dn_56_21 sky130_fd_pr_reram__reram_cell area_ox=0.0676
XMp_56_22 dp_56_22 WL56 SL22 VSS sky130_fd_pr__nfet_g5v0d10v5 w=1 l=0.5
XRp_56_22 BLP22 dp_56_22 sky130_fd_pr_reram__reram_cell area_ox=0.0676
XMn_56_22 dn_56_22 WL56 SL22 VSS sky130_fd_pr__nfet_g5v0d10v5 w=1 l=0.5
XRn_56_22 BLN22 dn_56_22 sky130_fd_pr_reram__reram_cell area_ox=0.0676
XMp_56_23 dp_56_23 WL56 SL23 VSS sky130_fd_pr__nfet_g5v0d10v5 w=1 l=0.5
XRp_56_23 BLP23 dp_56_23 sky130_fd_pr_reram__reram_cell area_ox=0.0676
XMn_56_23 dn_56_23 WL56 SL23 VSS sky130_fd_pr__nfet_g5v0d10v5 w=1 l=0.5
XRn_56_23 BLN23 dn_56_23 sky130_fd_pr_reram__reram_cell area_ox=0.0676
XMp_57_0 dp_57_0 WL57 SL0 VSS sky130_fd_pr__nfet_g5v0d10v5 w=1 l=0.5
XRp_57_0 BLP0 dp_57_0 sky130_fd_pr_reram__reram_cell area_ox=0.0676
XMn_57_0 dn_57_0 WL57 SL0 VSS sky130_fd_pr__nfet_g5v0d10v5 w=1 l=0.5
XRn_57_0 BLN0 dn_57_0 sky130_fd_pr_reram__reram_cell area_ox=0.0676
XMp_57_1 dp_57_1 WL57 SL1 VSS sky130_fd_pr__nfet_g5v0d10v5 w=1 l=0.5
XRp_57_1 BLP1 dp_57_1 sky130_fd_pr_reram__reram_cell area_ox=0.0676
XMn_57_1 dn_57_1 WL57 SL1 VSS sky130_fd_pr__nfet_g5v0d10v5 w=1 l=0.5
XRn_57_1 BLN1 dn_57_1 sky130_fd_pr_reram__reram_cell area_ox=0.0676
XMp_57_2 dp_57_2 WL57 SL2 VSS sky130_fd_pr__nfet_g5v0d10v5 w=1 l=0.5
XRp_57_2 BLP2 dp_57_2 sky130_fd_pr_reram__reram_cell area_ox=0.0676
XMn_57_2 dn_57_2 WL57 SL2 VSS sky130_fd_pr__nfet_g5v0d10v5 w=1 l=0.5
XRn_57_2 BLN2 dn_57_2 sky130_fd_pr_reram__reram_cell area_ox=0.0676
XMp_57_3 dp_57_3 WL57 SL3 VSS sky130_fd_pr__nfet_g5v0d10v5 w=1 l=0.5
XRp_57_3 BLP3 dp_57_3 sky130_fd_pr_reram__reram_cell area_ox=0.0676
XMn_57_3 dn_57_3 WL57 SL3 VSS sky130_fd_pr__nfet_g5v0d10v5 w=1 l=0.5
XRn_57_3 BLN3 dn_57_3 sky130_fd_pr_reram__reram_cell area_ox=0.0676
XMp_57_4 dp_57_4 WL57 SL4 VSS sky130_fd_pr__nfet_g5v0d10v5 w=1 l=0.5
XRp_57_4 BLP4 dp_57_4 sky130_fd_pr_reram__reram_cell area_ox=0.0676
XMn_57_4 dn_57_4 WL57 SL4 VSS sky130_fd_pr__nfet_g5v0d10v5 w=1 l=0.5
XRn_57_4 BLN4 dn_57_4 sky130_fd_pr_reram__reram_cell area_ox=0.0676
XMp_57_5 dp_57_5 WL57 SL5 VSS sky130_fd_pr__nfet_g5v0d10v5 w=1 l=0.5
XRp_57_5 BLP5 dp_57_5 sky130_fd_pr_reram__reram_cell area_ox=0.0676
XMn_57_5 dn_57_5 WL57 SL5 VSS sky130_fd_pr__nfet_g5v0d10v5 w=1 l=0.5
XRn_57_5 BLN5 dn_57_5 sky130_fd_pr_reram__reram_cell area_ox=0.0676
XMp_57_6 dp_57_6 WL57 SL6 VSS sky130_fd_pr__nfet_g5v0d10v5 w=1 l=0.5
XRp_57_6 BLP6 dp_57_6 sky130_fd_pr_reram__reram_cell area_ox=0.0676
XMn_57_6 dn_57_6 WL57 SL6 VSS sky130_fd_pr__nfet_g5v0d10v5 w=1 l=0.5
XRn_57_6 BLN6 dn_57_6 sky130_fd_pr_reram__reram_cell area_ox=0.0676
XMp_57_7 dp_57_7 WL57 SL7 VSS sky130_fd_pr__nfet_g5v0d10v5 w=1 l=0.5
XRp_57_7 BLP7 dp_57_7 sky130_fd_pr_reram__reram_cell area_ox=0.0676
XMn_57_7 dn_57_7 WL57 SL7 VSS sky130_fd_pr__nfet_g5v0d10v5 w=1 l=0.5
XRn_57_7 BLN7 dn_57_7 sky130_fd_pr_reram__reram_cell area_ox=0.0676
XMp_57_8 dp_57_8 WL57 SL8 VSS sky130_fd_pr__nfet_g5v0d10v5 w=1 l=0.5
XRp_57_8 BLP8 dp_57_8 sky130_fd_pr_reram__reram_cell area_ox=0.0676
XMn_57_8 dn_57_8 WL57 SL8 VSS sky130_fd_pr__nfet_g5v0d10v5 w=1 l=0.5
XRn_57_8 BLN8 dn_57_8 sky130_fd_pr_reram__reram_cell area_ox=0.0676
XMp_57_9 dp_57_9 WL57 SL9 VSS sky130_fd_pr__nfet_g5v0d10v5 w=1 l=0.5
XRp_57_9 BLP9 dp_57_9 sky130_fd_pr_reram__reram_cell area_ox=0.0676
XMn_57_9 dn_57_9 WL57 SL9 VSS sky130_fd_pr__nfet_g5v0d10v5 w=1 l=0.5
XRn_57_9 BLN9 dn_57_9 sky130_fd_pr_reram__reram_cell area_ox=0.0676
XMp_57_10 dp_57_10 WL57 SL10 VSS sky130_fd_pr__nfet_g5v0d10v5 w=1 l=0.5
XRp_57_10 BLP10 dp_57_10 sky130_fd_pr_reram__reram_cell area_ox=0.0676
XMn_57_10 dn_57_10 WL57 SL10 VSS sky130_fd_pr__nfet_g5v0d10v5 w=1 l=0.5
XRn_57_10 BLN10 dn_57_10 sky130_fd_pr_reram__reram_cell area_ox=0.0676
XMp_57_11 dp_57_11 WL57 SL11 VSS sky130_fd_pr__nfet_g5v0d10v5 w=1 l=0.5
XRp_57_11 BLP11 dp_57_11 sky130_fd_pr_reram__reram_cell area_ox=0.0676
XMn_57_11 dn_57_11 WL57 SL11 VSS sky130_fd_pr__nfet_g5v0d10v5 w=1 l=0.5
XRn_57_11 BLN11 dn_57_11 sky130_fd_pr_reram__reram_cell area_ox=0.0676
XMp_57_12 dp_57_12 WL57 SL12 VSS sky130_fd_pr__nfet_g5v0d10v5 w=1 l=0.5
XRp_57_12 BLP12 dp_57_12 sky130_fd_pr_reram__reram_cell area_ox=0.0676
XMn_57_12 dn_57_12 WL57 SL12 VSS sky130_fd_pr__nfet_g5v0d10v5 w=1 l=0.5
XRn_57_12 BLN12 dn_57_12 sky130_fd_pr_reram__reram_cell area_ox=0.0676
XMp_57_13 dp_57_13 WL57 SL13 VSS sky130_fd_pr__nfet_g5v0d10v5 w=1 l=0.5
XRp_57_13 BLP13 dp_57_13 sky130_fd_pr_reram__reram_cell area_ox=0.0676
XMn_57_13 dn_57_13 WL57 SL13 VSS sky130_fd_pr__nfet_g5v0d10v5 w=1 l=0.5
XRn_57_13 BLN13 dn_57_13 sky130_fd_pr_reram__reram_cell area_ox=0.0676
XMp_57_14 dp_57_14 WL57 SL14 VSS sky130_fd_pr__nfet_g5v0d10v5 w=1 l=0.5
XRp_57_14 BLP14 dp_57_14 sky130_fd_pr_reram__reram_cell area_ox=0.0676
XMn_57_14 dn_57_14 WL57 SL14 VSS sky130_fd_pr__nfet_g5v0d10v5 w=1 l=0.5
XRn_57_14 BLN14 dn_57_14 sky130_fd_pr_reram__reram_cell area_ox=0.0676
XMp_57_15 dp_57_15 WL57 SL15 VSS sky130_fd_pr__nfet_g5v0d10v5 w=1 l=0.5
XRp_57_15 BLP15 dp_57_15 sky130_fd_pr_reram__reram_cell area_ox=0.0676
XMn_57_15 dn_57_15 WL57 SL15 VSS sky130_fd_pr__nfet_g5v0d10v5 w=1 l=0.5
XRn_57_15 BLN15 dn_57_15 sky130_fd_pr_reram__reram_cell area_ox=0.0676
XMp_57_16 dp_57_16 WL57 SL16 VSS sky130_fd_pr__nfet_g5v0d10v5 w=1 l=0.5
XRp_57_16 BLP16 dp_57_16 sky130_fd_pr_reram__reram_cell area_ox=0.0676
XMn_57_16 dn_57_16 WL57 SL16 VSS sky130_fd_pr__nfet_g5v0d10v5 w=1 l=0.5
XRn_57_16 BLN16 dn_57_16 sky130_fd_pr_reram__reram_cell area_ox=0.0676
XMp_57_17 dp_57_17 WL57 SL17 VSS sky130_fd_pr__nfet_g5v0d10v5 w=1 l=0.5
XRp_57_17 BLP17 dp_57_17 sky130_fd_pr_reram__reram_cell area_ox=0.0676
XMn_57_17 dn_57_17 WL57 SL17 VSS sky130_fd_pr__nfet_g5v0d10v5 w=1 l=0.5
XRn_57_17 BLN17 dn_57_17 sky130_fd_pr_reram__reram_cell area_ox=0.0676
XMp_57_18 dp_57_18 WL57 SL18 VSS sky130_fd_pr__nfet_g5v0d10v5 w=1 l=0.5
XRp_57_18 BLP18 dp_57_18 sky130_fd_pr_reram__reram_cell area_ox=0.0676
XMn_57_18 dn_57_18 WL57 SL18 VSS sky130_fd_pr__nfet_g5v0d10v5 w=1 l=0.5
XRn_57_18 BLN18 dn_57_18 sky130_fd_pr_reram__reram_cell area_ox=0.0676
XMp_57_19 dp_57_19 WL57 SL19 VSS sky130_fd_pr__nfet_g5v0d10v5 w=1 l=0.5
XRp_57_19 BLP19 dp_57_19 sky130_fd_pr_reram__reram_cell area_ox=0.0676
XMn_57_19 dn_57_19 WL57 SL19 VSS sky130_fd_pr__nfet_g5v0d10v5 w=1 l=0.5
XRn_57_19 BLN19 dn_57_19 sky130_fd_pr_reram__reram_cell area_ox=0.0676
XMp_57_20 dp_57_20 WL57 SL20 VSS sky130_fd_pr__nfet_g5v0d10v5 w=1 l=0.5
XRp_57_20 BLP20 dp_57_20 sky130_fd_pr_reram__reram_cell area_ox=0.0676
XMn_57_20 dn_57_20 WL57 SL20 VSS sky130_fd_pr__nfet_g5v0d10v5 w=1 l=0.5
XRn_57_20 BLN20 dn_57_20 sky130_fd_pr_reram__reram_cell area_ox=0.0676
XMp_57_21 dp_57_21 WL57 SL21 VSS sky130_fd_pr__nfet_g5v0d10v5 w=1 l=0.5
XRp_57_21 BLP21 dp_57_21 sky130_fd_pr_reram__reram_cell area_ox=0.0676
XMn_57_21 dn_57_21 WL57 SL21 VSS sky130_fd_pr__nfet_g5v0d10v5 w=1 l=0.5
XRn_57_21 BLN21 dn_57_21 sky130_fd_pr_reram__reram_cell area_ox=0.0676
XMp_57_22 dp_57_22 WL57 SL22 VSS sky130_fd_pr__nfet_g5v0d10v5 w=1 l=0.5
XRp_57_22 BLP22 dp_57_22 sky130_fd_pr_reram__reram_cell area_ox=0.0676
XMn_57_22 dn_57_22 WL57 SL22 VSS sky130_fd_pr__nfet_g5v0d10v5 w=1 l=0.5
XRn_57_22 BLN22 dn_57_22 sky130_fd_pr_reram__reram_cell area_ox=0.0676
XMp_57_23 dp_57_23 WL57 SL23 VSS sky130_fd_pr__nfet_g5v0d10v5 w=1 l=0.5
XRp_57_23 BLP23 dp_57_23 sky130_fd_pr_reram__reram_cell area_ox=0.0676
XMn_57_23 dn_57_23 WL57 SL23 VSS sky130_fd_pr__nfet_g5v0d10v5 w=1 l=0.5
XRn_57_23 BLN23 dn_57_23 sky130_fd_pr_reram__reram_cell area_ox=0.0676
XMp_58_0 dp_58_0 WL58 SL0 VSS sky130_fd_pr__nfet_g5v0d10v5 w=1 l=0.5
XRp_58_0 BLP0 dp_58_0 sky130_fd_pr_reram__reram_cell area_ox=0.0676
XMn_58_0 dn_58_0 WL58 SL0 VSS sky130_fd_pr__nfet_g5v0d10v5 w=1 l=0.5
XRn_58_0 BLN0 dn_58_0 sky130_fd_pr_reram__reram_cell area_ox=0.0676
XMp_58_1 dp_58_1 WL58 SL1 VSS sky130_fd_pr__nfet_g5v0d10v5 w=1 l=0.5
XRp_58_1 BLP1 dp_58_1 sky130_fd_pr_reram__reram_cell area_ox=0.0676
XMn_58_1 dn_58_1 WL58 SL1 VSS sky130_fd_pr__nfet_g5v0d10v5 w=1 l=0.5
XRn_58_1 BLN1 dn_58_1 sky130_fd_pr_reram__reram_cell area_ox=0.0676
XMp_58_2 dp_58_2 WL58 SL2 VSS sky130_fd_pr__nfet_g5v0d10v5 w=1 l=0.5
XRp_58_2 BLP2 dp_58_2 sky130_fd_pr_reram__reram_cell area_ox=0.0676
XMn_58_2 dn_58_2 WL58 SL2 VSS sky130_fd_pr__nfet_g5v0d10v5 w=1 l=0.5
XRn_58_2 BLN2 dn_58_2 sky130_fd_pr_reram__reram_cell area_ox=0.0676
XMp_58_3 dp_58_3 WL58 SL3 VSS sky130_fd_pr__nfet_g5v0d10v5 w=1 l=0.5
XRp_58_3 BLP3 dp_58_3 sky130_fd_pr_reram__reram_cell area_ox=0.0676
XMn_58_3 dn_58_3 WL58 SL3 VSS sky130_fd_pr__nfet_g5v0d10v5 w=1 l=0.5
XRn_58_3 BLN3 dn_58_3 sky130_fd_pr_reram__reram_cell area_ox=0.0676
XMp_58_4 dp_58_4 WL58 SL4 VSS sky130_fd_pr__nfet_g5v0d10v5 w=1 l=0.5
XRp_58_4 BLP4 dp_58_4 sky130_fd_pr_reram__reram_cell area_ox=0.0676
XMn_58_4 dn_58_4 WL58 SL4 VSS sky130_fd_pr__nfet_g5v0d10v5 w=1 l=0.5
XRn_58_4 BLN4 dn_58_4 sky130_fd_pr_reram__reram_cell area_ox=0.0676
XMp_58_5 dp_58_5 WL58 SL5 VSS sky130_fd_pr__nfet_g5v0d10v5 w=1 l=0.5
XRp_58_5 BLP5 dp_58_5 sky130_fd_pr_reram__reram_cell area_ox=0.0676
XMn_58_5 dn_58_5 WL58 SL5 VSS sky130_fd_pr__nfet_g5v0d10v5 w=1 l=0.5
XRn_58_5 BLN5 dn_58_5 sky130_fd_pr_reram__reram_cell area_ox=0.0676
XMp_58_6 dp_58_6 WL58 SL6 VSS sky130_fd_pr__nfet_g5v0d10v5 w=1 l=0.5
XRp_58_6 BLP6 dp_58_6 sky130_fd_pr_reram__reram_cell area_ox=0.0676
XMn_58_6 dn_58_6 WL58 SL6 VSS sky130_fd_pr__nfet_g5v0d10v5 w=1 l=0.5
XRn_58_6 BLN6 dn_58_6 sky130_fd_pr_reram__reram_cell area_ox=0.0676
XMp_58_7 dp_58_7 WL58 SL7 VSS sky130_fd_pr__nfet_g5v0d10v5 w=1 l=0.5
XRp_58_7 BLP7 dp_58_7 sky130_fd_pr_reram__reram_cell area_ox=0.0676
XMn_58_7 dn_58_7 WL58 SL7 VSS sky130_fd_pr__nfet_g5v0d10v5 w=1 l=0.5
XRn_58_7 BLN7 dn_58_7 sky130_fd_pr_reram__reram_cell area_ox=0.0676
XMp_58_8 dp_58_8 WL58 SL8 VSS sky130_fd_pr__nfet_g5v0d10v5 w=1 l=0.5
XRp_58_8 BLP8 dp_58_8 sky130_fd_pr_reram__reram_cell area_ox=0.0676
XMn_58_8 dn_58_8 WL58 SL8 VSS sky130_fd_pr__nfet_g5v0d10v5 w=1 l=0.5
XRn_58_8 BLN8 dn_58_8 sky130_fd_pr_reram__reram_cell area_ox=0.0676
XMp_58_9 dp_58_9 WL58 SL9 VSS sky130_fd_pr__nfet_g5v0d10v5 w=1 l=0.5
XRp_58_9 BLP9 dp_58_9 sky130_fd_pr_reram__reram_cell area_ox=0.0676
XMn_58_9 dn_58_9 WL58 SL9 VSS sky130_fd_pr__nfet_g5v0d10v5 w=1 l=0.5
XRn_58_9 BLN9 dn_58_9 sky130_fd_pr_reram__reram_cell area_ox=0.0676
XMp_58_10 dp_58_10 WL58 SL10 VSS sky130_fd_pr__nfet_g5v0d10v5 w=1 l=0.5
XRp_58_10 BLP10 dp_58_10 sky130_fd_pr_reram__reram_cell area_ox=0.0676
XMn_58_10 dn_58_10 WL58 SL10 VSS sky130_fd_pr__nfet_g5v0d10v5 w=1 l=0.5
XRn_58_10 BLN10 dn_58_10 sky130_fd_pr_reram__reram_cell area_ox=0.0676
XMp_58_11 dp_58_11 WL58 SL11 VSS sky130_fd_pr__nfet_g5v0d10v5 w=1 l=0.5
XRp_58_11 BLP11 dp_58_11 sky130_fd_pr_reram__reram_cell area_ox=0.0676
XMn_58_11 dn_58_11 WL58 SL11 VSS sky130_fd_pr__nfet_g5v0d10v5 w=1 l=0.5
XRn_58_11 BLN11 dn_58_11 sky130_fd_pr_reram__reram_cell area_ox=0.0676
XMp_58_12 dp_58_12 WL58 SL12 VSS sky130_fd_pr__nfet_g5v0d10v5 w=1 l=0.5
XRp_58_12 BLP12 dp_58_12 sky130_fd_pr_reram__reram_cell area_ox=0.0676
XMn_58_12 dn_58_12 WL58 SL12 VSS sky130_fd_pr__nfet_g5v0d10v5 w=1 l=0.5
XRn_58_12 BLN12 dn_58_12 sky130_fd_pr_reram__reram_cell area_ox=0.0676
XMp_58_13 dp_58_13 WL58 SL13 VSS sky130_fd_pr__nfet_g5v0d10v5 w=1 l=0.5
XRp_58_13 BLP13 dp_58_13 sky130_fd_pr_reram__reram_cell area_ox=0.0676
XMn_58_13 dn_58_13 WL58 SL13 VSS sky130_fd_pr__nfet_g5v0d10v5 w=1 l=0.5
XRn_58_13 BLN13 dn_58_13 sky130_fd_pr_reram__reram_cell area_ox=0.0676
XMp_58_14 dp_58_14 WL58 SL14 VSS sky130_fd_pr__nfet_g5v0d10v5 w=1 l=0.5
XRp_58_14 BLP14 dp_58_14 sky130_fd_pr_reram__reram_cell area_ox=0.0676
XMn_58_14 dn_58_14 WL58 SL14 VSS sky130_fd_pr__nfet_g5v0d10v5 w=1 l=0.5
XRn_58_14 BLN14 dn_58_14 sky130_fd_pr_reram__reram_cell area_ox=0.0676
XMp_58_15 dp_58_15 WL58 SL15 VSS sky130_fd_pr__nfet_g5v0d10v5 w=1 l=0.5
XRp_58_15 BLP15 dp_58_15 sky130_fd_pr_reram__reram_cell area_ox=0.0676
XMn_58_15 dn_58_15 WL58 SL15 VSS sky130_fd_pr__nfet_g5v0d10v5 w=1 l=0.5
XRn_58_15 BLN15 dn_58_15 sky130_fd_pr_reram__reram_cell area_ox=0.0676
XMp_58_16 dp_58_16 WL58 SL16 VSS sky130_fd_pr__nfet_g5v0d10v5 w=1 l=0.5
XRp_58_16 BLP16 dp_58_16 sky130_fd_pr_reram__reram_cell area_ox=0.0676
XMn_58_16 dn_58_16 WL58 SL16 VSS sky130_fd_pr__nfet_g5v0d10v5 w=1 l=0.5
XRn_58_16 BLN16 dn_58_16 sky130_fd_pr_reram__reram_cell area_ox=0.0676
XMp_58_17 dp_58_17 WL58 SL17 VSS sky130_fd_pr__nfet_g5v0d10v5 w=1 l=0.5
XRp_58_17 BLP17 dp_58_17 sky130_fd_pr_reram__reram_cell area_ox=0.0676
XMn_58_17 dn_58_17 WL58 SL17 VSS sky130_fd_pr__nfet_g5v0d10v5 w=1 l=0.5
XRn_58_17 BLN17 dn_58_17 sky130_fd_pr_reram__reram_cell area_ox=0.0676
XMp_58_18 dp_58_18 WL58 SL18 VSS sky130_fd_pr__nfet_g5v0d10v5 w=1 l=0.5
XRp_58_18 BLP18 dp_58_18 sky130_fd_pr_reram__reram_cell area_ox=0.0676
XMn_58_18 dn_58_18 WL58 SL18 VSS sky130_fd_pr__nfet_g5v0d10v5 w=1 l=0.5
XRn_58_18 BLN18 dn_58_18 sky130_fd_pr_reram__reram_cell area_ox=0.0676
XMp_58_19 dp_58_19 WL58 SL19 VSS sky130_fd_pr__nfet_g5v0d10v5 w=1 l=0.5
XRp_58_19 BLP19 dp_58_19 sky130_fd_pr_reram__reram_cell area_ox=0.0676
XMn_58_19 dn_58_19 WL58 SL19 VSS sky130_fd_pr__nfet_g5v0d10v5 w=1 l=0.5
XRn_58_19 BLN19 dn_58_19 sky130_fd_pr_reram__reram_cell area_ox=0.0676
XMp_58_20 dp_58_20 WL58 SL20 VSS sky130_fd_pr__nfet_g5v0d10v5 w=1 l=0.5
XRp_58_20 BLP20 dp_58_20 sky130_fd_pr_reram__reram_cell area_ox=0.0676
XMn_58_20 dn_58_20 WL58 SL20 VSS sky130_fd_pr__nfet_g5v0d10v5 w=1 l=0.5
XRn_58_20 BLN20 dn_58_20 sky130_fd_pr_reram__reram_cell area_ox=0.0676
XMp_58_21 dp_58_21 WL58 SL21 VSS sky130_fd_pr__nfet_g5v0d10v5 w=1 l=0.5
XRp_58_21 BLP21 dp_58_21 sky130_fd_pr_reram__reram_cell area_ox=0.0676
XMn_58_21 dn_58_21 WL58 SL21 VSS sky130_fd_pr__nfet_g5v0d10v5 w=1 l=0.5
XRn_58_21 BLN21 dn_58_21 sky130_fd_pr_reram__reram_cell area_ox=0.0676
XMp_58_22 dp_58_22 WL58 SL22 VSS sky130_fd_pr__nfet_g5v0d10v5 w=1 l=0.5
XRp_58_22 BLP22 dp_58_22 sky130_fd_pr_reram__reram_cell area_ox=0.0676
XMn_58_22 dn_58_22 WL58 SL22 VSS sky130_fd_pr__nfet_g5v0d10v5 w=1 l=0.5
XRn_58_22 BLN22 dn_58_22 sky130_fd_pr_reram__reram_cell area_ox=0.0676
XMp_58_23 dp_58_23 WL58 SL23 VSS sky130_fd_pr__nfet_g5v0d10v5 w=1 l=0.5
XRp_58_23 BLP23 dp_58_23 sky130_fd_pr_reram__reram_cell area_ox=0.0676
XMn_58_23 dn_58_23 WL58 SL23 VSS sky130_fd_pr__nfet_g5v0d10v5 w=1 l=0.5
XRn_58_23 BLN23 dn_58_23 sky130_fd_pr_reram__reram_cell area_ox=0.0676
XMp_59_0 dp_59_0 WL59 SL0 VSS sky130_fd_pr__nfet_g5v0d10v5 w=1 l=0.5
XRp_59_0 BLP0 dp_59_0 sky130_fd_pr_reram__reram_cell area_ox=0.0676
XMn_59_0 dn_59_0 WL59 SL0 VSS sky130_fd_pr__nfet_g5v0d10v5 w=1 l=0.5
XRn_59_0 BLN0 dn_59_0 sky130_fd_pr_reram__reram_cell area_ox=0.0676
XMp_59_1 dp_59_1 WL59 SL1 VSS sky130_fd_pr__nfet_g5v0d10v5 w=1 l=0.5
XRp_59_1 BLP1 dp_59_1 sky130_fd_pr_reram__reram_cell area_ox=0.0676
XMn_59_1 dn_59_1 WL59 SL1 VSS sky130_fd_pr__nfet_g5v0d10v5 w=1 l=0.5
XRn_59_1 BLN1 dn_59_1 sky130_fd_pr_reram__reram_cell area_ox=0.0676
XMp_59_2 dp_59_2 WL59 SL2 VSS sky130_fd_pr__nfet_g5v0d10v5 w=1 l=0.5
XRp_59_2 BLP2 dp_59_2 sky130_fd_pr_reram__reram_cell area_ox=0.0676
XMn_59_2 dn_59_2 WL59 SL2 VSS sky130_fd_pr__nfet_g5v0d10v5 w=1 l=0.5
XRn_59_2 BLN2 dn_59_2 sky130_fd_pr_reram__reram_cell area_ox=0.0676
XMp_59_3 dp_59_3 WL59 SL3 VSS sky130_fd_pr__nfet_g5v0d10v5 w=1 l=0.5
XRp_59_3 BLP3 dp_59_3 sky130_fd_pr_reram__reram_cell area_ox=0.0676
XMn_59_3 dn_59_3 WL59 SL3 VSS sky130_fd_pr__nfet_g5v0d10v5 w=1 l=0.5
XRn_59_3 BLN3 dn_59_3 sky130_fd_pr_reram__reram_cell area_ox=0.0676
XMp_59_4 dp_59_4 WL59 SL4 VSS sky130_fd_pr__nfet_g5v0d10v5 w=1 l=0.5
XRp_59_4 BLP4 dp_59_4 sky130_fd_pr_reram__reram_cell area_ox=0.0676
XMn_59_4 dn_59_4 WL59 SL4 VSS sky130_fd_pr__nfet_g5v0d10v5 w=1 l=0.5
XRn_59_4 BLN4 dn_59_4 sky130_fd_pr_reram__reram_cell area_ox=0.0676
XMp_59_5 dp_59_5 WL59 SL5 VSS sky130_fd_pr__nfet_g5v0d10v5 w=1 l=0.5
XRp_59_5 BLP5 dp_59_5 sky130_fd_pr_reram__reram_cell area_ox=0.0676
XMn_59_5 dn_59_5 WL59 SL5 VSS sky130_fd_pr__nfet_g5v0d10v5 w=1 l=0.5
XRn_59_5 BLN5 dn_59_5 sky130_fd_pr_reram__reram_cell area_ox=0.0676
XMp_59_6 dp_59_6 WL59 SL6 VSS sky130_fd_pr__nfet_g5v0d10v5 w=1 l=0.5
XRp_59_6 BLP6 dp_59_6 sky130_fd_pr_reram__reram_cell area_ox=0.0676
XMn_59_6 dn_59_6 WL59 SL6 VSS sky130_fd_pr__nfet_g5v0d10v5 w=1 l=0.5
XRn_59_6 BLN6 dn_59_6 sky130_fd_pr_reram__reram_cell area_ox=0.0676
XMp_59_7 dp_59_7 WL59 SL7 VSS sky130_fd_pr__nfet_g5v0d10v5 w=1 l=0.5
XRp_59_7 BLP7 dp_59_7 sky130_fd_pr_reram__reram_cell area_ox=0.0676
XMn_59_7 dn_59_7 WL59 SL7 VSS sky130_fd_pr__nfet_g5v0d10v5 w=1 l=0.5
XRn_59_7 BLN7 dn_59_7 sky130_fd_pr_reram__reram_cell area_ox=0.0676
XMp_59_8 dp_59_8 WL59 SL8 VSS sky130_fd_pr__nfet_g5v0d10v5 w=1 l=0.5
XRp_59_8 BLP8 dp_59_8 sky130_fd_pr_reram__reram_cell area_ox=0.0676
XMn_59_8 dn_59_8 WL59 SL8 VSS sky130_fd_pr__nfet_g5v0d10v5 w=1 l=0.5
XRn_59_8 BLN8 dn_59_8 sky130_fd_pr_reram__reram_cell area_ox=0.0676
XMp_59_9 dp_59_9 WL59 SL9 VSS sky130_fd_pr__nfet_g5v0d10v5 w=1 l=0.5
XRp_59_9 BLP9 dp_59_9 sky130_fd_pr_reram__reram_cell area_ox=0.0676
XMn_59_9 dn_59_9 WL59 SL9 VSS sky130_fd_pr__nfet_g5v0d10v5 w=1 l=0.5
XRn_59_9 BLN9 dn_59_9 sky130_fd_pr_reram__reram_cell area_ox=0.0676
XMp_59_10 dp_59_10 WL59 SL10 VSS sky130_fd_pr__nfet_g5v0d10v5 w=1 l=0.5
XRp_59_10 BLP10 dp_59_10 sky130_fd_pr_reram__reram_cell area_ox=0.0676
XMn_59_10 dn_59_10 WL59 SL10 VSS sky130_fd_pr__nfet_g5v0d10v5 w=1 l=0.5
XRn_59_10 BLN10 dn_59_10 sky130_fd_pr_reram__reram_cell area_ox=0.0676
XMp_59_11 dp_59_11 WL59 SL11 VSS sky130_fd_pr__nfet_g5v0d10v5 w=1 l=0.5
XRp_59_11 BLP11 dp_59_11 sky130_fd_pr_reram__reram_cell area_ox=0.0676
XMn_59_11 dn_59_11 WL59 SL11 VSS sky130_fd_pr__nfet_g5v0d10v5 w=1 l=0.5
XRn_59_11 BLN11 dn_59_11 sky130_fd_pr_reram__reram_cell area_ox=0.0676
XMp_59_12 dp_59_12 WL59 SL12 VSS sky130_fd_pr__nfet_g5v0d10v5 w=1 l=0.5
XRp_59_12 BLP12 dp_59_12 sky130_fd_pr_reram__reram_cell area_ox=0.0676
XMn_59_12 dn_59_12 WL59 SL12 VSS sky130_fd_pr__nfet_g5v0d10v5 w=1 l=0.5
XRn_59_12 BLN12 dn_59_12 sky130_fd_pr_reram__reram_cell area_ox=0.0676
XMp_59_13 dp_59_13 WL59 SL13 VSS sky130_fd_pr__nfet_g5v0d10v5 w=1 l=0.5
XRp_59_13 BLP13 dp_59_13 sky130_fd_pr_reram__reram_cell area_ox=0.0676
XMn_59_13 dn_59_13 WL59 SL13 VSS sky130_fd_pr__nfet_g5v0d10v5 w=1 l=0.5
XRn_59_13 BLN13 dn_59_13 sky130_fd_pr_reram__reram_cell area_ox=0.0676
XMp_59_14 dp_59_14 WL59 SL14 VSS sky130_fd_pr__nfet_g5v0d10v5 w=1 l=0.5
XRp_59_14 BLP14 dp_59_14 sky130_fd_pr_reram__reram_cell area_ox=0.0676
XMn_59_14 dn_59_14 WL59 SL14 VSS sky130_fd_pr__nfet_g5v0d10v5 w=1 l=0.5
XRn_59_14 BLN14 dn_59_14 sky130_fd_pr_reram__reram_cell area_ox=0.0676
XMp_59_15 dp_59_15 WL59 SL15 VSS sky130_fd_pr__nfet_g5v0d10v5 w=1 l=0.5
XRp_59_15 BLP15 dp_59_15 sky130_fd_pr_reram__reram_cell area_ox=0.0676
XMn_59_15 dn_59_15 WL59 SL15 VSS sky130_fd_pr__nfet_g5v0d10v5 w=1 l=0.5
XRn_59_15 BLN15 dn_59_15 sky130_fd_pr_reram__reram_cell area_ox=0.0676
XMp_59_16 dp_59_16 WL59 SL16 VSS sky130_fd_pr__nfet_g5v0d10v5 w=1 l=0.5
XRp_59_16 BLP16 dp_59_16 sky130_fd_pr_reram__reram_cell area_ox=0.0676
XMn_59_16 dn_59_16 WL59 SL16 VSS sky130_fd_pr__nfet_g5v0d10v5 w=1 l=0.5
XRn_59_16 BLN16 dn_59_16 sky130_fd_pr_reram__reram_cell area_ox=0.0676
XMp_59_17 dp_59_17 WL59 SL17 VSS sky130_fd_pr__nfet_g5v0d10v5 w=1 l=0.5
XRp_59_17 BLP17 dp_59_17 sky130_fd_pr_reram__reram_cell area_ox=0.0676
XMn_59_17 dn_59_17 WL59 SL17 VSS sky130_fd_pr__nfet_g5v0d10v5 w=1 l=0.5
XRn_59_17 BLN17 dn_59_17 sky130_fd_pr_reram__reram_cell area_ox=0.0676
XMp_59_18 dp_59_18 WL59 SL18 VSS sky130_fd_pr__nfet_g5v0d10v5 w=1 l=0.5
XRp_59_18 BLP18 dp_59_18 sky130_fd_pr_reram__reram_cell area_ox=0.0676
XMn_59_18 dn_59_18 WL59 SL18 VSS sky130_fd_pr__nfet_g5v0d10v5 w=1 l=0.5
XRn_59_18 BLN18 dn_59_18 sky130_fd_pr_reram__reram_cell area_ox=0.0676
XMp_59_19 dp_59_19 WL59 SL19 VSS sky130_fd_pr__nfet_g5v0d10v5 w=1 l=0.5
XRp_59_19 BLP19 dp_59_19 sky130_fd_pr_reram__reram_cell area_ox=0.0676
XMn_59_19 dn_59_19 WL59 SL19 VSS sky130_fd_pr__nfet_g5v0d10v5 w=1 l=0.5
XRn_59_19 BLN19 dn_59_19 sky130_fd_pr_reram__reram_cell area_ox=0.0676
XMp_59_20 dp_59_20 WL59 SL20 VSS sky130_fd_pr__nfet_g5v0d10v5 w=1 l=0.5
XRp_59_20 BLP20 dp_59_20 sky130_fd_pr_reram__reram_cell area_ox=0.0676
XMn_59_20 dn_59_20 WL59 SL20 VSS sky130_fd_pr__nfet_g5v0d10v5 w=1 l=0.5
XRn_59_20 BLN20 dn_59_20 sky130_fd_pr_reram__reram_cell area_ox=0.0676
XMp_59_21 dp_59_21 WL59 SL21 VSS sky130_fd_pr__nfet_g5v0d10v5 w=1 l=0.5
XRp_59_21 BLP21 dp_59_21 sky130_fd_pr_reram__reram_cell area_ox=0.0676
XMn_59_21 dn_59_21 WL59 SL21 VSS sky130_fd_pr__nfet_g5v0d10v5 w=1 l=0.5
XRn_59_21 BLN21 dn_59_21 sky130_fd_pr_reram__reram_cell area_ox=0.0676
XMp_59_22 dp_59_22 WL59 SL22 VSS sky130_fd_pr__nfet_g5v0d10v5 w=1 l=0.5
XRp_59_22 BLP22 dp_59_22 sky130_fd_pr_reram__reram_cell area_ox=0.0676
XMn_59_22 dn_59_22 WL59 SL22 VSS sky130_fd_pr__nfet_g5v0d10v5 w=1 l=0.5
XRn_59_22 BLN22 dn_59_22 sky130_fd_pr_reram__reram_cell area_ox=0.0676
XMp_59_23 dp_59_23 WL59 SL23 VSS sky130_fd_pr__nfet_g5v0d10v5 w=1 l=0.5
XRp_59_23 BLP23 dp_59_23 sky130_fd_pr_reram__reram_cell area_ox=0.0676
XMn_59_23 dn_59_23 WL59 SL23 VSS sky130_fd_pr__nfet_g5v0d10v5 w=1 l=0.5
XRn_59_23 BLN23 dn_59_23 sky130_fd_pr_reram__reram_cell area_ox=0.0676
XMp_60_0 dp_60_0 WL60 SL0 VSS sky130_fd_pr__nfet_g5v0d10v5 w=1 l=0.5
XRp_60_0 BLP0 dp_60_0 sky130_fd_pr_reram__reram_cell area_ox=0.0676
XMn_60_0 dn_60_0 WL60 SL0 VSS sky130_fd_pr__nfet_g5v0d10v5 w=1 l=0.5
XRn_60_0 BLN0 dn_60_0 sky130_fd_pr_reram__reram_cell area_ox=0.0676
XMp_60_1 dp_60_1 WL60 SL1 VSS sky130_fd_pr__nfet_g5v0d10v5 w=1 l=0.5
XRp_60_1 BLP1 dp_60_1 sky130_fd_pr_reram__reram_cell area_ox=0.0676
XMn_60_1 dn_60_1 WL60 SL1 VSS sky130_fd_pr__nfet_g5v0d10v5 w=1 l=0.5
XRn_60_1 BLN1 dn_60_1 sky130_fd_pr_reram__reram_cell area_ox=0.0676
XMp_60_2 dp_60_2 WL60 SL2 VSS sky130_fd_pr__nfet_g5v0d10v5 w=1 l=0.5
XRp_60_2 BLP2 dp_60_2 sky130_fd_pr_reram__reram_cell area_ox=0.0676
XMn_60_2 dn_60_2 WL60 SL2 VSS sky130_fd_pr__nfet_g5v0d10v5 w=1 l=0.5
XRn_60_2 BLN2 dn_60_2 sky130_fd_pr_reram__reram_cell area_ox=0.0676
XMp_60_3 dp_60_3 WL60 SL3 VSS sky130_fd_pr__nfet_g5v0d10v5 w=1 l=0.5
XRp_60_3 BLP3 dp_60_3 sky130_fd_pr_reram__reram_cell area_ox=0.0676
XMn_60_3 dn_60_3 WL60 SL3 VSS sky130_fd_pr__nfet_g5v0d10v5 w=1 l=0.5
XRn_60_3 BLN3 dn_60_3 sky130_fd_pr_reram__reram_cell area_ox=0.0676
XMp_60_4 dp_60_4 WL60 SL4 VSS sky130_fd_pr__nfet_g5v0d10v5 w=1 l=0.5
XRp_60_4 BLP4 dp_60_4 sky130_fd_pr_reram__reram_cell area_ox=0.0676
XMn_60_4 dn_60_4 WL60 SL4 VSS sky130_fd_pr__nfet_g5v0d10v5 w=1 l=0.5
XRn_60_4 BLN4 dn_60_4 sky130_fd_pr_reram__reram_cell area_ox=0.0676
XMp_60_5 dp_60_5 WL60 SL5 VSS sky130_fd_pr__nfet_g5v0d10v5 w=1 l=0.5
XRp_60_5 BLP5 dp_60_5 sky130_fd_pr_reram__reram_cell area_ox=0.0676
XMn_60_5 dn_60_5 WL60 SL5 VSS sky130_fd_pr__nfet_g5v0d10v5 w=1 l=0.5
XRn_60_5 BLN5 dn_60_5 sky130_fd_pr_reram__reram_cell area_ox=0.0676
XMp_60_6 dp_60_6 WL60 SL6 VSS sky130_fd_pr__nfet_g5v0d10v5 w=1 l=0.5
XRp_60_6 BLP6 dp_60_6 sky130_fd_pr_reram__reram_cell area_ox=0.0676
XMn_60_6 dn_60_6 WL60 SL6 VSS sky130_fd_pr__nfet_g5v0d10v5 w=1 l=0.5
XRn_60_6 BLN6 dn_60_6 sky130_fd_pr_reram__reram_cell area_ox=0.0676
XMp_60_7 dp_60_7 WL60 SL7 VSS sky130_fd_pr__nfet_g5v0d10v5 w=1 l=0.5
XRp_60_7 BLP7 dp_60_7 sky130_fd_pr_reram__reram_cell area_ox=0.0676
XMn_60_7 dn_60_7 WL60 SL7 VSS sky130_fd_pr__nfet_g5v0d10v5 w=1 l=0.5
XRn_60_7 BLN7 dn_60_7 sky130_fd_pr_reram__reram_cell area_ox=0.0676
XMp_60_8 dp_60_8 WL60 SL8 VSS sky130_fd_pr__nfet_g5v0d10v5 w=1 l=0.5
XRp_60_8 BLP8 dp_60_8 sky130_fd_pr_reram__reram_cell area_ox=0.0676
XMn_60_8 dn_60_8 WL60 SL8 VSS sky130_fd_pr__nfet_g5v0d10v5 w=1 l=0.5
XRn_60_8 BLN8 dn_60_8 sky130_fd_pr_reram__reram_cell area_ox=0.0676
XMp_60_9 dp_60_9 WL60 SL9 VSS sky130_fd_pr__nfet_g5v0d10v5 w=1 l=0.5
XRp_60_9 BLP9 dp_60_9 sky130_fd_pr_reram__reram_cell area_ox=0.0676
XMn_60_9 dn_60_9 WL60 SL9 VSS sky130_fd_pr__nfet_g5v0d10v5 w=1 l=0.5
XRn_60_9 BLN9 dn_60_9 sky130_fd_pr_reram__reram_cell area_ox=0.0676
XMp_60_10 dp_60_10 WL60 SL10 VSS sky130_fd_pr__nfet_g5v0d10v5 w=1 l=0.5
XRp_60_10 BLP10 dp_60_10 sky130_fd_pr_reram__reram_cell area_ox=0.0676
XMn_60_10 dn_60_10 WL60 SL10 VSS sky130_fd_pr__nfet_g5v0d10v5 w=1 l=0.5
XRn_60_10 BLN10 dn_60_10 sky130_fd_pr_reram__reram_cell area_ox=0.0676
XMp_60_11 dp_60_11 WL60 SL11 VSS sky130_fd_pr__nfet_g5v0d10v5 w=1 l=0.5
XRp_60_11 BLP11 dp_60_11 sky130_fd_pr_reram__reram_cell area_ox=0.0676
XMn_60_11 dn_60_11 WL60 SL11 VSS sky130_fd_pr__nfet_g5v0d10v5 w=1 l=0.5
XRn_60_11 BLN11 dn_60_11 sky130_fd_pr_reram__reram_cell area_ox=0.0676
XMp_60_12 dp_60_12 WL60 SL12 VSS sky130_fd_pr__nfet_g5v0d10v5 w=1 l=0.5
XRp_60_12 BLP12 dp_60_12 sky130_fd_pr_reram__reram_cell area_ox=0.0676
XMn_60_12 dn_60_12 WL60 SL12 VSS sky130_fd_pr__nfet_g5v0d10v5 w=1 l=0.5
XRn_60_12 BLN12 dn_60_12 sky130_fd_pr_reram__reram_cell area_ox=0.0676
XMp_60_13 dp_60_13 WL60 SL13 VSS sky130_fd_pr__nfet_g5v0d10v5 w=1 l=0.5
XRp_60_13 BLP13 dp_60_13 sky130_fd_pr_reram__reram_cell area_ox=0.0676
XMn_60_13 dn_60_13 WL60 SL13 VSS sky130_fd_pr__nfet_g5v0d10v5 w=1 l=0.5
XRn_60_13 BLN13 dn_60_13 sky130_fd_pr_reram__reram_cell area_ox=0.0676
XMp_60_14 dp_60_14 WL60 SL14 VSS sky130_fd_pr__nfet_g5v0d10v5 w=1 l=0.5
XRp_60_14 BLP14 dp_60_14 sky130_fd_pr_reram__reram_cell area_ox=0.0676
XMn_60_14 dn_60_14 WL60 SL14 VSS sky130_fd_pr__nfet_g5v0d10v5 w=1 l=0.5
XRn_60_14 BLN14 dn_60_14 sky130_fd_pr_reram__reram_cell area_ox=0.0676
XMp_60_15 dp_60_15 WL60 SL15 VSS sky130_fd_pr__nfet_g5v0d10v5 w=1 l=0.5
XRp_60_15 BLP15 dp_60_15 sky130_fd_pr_reram__reram_cell area_ox=0.0676
XMn_60_15 dn_60_15 WL60 SL15 VSS sky130_fd_pr__nfet_g5v0d10v5 w=1 l=0.5
XRn_60_15 BLN15 dn_60_15 sky130_fd_pr_reram__reram_cell area_ox=0.0676
XMp_60_16 dp_60_16 WL60 SL16 VSS sky130_fd_pr__nfet_g5v0d10v5 w=1 l=0.5
XRp_60_16 BLP16 dp_60_16 sky130_fd_pr_reram__reram_cell area_ox=0.0676
XMn_60_16 dn_60_16 WL60 SL16 VSS sky130_fd_pr__nfet_g5v0d10v5 w=1 l=0.5
XRn_60_16 BLN16 dn_60_16 sky130_fd_pr_reram__reram_cell area_ox=0.0676
XMp_60_17 dp_60_17 WL60 SL17 VSS sky130_fd_pr__nfet_g5v0d10v5 w=1 l=0.5
XRp_60_17 BLP17 dp_60_17 sky130_fd_pr_reram__reram_cell area_ox=0.0676
XMn_60_17 dn_60_17 WL60 SL17 VSS sky130_fd_pr__nfet_g5v0d10v5 w=1 l=0.5
XRn_60_17 BLN17 dn_60_17 sky130_fd_pr_reram__reram_cell area_ox=0.0676
XMp_60_18 dp_60_18 WL60 SL18 VSS sky130_fd_pr__nfet_g5v0d10v5 w=1 l=0.5
XRp_60_18 BLP18 dp_60_18 sky130_fd_pr_reram__reram_cell area_ox=0.0676
XMn_60_18 dn_60_18 WL60 SL18 VSS sky130_fd_pr__nfet_g5v0d10v5 w=1 l=0.5
XRn_60_18 BLN18 dn_60_18 sky130_fd_pr_reram__reram_cell area_ox=0.0676
XMp_60_19 dp_60_19 WL60 SL19 VSS sky130_fd_pr__nfet_g5v0d10v5 w=1 l=0.5
XRp_60_19 BLP19 dp_60_19 sky130_fd_pr_reram__reram_cell area_ox=0.0676
XMn_60_19 dn_60_19 WL60 SL19 VSS sky130_fd_pr__nfet_g5v0d10v5 w=1 l=0.5
XRn_60_19 BLN19 dn_60_19 sky130_fd_pr_reram__reram_cell area_ox=0.0676
XMp_60_20 dp_60_20 WL60 SL20 VSS sky130_fd_pr__nfet_g5v0d10v5 w=1 l=0.5
XRp_60_20 BLP20 dp_60_20 sky130_fd_pr_reram__reram_cell area_ox=0.0676
XMn_60_20 dn_60_20 WL60 SL20 VSS sky130_fd_pr__nfet_g5v0d10v5 w=1 l=0.5
XRn_60_20 BLN20 dn_60_20 sky130_fd_pr_reram__reram_cell area_ox=0.0676
XMp_60_21 dp_60_21 WL60 SL21 VSS sky130_fd_pr__nfet_g5v0d10v5 w=1 l=0.5
XRp_60_21 BLP21 dp_60_21 sky130_fd_pr_reram__reram_cell area_ox=0.0676
XMn_60_21 dn_60_21 WL60 SL21 VSS sky130_fd_pr__nfet_g5v0d10v5 w=1 l=0.5
XRn_60_21 BLN21 dn_60_21 sky130_fd_pr_reram__reram_cell area_ox=0.0676
XMp_60_22 dp_60_22 WL60 SL22 VSS sky130_fd_pr__nfet_g5v0d10v5 w=1 l=0.5
XRp_60_22 BLP22 dp_60_22 sky130_fd_pr_reram__reram_cell area_ox=0.0676
XMn_60_22 dn_60_22 WL60 SL22 VSS sky130_fd_pr__nfet_g5v0d10v5 w=1 l=0.5
XRn_60_22 BLN22 dn_60_22 sky130_fd_pr_reram__reram_cell area_ox=0.0676
XMp_60_23 dp_60_23 WL60 SL23 VSS sky130_fd_pr__nfet_g5v0d10v5 w=1 l=0.5
XRp_60_23 BLP23 dp_60_23 sky130_fd_pr_reram__reram_cell area_ox=0.0676
XMn_60_23 dn_60_23 WL60 SL23 VSS sky130_fd_pr__nfet_g5v0d10v5 w=1 l=0.5
XRn_60_23 BLN23 dn_60_23 sky130_fd_pr_reram__reram_cell area_ox=0.0676
XMp_61_0 dp_61_0 WL61 SL0 VSS sky130_fd_pr__nfet_g5v0d10v5 w=1 l=0.5
XRp_61_0 BLP0 dp_61_0 sky130_fd_pr_reram__reram_cell area_ox=0.0676
XMn_61_0 dn_61_0 WL61 SL0 VSS sky130_fd_pr__nfet_g5v0d10v5 w=1 l=0.5
XRn_61_0 BLN0 dn_61_0 sky130_fd_pr_reram__reram_cell area_ox=0.0676
XMp_61_1 dp_61_1 WL61 SL1 VSS sky130_fd_pr__nfet_g5v0d10v5 w=1 l=0.5
XRp_61_1 BLP1 dp_61_1 sky130_fd_pr_reram__reram_cell area_ox=0.0676
XMn_61_1 dn_61_1 WL61 SL1 VSS sky130_fd_pr__nfet_g5v0d10v5 w=1 l=0.5
XRn_61_1 BLN1 dn_61_1 sky130_fd_pr_reram__reram_cell area_ox=0.0676
XMp_61_2 dp_61_2 WL61 SL2 VSS sky130_fd_pr__nfet_g5v0d10v5 w=1 l=0.5
XRp_61_2 BLP2 dp_61_2 sky130_fd_pr_reram__reram_cell area_ox=0.0676
XMn_61_2 dn_61_2 WL61 SL2 VSS sky130_fd_pr__nfet_g5v0d10v5 w=1 l=0.5
XRn_61_2 BLN2 dn_61_2 sky130_fd_pr_reram__reram_cell area_ox=0.0676
XMp_61_3 dp_61_3 WL61 SL3 VSS sky130_fd_pr__nfet_g5v0d10v5 w=1 l=0.5
XRp_61_3 BLP3 dp_61_3 sky130_fd_pr_reram__reram_cell area_ox=0.0676
XMn_61_3 dn_61_3 WL61 SL3 VSS sky130_fd_pr__nfet_g5v0d10v5 w=1 l=0.5
XRn_61_3 BLN3 dn_61_3 sky130_fd_pr_reram__reram_cell area_ox=0.0676
XMp_61_4 dp_61_4 WL61 SL4 VSS sky130_fd_pr__nfet_g5v0d10v5 w=1 l=0.5
XRp_61_4 BLP4 dp_61_4 sky130_fd_pr_reram__reram_cell area_ox=0.0676
XMn_61_4 dn_61_4 WL61 SL4 VSS sky130_fd_pr__nfet_g5v0d10v5 w=1 l=0.5
XRn_61_4 BLN4 dn_61_4 sky130_fd_pr_reram__reram_cell area_ox=0.0676
XMp_61_5 dp_61_5 WL61 SL5 VSS sky130_fd_pr__nfet_g5v0d10v5 w=1 l=0.5
XRp_61_5 BLP5 dp_61_5 sky130_fd_pr_reram__reram_cell area_ox=0.0676
XMn_61_5 dn_61_5 WL61 SL5 VSS sky130_fd_pr__nfet_g5v0d10v5 w=1 l=0.5
XRn_61_5 BLN5 dn_61_5 sky130_fd_pr_reram__reram_cell area_ox=0.0676
XMp_61_6 dp_61_6 WL61 SL6 VSS sky130_fd_pr__nfet_g5v0d10v5 w=1 l=0.5
XRp_61_6 BLP6 dp_61_6 sky130_fd_pr_reram__reram_cell area_ox=0.0676
XMn_61_6 dn_61_6 WL61 SL6 VSS sky130_fd_pr__nfet_g5v0d10v5 w=1 l=0.5
XRn_61_6 BLN6 dn_61_6 sky130_fd_pr_reram__reram_cell area_ox=0.0676
XMp_61_7 dp_61_7 WL61 SL7 VSS sky130_fd_pr__nfet_g5v0d10v5 w=1 l=0.5
XRp_61_7 BLP7 dp_61_7 sky130_fd_pr_reram__reram_cell area_ox=0.0676
XMn_61_7 dn_61_7 WL61 SL7 VSS sky130_fd_pr__nfet_g5v0d10v5 w=1 l=0.5
XRn_61_7 BLN7 dn_61_7 sky130_fd_pr_reram__reram_cell area_ox=0.0676
XMp_61_8 dp_61_8 WL61 SL8 VSS sky130_fd_pr__nfet_g5v0d10v5 w=1 l=0.5
XRp_61_8 BLP8 dp_61_8 sky130_fd_pr_reram__reram_cell area_ox=0.0676
XMn_61_8 dn_61_8 WL61 SL8 VSS sky130_fd_pr__nfet_g5v0d10v5 w=1 l=0.5
XRn_61_8 BLN8 dn_61_8 sky130_fd_pr_reram__reram_cell area_ox=0.0676
XMp_61_9 dp_61_9 WL61 SL9 VSS sky130_fd_pr__nfet_g5v0d10v5 w=1 l=0.5
XRp_61_9 BLP9 dp_61_9 sky130_fd_pr_reram__reram_cell area_ox=0.0676
XMn_61_9 dn_61_9 WL61 SL9 VSS sky130_fd_pr__nfet_g5v0d10v5 w=1 l=0.5
XRn_61_9 BLN9 dn_61_9 sky130_fd_pr_reram__reram_cell area_ox=0.0676
XMp_61_10 dp_61_10 WL61 SL10 VSS sky130_fd_pr__nfet_g5v0d10v5 w=1 l=0.5
XRp_61_10 BLP10 dp_61_10 sky130_fd_pr_reram__reram_cell area_ox=0.0676
XMn_61_10 dn_61_10 WL61 SL10 VSS sky130_fd_pr__nfet_g5v0d10v5 w=1 l=0.5
XRn_61_10 BLN10 dn_61_10 sky130_fd_pr_reram__reram_cell area_ox=0.0676
XMp_61_11 dp_61_11 WL61 SL11 VSS sky130_fd_pr__nfet_g5v0d10v5 w=1 l=0.5
XRp_61_11 BLP11 dp_61_11 sky130_fd_pr_reram__reram_cell area_ox=0.0676
XMn_61_11 dn_61_11 WL61 SL11 VSS sky130_fd_pr__nfet_g5v0d10v5 w=1 l=0.5
XRn_61_11 BLN11 dn_61_11 sky130_fd_pr_reram__reram_cell area_ox=0.0676
XMp_61_12 dp_61_12 WL61 SL12 VSS sky130_fd_pr__nfet_g5v0d10v5 w=1 l=0.5
XRp_61_12 BLP12 dp_61_12 sky130_fd_pr_reram__reram_cell area_ox=0.0676
XMn_61_12 dn_61_12 WL61 SL12 VSS sky130_fd_pr__nfet_g5v0d10v5 w=1 l=0.5
XRn_61_12 BLN12 dn_61_12 sky130_fd_pr_reram__reram_cell area_ox=0.0676
XMp_61_13 dp_61_13 WL61 SL13 VSS sky130_fd_pr__nfet_g5v0d10v5 w=1 l=0.5
XRp_61_13 BLP13 dp_61_13 sky130_fd_pr_reram__reram_cell area_ox=0.0676
XMn_61_13 dn_61_13 WL61 SL13 VSS sky130_fd_pr__nfet_g5v0d10v5 w=1 l=0.5
XRn_61_13 BLN13 dn_61_13 sky130_fd_pr_reram__reram_cell area_ox=0.0676
XMp_61_14 dp_61_14 WL61 SL14 VSS sky130_fd_pr__nfet_g5v0d10v5 w=1 l=0.5
XRp_61_14 BLP14 dp_61_14 sky130_fd_pr_reram__reram_cell area_ox=0.0676
XMn_61_14 dn_61_14 WL61 SL14 VSS sky130_fd_pr__nfet_g5v0d10v5 w=1 l=0.5
XRn_61_14 BLN14 dn_61_14 sky130_fd_pr_reram__reram_cell area_ox=0.0676
XMp_61_15 dp_61_15 WL61 SL15 VSS sky130_fd_pr__nfet_g5v0d10v5 w=1 l=0.5
XRp_61_15 BLP15 dp_61_15 sky130_fd_pr_reram__reram_cell area_ox=0.0676
XMn_61_15 dn_61_15 WL61 SL15 VSS sky130_fd_pr__nfet_g5v0d10v5 w=1 l=0.5
XRn_61_15 BLN15 dn_61_15 sky130_fd_pr_reram__reram_cell area_ox=0.0676
XMp_61_16 dp_61_16 WL61 SL16 VSS sky130_fd_pr__nfet_g5v0d10v5 w=1 l=0.5
XRp_61_16 BLP16 dp_61_16 sky130_fd_pr_reram__reram_cell area_ox=0.0676
XMn_61_16 dn_61_16 WL61 SL16 VSS sky130_fd_pr__nfet_g5v0d10v5 w=1 l=0.5
XRn_61_16 BLN16 dn_61_16 sky130_fd_pr_reram__reram_cell area_ox=0.0676
XMp_61_17 dp_61_17 WL61 SL17 VSS sky130_fd_pr__nfet_g5v0d10v5 w=1 l=0.5
XRp_61_17 BLP17 dp_61_17 sky130_fd_pr_reram__reram_cell area_ox=0.0676
XMn_61_17 dn_61_17 WL61 SL17 VSS sky130_fd_pr__nfet_g5v0d10v5 w=1 l=0.5
XRn_61_17 BLN17 dn_61_17 sky130_fd_pr_reram__reram_cell area_ox=0.0676
XMp_61_18 dp_61_18 WL61 SL18 VSS sky130_fd_pr__nfet_g5v0d10v5 w=1 l=0.5
XRp_61_18 BLP18 dp_61_18 sky130_fd_pr_reram__reram_cell area_ox=0.0676
XMn_61_18 dn_61_18 WL61 SL18 VSS sky130_fd_pr__nfet_g5v0d10v5 w=1 l=0.5
XRn_61_18 BLN18 dn_61_18 sky130_fd_pr_reram__reram_cell area_ox=0.0676
XMp_61_19 dp_61_19 WL61 SL19 VSS sky130_fd_pr__nfet_g5v0d10v5 w=1 l=0.5
XRp_61_19 BLP19 dp_61_19 sky130_fd_pr_reram__reram_cell area_ox=0.0676
XMn_61_19 dn_61_19 WL61 SL19 VSS sky130_fd_pr__nfet_g5v0d10v5 w=1 l=0.5
XRn_61_19 BLN19 dn_61_19 sky130_fd_pr_reram__reram_cell area_ox=0.0676
XMp_61_20 dp_61_20 WL61 SL20 VSS sky130_fd_pr__nfet_g5v0d10v5 w=1 l=0.5
XRp_61_20 BLP20 dp_61_20 sky130_fd_pr_reram__reram_cell area_ox=0.0676
XMn_61_20 dn_61_20 WL61 SL20 VSS sky130_fd_pr__nfet_g5v0d10v5 w=1 l=0.5
XRn_61_20 BLN20 dn_61_20 sky130_fd_pr_reram__reram_cell area_ox=0.0676
XMp_61_21 dp_61_21 WL61 SL21 VSS sky130_fd_pr__nfet_g5v0d10v5 w=1 l=0.5
XRp_61_21 BLP21 dp_61_21 sky130_fd_pr_reram__reram_cell area_ox=0.0676
XMn_61_21 dn_61_21 WL61 SL21 VSS sky130_fd_pr__nfet_g5v0d10v5 w=1 l=0.5
XRn_61_21 BLN21 dn_61_21 sky130_fd_pr_reram__reram_cell area_ox=0.0676
XMp_61_22 dp_61_22 WL61 SL22 VSS sky130_fd_pr__nfet_g5v0d10v5 w=1 l=0.5
XRp_61_22 BLP22 dp_61_22 sky130_fd_pr_reram__reram_cell area_ox=0.0676
XMn_61_22 dn_61_22 WL61 SL22 VSS sky130_fd_pr__nfet_g5v0d10v5 w=1 l=0.5
XRn_61_22 BLN22 dn_61_22 sky130_fd_pr_reram__reram_cell area_ox=0.0676
XMp_61_23 dp_61_23 WL61 SL23 VSS sky130_fd_pr__nfet_g5v0d10v5 w=1 l=0.5
XRp_61_23 BLP23 dp_61_23 sky130_fd_pr_reram__reram_cell area_ox=0.0676
XMn_61_23 dn_61_23 WL61 SL23 VSS sky130_fd_pr__nfet_g5v0d10v5 w=1 l=0.5
XRn_61_23 BLN23 dn_61_23 sky130_fd_pr_reram__reram_cell area_ox=0.0676
XMp_62_0 dp_62_0 WL62 SL0 VSS sky130_fd_pr__nfet_g5v0d10v5 w=1 l=0.5
XRp_62_0 BLP0 dp_62_0 sky130_fd_pr_reram__reram_cell area_ox=0.0676
XMn_62_0 dn_62_0 WL62 SL0 VSS sky130_fd_pr__nfet_g5v0d10v5 w=1 l=0.5
XRn_62_0 BLN0 dn_62_0 sky130_fd_pr_reram__reram_cell area_ox=0.0676
XMp_62_1 dp_62_1 WL62 SL1 VSS sky130_fd_pr__nfet_g5v0d10v5 w=1 l=0.5
XRp_62_1 BLP1 dp_62_1 sky130_fd_pr_reram__reram_cell area_ox=0.0676
XMn_62_1 dn_62_1 WL62 SL1 VSS sky130_fd_pr__nfet_g5v0d10v5 w=1 l=0.5
XRn_62_1 BLN1 dn_62_1 sky130_fd_pr_reram__reram_cell area_ox=0.0676
XMp_62_2 dp_62_2 WL62 SL2 VSS sky130_fd_pr__nfet_g5v0d10v5 w=1 l=0.5
XRp_62_2 BLP2 dp_62_2 sky130_fd_pr_reram__reram_cell area_ox=0.0676
XMn_62_2 dn_62_2 WL62 SL2 VSS sky130_fd_pr__nfet_g5v0d10v5 w=1 l=0.5
XRn_62_2 BLN2 dn_62_2 sky130_fd_pr_reram__reram_cell area_ox=0.0676
XMp_62_3 dp_62_3 WL62 SL3 VSS sky130_fd_pr__nfet_g5v0d10v5 w=1 l=0.5
XRp_62_3 BLP3 dp_62_3 sky130_fd_pr_reram__reram_cell area_ox=0.0676
XMn_62_3 dn_62_3 WL62 SL3 VSS sky130_fd_pr__nfet_g5v0d10v5 w=1 l=0.5
XRn_62_3 BLN3 dn_62_3 sky130_fd_pr_reram__reram_cell area_ox=0.0676
XMp_62_4 dp_62_4 WL62 SL4 VSS sky130_fd_pr__nfet_g5v0d10v5 w=1 l=0.5
XRp_62_4 BLP4 dp_62_4 sky130_fd_pr_reram__reram_cell area_ox=0.0676
XMn_62_4 dn_62_4 WL62 SL4 VSS sky130_fd_pr__nfet_g5v0d10v5 w=1 l=0.5
XRn_62_4 BLN4 dn_62_4 sky130_fd_pr_reram__reram_cell area_ox=0.0676
XMp_62_5 dp_62_5 WL62 SL5 VSS sky130_fd_pr__nfet_g5v0d10v5 w=1 l=0.5
XRp_62_5 BLP5 dp_62_5 sky130_fd_pr_reram__reram_cell area_ox=0.0676
XMn_62_5 dn_62_5 WL62 SL5 VSS sky130_fd_pr__nfet_g5v0d10v5 w=1 l=0.5
XRn_62_5 BLN5 dn_62_5 sky130_fd_pr_reram__reram_cell area_ox=0.0676
XMp_62_6 dp_62_6 WL62 SL6 VSS sky130_fd_pr__nfet_g5v0d10v5 w=1 l=0.5
XRp_62_6 BLP6 dp_62_6 sky130_fd_pr_reram__reram_cell area_ox=0.0676
XMn_62_6 dn_62_6 WL62 SL6 VSS sky130_fd_pr__nfet_g5v0d10v5 w=1 l=0.5
XRn_62_6 BLN6 dn_62_6 sky130_fd_pr_reram__reram_cell area_ox=0.0676
XMp_62_7 dp_62_7 WL62 SL7 VSS sky130_fd_pr__nfet_g5v0d10v5 w=1 l=0.5
XRp_62_7 BLP7 dp_62_7 sky130_fd_pr_reram__reram_cell area_ox=0.0676
XMn_62_7 dn_62_7 WL62 SL7 VSS sky130_fd_pr__nfet_g5v0d10v5 w=1 l=0.5
XRn_62_7 BLN7 dn_62_7 sky130_fd_pr_reram__reram_cell area_ox=0.0676
XMp_62_8 dp_62_8 WL62 SL8 VSS sky130_fd_pr__nfet_g5v0d10v5 w=1 l=0.5
XRp_62_8 BLP8 dp_62_8 sky130_fd_pr_reram__reram_cell area_ox=0.0676
XMn_62_8 dn_62_8 WL62 SL8 VSS sky130_fd_pr__nfet_g5v0d10v5 w=1 l=0.5
XRn_62_8 BLN8 dn_62_8 sky130_fd_pr_reram__reram_cell area_ox=0.0676
XMp_62_9 dp_62_9 WL62 SL9 VSS sky130_fd_pr__nfet_g5v0d10v5 w=1 l=0.5
XRp_62_9 BLP9 dp_62_9 sky130_fd_pr_reram__reram_cell area_ox=0.0676
XMn_62_9 dn_62_9 WL62 SL9 VSS sky130_fd_pr__nfet_g5v0d10v5 w=1 l=0.5
XRn_62_9 BLN9 dn_62_9 sky130_fd_pr_reram__reram_cell area_ox=0.0676
XMp_62_10 dp_62_10 WL62 SL10 VSS sky130_fd_pr__nfet_g5v0d10v5 w=1 l=0.5
XRp_62_10 BLP10 dp_62_10 sky130_fd_pr_reram__reram_cell area_ox=0.0676
XMn_62_10 dn_62_10 WL62 SL10 VSS sky130_fd_pr__nfet_g5v0d10v5 w=1 l=0.5
XRn_62_10 BLN10 dn_62_10 sky130_fd_pr_reram__reram_cell area_ox=0.0676
XMp_62_11 dp_62_11 WL62 SL11 VSS sky130_fd_pr__nfet_g5v0d10v5 w=1 l=0.5
XRp_62_11 BLP11 dp_62_11 sky130_fd_pr_reram__reram_cell area_ox=0.0676
XMn_62_11 dn_62_11 WL62 SL11 VSS sky130_fd_pr__nfet_g5v0d10v5 w=1 l=0.5
XRn_62_11 BLN11 dn_62_11 sky130_fd_pr_reram__reram_cell area_ox=0.0676
XMp_62_12 dp_62_12 WL62 SL12 VSS sky130_fd_pr__nfet_g5v0d10v5 w=1 l=0.5
XRp_62_12 BLP12 dp_62_12 sky130_fd_pr_reram__reram_cell area_ox=0.0676
XMn_62_12 dn_62_12 WL62 SL12 VSS sky130_fd_pr__nfet_g5v0d10v5 w=1 l=0.5
XRn_62_12 BLN12 dn_62_12 sky130_fd_pr_reram__reram_cell area_ox=0.0676
XMp_62_13 dp_62_13 WL62 SL13 VSS sky130_fd_pr__nfet_g5v0d10v5 w=1 l=0.5
XRp_62_13 BLP13 dp_62_13 sky130_fd_pr_reram__reram_cell area_ox=0.0676
XMn_62_13 dn_62_13 WL62 SL13 VSS sky130_fd_pr__nfet_g5v0d10v5 w=1 l=0.5
XRn_62_13 BLN13 dn_62_13 sky130_fd_pr_reram__reram_cell area_ox=0.0676
XMp_62_14 dp_62_14 WL62 SL14 VSS sky130_fd_pr__nfet_g5v0d10v5 w=1 l=0.5
XRp_62_14 BLP14 dp_62_14 sky130_fd_pr_reram__reram_cell area_ox=0.0676
XMn_62_14 dn_62_14 WL62 SL14 VSS sky130_fd_pr__nfet_g5v0d10v5 w=1 l=0.5
XRn_62_14 BLN14 dn_62_14 sky130_fd_pr_reram__reram_cell area_ox=0.0676
XMp_62_15 dp_62_15 WL62 SL15 VSS sky130_fd_pr__nfet_g5v0d10v5 w=1 l=0.5
XRp_62_15 BLP15 dp_62_15 sky130_fd_pr_reram__reram_cell area_ox=0.0676
XMn_62_15 dn_62_15 WL62 SL15 VSS sky130_fd_pr__nfet_g5v0d10v5 w=1 l=0.5
XRn_62_15 BLN15 dn_62_15 sky130_fd_pr_reram__reram_cell area_ox=0.0676
XMp_62_16 dp_62_16 WL62 SL16 VSS sky130_fd_pr__nfet_g5v0d10v5 w=1 l=0.5
XRp_62_16 BLP16 dp_62_16 sky130_fd_pr_reram__reram_cell area_ox=0.0676
XMn_62_16 dn_62_16 WL62 SL16 VSS sky130_fd_pr__nfet_g5v0d10v5 w=1 l=0.5
XRn_62_16 BLN16 dn_62_16 sky130_fd_pr_reram__reram_cell area_ox=0.0676
XMp_62_17 dp_62_17 WL62 SL17 VSS sky130_fd_pr__nfet_g5v0d10v5 w=1 l=0.5
XRp_62_17 BLP17 dp_62_17 sky130_fd_pr_reram__reram_cell area_ox=0.0676
XMn_62_17 dn_62_17 WL62 SL17 VSS sky130_fd_pr__nfet_g5v0d10v5 w=1 l=0.5
XRn_62_17 BLN17 dn_62_17 sky130_fd_pr_reram__reram_cell area_ox=0.0676
XMp_62_18 dp_62_18 WL62 SL18 VSS sky130_fd_pr__nfet_g5v0d10v5 w=1 l=0.5
XRp_62_18 BLP18 dp_62_18 sky130_fd_pr_reram__reram_cell area_ox=0.0676
XMn_62_18 dn_62_18 WL62 SL18 VSS sky130_fd_pr__nfet_g5v0d10v5 w=1 l=0.5
XRn_62_18 BLN18 dn_62_18 sky130_fd_pr_reram__reram_cell area_ox=0.0676
XMp_62_19 dp_62_19 WL62 SL19 VSS sky130_fd_pr__nfet_g5v0d10v5 w=1 l=0.5
XRp_62_19 BLP19 dp_62_19 sky130_fd_pr_reram__reram_cell area_ox=0.0676
XMn_62_19 dn_62_19 WL62 SL19 VSS sky130_fd_pr__nfet_g5v0d10v5 w=1 l=0.5
XRn_62_19 BLN19 dn_62_19 sky130_fd_pr_reram__reram_cell area_ox=0.0676
XMp_62_20 dp_62_20 WL62 SL20 VSS sky130_fd_pr__nfet_g5v0d10v5 w=1 l=0.5
XRp_62_20 BLP20 dp_62_20 sky130_fd_pr_reram__reram_cell area_ox=0.0676
XMn_62_20 dn_62_20 WL62 SL20 VSS sky130_fd_pr__nfet_g5v0d10v5 w=1 l=0.5
XRn_62_20 BLN20 dn_62_20 sky130_fd_pr_reram__reram_cell area_ox=0.0676
XMp_62_21 dp_62_21 WL62 SL21 VSS sky130_fd_pr__nfet_g5v0d10v5 w=1 l=0.5
XRp_62_21 BLP21 dp_62_21 sky130_fd_pr_reram__reram_cell area_ox=0.0676
XMn_62_21 dn_62_21 WL62 SL21 VSS sky130_fd_pr__nfet_g5v0d10v5 w=1 l=0.5
XRn_62_21 BLN21 dn_62_21 sky130_fd_pr_reram__reram_cell area_ox=0.0676
XMp_62_22 dp_62_22 WL62 SL22 VSS sky130_fd_pr__nfet_g5v0d10v5 w=1 l=0.5
XRp_62_22 BLP22 dp_62_22 sky130_fd_pr_reram__reram_cell area_ox=0.0676
XMn_62_22 dn_62_22 WL62 SL22 VSS sky130_fd_pr__nfet_g5v0d10v5 w=1 l=0.5
XRn_62_22 BLN22 dn_62_22 sky130_fd_pr_reram__reram_cell area_ox=0.0676
XMp_62_23 dp_62_23 WL62 SL23 VSS sky130_fd_pr__nfet_g5v0d10v5 w=1 l=0.5
XRp_62_23 BLP23 dp_62_23 sky130_fd_pr_reram__reram_cell area_ox=0.0676
XMn_62_23 dn_62_23 WL62 SL23 VSS sky130_fd_pr__nfet_g5v0d10v5 w=1 l=0.5
XRn_62_23 BLN23 dn_62_23 sky130_fd_pr_reram__reram_cell area_ox=0.0676
XMp_63_0 dp_63_0 WL63 SL0 VSS sky130_fd_pr__nfet_g5v0d10v5 w=1 l=0.5
XRp_63_0 BLP0 dp_63_0 sky130_fd_pr_reram__reram_cell area_ox=0.0676
XMn_63_0 dn_63_0 WL63 SL0 VSS sky130_fd_pr__nfet_g5v0d10v5 w=1 l=0.5
XRn_63_0 BLN0 dn_63_0 sky130_fd_pr_reram__reram_cell area_ox=0.0676
XMp_63_1 dp_63_1 WL63 SL1 VSS sky130_fd_pr__nfet_g5v0d10v5 w=1 l=0.5
XRp_63_1 BLP1 dp_63_1 sky130_fd_pr_reram__reram_cell area_ox=0.0676
XMn_63_1 dn_63_1 WL63 SL1 VSS sky130_fd_pr__nfet_g5v0d10v5 w=1 l=0.5
XRn_63_1 BLN1 dn_63_1 sky130_fd_pr_reram__reram_cell area_ox=0.0676
XMp_63_2 dp_63_2 WL63 SL2 VSS sky130_fd_pr__nfet_g5v0d10v5 w=1 l=0.5
XRp_63_2 BLP2 dp_63_2 sky130_fd_pr_reram__reram_cell area_ox=0.0676
XMn_63_2 dn_63_2 WL63 SL2 VSS sky130_fd_pr__nfet_g5v0d10v5 w=1 l=0.5
XRn_63_2 BLN2 dn_63_2 sky130_fd_pr_reram__reram_cell area_ox=0.0676
XMp_63_3 dp_63_3 WL63 SL3 VSS sky130_fd_pr__nfet_g5v0d10v5 w=1 l=0.5
XRp_63_3 BLP3 dp_63_3 sky130_fd_pr_reram__reram_cell area_ox=0.0676
XMn_63_3 dn_63_3 WL63 SL3 VSS sky130_fd_pr__nfet_g5v0d10v5 w=1 l=0.5
XRn_63_3 BLN3 dn_63_3 sky130_fd_pr_reram__reram_cell area_ox=0.0676
XMp_63_4 dp_63_4 WL63 SL4 VSS sky130_fd_pr__nfet_g5v0d10v5 w=1 l=0.5
XRp_63_4 BLP4 dp_63_4 sky130_fd_pr_reram__reram_cell area_ox=0.0676
XMn_63_4 dn_63_4 WL63 SL4 VSS sky130_fd_pr__nfet_g5v0d10v5 w=1 l=0.5
XRn_63_4 BLN4 dn_63_4 sky130_fd_pr_reram__reram_cell area_ox=0.0676
XMp_63_5 dp_63_5 WL63 SL5 VSS sky130_fd_pr__nfet_g5v0d10v5 w=1 l=0.5
XRp_63_5 BLP5 dp_63_5 sky130_fd_pr_reram__reram_cell area_ox=0.0676
XMn_63_5 dn_63_5 WL63 SL5 VSS sky130_fd_pr__nfet_g5v0d10v5 w=1 l=0.5
XRn_63_5 BLN5 dn_63_5 sky130_fd_pr_reram__reram_cell area_ox=0.0676
XMp_63_6 dp_63_6 WL63 SL6 VSS sky130_fd_pr__nfet_g5v0d10v5 w=1 l=0.5
XRp_63_6 BLP6 dp_63_6 sky130_fd_pr_reram__reram_cell area_ox=0.0676
XMn_63_6 dn_63_6 WL63 SL6 VSS sky130_fd_pr__nfet_g5v0d10v5 w=1 l=0.5
XRn_63_6 BLN6 dn_63_6 sky130_fd_pr_reram__reram_cell area_ox=0.0676
XMp_63_7 dp_63_7 WL63 SL7 VSS sky130_fd_pr__nfet_g5v0d10v5 w=1 l=0.5
XRp_63_7 BLP7 dp_63_7 sky130_fd_pr_reram__reram_cell area_ox=0.0676
XMn_63_7 dn_63_7 WL63 SL7 VSS sky130_fd_pr__nfet_g5v0d10v5 w=1 l=0.5
XRn_63_7 BLN7 dn_63_7 sky130_fd_pr_reram__reram_cell area_ox=0.0676
XMp_63_8 dp_63_8 WL63 SL8 VSS sky130_fd_pr__nfet_g5v0d10v5 w=1 l=0.5
XRp_63_8 BLP8 dp_63_8 sky130_fd_pr_reram__reram_cell area_ox=0.0676
XMn_63_8 dn_63_8 WL63 SL8 VSS sky130_fd_pr__nfet_g5v0d10v5 w=1 l=0.5
XRn_63_8 BLN8 dn_63_8 sky130_fd_pr_reram__reram_cell area_ox=0.0676
XMp_63_9 dp_63_9 WL63 SL9 VSS sky130_fd_pr__nfet_g5v0d10v5 w=1 l=0.5
XRp_63_9 BLP9 dp_63_9 sky130_fd_pr_reram__reram_cell area_ox=0.0676
XMn_63_9 dn_63_9 WL63 SL9 VSS sky130_fd_pr__nfet_g5v0d10v5 w=1 l=0.5
XRn_63_9 BLN9 dn_63_9 sky130_fd_pr_reram__reram_cell area_ox=0.0676
XMp_63_10 dp_63_10 WL63 SL10 VSS sky130_fd_pr__nfet_g5v0d10v5 w=1 l=0.5
XRp_63_10 BLP10 dp_63_10 sky130_fd_pr_reram__reram_cell area_ox=0.0676
XMn_63_10 dn_63_10 WL63 SL10 VSS sky130_fd_pr__nfet_g5v0d10v5 w=1 l=0.5
XRn_63_10 BLN10 dn_63_10 sky130_fd_pr_reram__reram_cell area_ox=0.0676
XMp_63_11 dp_63_11 WL63 SL11 VSS sky130_fd_pr__nfet_g5v0d10v5 w=1 l=0.5
XRp_63_11 BLP11 dp_63_11 sky130_fd_pr_reram__reram_cell area_ox=0.0676
XMn_63_11 dn_63_11 WL63 SL11 VSS sky130_fd_pr__nfet_g5v0d10v5 w=1 l=0.5
XRn_63_11 BLN11 dn_63_11 sky130_fd_pr_reram__reram_cell area_ox=0.0676
XMp_63_12 dp_63_12 WL63 SL12 VSS sky130_fd_pr__nfet_g5v0d10v5 w=1 l=0.5
XRp_63_12 BLP12 dp_63_12 sky130_fd_pr_reram__reram_cell area_ox=0.0676
XMn_63_12 dn_63_12 WL63 SL12 VSS sky130_fd_pr__nfet_g5v0d10v5 w=1 l=0.5
XRn_63_12 BLN12 dn_63_12 sky130_fd_pr_reram__reram_cell area_ox=0.0676
XMp_63_13 dp_63_13 WL63 SL13 VSS sky130_fd_pr__nfet_g5v0d10v5 w=1 l=0.5
XRp_63_13 BLP13 dp_63_13 sky130_fd_pr_reram__reram_cell area_ox=0.0676
XMn_63_13 dn_63_13 WL63 SL13 VSS sky130_fd_pr__nfet_g5v0d10v5 w=1 l=0.5
XRn_63_13 BLN13 dn_63_13 sky130_fd_pr_reram__reram_cell area_ox=0.0676
XMp_63_14 dp_63_14 WL63 SL14 VSS sky130_fd_pr__nfet_g5v0d10v5 w=1 l=0.5
XRp_63_14 BLP14 dp_63_14 sky130_fd_pr_reram__reram_cell area_ox=0.0676
XMn_63_14 dn_63_14 WL63 SL14 VSS sky130_fd_pr__nfet_g5v0d10v5 w=1 l=0.5
XRn_63_14 BLN14 dn_63_14 sky130_fd_pr_reram__reram_cell area_ox=0.0676
XMp_63_15 dp_63_15 WL63 SL15 VSS sky130_fd_pr__nfet_g5v0d10v5 w=1 l=0.5
XRp_63_15 BLP15 dp_63_15 sky130_fd_pr_reram__reram_cell area_ox=0.0676
XMn_63_15 dn_63_15 WL63 SL15 VSS sky130_fd_pr__nfet_g5v0d10v5 w=1 l=0.5
XRn_63_15 BLN15 dn_63_15 sky130_fd_pr_reram__reram_cell area_ox=0.0676
XMp_63_16 dp_63_16 WL63 SL16 VSS sky130_fd_pr__nfet_g5v0d10v5 w=1 l=0.5
XRp_63_16 BLP16 dp_63_16 sky130_fd_pr_reram__reram_cell area_ox=0.0676
XMn_63_16 dn_63_16 WL63 SL16 VSS sky130_fd_pr__nfet_g5v0d10v5 w=1 l=0.5
XRn_63_16 BLN16 dn_63_16 sky130_fd_pr_reram__reram_cell area_ox=0.0676
XMp_63_17 dp_63_17 WL63 SL17 VSS sky130_fd_pr__nfet_g5v0d10v5 w=1 l=0.5
XRp_63_17 BLP17 dp_63_17 sky130_fd_pr_reram__reram_cell area_ox=0.0676
XMn_63_17 dn_63_17 WL63 SL17 VSS sky130_fd_pr__nfet_g5v0d10v5 w=1 l=0.5
XRn_63_17 BLN17 dn_63_17 sky130_fd_pr_reram__reram_cell area_ox=0.0676
XMp_63_18 dp_63_18 WL63 SL18 VSS sky130_fd_pr__nfet_g5v0d10v5 w=1 l=0.5
XRp_63_18 BLP18 dp_63_18 sky130_fd_pr_reram__reram_cell area_ox=0.0676
XMn_63_18 dn_63_18 WL63 SL18 VSS sky130_fd_pr__nfet_g5v0d10v5 w=1 l=0.5
XRn_63_18 BLN18 dn_63_18 sky130_fd_pr_reram__reram_cell area_ox=0.0676
XMp_63_19 dp_63_19 WL63 SL19 VSS sky130_fd_pr__nfet_g5v0d10v5 w=1 l=0.5
XRp_63_19 BLP19 dp_63_19 sky130_fd_pr_reram__reram_cell area_ox=0.0676
XMn_63_19 dn_63_19 WL63 SL19 VSS sky130_fd_pr__nfet_g5v0d10v5 w=1 l=0.5
XRn_63_19 BLN19 dn_63_19 sky130_fd_pr_reram__reram_cell area_ox=0.0676
XMp_63_20 dp_63_20 WL63 SL20 VSS sky130_fd_pr__nfet_g5v0d10v5 w=1 l=0.5
XRp_63_20 BLP20 dp_63_20 sky130_fd_pr_reram__reram_cell area_ox=0.0676
XMn_63_20 dn_63_20 WL63 SL20 VSS sky130_fd_pr__nfet_g5v0d10v5 w=1 l=0.5
XRn_63_20 BLN20 dn_63_20 sky130_fd_pr_reram__reram_cell area_ox=0.0676
XMp_63_21 dp_63_21 WL63 SL21 VSS sky130_fd_pr__nfet_g5v0d10v5 w=1 l=0.5
XRp_63_21 BLP21 dp_63_21 sky130_fd_pr_reram__reram_cell area_ox=0.0676
XMn_63_21 dn_63_21 WL63 SL21 VSS sky130_fd_pr__nfet_g5v0d10v5 w=1 l=0.5
XRn_63_21 BLN21 dn_63_21 sky130_fd_pr_reram__reram_cell area_ox=0.0676
XMp_63_22 dp_63_22 WL63 SL22 VSS sky130_fd_pr__nfet_g5v0d10v5 w=1 l=0.5
XRp_63_22 BLP22 dp_63_22 sky130_fd_pr_reram__reram_cell area_ox=0.0676
XMn_63_22 dn_63_22 WL63 SL22 VSS sky130_fd_pr__nfet_g5v0d10v5 w=1 l=0.5
XRn_63_22 BLN22 dn_63_22 sky130_fd_pr_reram__reram_cell area_ox=0.0676
XMp_63_23 dp_63_23 WL63 SL23 VSS sky130_fd_pr__nfet_g5v0d10v5 w=1 l=0.5
XRp_63_23 BLP23 dp_63_23 sky130_fd_pr_reram__reram_cell area_ox=0.0676
XMn_63_23 dn_63_23 WL63 SL23 VSS sky130_fd_pr__nfet_g5v0d10v5 w=1 l=0.5
XRn_63_23 BLN23 dn_63_23 sky130_fd_pr_reram__reram_cell area_ox=0.0676
XMp_64_0 dp_64_0 WL64 SL0 VSS sky130_fd_pr__nfet_g5v0d10v5 w=1 l=0.5
XRp_64_0 BLP0 dp_64_0 sky130_fd_pr_reram__reram_cell area_ox=0.0676
XMn_64_0 dn_64_0 WL64 SL0 VSS sky130_fd_pr__nfet_g5v0d10v5 w=1 l=0.5
XRn_64_0 BLN0 dn_64_0 sky130_fd_pr_reram__reram_cell area_ox=0.0676
XMp_64_1 dp_64_1 WL64 SL1 VSS sky130_fd_pr__nfet_g5v0d10v5 w=1 l=0.5
XRp_64_1 BLP1 dp_64_1 sky130_fd_pr_reram__reram_cell area_ox=0.0676
XMn_64_1 dn_64_1 WL64 SL1 VSS sky130_fd_pr__nfet_g5v0d10v5 w=1 l=0.5
XRn_64_1 BLN1 dn_64_1 sky130_fd_pr_reram__reram_cell area_ox=0.0676
XMp_64_2 dp_64_2 WL64 SL2 VSS sky130_fd_pr__nfet_g5v0d10v5 w=1 l=0.5
XRp_64_2 BLP2 dp_64_2 sky130_fd_pr_reram__reram_cell area_ox=0.0676
XMn_64_2 dn_64_2 WL64 SL2 VSS sky130_fd_pr__nfet_g5v0d10v5 w=1 l=0.5
XRn_64_2 BLN2 dn_64_2 sky130_fd_pr_reram__reram_cell area_ox=0.0676
XMp_64_3 dp_64_3 WL64 SL3 VSS sky130_fd_pr__nfet_g5v0d10v5 w=1 l=0.5
XRp_64_3 BLP3 dp_64_3 sky130_fd_pr_reram__reram_cell area_ox=0.0676
XMn_64_3 dn_64_3 WL64 SL3 VSS sky130_fd_pr__nfet_g5v0d10v5 w=1 l=0.5
XRn_64_3 BLN3 dn_64_3 sky130_fd_pr_reram__reram_cell area_ox=0.0676
XMp_64_4 dp_64_4 WL64 SL4 VSS sky130_fd_pr__nfet_g5v0d10v5 w=1 l=0.5
XRp_64_4 BLP4 dp_64_4 sky130_fd_pr_reram__reram_cell area_ox=0.0676
XMn_64_4 dn_64_4 WL64 SL4 VSS sky130_fd_pr__nfet_g5v0d10v5 w=1 l=0.5
XRn_64_4 BLN4 dn_64_4 sky130_fd_pr_reram__reram_cell area_ox=0.0676
XMp_64_5 dp_64_5 WL64 SL5 VSS sky130_fd_pr__nfet_g5v0d10v5 w=1 l=0.5
XRp_64_5 BLP5 dp_64_5 sky130_fd_pr_reram__reram_cell area_ox=0.0676
XMn_64_5 dn_64_5 WL64 SL5 VSS sky130_fd_pr__nfet_g5v0d10v5 w=1 l=0.5
XRn_64_5 BLN5 dn_64_5 sky130_fd_pr_reram__reram_cell area_ox=0.0676
XMp_64_6 dp_64_6 WL64 SL6 VSS sky130_fd_pr__nfet_g5v0d10v5 w=1 l=0.5
XRp_64_6 BLP6 dp_64_6 sky130_fd_pr_reram__reram_cell area_ox=0.0676
XMn_64_6 dn_64_6 WL64 SL6 VSS sky130_fd_pr__nfet_g5v0d10v5 w=1 l=0.5
XRn_64_6 BLN6 dn_64_6 sky130_fd_pr_reram__reram_cell area_ox=0.0676
XMp_64_7 dp_64_7 WL64 SL7 VSS sky130_fd_pr__nfet_g5v0d10v5 w=1 l=0.5
XRp_64_7 BLP7 dp_64_7 sky130_fd_pr_reram__reram_cell area_ox=0.0676
XMn_64_7 dn_64_7 WL64 SL7 VSS sky130_fd_pr__nfet_g5v0d10v5 w=1 l=0.5
XRn_64_7 BLN7 dn_64_7 sky130_fd_pr_reram__reram_cell area_ox=0.0676
XMp_64_8 dp_64_8 WL64 SL8 VSS sky130_fd_pr__nfet_g5v0d10v5 w=1 l=0.5
XRp_64_8 BLP8 dp_64_8 sky130_fd_pr_reram__reram_cell area_ox=0.0676
XMn_64_8 dn_64_8 WL64 SL8 VSS sky130_fd_pr__nfet_g5v0d10v5 w=1 l=0.5
XRn_64_8 BLN8 dn_64_8 sky130_fd_pr_reram__reram_cell area_ox=0.0676
XMp_64_9 dp_64_9 WL64 SL9 VSS sky130_fd_pr__nfet_g5v0d10v5 w=1 l=0.5
XRp_64_9 BLP9 dp_64_9 sky130_fd_pr_reram__reram_cell area_ox=0.0676
XMn_64_9 dn_64_9 WL64 SL9 VSS sky130_fd_pr__nfet_g5v0d10v5 w=1 l=0.5
XRn_64_9 BLN9 dn_64_9 sky130_fd_pr_reram__reram_cell area_ox=0.0676
XMp_64_10 dp_64_10 WL64 SL10 VSS sky130_fd_pr__nfet_g5v0d10v5 w=1 l=0.5
XRp_64_10 BLP10 dp_64_10 sky130_fd_pr_reram__reram_cell area_ox=0.0676
XMn_64_10 dn_64_10 WL64 SL10 VSS sky130_fd_pr__nfet_g5v0d10v5 w=1 l=0.5
XRn_64_10 BLN10 dn_64_10 sky130_fd_pr_reram__reram_cell area_ox=0.0676
XMp_64_11 dp_64_11 WL64 SL11 VSS sky130_fd_pr__nfet_g5v0d10v5 w=1 l=0.5
XRp_64_11 BLP11 dp_64_11 sky130_fd_pr_reram__reram_cell area_ox=0.0676
XMn_64_11 dn_64_11 WL64 SL11 VSS sky130_fd_pr__nfet_g5v0d10v5 w=1 l=0.5
XRn_64_11 BLN11 dn_64_11 sky130_fd_pr_reram__reram_cell area_ox=0.0676
XMp_64_12 dp_64_12 WL64 SL12 VSS sky130_fd_pr__nfet_g5v0d10v5 w=1 l=0.5
XRp_64_12 BLP12 dp_64_12 sky130_fd_pr_reram__reram_cell area_ox=0.0676
XMn_64_12 dn_64_12 WL64 SL12 VSS sky130_fd_pr__nfet_g5v0d10v5 w=1 l=0.5
XRn_64_12 BLN12 dn_64_12 sky130_fd_pr_reram__reram_cell area_ox=0.0676
XMp_64_13 dp_64_13 WL64 SL13 VSS sky130_fd_pr__nfet_g5v0d10v5 w=1 l=0.5
XRp_64_13 BLP13 dp_64_13 sky130_fd_pr_reram__reram_cell area_ox=0.0676
XMn_64_13 dn_64_13 WL64 SL13 VSS sky130_fd_pr__nfet_g5v0d10v5 w=1 l=0.5
XRn_64_13 BLN13 dn_64_13 sky130_fd_pr_reram__reram_cell area_ox=0.0676
XMp_64_14 dp_64_14 WL64 SL14 VSS sky130_fd_pr__nfet_g5v0d10v5 w=1 l=0.5
XRp_64_14 BLP14 dp_64_14 sky130_fd_pr_reram__reram_cell area_ox=0.0676
XMn_64_14 dn_64_14 WL64 SL14 VSS sky130_fd_pr__nfet_g5v0d10v5 w=1 l=0.5
XRn_64_14 BLN14 dn_64_14 sky130_fd_pr_reram__reram_cell area_ox=0.0676
XMp_64_15 dp_64_15 WL64 SL15 VSS sky130_fd_pr__nfet_g5v0d10v5 w=1 l=0.5
XRp_64_15 BLP15 dp_64_15 sky130_fd_pr_reram__reram_cell area_ox=0.0676
XMn_64_15 dn_64_15 WL64 SL15 VSS sky130_fd_pr__nfet_g5v0d10v5 w=1 l=0.5
XRn_64_15 BLN15 dn_64_15 sky130_fd_pr_reram__reram_cell area_ox=0.0676
XMp_64_16 dp_64_16 WL64 SL16 VSS sky130_fd_pr__nfet_g5v0d10v5 w=1 l=0.5
XRp_64_16 BLP16 dp_64_16 sky130_fd_pr_reram__reram_cell area_ox=0.0676
XMn_64_16 dn_64_16 WL64 SL16 VSS sky130_fd_pr__nfet_g5v0d10v5 w=1 l=0.5
XRn_64_16 BLN16 dn_64_16 sky130_fd_pr_reram__reram_cell area_ox=0.0676
XMp_64_17 dp_64_17 WL64 SL17 VSS sky130_fd_pr__nfet_g5v0d10v5 w=1 l=0.5
XRp_64_17 BLP17 dp_64_17 sky130_fd_pr_reram__reram_cell area_ox=0.0676
XMn_64_17 dn_64_17 WL64 SL17 VSS sky130_fd_pr__nfet_g5v0d10v5 w=1 l=0.5
XRn_64_17 BLN17 dn_64_17 sky130_fd_pr_reram__reram_cell area_ox=0.0676
XMp_64_18 dp_64_18 WL64 SL18 VSS sky130_fd_pr__nfet_g5v0d10v5 w=1 l=0.5
XRp_64_18 BLP18 dp_64_18 sky130_fd_pr_reram__reram_cell area_ox=0.0676
XMn_64_18 dn_64_18 WL64 SL18 VSS sky130_fd_pr__nfet_g5v0d10v5 w=1 l=0.5
XRn_64_18 BLN18 dn_64_18 sky130_fd_pr_reram__reram_cell area_ox=0.0676
XMp_64_19 dp_64_19 WL64 SL19 VSS sky130_fd_pr__nfet_g5v0d10v5 w=1 l=0.5
XRp_64_19 BLP19 dp_64_19 sky130_fd_pr_reram__reram_cell area_ox=0.0676
XMn_64_19 dn_64_19 WL64 SL19 VSS sky130_fd_pr__nfet_g5v0d10v5 w=1 l=0.5
XRn_64_19 BLN19 dn_64_19 sky130_fd_pr_reram__reram_cell area_ox=0.0676
XMp_64_20 dp_64_20 WL64 SL20 VSS sky130_fd_pr__nfet_g5v0d10v5 w=1 l=0.5
XRp_64_20 BLP20 dp_64_20 sky130_fd_pr_reram__reram_cell area_ox=0.0676
XMn_64_20 dn_64_20 WL64 SL20 VSS sky130_fd_pr__nfet_g5v0d10v5 w=1 l=0.5
XRn_64_20 BLN20 dn_64_20 sky130_fd_pr_reram__reram_cell area_ox=0.0676
XMp_64_21 dp_64_21 WL64 SL21 VSS sky130_fd_pr__nfet_g5v0d10v5 w=1 l=0.5
XRp_64_21 BLP21 dp_64_21 sky130_fd_pr_reram__reram_cell area_ox=0.0676
XMn_64_21 dn_64_21 WL64 SL21 VSS sky130_fd_pr__nfet_g5v0d10v5 w=1 l=0.5
XRn_64_21 BLN21 dn_64_21 sky130_fd_pr_reram__reram_cell area_ox=0.0676
XMp_64_22 dp_64_22 WL64 SL22 VSS sky130_fd_pr__nfet_g5v0d10v5 w=1 l=0.5
XRp_64_22 BLP22 dp_64_22 sky130_fd_pr_reram__reram_cell area_ox=0.0676
XMn_64_22 dn_64_22 WL64 SL22 VSS sky130_fd_pr__nfet_g5v0d10v5 w=1 l=0.5
XRn_64_22 BLN22 dn_64_22 sky130_fd_pr_reram__reram_cell area_ox=0.0676
XMp_64_23 dp_64_23 WL64 SL23 VSS sky130_fd_pr__nfet_g5v0d10v5 w=1 l=0.5
XRp_64_23 BLP23 dp_64_23 sky130_fd_pr_reram__reram_cell area_ox=0.0676
XMn_64_23 dn_64_23 WL64 SL23 VSS sky130_fd_pr__nfet_g5v0d10v5 w=1 l=0.5
XRn_64_23 BLN23 dn_64_23 sky130_fd_pr_reram__reram_cell area_ox=0.0676
XMp_65_0 dp_65_0 WL65 SL0 VSS sky130_fd_pr__nfet_g5v0d10v5 w=1 l=0.5
XRp_65_0 BLP0 dp_65_0 sky130_fd_pr_reram__reram_cell area_ox=0.0676
XMn_65_0 dn_65_0 WL65 SL0 VSS sky130_fd_pr__nfet_g5v0d10v5 w=1 l=0.5
XRn_65_0 BLN0 dn_65_0 sky130_fd_pr_reram__reram_cell area_ox=0.0676
XMp_65_1 dp_65_1 WL65 SL1 VSS sky130_fd_pr__nfet_g5v0d10v5 w=1 l=0.5
XRp_65_1 BLP1 dp_65_1 sky130_fd_pr_reram__reram_cell area_ox=0.0676
XMn_65_1 dn_65_1 WL65 SL1 VSS sky130_fd_pr__nfet_g5v0d10v5 w=1 l=0.5
XRn_65_1 BLN1 dn_65_1 sky130_fd_pr_reram__reram_cell area_ox=0.0676
XMp_65_2 dp_65_2 WL65 SL2 VSS sky130_fd_pr__nfet_g5v0d10v5 w=1 l=0.5
XRp_65_2 BLP2 dp_65_2 sky130_fd_pr_reram__reram_cell area_ox=0.0676
XMn_65_2 dn_65_2 WL65 SL2 VSS sky130_fd_pr__nfet_g5v0d10v5 w=1 l=0.5
XRn_65_2 BLN2 dn_65_2 sky130_fd_pr_reram__reram_cell area_ox=0.0676
XMp_65_3 dp_65_3 WL65 SL3 VSS sky130_fd_pr__nfet_g5v0d10v5 w=1 l=0.5
XRp_65_3 BLP3 dp_65_3 sky130_fd_pr_reram__reram_cell area_ox=0.0676
XMn_65_3 dn_65_3 WL65 SL3 VSS sky130_fd_pr__nfet_g5v0d10v5 w=1 l=0.5
XRn_65_3 BLN3 dn_65_3 sky130_fd_pr_reram__reram_cell area_ox=0.0676
XMp_65_4 dp_65_4 WL65 SL4 VSS sky130_fd_pr__nfet_g5v0d10v5 w=1 l=0.5
XRp_65_4 BLP4 dp_65_4 sky130_fd_pr_reram__reram_cell area_ox=0.0676
XMn_65_4 dn_65_4 WL65 SL4 VSS sky130_fd_pr__nfet_g5v0d10v5 w=1 l=0.5
XRn_65_4 BLN4 dn_65_4 sky130_fd_pr_reram__reram_cell area_ox=0.0676
XMp_65_5 dp_65_5 WL65 SL5 VSS sky130_fd_pr__nfet_g5v0d10v5 w=1 l=0.5
XRp_65_5 BLP5 dp_65_5 sky130_fd_pr_reram__reram_cell area_ox=0.0676
XMn_65_5 dn_65_5 WL65 SL5 VSS sky130_fd_pr__nfet_g5v0d10v5 w=1 l=0.5
XRn_65_5 BLN5 dn_65_5 sky130_fd_pr_reram__reram_cell area_ox=0.0676
XMp_65_6 dp_65_6 WL65 SL6 VSS sky130_fd_pr__nfet_g5v0d10v5 w=1 l=0.5
XRp_65_6 BLP6 dp_65_6 sky130_fd_pr_reram__reram_cell area_ox=0.0676
XMn_65_6 dn_65_6 WL65 SL6 VSS sky130_fd_pr__nfet_g5v0d10v5 w=1 l=0.5
XRn_65_6 BLN6 dn_65_6 sky130_fd_pr_reram__reram_cell area_ox=0.0676
XMp_65_7 dp_65_7 WL65 SL7 VSS sky130_fd_pr__nfet_g5v0d10v5 w=1 l=0.5
XRp_65_7 BLP7 dp_65_7 sky130_fd_pr_reram__reram_cell area_ox=0.0676
XMn_65_7 dn_65_7 WL65 SL7 VSS sky130_fd_pr__nfet_g5v0d10v5 w=1 l=0.5
XRn_65_7 BLN7 dn_65_7 sky130_fd_pr_reram__reram_cell area_ox=0.0676
XMp_65_8 dp_65_8 WL65 SL8 VSS sky130_fd_pr__nfet_g5v0d10v5 w=1 l=0.5
XRp_65_8 BLP8 dp_65_8 sky130_fd_pr_reram__reram_cell area_ox=0.0676
XMn_65_8 dn_65_8 WL65 SL8 VSS sky130_fd_pr__nfet_g5v0d10v5 w=1 l=0.5
XRn_65_8 BLN8 dn_65_8 sky130_fd_pr_reram__reram_cell area_ox=0.0676
XMp_65_9 dp_65_9 WL65 SL9 VSS sky130_fd_pr__nfet_g5v0d10v5 w=1 l=0.5
XRp_65_9 BLP9 dp_65_9 sky130_fd_pr_reram__reram_cell area_ox=0.0676
XMn_65_9 dn_65_9 WL65 SL9 VSS sky130_fd_pr__nfet_g5v0d10v5 w=1 l=0.5
XRn_65_9 BLN9 dn_65_9 sky130_fd_pr_reram__reram_cell area_ox=0.0676
XMp_65_10 dp_65_10 WL65 SL10 VSS sky130_fd_pr__nfet_g5v0d10v5 w=1 l=0.5
XRp_65_10 BLP10 dp_65_10 sky130_fd_pr_reram__reram_cell area_ox=0.0676
XMn_65_10 dn_65_10 WL65 SL10 VSS sky130_fd_pr__nfet_g5v0d10v5 w=1 l=0.5
XRn_65_10 BLN10 dn_65_10 sky130_fd_pr_reram__reram_cell area_ox=0.0676
XMp_65_11 dp_65_11 WL65 SL11 VSS sky130_fd_pr__nfet_g5v0d10v5 w=1 l=0.5
XRp_65_11 BLP11 dp_65_11 sky130_fd_pr_reram__reram_cell area_ox=0.0676
XMn_65_11 dn_65_11 WL65 SL11 VSS sky130_fd_pr__nfet_g5v0d10v5 w=1 l=0.5
XRn_65_11 BLN11 dn_65_11 sky130_fd_pr_reram__reram_cell area_ox=0.0676
XMp_65_12 dp_65_12 WL65 SL12 VSS sky130_fd_pr__nfet_g5v0d10v5 w=1 l=0.5
XRp_65_12 BLP12 dp_65_12 sky130_fd_pr_reram__reram_cell area_ox=0.0676
XMn_65_12 dn_65_12 WL65 SL12 VSS sky130_fd_pr__nfet_g5v0d10v5 w=1 l=0.5
XRn_65_12 BLN12 dn_65_12 sky130_fd_pr_reram__reram_cell area_ox=0.0676
XMp_65_13 dp_65_13 WL65 SL13 VSS sky130_fd_pr__nfet_g5v0d10v5 w=1 l=0.5
XRp_65_13 BLP13 dp_65_13 sky130_fd_pr_reram__reram_cell area_ox=0.0676
XMn_65_13 dn_65_13 WL65 SL13 VSS sky130_fd_pr__nfet_g5v0d10v5 w=1 l=0.5
XRn_65_13 BLN13 dn_65_13 sky130_fd_pr_reram__reram_cell area_ox=0.0676
XMp_65_14 dp_65_14 WL65 SL14 VSS sky130_fd_pr__nfet_g5v0d10v5 w=1 l=0.5
XRp_65_14 BLP14 dp_65_14 sky130_fd_pr_reram__reram_cell area_ox=0.0676
XMn_65_14 dn_65_14 WL65 SL14 VSS sky130_fd_pr__nfet_g5v0d10v5 w=1 l=0.5
XRn_65_14 BLN14 dn_65_14 sky130_fd_pr_reram__reram_cell area_ox=0.0676
XMp_65_15 dp_65_15 WL65 SL15 VSS sky130_fd_pr__nfet_g5v0d10v5 w=1 l=0.5
XRp_65_15 BLP15 dp_65_15 sky130_fd_pr_reram__reram_cell area_ox=0.0676
XMn_65_15 dn_65_15 WL65 SL15 VSS sky130_fd_pr__nfet_g5v0d10v5 w=1 l=0.5
XRn_65_15 BLN15 dn_65_15 sky130_fd_pr_reram__reram_cell area_ox=0.0676
XMp_65_16 dp_65_16 WL65 SL16 VSS sky130_fd_pr__nfet_g5v0d10v5 w=1 l=0.5
XRp_65_16 BLP16 dp_65_16 sky130_fd_pr_reram__reram_cell area_ox=0.0676
XMn_65_16 dn_65_16 WL65 SL16 VSS sky130_fd_pr__nfet_g5v0d10v5 w=1 l=0.5
XRn_65_16 BLN16 dn_65_16 sky130_fd_pr_reram__reram_cell area_ox=0.0676
XMp_65_17 dp_65_17 WL65 SL17 VSS sky130_fd_pr__nfet_g5v0d10v5 w=1 l=0.5
XRp_65_17 BLP17 dp_65_17 sky130_fd_pr_reram__reram_cell area_ox=0.0676
XMn_65_17 dn_65_17 WL65 SL17 VSS sky130_fd_pr__nfet_g5v0d10v5 w=1 l=0.5
XRn_65_17 BLN17 dn_65_17 sky130_fd_pr_reram__reram_cell area_ox=0.0676
XMp_65_18 dp_65_18 WL65 SL18 VSS sky130_fd_pr__nfet_g5v0d10v5 w=1 l=0.5
XRp_65_18 BLP18 dp_65_18 sky130_fd_pr_reram__reram_cell area_ox=0.0676
XMn_65_18 dn_65_18 WL65 SL18 VSS sky130_fd_pr__nfet_g5v0d10v5 w=1 l=0.5
XRn_65_18 BLN18 dn_65_18 sky130_fd_pr_reram__reram_cell area_ox=0.0676
XMp_65_19 dp_65_19 WL65 SL19 VSS sky130_fd_pr__nfet_g5v0d10v5 w=1 l=0.5
XRp_65_19 BLP19 dp_65_19 sky130_fd_pr_reram__reram_cell area_ox=0.0676
XMn_65_19 dn_65_19 WL65 SL19 VSS sky130_fd_pr__nfet_g5v0d10v5 w=1 l=0.5
XRn_65_19 BLN19 dn_65_19 sky130_fd_pr_reram__reram_cell area_ox=0.0676
XMp_65_20 dp_65_20 WL65 SL20 VSS sky130_fd_pr__nfet_g5v0d10v5 w=1 l=0.5
XRp_65_20 BLP20 dp_65_20 sky130_fd_pr_reram__reram_cell area_ox=0.0676
XMn_65_20 dn_65_20 WL65 SL20 VSS sky130_fd_pr__nfet_g5v0d10v5 w=1 l=0.5
XRn_65_20 BLN20 dn_65_20 sky130_fd_pr_reram__reram_cell area_ox=0.0676
XMp_65_21 dp_65_21 WL65 SL21 VSS sky130_fd_pr__nfet_g5v0d10v5 w=1 l=0.5
XRp_65_21 BLP21 dp_65_21 sky130_fd_pr_reram__reram_cell area_ox=0.0676
XMn_65_21 dn_65_21 WL65 SL21 VSS sky130_fd_pr__nfet_g5v0d10v5 w=1 l=0.5
XRn_65_21 BLN21 dn_65_21 sky130_fd_pr_reram__reram_cell area_ox=0.0676
XMp_65_22 dp_65_22 WL65 SL22 VSS sky130_fd_pr__nfet_g5v0d10v5 w=1 l=0.5
XRp_65_22 BLP22 dp_65_22 sky130_fd_pr_reram__reram_cell area_ox=0.0676
XMn_65_22 dn_65_22 WL65 SL22 VSS sky130_fd_pr__nfet_g5v0d10v5 w=1 l=0.5
XRn_65_22 BLN22 dn_65_22 sky130_fd_pr_reram__reram_cell area_ox=0.0676
XMp_65_23 dp_65_23 WL65 SL23 VSS sky130_fd_pr__nfet_g5v0d10v5 w=1 l=0.5
XRp_65_23 BLP23 dp_65_23 sky130_fd_pr_reram__reram_cell area_ox=0.0676
XMn_65_23 dn_65_23 WL65 SL23 VSS sky130_fd_pr__nfet_g5v0d10v5 w=1 l=0.5
XRn_65_23 BLN23 dn_65_23 sky130_fd_pr_reram__reram_cell area_ox=0.0676
XMp_66_0 dp_66_0 WL66 SL0 VSS sky130_fd_pr__nfet_g5v0d10v5 w=1 l=0.5
XRp_66_0 BLP0 dp_66_0 sky130_fd_pr_reram__reram_cell area_ox=0.0676
XMn_66_0 dn_66_0 WL66 SL0 VSS sky130_fd_pr__nfet_g5v0d10v5 w=1 l=0.5
XRn_66_0 BLN0 dn_66_0 sky130_fd_pr_reram__reram_cell area_ox=0.0676
XMp_66_1 dp_66_1 WL66 SL1 VSS sky130_fd_pr__nfet_g5v0d10v5 w=1 l=0.5
XRp_66_1 BLP1 dp_66_1 sky130_fd_pr_reram__reram_cell area_ox=0.0676
XMn_66_1 dn_66_1 WL66 SL1 VSS sky130_fd_pr__nfet_g5v0d10v5 w=1 l=0.5
XRn_66_1 BLN1 dn_66_1 sky130_fd_pr_reram__reram_cell area_ox=0.0676
XMp_66_2 dp_66_2 WL66 SL2 VSS sky130_fd_pr__nfet_g5v0d10v5 w=1 l=0.5
XRp_66_2 BLP2 dp_66_2 sky130_fd_pr_reram__reram_cell area_ox=0.0676
XMn_66_2 dn_66_2 WL66 SL2 VSS sky130_fd_pr__nfet_g5v0d10v5 w=1 l=0.5
XRn_66_2 BLN2 dn_66_2 sky130_fd_pr_reram__reram_cell area_ox=0.0676
XMp_66_3 dp_66_3 WL66 SL3 VSS sky130_fd_pr__nfet_g5v0d10v5 w=1 l=0.5
XRp_66_3 BLP3 dp_66_3 sky130_fd_pr_reram__reram_cell area_ox=0.0676
XMn_66_3 dn_66_3 WL66 SL3 VSS sky130_fd_pr__nfet_g5v0d10v5 w=1 l=0.5
XRn_66_3 BLN3 dn_66_3 sky130_fd_pr_reram__reram_cell area_ox=0.0676
XMp_66_4 dp_66_4 WL66 SL4 VSS sky130_fd_pr__nfet_g5v0d10v5 w=1 l=0.5
XRp_66_4 BLP4 dp_66_4 sky130_fd_pr_reram__reram_cell area_ox=0.0676
XMn_66_4 dn_66_4 WL66 SL4 VSS sky130_fd_pr__nfet_g5v0d10v5 w=1 l=0.5
XRn_66_4 BLN4 dn_66_4 sky130_fd_pr_reram__reram_cell area_ox=0.0676
XMp_66_5 dp_66_5 WL66 SL5 VSS sky130_fd_pr__nfet_g5v0d10v5 w=1 l=0.5
XRp_66_5 BLP5 dp_66_5 sky130_fd_pr_reram__reram_cell area_ox=0.0676
XMn_66_5 dn_66_5 WL66 SL5 VSS sky130_fd_pr__nfet_g5v0d10v5 w=1 l=0.5
XRn_66_5 BLN5 dn_66_5 sky130_fd_pr_reram__reram_cell area_ox=0.0676
XMp_66_6 dp_66_6 WL66 SL6 VSS sky130_fd_pr__nfet_g5v0d10v5 w=1 l=0.5
XRp_66_6 BLP6 dp_66_6 sky130_fd_pr_reram__reram_cell area_ox=0.0676
XMn_66_6 dn_66_6 WL66 SL6 VSS sky130_fd_pr__nfet_g5v0d10v5 w=1 l=0.5
XRn_66_6 BLN6 dn_66_6 sky130_fd_pr_reram__reram_cell area_ox=0.0676
XMp_66_7 dp_66_7 WL66 SL7 VSS sky130_fd_pr__nfet_g5v0d10v5 w=1 l=0.5
XRp_66_7 BLP7 dp_66_7 sky130_fd_pr_reram__reram_cell area_ox=0.0676
XMn_66_7 dn_66_7 WL66 SL7 VSS sky130_fd_pr__nfet_g5v0d10v5 w=1 l=0.5
XRn_66_7 BLN7 dn_66_7 sky130_fd_pr_reram__reram_cell area_ox=0.0676
XMp_66_8 dp_66_8 WL66 SL8 VSS sky130_fd_pr__nfet_g5v0d10v5 w=1 l=0.5
XRp_66_8 BLP8 dp_66_8 sky130_fd_pr_reram__reram_cell area_ox=0.0676
XMn_66_8 dn_66_8 WL66 SL8 VSS sky130_fd_pr__nfet_g5v0d10v5 w=1 l=0.5
XRn_66_8 BLN8 dn_66_8 sky130_fd_pr_reram__reram_cell area_ox=0.0676
XMp_66_9 dp_66_9 WL66 SL9 VSS sky130_fd_pr__nfet_g5v0d10v5 w=1 l=0.5
XRp_66_9 BLP9 dp_66_9 sky130_fd_pr_reram__reram_cell area_ox=0.0676
XMn_66_9 dn_66_9 WL66 SL9 VSS sky130_fd_pr__nfet_g5v0d10v5 w=1 l=0.5
XRn_66_9 BLN9 dn_66_9 sky130_fd_pr_reram__reram_cell area_ox=0.0676
XMp_66_10 dp_66_10 WL66 SL10 VSS sky130_fd_pr__nfet_g5v0d10v5 w=1 l=0.5
XRp_66_10 BLP10 dp_66_10 sky130_fd_pr_reram__reram_cell area_ox=0.0676
XMn_66_10 dn_66_10 WL66 SL10 VSS sky130_fd_pr__nfet_g5v0d10v5 w=1 l=0.5
XRn_66_10 BLN10 dn_66_10 sky130_fd_pr_reram__reram_cell area_ox=0.0676
XMp_66_11 dp_66_11 WL66 SL11 VSS sky130_fd_pr__nfet_g5v0d10v5 w=1 l=0.5
XRp_66_11 BLP11 dp_66_11 sky130_fd_pr_reram__reram_cell area_ox=0.0676
XMn_66_11 dn_66_11 WL66 SL11 VSS sky130_fd_pr__nfet_g5v0d10v5 w=1 l=0.5
XRn_66_11 BLN11 dn_66_11 sky130_fd_pr_reram__reram_cell area_ox=0.0676
XMp_66_12 dp_66_12 WL66 SL12 VSS sky130_fd_pr__nfet_g5v0d10v5 w=1 l=0.5
XRp_66_12 BLP12 dp_66_12 sky130_fd_pr_reram__reram_cell area_ox=0.0676
XMn_66_12 dn_66_12 WL66 SL12 VSS sky130_fd_pr__nfet_g5v0d10v5 w=1 l=0.5
XRn_66_12 BLN12 dn_66_12 sky130_fd_pr_reram__reram_cell area_ox=0.0676
XMp_66_13 dp_66_13 WL66 SL13 VSS sky130_fd_pr__nfet_g5v0d10v5 w=1 l=0.5
XRp_66_13 BLP13 dp_66_13 sky130_fd_pr_reram__reram_cell area_ox=0.0676
XMn_66_13 dn_66_13 WL66 SL13 VSS sky130_fd_pr__nfet_g5v0d10v5 w=1 l=0.5
XRn_66_13 BLN13 dn_66_13 sky130_fd_pr_reram__reram_cell area_ox=0.0676
XMp_66_14 dp_66_14 WL66 SL14 VSS sky130_fd_pr__nfet_g5v0d10v5 w=1 l=0.5
XRp_66_14 BLP14 dp_66_14 sky130_fd_pr_reram__reram_cell area_ox=0.0676
XMn_66_14 dn_66_14 WL66 SL14 VSS sky130_fd_pr__nfet_g5v0d10v5 w=1 l=0.5
XRn_66_14 BLN14 dn_66_14 sky130_fd_pr_reram__reram_cell area_ox=0.0676
XMp_66_15 dp_66_15 WL66 SL15 VSS sky130_fd_pr__nfet_g5v0d10v5 w=1 l=0.5
XRp_66_15 BLP15 dp_66_15 sky130_fd_pr_reram__reram_cell area_ox=0.0676
XMn_66_15 dn_66_15 WL66 SL15 VSS sky130_fd_pr__nfet_g5v0d10v5 w=1 l=0.5
XRn_66_15 BLN15 dn_66_15 sky130_fd_pr_reram__reram_cell area_ox=0.0676
XMp_66_16 dp_66_16 WL66 SL16 VSS sky130_fd_pr__nfet_g5v0d10v5 w=1 l=0.5
XRp_66_16 BLP16 dp_66_16 sky130_fd_pr_reram__reram_cell area_ox=0.0676
XMn_66_16 dn_66_16 WL66 SL16 VSS sky130_fd_pr__nfet_g5v0d10v5 w=1 l=0.5
XRn_66_16 BLN16 dn_66_16 sky130_fd_pr_reram__reram_cell area_ox=0.0676
XMp_66_17 dp_66_17 WL66 SL17 VSS sky130_fd_pr__nfet_g5v0d10v5 w=1 l=0.5
XRp_66_17 BLP17 dp_66_17 sky130_fd_pr_reram__reram_cell area_ox=0.0676
XMn_66_17 dn_66_17 WL66 SL17 VSS sky130_fd_pr__nfet_g5v0d10v5 w=1 l=0.5
XRn_66_17 BLN17 dn_66_17 sky130_fd_pr_reram__reram_cell area_ox=0.0676
XMp_66_18 dp_66_18 WL66 SL18 VSS sky130_fd_pr__nfet_g5v0d10v5 w=1 l=0.5
XRp_66_18 BLP18 dp_66_18 sky130_fd_pr_reram__reram_cell area_ox=0.0676
XMn_66_18 dn_66_18 WL66 SL18 VSS sky130_fd_pr__nfet_g5v0d10v5 w=1 l=0.5
XRn_66_18 BLN18 dn_66_18 sky130_fd_pr_reram__reram_cell area_ox=0.0676
XMp_66_19 dp_66_19 WL66 SL19 VSS sky130_fd_pr__nfet_g5v0d10v5 w=1 l=0.5
XRp_66_19 BLP19 dp_66_19 sky130_fd_pr_reram__reram_cell area_ox=0.0676
XMn_66_19 dn_66_19 WL66 SL19 VSS sky130_fd_pr__nfet_g5v0d10v5 w=1 l=0.5
XRn_66_19 BLN19 dn_66_19 sky130_fd_pr_reram__reram_cell area_ox=0.0676
XMp_66_20 dp_66_20 WL66 SL20 VSS sky130_fd_pr__nfet_g5v0d10v5 w=1 l=0.5
XRp_66_20 BLP20 dp_66_20 sky130_fd_pr_reram__reram_cell area_ox=0.0676
XMn_66_20 dn_66_20 WL66 SL20 VSS sky130_fd_pr__nfet_g5v0d10v5 w=1 l=0.5
XRn_66_20 BLN20 dn_66_20 sky130_fd_pr_reram__reram_cell area_ox=0.0676
XMp_66_21 dp_66_21 WL66 SL21 VSS sky130_fd_pr__nfet_g5v0d10v5 w=1 l=0.5
XRp_66_21 BLP21 dp_66_21 sky130_fd_pr_reram__reram_cell area_ox=0.0676
XMn_66_21 dn_66_21 WL66 SL21 VSS sky130_fd_pr__nfet_g5v0d10v5 w=1 l=0.5
XRn_66_21 BLN21 dn_66_21 sky130_fd_pr_reram__reram_cell area_ox=0.0676
XMp_66_22 dp_66_22 WL66 SL22 VSS sky130_fd_pr__nfet_g5v0d10v5 w=1 l=0.5
XRp_66_22 BLP22 dp_66_22 sky130_fd_pr_reram__reram_cell area_ox=0.0676
XMn_66_22 dn_66_22 WL66 SL22 VSS sky130_fd_pr__nfet_g5v0d10v5 w=1 l=0.5
XRn_66_22 BLN22 dn_66_22 sky130_fd_pr_reram__reram_cell area_ox=0.0676
XMp_66_23 dp_66_23 WL66 SL23 VSS sky130_fd_pr__nfet_g5v0d10v5 w=1 l=0.5
XRp_66_23 BLP23 dp_66_23 sky130_fd_pr_reram__reram_cell area_ox=0.0676
XMn_66_23 dn_66_23 WL66 SL23 VSS sky130_fd_pr__nfet_g5v0d10v5 w=1 l=0.5
XRn_66_23 BLN23 dn_66_23 sky130_fd_pr_reram__reram_cell area_ox=0.0676
XMp_67_0 dp_67_0 WL67 SL0 VSS sky130_fd_pr__nfet_g5v0d10v5 w=1 l=0.5
XRp_67_0 BLP0 dp_67_0 sky130_fd_pr_reram__reram_cell area_ox=0.0676
XMn_67_0 dn_67_0 WL67 SL0 VSS sky130_fd_pr__nfet_g5v0d10v5 w=1 l=0.5
XRn_67_0 BLN0 dn_67_0 sky130_fd_pr_reram__reram_cell area_ox=0.0676
XMp_67_1 dp_67_1 WL67 SL1 VSS sky130_fd_pr__nfet_g5v0d10v5 w=1 l=0.5
XRp_67_1 BLP1 dp_67_1 sky130_fd_pr_reram__reram_cell area_ox=0.0676
XMn_67_1 dn_67_1 WL67 SL1 VSS sky130_fd_pr__nfet_g5v0d10v5 w=1 l=0.5
XRn_67_1 BLN1 dn_67_1 sky130_fd_pr_reram__reram_cell area_ox=0.0676
XMp_67_2 dp_67_2 WL67 SL2 VSS sky130_fd_pr__nfet_g5v0d10v5 w=1 l=0.5
XRp_67_2 BLP2 dp_67_2 sky130_fd_pr_reram__reram_cell area_ox=0.0676
XMn_67_2 dn_67_2 WL67 SL2 VSS sky130_fd_pr__nfet_g5v0d10v5 w=1 l=0.5
XRn_67_2 BLN2 dn_67_2 sky130_fd_pr_reram__reram_cell area_ox=0.0676
XMp_67_3 dp_67_3 WL67 SL3 VSS sky130_fd_pr__nfet_g5v0d10v5 w=1 l=0.5
XRp_67_3 BLP3 dp_67_3 sky130_fd_pr_reram__reram_cell area_ox=0.0676
XMn_67_3 dn_67_3 WL67 SL3 VSS sky130_fd_pr__nfet_g5v0d10v5 w=1 l=0.5
XRn_67_3 BLN3 dn_67_3 sky130_fd_pr_reram__reram_cell area_ox=0.0676
XMp_67_4 dp_67_4 WL67 SL4 VSS sky130_fd_pr__nfet_g5v0d10v5 w=1 l=0.5
XRp_67_4 BLP4 dp_67_4 sky130_fd_pr_reram__reram_cell area_ox=0.0676
XMn_67_4 dn_67_4 WL67 SL4 VSS sky130_fd_pr__nfet_g5v0d10v5 w=1 l=0.5
XRn_67_4 BLN4 dn_67_4 sky130_fd_pr_reram__reram_cell area_ox=0.0676
XMp_67_5 dp_67_5 WL67 SL5 VSS sky130_fd_pr__nfet_g5v0d10v5 w=1 l=0.5
XRp_67_5 BLP5 dp_67_5 sky130_fd_pr_reram__reram_cell area_ox=0.0676
XMn_67_5 dn_67_5 WL67 SL5 VSS sky130_fd_pr__nfet_g5v0d10v5 w=1 l=0.5
XRn_67_5 BLN5 dn_67_5 sky130_fd_pr_reram__reram_cell area_ox=0.0676
XMp_67_6 dp_67_6 WL67 SL6 VSS sky130_fd_pr__nfet_g5v0d10v5 w=1 l=0.5
XRp_67_6 BLP6 dp_67_6 sky130_fd_pr_reram__reram_cell area_ox=0.0676
XMn_67_6 dn_67_6 WL67 SL6 VSS sky130_fd_pr__nfet_g5v0d10v5 w=1 l=0.5
XRn_67_6 BLN6 dn_67_6 sky130_fd_pr_reram__reram_cell area_ox=0.0676
XMp_67_7 dp_67_7 WL67 SL7 VSS sky130_fd_pr__nfet_g5v0d10v5 w=1 l=0.5
XRp_67_7 BLP7 dp_67_7 sky130_fd_pr_reram__reram_cell area_ox=0.0676
XMn_67_7 dn_67_7 WL67 SL7 VSS sky130_fd_pr__nfet_g5v0d10v5 w=1 l=0.5
XRn_67_7 BLN7 dn_67_7 sky130_fd_pr_reram__reram_cell area_ox=0.0676
XMp_67_8 dp_67_8 WL67 SL8 VSS sky130_fd_pr__nfet_g5v0d10v5 w=1 l=0.5
XRp_67_8 BLP8 dp_67_8 sky130_fd_pr_reram__reram_cell area_ox=0.0676
XMn_67_8 dn_67_8 WL67 SL8 VSS sky130_fd_pr__nfet_g5v0d10v5 w=1 l=0.5
XRn_67_8 BLN8 dn_67_8 sky130_fd_pr_reram__reram_cell area_ox=0.0676
XMp_67_9 dp_67_9 WL67 SL9 VSS sky130_fd_pr__nfet_g5v0d10v5 w=1 l=0.5
XRp_67_9 BLP9 dp_67_9 sky130_fd_pr_reram__reram_cell area_ox=0.0676
XMn_67_9 dn_67_9 WL67 SL9 VSS sky130_fd_pr__nfet_g5v0d10v5 w=1 l=0.5
XRn_67_9 BLN9 dn_67_9 sky130_fd_pr_reram__reram_cell area_ox=0.0676
XMp_67_10 dp_67_10 WL67 SL10 VSS sky130_fd_pr__nfet_g5v0d10v5 w=1 l=0.5
XRp_67_10 BLP10 dp_67_10 sky130_fd_pr_reram__reram_cell area_ox=0.0676
XMn_67_10 dn_67_10 WL67 SL10 VSS sky130_fd_pr__nfet_g5v0d10v5 w=1 l=0.5
XRn_67_10 BLN10 dn_67_10 sky130_fd_pr_reram__reram_cell area_ox=0.0676
XMp_67_11 dp_67_11 WL67 SL11 VSS sky130_fd_pr__nfet_g5v0d10v5 w=1 l=0.5
XRp_67_11 BLP11 dp_67_11 sky130_fd_pr_reram__reram_cell area_ox=0.0676
XMn_67_11 dn_67_11 WL67 SL11 VSS sky130_fd_pr__nfet_g5v0d10v5 w=1 l=0.5
XRn_67_11 BLN11 dn_67_11 sky130_fd_pr_reram__reram_cell area_ox=0.0676
XMp_67_12 dp_67_12 WL67 SL12 VSS sky130_fd_pr__nfet_g5v0d10v5 w=1 l=0.5
XRp_67_12 BLP12 dp_67_12 sky130_fd_pr_reram__reram_cell area_ox=0.0676
XMn_67_12 dn_67_12 WL67 SL12 VSS sky130_fd_pr__nfet_g5v0d10v5 w=1 l=0.5
XRn_67_12 BLN12 dn_67_12 sky130_fd_pr_reram__reram_cell area_ox=0.0676
XMp_67_13 dp_67_13 WL67 SL13 VSS sky130_fd_pr__nfet_g5v0d10v5 w=1 l=0.5
XRp_67_13 BLP13 dp_67_13 sky130_fd_pr_reram__reram_cell area_ox=0.0676
XMn_67_13 dn_67_13 WL67 SL13 VSS sky130_fd_pr__nfet_g5v0d10v5 w=1 l=0.5
XRn_67_13 BLN13 dn_67_13 sky130_fd_pr_reram__reram_cell area_ox=0.0676
XMp_67_14 dp_67_14 WL67 SL14 VSS sky130_fd_pr__nfet_g5v0d10v5 w=1 l=0.5
XRp_67_14 BLP14 dp_67_14 sky130_fd_pr_reram__reram_cell area_ox=0.0676
XMn_67_14 dn_67_14 WL67 SL14 VSS sky130_fd_pr__nfet_g5v0d10v5 w=1 l=0.5
XRn_67_14 BLN14 dn_67_14 sky130_fd_pr_reram__reram_cell area_ox=0.0676
XMp_67_15 dp_67_15 WL67 SL15 VSS sky130_fd_pr__nfet_g5v0d10v5 w=1 l=0.5
XRp_67_15 BLP15 dp_67_15 sky130_fd_pr_reram__reram_cell area_ox=0.0676
XMn_67_15 dn_67_15 WL67 SL15 VSS sky130_fd_pr__nfet_g5v0d10v5 w=1 l=0.5
XRn_67_15 BLN15 dn_67_15 sky130_fd_pr_reram__reram_cell area_ox=0.0676
XMp_67_16 dp_67_16 WL67 SL16 VSS sky130_fd_pr__nfet_g5v0d10v5 w=1 l=0.5
XRp_67_16 BLP16 dp_67_16 sky130_fd_pr_reram__reram_cell area_ox=0.0676
XMn_67_16 dn_67_16 WL67 SL16 VSS sky130_fd_pr__nfet_g5v0d10v5 w=1 l=0.5
XRn_67_16 BLN16 dn_67_16 sky130_fd_pr_reram__reram_cell area_ox=0.0676
XMp_67_17 dp_67_17 WL67 SL17 VSS sky130_fd_pr__nfet_g5v0d10v5 w=1 l=0.5
XRp_67_17 BLP17 dp_67_17 sky130_fd_pr_reram__reram_cell area_ox=0.0676
XMn_67_17 dn_67_17 WL67 SL17 VSS sky130_fd_pr__nfet_g5v0d10v5 w=1 l=0.5
XRn_67_17 BLN17 dn_67_17 sky130_fd_pr_reram__reram_cell area_ox=0.0676
XMp_67_18 dp_67_18 WL67 SL18 VSS sky130_fd_pr__nfet_g5v0d10v5 w=1 l=0.5
XRp_67_18 BLP18 dp_67_18 sky130_fd_pr_reram__reram_cell area_ox=0.0676
XMn_67_18 dn_67_18 WL67 SL18 VSS sky130_fd_pr__nfet_g5v0d10v5 w=1 l=0.5
XRn_67_18 BLN18 dn_67_18 sky130_fd_pr_reram__reram_cell area_ox=0.0676
XMp_67_19 dp_67_19 WL67 SL19 VSS sky130_fd_pr__nfet_g5v0d10v5 w=1 l=0.5
XRp_67_19 BLP19 dp_67_19 sky130_fd_pr_reram__reram_cell area_ox=0.0676
XMn_67_19 dn_67_19 WL67 SL19 VSS sky130_fd_pr__nfet_g5v0d10v5 w=1 l=0.5
XRn_67_19 BLN19 dn_67_19 sky130_fd_pr_reram__reram_cell area_ox=0.0676
XMp_67_20 dp_67_20 WL67 SL20 VSS sky130_fd_pr__nfet_g5v0d10v5 w=1 l=0.5
XRp_67_20 BLP20 dp_67_20 sky130_fd_pr_reram__reram_cell area_ox=0.0676
XMn_67_20 dn_67_20 WL67 SL20 VSS sky130_fd_pr__nfet_g5v0d10v5 w=1 l=0.5
XRn_67_20 BLN20 dn_67_20 sky130_fd_pr_reram__reram_cell area_ox=0.0676
XMp_67_21 dp_67_21 WL67 SL21 VSS sky130_fd_pr__nfet_g5v0d10v5 w=1 l=0.5
XRp_67_21 BLP21 dp_67_21 sky130_fd_pr_reram__reram_cell area_ox=0.0676
XMn_67_21 dn_67_21 WL67 SL21 VSS sky130_fd_pr__nfet_g5v0d10v5 w=1 l=0.5
XRn_67_21 BLN21 dn_67_21 sky130_fd_pr_reram__reram_cell area_ox=0.0676
XMp_67_22 dp_67_22 WL67 SL22 VSS sky130_fd_pr__nfet_g5v0d10v5 w=1 l=0.5
XRp_67_22 BLP22 dp_67_22 sky130_fd_pr_reram__reram_cell area_ox=0.0676
XMn_67_22 dn_67_22 WL67 SL22 VSS sky130_fd_pr__nfet_g5v0d10v5 w=1 l=0.5
XRn_67_22 BLN22 dn_67_22 sky130_fd_pr_reram__reram_cell area_ox=0.0676
XMp_67_23 dp_67_23 WL67 SL23 VSS sky130_fd_pr__nfet_g5v0d10v5 w=1 l=0.5
XRp_67_23 BLP23 dp_67_23 sky130_fd_pr_reram__reram_cell area_ox=0.0676
XMn_67_23 dn_67_23 WL67 SL23 VSS sky130_fd_pr__nfet_g5v0d10v5 w=1 l=0.5
XRn_67_23 BLN23 dn_67_23 sky130_fd_pr_reram__reram_cell area_ox=0.0676
XMp_68_0 dp_68_0 WL68 SL0 VSS sky130_fd_pr__nfet_g5v0d10v5 w=1 l=0.5
XRp_68_0 BLP0 dp_68_0 sky130_fd_pr_reram__reram_cell area_ox=0.0676
XMn_68_0 dn_68_0 WL68 SL0 VSS sky130_fd_pr__nfet_g5v0d10v5 w=1 l=0.5
XRn_68_0 BLN0 dn_68_0 sky130_fd_pr_reram__reram_cell area_ox=0.0676
XMp_68_1 dp_68_1 WL68 SL1 VSS sky130_fd_pr__nfet_g5v0d10v5 w=1 l=0.5
XRp_68_1 BLP1 dp_68_1 sky130_fd_pr_reram__reram_cell area_ox=0.0676
XMn_68_1 dn_68_1 WL68 SL1 VSS sky130_fd_pr__nfet_g5v0d10v5 w=1 l=0.5
XRn_68_1 BLN1 dn_68_1 sky130_fd_pr_reram__reram_cell area_ox=0.0676
XMp_68_2 dp_68_2 WL68 SL2 VSS sky130_fd_pr__nfet_g5v0d10v5 w=1 l=0.5
XRp_68_2 BLP2 dp_68_2 sky130_fd_pr_reram__reram_cell area_ox=0.0676
XMn_68_2 dn_68_2 WL68 SL2 VSS sky130_fd_pr__nfet_g5v0d10v5 w=1 l=0.5
XRn_68_2 BLN2 dn_68_2 sky130_fd_pr_reram__reram_cell area_ox=0.0676
XMp_68_3 dp_68_3 WL68 SL3 VSS sky130_fd_pr__nfet_g5v0d10v5 w=1 l=0.5
XRp_68_3 BLP3 dp_68_3 sky130_fd_pr_reram__reram_cell area_ox=0.0676
XMn_68_3 dn_68_3 WL68 SL3 VSS sky130_fd_pr__nfet_g5v0d10v5 w=1 l=0.5
XRn_68_3 BLN3 dn_68_3 sky130_fd_pr_reram__reram_cell area_ox=0.0676
XMp_68_4 dp_68_4 WL68 SL4 VSS sky130_fd_pr__nfet_g5v0d10v5 w=1 l=0.5
XRp_68_4 BLP4 dp_68_4 sky130_fd_pr_reram__reram_cell area_ox=0.0676
XMn_68_4 dn_68_4 WL68 SL4 VSS sky130_fd_pr__nfet_g5v0d10v5 w=1 l=0.5
XRn_68_4 BLN4 dn_68_4 sky130_fd_pr_reram__reram_cell area_ox=0.0676
XMp_68_5 dp_68_5 WL68 SL5 VSS sky130_fd_pr__nfet_g5v0d10v5 w=1 l=0.5
XRp_68_5 BLP5 dp_68_5 sky130_fd_pr_reram__reram_cell area_ox=0.0676
XMn_68_5 dn_68_5 WL68 SL5 VSS sky130_fd_pr__nfet_g5v0d10v5 w=1 l=0.5
XRn_68_5 BLN5 dn_68_5 sky130_fd_pr_reram__reram_cell area_ox=0.0676
XMp_68_6 dp_68_6 WL68 SL6 VSS sky130_fd_pr__nfet_g5v0d10v5 w=1 l=0.5
XRp_68_6 BLP6 dp_68_6 sky130_fd_pr_reram__reram_cell area_ox=0.0676
XMn_68_6 dn_68_6 WL68 SL6 VSS sky130_fd_pr__nfet_g5v0d10v5 w=1 l=0.5
XRn_68_6 BLN6 dn_68_6 sky130_fd_pr_reram__reram_cell area_ox=0.0676
XMp_68_7 dp_68_7 WL68 SL7 VSS sky130_fd_pr__nfet_g5v0d10v5 w=1 l=0.5
XRp_68_7 BLP7 dp_68_7 sky130_fd_pr_reram__reram_cell area_ox=0.0676
XMn_68_7 dn_68_7 WL68 SL7 VSS sky130_fd_pr__nfet_g5v0d10v5 w=1 l=0.5
XRn_68_7 BLN7 dn_68_7 sky130_fd_pr_reram__reram_cell area_ox=0.0676
XMp_68_8 dp_68_8 WL68 SL8 VSS sky130_fd_pr__nfet_g5v0d10v5 w=1 l=0.5
XRp_68_8 BLP8 dp_68_8 sky130_fd_pr_reram__reram_cell area_ox=0.0676
XMn_68_8 dn_68_8 WL68 SL8 VSS sky130_fd_pr__nfet_g5v0d10v5 w=1 l=0.5
XRn_68_8 BLN8 dn_68_8 sky130_fd_pr_reram__reram_cell area_ox=0.0676
XMp_68_9 dp_68_9 WL68 SL9 VSS sky130_fd_pr__nfet_g5v0d10v5 w=1 l=0.5
XRp_68_9 BLP9 dp_68_9 sky130_fd_pr_reram__reram_cell area_ox=0.0676
XMn_68_9 dn_68_9 WL68 SL9 VSS sky130_fd_pr__nfet_g5v0d10v5 w=1 l=0.5
XRn_68_9 BLN9 dn_68_9 sky130_fd_pr_reram__reram_cell area_ox=0.0676
XMp_68_10 dp_68_10 WL68 SL10 VSS sky130_fd_pr__nfet_g5v0d10v5 w=1 l=0.5
XRp_68_10 BLP10 dp_68_10 sky130_fd_pr_reram__reram_cell area_ox=0.0676
XMn_68_10 dn_68_10 WL68 SL10 VSS sky130_fd_pr__nfet_g5v0d10v5 w=1 l=0.5
XRn_68_10 BLN10 dn_68_10 sky130_fd_pr_reram__reram_cell area_ox=0.0676
XMp_68_11 dp_68_11 WL68 SL11 VSS sky130_fd_pr__nfet_g5v0d10v5 w=1 l=0.5
XRp_68_11 BLP11 dp_68_11 sky130_fd_pr_reram__reram_cell area_ox=0.0676
XMn_68_11 dn_68_11 WL68 SL11 VSS sky130_fd_pr__nfet_g5v0d10v5 w=1 l=0.5
XRn_68_11 BLN11 dn_68_11 sky130_fd_pr_reram__reram_cell area_ox=0.0676
XMp_68_12 dp_68_12 WL68 SL12 VSS sky130_fd_pr__nfet_g5v0d10v5 w=1 l=0.5
XRp_68_12 BLP12 dp_68_12 sky130_fd_pr_reram__reram_cell area_ox=0.0676
XMn_68_12 dn_68_12 WL68 SL12 VSS sky130_fd_pr__nfet_g5v0d10v5 w=1 l=0.5
XRn_68_12 BLN12 dn_68_12 sky130_fd_pr_reram__reram_cell area_ox=0.0676
XMp_68_13 dp_68_13 WL68 SL13 VSS sky130_fd_pr__nfet_g5v0d10v5 w=1 l=0.5
XRp_68_13 BLP13 dp_68_13 sky130_fd_pr_reram__reram_cell area_ox=0.0676
XMn_68_13 dn_68_13 WL68 SL13 VSS sky130_fd_pr__nfet_g5v0d10v5 w=1 l=0.5
XRn_68_13 BLN13 dn_68_13 sky130_fd_pr_reram__reram_cell area_ox=0.0676
XMp_68_14 dp_68_14 WL68 SL14 VSS sky130_fd_pr__nfet_g5v0d10v5 w=1 l=0.5
XRp_68_14 BLP14 dp_68_14 sky130_fd_pr_reram__reram_cell area_ox=0.0676
XMn_68_14 dn_68_14 WL68 SL14 VSS sky130_fd_pr__nfet_g5v0d10v5 w=1 l=0.5
XRn_68_14 BLN14 dn_68_14 sky130_fd_pr_reram__reram_cell area_ox=0.0676
XMp_68_15 dp_68_15 WL68 SL15 VSS sky130_fd_pr__nfet_g5v0d10v5 w=1 l=0.5
XRp_68_15 BLP15 dp_68_15 sky130_fd_pr_reram__reram_cell area_ox=0.0676
XMn_68_15 dn_68_15 WL68 SL15 VSS sky130_fd_pr__nfet_g5v0d10v5 w=1 l=0.5
XRn_68_15 BLN15 dn_68_15 sky130_fd_pr_reram__reram_cell area_ox=0.0676
XMp_68_16 dp_68_16 WL68 SL16 VSS sky130_fd_pr__nfet_g5v0d10v5 w=1 l=0.5
XRp_68_16 BLP16 dp_68_16 sky130_fd_pr_reram__reram_cell area_ox=0.0676
XMn_68_16 dn_68_16 WL68 SL16 VSS sky130_fd_pr__nfet_g5v0d10v5 w=1 l=0.5
XRn_68_16 BLN16 dn_68_16 sky130_fd_pr_reram__reram_cell area_ox=0.0676
XMp_68_17 dp_68_17 WL68 SL17 VSS sky130_fd_pr__nfet_g5v0d10v5 w=1 l=0.5
XRp_68_17 BLP17 dp_68_17 sky130_fd_pr_reram__reram_cell area_ox=0.0676
XMn_68_17 dn_68_17 WL68 SL17 VSS sky130_fd_pr__nfet_g5v0d10v5 w=1 l=0.5
XRn_68_17 BLN17 dn_68_17 sky130_fd_pr_reram__reram_cell area_ox=0.0676
XMp_68_18 dp_68_18 WL68 SL18 VSS sky130_fd_pr__nfet_g5v0d10v5 w=1 l=0.5
XRp_68_18 BLP18 dp_68_18 sky130_fd_pr_reram__reram_cell area_ox=0.0676
XMn_68_18 dn_68_18 WL68 SL18 VSS sky130_fd_pr__nfet_g5v0d10v5 w=1 l=0.5
XRn_68_18 BLN18 dn_68_18 sky130_fd_pr_reram__reram_cell area_ox=0.0676
XMp_68_19 dp_68_19 WL68 SL19 VSS sky130_fd_pr__nfet_g5v0d10v5 w=1 l=0.5
XRp_68_19 BLP19 dp_68_19 sky130_fd_pr_reram__reram_cell area_ox=0.0676
XMn_68_19 dn_68_19 WL68 SL19 VSS sky130_fd_pr__nfet_g5v0d10v5 w=1 l=0.5
XRn_68_19 BLN19 dn_68_19 sky130_fd_pr_reram__reram_cell area_ox=0.0676
XMp_68_20 dp_68_20 WL68 SL20 VSS sky130_fd_pr__nfet_g5v0d10v5 w=1 l=0.5
XRp_68_20 BLP20 dp_68_20 sky130_fd_pr_reram__reram_cell area_ox=0.0676
XMn_68_20 dn_68_20 WL68 SL20 VSS sky130_fd_pr__nfet_g5v0d10v5 w=1 l=0.5
XRn_68_20 BLN20 dn_68_20 sky130_fd_pr_reram__reram_cell area_ox=0.0676
XMp_68_21 dp_68_21 WL68 SL21 VSS sky130_fd_pr__nfet_g5v0d10v5 w=1 l=0.5
XRp_68_21 BLP21 dp_68_21 sky130_fd_pr_reram__reram_cell area_ox=0.0676
XMn_68_21 dn_68_21 WL68 SL21 VSS sky130_fd_pr__nfet_g5v0d10v5 w=1 l=0.5
XRn_68_21 BLN21 dn_68_21 sky130_fd_pr_reram__reram_cell area_ox=0.0676
XMp_68_22 dp_68_22 WL68 SL22 VSS sky130_fd_pr__nfet_g5v0d10v5 w=1 l=0.5
XRp_68_22 BLP22 dp_68_22 sky130_fd_pr_reram__reram_cell area_ox=0.0676
XMn_68_22 dn_68_22 WL68 SL22 VSS sky130_fd_pr__nfet_g5v0d10v5 w=1 l=0.5
XRn_68_22 BLN22 dn_68_22 sky130_fd_pr_reram__reram_cell area_ox=0.0676
XMp_68_23 dp_68_23 WL68 SL23 VSS sky130_fd_pr__nfet_g5v0d10v5 w=1 l=0.5
XRp_68_23 BLP23 dp_68_23 sky130_fd_pr_reram__reram_cell area_ox=0.0676
XMn_68_23 dn_68_23 WL68 SL23 VSS sky130_fd_pr__nfet_g5v0d10v5 w=1 l=0.5
XRn_68_23 BLN23 dn_68_23 sky130_fd_pr_reram__reram_cell area_ox=0.0676
XMp_69_0 dp_69_0 WL69 SL0 VSS sky130_fd_pr__nfet_g5v0d10v5 w=1 l=0.5
XRp_69_0 BLP0 dp_69_0 sky130_fd_pr_reram__reram_cell area_ox=0.0676
XMn_69_0 dn_69_0 WL69 SL0 VSS sky130_fd_pr__nfet_g5v0d10v5 w=1 l=0.5
XRn_69_0 BLN0 dn_69_0 sky130_fd_pr_reram__reram_cell area_ox=0.0676
XMp_69_1 dp_69_1 WL69 SL1 VSS sky130_fd_pr__nfet_g5v0d10v5 w=1 l=0.5
XRp_69_1 BLP1 dp_69_1 sky130_fd_pr_reram__reram_cell area_ox=0.0676
XMn_69_1 dn_69_1 WL69 SL1 VSS sky130_fd_pr__nfet_g5v0d10v5 w=1 l=0.5
XRn_69_1 BLN1 dn_69_1 sky130_fd_pr_reram__reram_cell area_ox=0.0676
XMp_69_2 dp_69_2 WL69 SL2 VSS sky130_fd_pr__nfet_g5v0d10v5 w=1 l=0.5
XRp_69_2 BLP2 dp_69_2 sky130_fd_pr_reram__reram_cell area_ox=0.0676
XMn_69_2 dn_69_2 WL69 SL2 VSS sky130_fd_pr__nfet_g5v0d10v5 w=1 l=0.5
XRn_69_2 BLN2 dn_69_2 sky130_fd_pr_reram__reram_cell area_ox=0.0676
XMp_69_3 dp_69_3 WL69 SL3 VSS sky130_fd_pr__nfet_g5v0d10v5 w=1 l=0.5
XRp_69_3 BLP3 dp_69_3 sky130_fd_pr_reram__reram_cell area_ox=0.0676
XMn_69_3 dn_69_3 WL69 SL3 VSS sky130_fd_pr__nfet_g5v0d10v5 w=1 l=0.5
XRn_69_3 BLN3 dn_69_3 sky130_fd_pr_reram__reram_cell area_ox=0.0676
XMp_69_4 dp_69_4 WL69 SL4 VSS sky130_fd_pr__nfet_g5v0d10v5 w=1 l=0.5
XRp_69_4 BLP4 dp_69_4 sky130_fd_pr_reram__reram_cell area_ox=0.0676
XMn_69_4 dn_69_4 WL69 SL4 VSS sky130_fd_pr__nfet_g5v0d10v5 w=1 l=0.5
XRn_69_4 BLN4 dn_69_4 sky130_fd_pr_reram__reram_cell area_ox=0.0676
XMp_69_5 dp_69_5 WL69 SL5 VSS sky130_fd_pr__nfet_g5v0d10v5 w=1 l=0.5
XRp_69_5 BLP5 dp_69_5 sky130_fd_pr_reram__reram_cell area_ox=0.0676
XMn_69_5 dn_69_5 WL69 SL5 VSS sky130_fd_pr__nfet_g5v0d10v5 w=1 l=0.5
XRn_69_5 BLN5 dn_69_5 sky130_fd_pr_reram__reram_cell area_ox=0.0676
XMp_69_6 dp_69_6 WL69 SL6 VSS sky130_fd_pr__nfet_g5v0d10v5 w=1 l=0.5
XRp_69_6 BLP6 dp_69_6 sky130_fd_pr_reram__reram_cell area_ox=0.0676
XMn_69_6 dn_69_6 WL69 SL6 VSS sky130_fd_pr__nfet_g5v0d10v5 w=1 l=0.5
XRn_69_6 BLN6 dn_69_6 sky130_fd_pr_reram__reram_cell area_ox=0.0676
XMp_69_7 dp_69_7 WL69 SL7 VSS sky130_fd_pr__nfet_g5v0d10v5 w=1 l=0.5
XRp_69_7 BLP7 dp_69_7 sky130_fd_pr_reram__reram_cell area_ox=0.0676
XMn_69_7 dn_69_7 WL69 SL7 VSS sky130_fd_pr__nfet_g5v0d10v5 w=1 l=0.5
XRn_69_7 BLN7 dn_69_7 sky130_fd_pr_reram__reram_cell area_ox=0.0676
XMp_69_8 dp_69_8 WL69 SL8 VSS sky130_fd_pr__nfet_g5v0d10v5 w=1 l=0.5
XRp_69_8 BLP8 dp_69_8 sky130_fd_pr_reram__reram_cell area_ox=0.0676
XMn_69_8 dn_69_8 WL69 SL8 VSS sky130_fd_pr__nfet_g5v0d10v5 w=1 l=0.5
XRn_69_8 BLN8 dn_69_8 sky130_fd_pr_reram__reram_cell area_ox=0.0676
XMp_69_9 dp_69_9 WL69 SL9 VSS sky130_fd_pr__nfet_g5v0d10v5 w=1 l=0.5
XRp_69_9 BLP9 dp_69_9 sky130_fd_pr_reram__reram_cell area_ox=0.0676
XMn_69_9 dn_69_9 WL69 SL9 VSS sky130_fd_pr__nfet_g5v0d10v5 w=1 l=0.5
XRn_69_9 BLN9 dn_69_9 sky130_fd_pr_reram__reram_cell area_ox=0.0676
XMp_69_10 dp_69_10 WL69 SL10 VSS sky130_fd_pr__nfet_g5v0d10v5 w=1 l=0.5
XRp_69_10 BLP10 dp_69_10 sky130_fd_pr_reram__reram_cell area_ox=0.0676
XMn_69_10 dn_69_10 WL69 SL10 VSS sky130_fd_pr__nfet_g5v0d10v5 w=1 l=0.5
XRn_69_10 BLN10 dn_69_10 sky130_fd_pr_reram__reram_cell area_ox=0.0676
XMp_69_11 dp_69_11 WL69 SL11 VSS sky130_fd_pr__nfet_g5v0d10v5 w=1 l=0.5
XRp_69_11 BLP11 dp_69_11 sky130_fd_pr_reram__reram_cell area_ox=0.0676
XMn_69_11 dn_69_11 WL69 SL11 VSS sky130_fd_pr__nfet_g5v0d10v5 w=1 l=0.5
XRn_69_11 BLN11 dn_69_11 sky130_fd_pr_reram__reram_cell area_ox=0.0676
XMp_69_12 dp_69_12 WL69 SL12 VSS sky130_fd_pr__nfet_g5v0d10v5 w=1 l=0.5
XRp_69_12 BLP12 dp_69_12 sky130_fd_pr_reram__reram_cell area_ox=0.0676
XMn_69_12 dn_69_12 WL69 SL12 VSS sky130_fd_pr__nfet_g5v0d10v5 w=1 l=0.5
XRn_69_12 BLN12 dn_69_12 sky130_fd_pr_reram__reram_cell area_ox=0.0676
XMp_69_13 dp_69_13 WL69 SL13 VSS sky130_fd_pr__nfet_g5v0d10v5 w=1 l=0.5
XRp_69_13 BLP13 dp_69_13 sky130_fd_pr_reram__reram_cell area_ox=0.0676
XMn_69_13 dn_69_13 WL69 SL13 VSS sky130_fd_pr__nfet_g5v0d10v5 w=1 l=0.5
XRn_69_13 BLN13 dn_69_13 sky130_fd_pr_reram__reram_cell area_ox=0.0676
XMp_69_14 dp_69_14 WL69 SL14 VSS sky130_fd_pr__nfet_g5v0d10v5 w=1 l=0.5
XRp_69_14 BLP14 dp_69_14 sky130_fd_pr_reram__reram_cell area_ox=0.0676
XMn_69_14 dn_69_14 WL69 SL14 VSS sky130_fd_pr__nfet_g5v0d10v5 w=1 l=0.5
XRn_69_14 BLN14 dn_69_14 sky130_fd_pr_reram__reram_cell area_ox=0.0676
XMp_69_15 dp_69_15 WL69 SL15 VSS sky130_fd_pr__nfet_g5v0d10v5 w=1 l=0.5
XRp_69_15 BLP15 dp_69_15 sky130_fd_pr_reram__reram_cell area_ox=0.0676
XMn_69_15 dn_69_15 WL69 SL15 VSS sky130_fd_pr__nfet_g5v0d10v5 w=1 l=0.5
XRn_69_15 BLN15 dn_69_15 sky130_fd_pr_reram__reram_cell area_ox=0.0676
XMp_69_16 dp_69_16 WL69 SL16 VSS sky130_fd_pr__nfet_g5v0d10v5 w=1 l=0.5
XRp_69_16 BLP16 dp_69_16 sky130_fd_pr_reram__reram_cell area_ox=0.0676
XMn_69_16 dn_69_16 WL69 SL16 VSS sky130_fd_pr__nfet_g5v0d10v5 w=1 l=0.5
XRn_69_16 BLN16 dn_69_16 sky130_fd_pr_reram__reram_cell area_ox=0.0676
XMp_69_17 dp_69_17 WL69 SL17 VSS sky130_fd_pr__nfet_g5v0d10v5 w=1 l=0.5
XRp_69_17 BLP17 dp_69_17 sky130_fd_pr_reram__reram_cell area_ox=0.0676
XMn_69_17 dn_69_17 WL69 SL17 VSS sky130_fd_pr__nfet_g5v0d10v5 w=1 l=0.5
XRn_69_17 BLN17 dn_69_17 sky130_fd_pr_reram__reram_cell area_ox=0.0676
XMp_69_18 dp_69_18 WL69 SL18 VSS sky130_fd_pr__nfet_g5v0d10v5 w=1 l=0.5
XRp_69_18 BLP18 dp_69_18 sky130_fd_pr_reram__reram_cell area_ox=0.0676
XMn_69_18 dn_69_18 WL69 SL18 VSS sky130_fd_pr__nfet_g5v0d10v5 w=1 l=0.5
XRn_69_18 BLN18 dn_69_18 sky130_fd_pr_reram__reram_cell area_ox=0.0676
XMp_69_19 dp_69_19 WL69 SL19 VSS sky130_fd_pr__nfet_g5v0d10v5 w=1 l=0.5
XRp_69_19 BLP19 dp_69_19 sky130_fd_pr_reram__reram_cell area_ox=0.0676
XMn_69_19 dn_69_19 WL69 SL19 VSS sky130_fd_pr__nfet_g5v0d10v5 w=1 l=0.5
XRn_69_19 BLN19 dn_69_19 sky130_fd_pr_reram__reram_cell area_ox=0.0676
XMp_69_20 dp_69_20 WL69 SL20 VSS sky130_fd_pr__nfet_g5v0d10v5 w=1 l=0.5
XRp_69_20 BLP20 dp_69_20 sky130_fd_pr_reram__reram_cell area_ox=0.0676
XMn_69_20 dn_69_20 WL69 SL20 VSS sky130_fd_pr__nfet_g5v0d10v5 w=1 l=0.5
XRn_69_20 BLN20 dn_69_20 sky130_fd_pr_reram__reram_cell area_ox=0.0676
XMp_69_21 dp_69_21 WL69 SL21 VSS sky130_fd_pr__nfet_g5v0d10v5 w=1 l=0.5
XRp_69_21 BLP21 dp_69_21 sky130_fd_pr_reram__reram_cell area_ox=0.0676
XMn_69_21 dn_69_21 WL69 SL21 VSS sky130_fd_pr__nfet_g5v0d10v5 w=1 l=0.5
XRn_69_21 BLN21 dn_69_21 sky130_fd_pr_reram__reram_cell area_ox=0.0676
XMp_69_22 dp_69_22 WL69 SL22 VSS sky130_fd_pr__nfet_g5v0d10v5 w=1 l=0.5
XRp_69_22 BLP22 dp_69_22 sky130_fd_pr_reram__reram_cell area_ox=0.0676
XMn_69_22 dn_69_22 WL69 SL22 VSS sky130_fd_pr__nfet_g5v0d10v5 w=1 l=0.5
XRn_69_22 BLN22 dn_69_22 sky130_fd_pr_reram__reram_cell area_ox=0.0676
XMp_69_23 dp_69_23 WL69 SL23 VSS sky130_fd_pr__nfet_g5v0d10v5 w=1 l=0.5
XRp_69_23 BLP23 dp_69_23 sky130_fd_pr_reram__reram_cell area_ox=0.0676
XMn_69_23 dn_69_23 WL69 SL23 VSS sky130_fd_pr__nfet_g5v0d10v5 w=1 l=0.5
XRn_69_23 BLN23 dn_69_23 sky130_fd_pr_reram__reram_cell area_ox=0.0676
XMp_70_0 dp_70_0 WL70 SL0 VSS sky130_fd_pr__nfet_g5v0d10v5 w=1 l=0.5
XRp_70_0 BLP0 dp_70_0 sky130_fd_pr_reram__reram_cell area_ox=0.0676
XMn_70_0 dn_70_0 WL70 SL0 VSS sky130_fd_pr__nfet_g5v0d10v5 w=1 l=0.5
XRn_70_0 BLN0 dn_70_0 sky130_fd_pr_reram__reram_cell area_ox=0.0676
XMp_70_1 dp_70_1 WL70 SL1 VSS sky130_fd_pr__nfet_g5v0d10v5 w=1 l=0.5
XRp_70_1 BLP1 dp_70_1 sky130_fd_pr_reram__reram_cell area_ox=0.0676
XMn_70_1 dn_70_1 WL70 SL1 VSS sky130_fd_pr__nfet_g5v0d10v5 w=1 l=0.5
XRn_70_1 BLN1 dn_70_1 sky130_fd_pr_reram__reram_cell area_ox=0.0676
XMp_70_2 dp_70_2 WL70 SL2 VSS sky130_fd_pr__nfet_g5v0d10v5 w=1 l=0.5
XRp_70_2 BLP2 dp_70_2 sky130_fd_pr_reram__reram_cell area_ox=0.0676
XMn_70_2 dn_70_2 WL70 SL2 VSS sky130_fd_pr__nfet_g5v0d10v5 w=1 l=0.5
XRn_70_2 BLN2 dn_70_2 sky130_fd_pr_reram__reram_cell area_ox=0.0676
XMp_70_3 dp_70_3 WL70 SL3 VSS sky130_fd_pr__nfet_g5v0d10v5 w=1 l=0.5
XRp_70_3 BLP3 dp_70_3 sky130_fd_pr_reram__reram_cell area_ox=0.0676
XMn_70_3 dn_70_3 WL70 SL3 VSS sky130_fd_pr__nfet_g5v0d10v5 w=1 l=0.5
XRn_70_3 BLN3 dn_70_3 sky130_fd_pr_reram__reram_cell area_ox=0.0676
XMp_70_4 dp_70_4 WL70 SL4 VSS sky130_fd_pr__nfet_g5v0d10v5 w=1 l=0.5
XRp_70_4 BLP4 dp_70_4 sky130_fd_pr_reram__reram_cell area_ox=0.0676
XMn_70_4 dn_70_4 WL70 SL4 VSS sky130_fd_pr__nfet_g5v0d10v5 w=1 l=0.5
XRn_70_4 BLN4 dn_70_4 sky130_fd_pr_reram__reram_cell area_ox=0.0676
XMp_70_5 dp_70_5 WL70 SL5 VSS sky130_fd_pr__nfet_g5v0d10v5 w=1 l=0.5
XRp_70_5 BLP5 dp_70_5 sky130_fd_pr_reram__reram_cell area_ox=0.0676
XMn_70_5 dn_70_5 WL70 SL5 VSS sky130_fd_pr__nfet_g5v0d10v5 w=1 l=0.5
XRn_70_5 BLN5 dn_70_5 sky130_fd_pr_reram__reram_cell area_ox=0.0676
XMp_70_6 dp_70_6 WL70 SL6 VSS sky130_fd_pr__nfet_g5v0d10v5 w=1 l=0.5
XRp_70_6 BLP6 dp_70_6 sky130_fd_pr_reram__reram_cell area_ox=0.0676
XMn_70_6 dn_70_6 WL70 SL6 VSS sky130_fd_pr__nfet_g5v0d10v5 w=1 l=0.5
XRn_70_6 BLN6 dn_70_6 sky130_fd_pr_reram__reram_cell area_ox=0.0676
XMp_70_7 dp_70_7 WL70 SL7 VSS sky130_fd_pr__nfet_g5v0d10v5 w=1 l=0.5
XRp_70_7 BLP7 dp_70_7 sky130_fd_pr_reram__reram_cell area_ox=0.0676
XMn_70_7 dn_70_7 WL70 SL7 VSS sky130_fd_pr__nfet_g5v0d10v5 w=1 l=0.5
XRn_70_7 BLN7 dn_70_7 sky130_fd_pr_reram__reram_cell area_ox=0.0676
XMp_70_8 dp_70_8 WL70 SL8 VSS sky130_fd_pr__nfet_g5v0d10v5 w=1 l=0.5
XRp_70_8 BLP8 dp_70_8 sky130_fd_pr_reram__reram_cell area_ox=0.0676
XMn_70_8 dn_70_8 WL70 SL8 VSS sky130_fd_pr__nfet_g5v0d10v5 w=1 l=0.5
XRn_70_8 BLN8 dn_70_8 sky130_fd_pr_reram__reram_cell area_ox=0.0676
XMp_70_9 dp_70_9 WL70 SL9 VSS sky130_fd_pr__nfet_g5v0d10v5 w=1 l=0.5
XRp_70_9 BLP9 dp_70_9 sky130_fd_pr_reram__reram_cell area_ox=0.0676
XMn_70_9 dn_70_9 WL70 SL9 VSS sky130_fd_pr__nfet_g5v0d10v5 w=1 l=0.5
XRn_70_9 BLN9 dn_70_9 sky130_fd_pr_reram__reram_cell area_ox=0.0676
XMp_70_10 dp_70_10 WL70 SL10 VSS sky130_fd_pr__nfet_g5v0d10v5 w=1 l=0.5
XRp_70_10 BLP10 dp_70_10 sky130_fd_pr_reram__reram_cell area_ox=0.0676
XMn_70_10 dn_70_10 WL70 SL10 VSS sky130_fd_pr__nfet_g5v0d10v5 w=1 l=0.5
XRn_70_10 BLN10 dn_70_10 sky130_fd_pr_reram__reram_cell area_ox=0.0676
XMp_70_11 dp_70_11 WL70 SL11 VSS sky130_fd_pr__nfet_g5v0d10v5 w=1 l=0.5
XRp_70_11 BLP11 dp_70_11 sky130_fd_pr_reram__reram_cell area_ox=0.0676
XMn_70_11 dn_70_11 WL70 SL11 VSS sky130_fd_pr__nfet_g5v0d10v5 w=1 l=0.5
XRn_70_11 BLN11 dn_70_11 sky130_fd_pr_reram__reram_cell area_ox=0.0676
XMp_70_12 dp_70_12 WL70 SL12 VSS sky130_fd_pr__nfet_g5v0d10v5 w=1 l=0.5
XRp_70_12 BLP12 dp_70_12 sky130_fd_pr_reram__reram_cell area_ox=0.0676
XMn_70_12 dn_70_12 WL70 SL12 VSS sky130_fd_pr__nfet_g5v0d10v5 w=1 l=0.5
XRn_70_12 BLN12 dn_70_12 sky130_fd_pr_reram__reram_cell area_ox=0.0676
XMp_70_13 dp_70_13 WL70 SL13 VSS sky130_fd_pr__nfet_g5v0d10v5 w=1 l=0.5
XRp_70_13 BLP13 dp_70_13 sky130_fd_pr_reram__reram_cell area_ox=0.0676
XMn_70_13 dn_70_13 WL70 SL13 VSS sky130_fd_pr__nfet_g5v0d10v5 w=1 l=0.5
XRn_70_13 BLN13 dn_70_13 sky130_fd_pr_reram__reram_cell area_ox=0.0676
XMp_70_14 dp_70_14 WL70 SL14 VSS sky130_fd_pr__nfet_g5v0d10v5 w=1 l=0.5
XRp_70_14 BLP14 dp_70_14 sky130_fd_pr_reram__reram_cell area_ox=0.0676
XMn_70_14 dn_70_14 WL70 SL14 VSS sky130_fd_pr__nfet_g5v0d10v5 w=1 l=0.5
XRn_70_14 BLN14 dn_70_14 sky130_fd_pr_reram__reram_cell area_ox=0.0676
XMp_70_15 dp_70_15 WL70 SL15 VSS sky130_fd_pr__nfet_g5v0d10v5 w=1 l=0.5
XRp_70_15 BLP15 dp_70_15 sky130_fd_pr_reram__reram_cell area_ox=0.0676
XMn_70_15 dn_70_15 WL70 SL15 VSS sky130_fd_pr__nfet_g5v0d10v5 w=1 l=0.5
XRn_70_15 BLN15 dn_70_15 sky130_fd_pr_reram__reram_cell area_ox=0.0676
XMp_70_16 dp_70_16 WL70 SL16 VSS sky130_fd_pr__nfet_g5v0d10v5 w=1 l=0.5
XRp_70_16 BLP16 dp_70_16 sky130_fd_pr_reram__reram_cell area_ox=0.0676
XMn_70_16 dn_70_16 WL70 SL16 VSS sky130_fd_pr__nfet_g5v0d10v5 w=1 l=0.5
XRn_70_16 BLN16 dn_70_16 sky130_fd_pr_reram__reram_cell area_ox=0.0676
XMp_70_17 dp_70_17 WL70 SL17 VSS sky130_fd_pr__nfet_g5v0d10v5 w=1 l=0.5
XRp_70_17 BLP17 dp_70_17 sky130_fd_pr_reram__reram_cell area_ox=0.0676
XMn_70_17 dn_70_17 WL70 SL17 VSS sky130_fd_pr__nfet_g5v0d10v5 w=1 l=0.5
XRn_70_17 BLN17 dn_70_17 sky130_fd_pr_reram__reram_cell area_ox=0.0676
XMp_70_18 dp_70_18 WL70 SL18 VSS sky130_fd_pr__nfet_g5v0d10v5 w=1 l=0.5
XRp_70_18 BLP18 dp_70_18 sky130_fd_pr_reram__reram_cell area_ox=0.0676
XMn_70_18 dn_70_18 WL70 SL18 VSS sky130_fd_pr__nfet_g5v0d10v5 w=1 l=0.5
XRn_70_18 BLN18 dn_70_18 sky130_fd_pr_reram__reram_cell area_ox=0.0676
XMp_70_19 dp_70_19 WL70 SL19 VSS sky130_fd_pr__nfet_g5v0d10v5 w=1 l=0.5
XRp_70_19 BLP19 dp_70_19 sky130_fd_pr_reram__reram_cell area_ox=0.0676
XMn_70_19 dn_70_19 WL70 SL19 VSS sky130_fd_pr__nfet_g5v0d10v5 w=1 l=0.5
XRn_70_19 BLN19 dn_70_19 sky130_fd_pr_reram__reram_cell area_ox=0.0676
XMp_70_20 dp_70_20 WL70 SL20 VSS sky130_fd_pr__nfet_g5v0d10v5 w=1 l=0.5
XRp_70_20 BLP20 dp_70_20 sky130_fd_pr_reram__reram_cell area_ox=0.0676
XMn_70_20 dn_70_20 WL70 SL20 VSS sky130_fd_pr__nfet_g5v0d10v5 w=1 l=0.5
XRn_70_20 BLN20 dn_70_20 sky130_fd_pr_reram__reram_cell area_ox=0.0676
XMp_70_21 dp_70_21 WL70 SL21 VSS sky130_fd_pr__nfet_g5v0d10v5 w=1 l=0.5
XRp_70_21 BLP21 dp_70_21 sky130_fd_pr_reram__reram_cell area_ox=0.0676
XMn_70_21 dn_70_21 WL70 SL21 VSS sky130_fd_pr__nfet_g5v0d10v5 w=1 l=0.5
XRn_70_21 BLN21 dn_70_21 sky130_fd_pr_reram__reram_cell area_ox=0.0676
XMp_70_22 dp_70_22 WL70 SL22 VSS sky130_fd_pr__nfet_g5v0d10v5 w=1 l=0.5
XRp_70_22 BLP22 dp_70_22 sky130_fd_pr_reram__reram_cell area_ox=0.0676
XMn_70_22 dn_70_22 WL70 SL22 VSS sky130_fd_pr__nfet_g5v0d10v5 w=1 l=0.5
XRn_70_22 BLN22 dn_70_22 sky130_fd_pr_reram__reram_cell area_ox=0.0676
XMp_70_23 dp_70_23 WL70 SL23 VSS sky130_fd_pr__nfet_g5v0d10v5 w=1 l=0.5
XRp_70_23 BLP23 dp_70_23 sky130_fd_pr_reram__reram_cell area_ox=0.0676
XMn_70_23 dn_70_23 WL70 SL23 VSS sky130_fd_pr__nfet_g5v0d10v5 w=1 l=0.5
XRn_70_23 BLN23 dn_70_23 sky130_fd_pr_reram__reram_cell area_ox=0.0676
XMp_71_0 dp_71_0 WL71 SL0 VSS sky130_fd_pr__nfet_g5v0d10v5 w=1 l=0.5
XRp_71_0 BLP0 dp_71_0 sky130_fd_pr_reram__reram_cell area_ox=0.0676
XMn_71_0 dn_71_0 WL71 SL0 VSS sky130_fd_pr__nfet_g5v0d10v5 w=1 l=0.5
XRn_71_0 BLN0 dn_71_0 sky130_fd_pr_reram__reram_cell area_ox=0.0676
XMp_71_1 dp_71_1 WL71 SL1 VSS sky130_fd_pr__nfet_g5v0d10v5 w=1 l=0.5
XRp_71_1 BLP1 dp_71_1 sky130_fd_pr_reram__reram_cell area_ox=0.0676
XMn_71_1 dn_71_1 WL71 SL1 VSS sky130_fd_pr__nfet_g5v0d10v5 w=1 l=0.5
XRn_71_1 BLN1 dn_71_1 sky130_fd_pr_reram__reram_cell area_ox=0.0676
XMp_71_2 dp_71_2 WL71 SL2 VSS sky130_fd_pr__nfet_g5v0d10v5 w=1 l=0.5
XRp_71_2 BLP2 dp_71_2 sky130_fd_pr_reram__reram_cell area_ox=0.0676
XMn_71_2 dn_71_2 WL71 SL2 VSS sky130_fd_pr__nfet_g5v0d10v5 w=1 l=0.5
XRn_71_2 BLN2 dn_71_2 sky130_fd_pr_reram__reram_cell area_ox=0.0676
XMp_71_3 dp_71_3 WL71 SL3 VSS sky130_fd_pr__nfet_g5v0d10v5 w=1 l=0.5
XRp_71_3 BLP3 dp_71_3 sky130_fd_pr_reram__reram_cell area_ox=0.0676
XMn_71_3 dn_71_3 WL71 SL3 VSS sky130_fd_pr__nfet_g5v0d10v5 w=1 l=0.5
XRn_71_3 BLN3 dn_71_3 sky130_fd_pr_reram__reram_cell area_ox=0.0676
XMp_71_4 dp_71_4 WL71 SL4 VSS sky130_fd_pr__nfet_g5v0d10v5 w=1 l=0.5
XRp_71_4 BLP4 dp_71_4 sky130_fd_pr_reram__reram_cell area_ox=0.0676
XMn_71_4 dn_71_4 WL71 SL4 VSS sky130_fd_pr__nfet_g5v0d10v5 w=1 l=0.5
XRn_71_4 BLN4 dn_71_4 sky130_fd_pr_reram__reram_cell area_ox=0.0676
XMp_71_5 dp_71_5 WL71 SL5 VSS sky130_fd_pr__nfet_g5v0d10v5 w=1 l=0.5
XRp_71_5 BLP5 dp_71_5 sky130_fd_pr_reram__reram_cell area_ox=0.0676
XMn_71_5 dn_71_5 WL71 SL5 VSS sky130_fd_pr__nfet_g5v0d10v5 w=1 l=0.5
XRn_71_5 BLN5 dn_71_5 sky130_fd_pr_reram__reram_cell area_ox=0.0676
XMp_71_6 dp_71_6 WL71 SL6 VSS sky130_fd_pr__nfet_g5v0d10v5 w=1 l=0.5
XRp_71_6 BLP6 dp_71_6 sky130_fd_pr_reram__reram_cell area_ox=0.0676
XMn_71_6 dn_71_6 WL71 SL6 VSS sky130_fd_pr__nfet_g5v0d10v5 w=1 l=0.5
XRn_71_6 BLN6 dn_71_6 sky130_fd_pr_reram__reram_cell area_ox=0.0676
XMp_71_7 dp_71_7 WL71 SL7 VSS sky130_fd_pr__nfet_g5v0d10v5 w=1 l=0.5
XRp_71_7 BLP7 dp_71_7 sky130_fd_pr_reram__reram_cell area_ox=0.0676
XMn_71_7 dn_71_7 WL71 SL7 VSS sky130_fd_pr__nfet_g5v0d10v5 w=1 l=0.5
XRn_71_7 BLN7 dn_71_7 sky130_fd_pr_reram__reram_cell area_ox=0.0676
XMp_71_8 dp_71_8 WL71 SL8 VSS sky130_fd_pr__nfet_g5v0d10v5 w=1 l=0.5
XRp_71_8 BLP8 dp_71_8 sky130_fd_pr_reram__reram_cell area_ox=0.0676
XMn_71_8 dn_71_8 WL71 SL8 VSS sky130_fd_pr__nfet_g5v0d10v5 w=1 l=0.5
XRn_71_8 BLN8 dn_71_8 sky130_fd_pr_reram__reram_cell area_ox=0.0676
XMp_71_9 dp_71_9 WL71 SL9 VSS sky130_fd_pr__nfet_g5v0d10v5 w=1 l=0.5
XRp_71_9 BLP9 dp_71_9 sky130_fd_pr_reram__reram_cell area_ox=0.0676
XMn_71_9 dn_71_9 WL71 SL9 VSS sky130_fd_pr__nfet_g5v0d10v5 w=1 l=0.5
XRn_71_9 BLN9 dn_71_9 sky130_fd_pr_reram__reram_cell area_ox=0.0676
XMp_71_10 dp_71_10 WL71 SL10 VSS sky130_fd_pr__nfet_g5v0d10v5 w=1 l=0.5
XRp_71_10 BLP10 dp_71_10 sky130_fd_pr_reram__reram_cell area_ox=0.0676
XMn_71_10 dn_71_10 WL71 SL10 VSS sky130_fd_pr__nfet_g5v0d10v5 w=1 l=0.5
XRn_71_10 BLN10 dn_71_10 sky130_fd_pr_reram__reram_cell area_ox=0.0676
XMp_71_11 dp_71_11 WL71 SL11 VSS sky130_fd_pr__nfet_g5v0d10v5 w=1 l=0.5
XRp_71_11 BLP11 dp_71_11 sky130_fd_pr_reram__reram_cell area_ox=0.0676
XMn_71_11 dn_71_11 WL71 SL11 VSS sky130_fd_pr__nfet_g5v0d10v5 w=1 l=0.5
XRn_71_11 BLN11 dn_71_11 sky130_fd_pr_reram__reram_cell area_ox=0.0676
XMp_71_12 dp_71_12 WL71 SL12 VSS sky130_fd_pr__nfet_g5v0d10v5 w=1 l=0.5
XRp_71_12 BLP12 dp_71_12 sky130_fd_pr_reram__reram_cell area_ox=0.0676
XMn_71_12 dn_71_12 WL71 SL12 VSS sky130_fd_pr__nfet_g5v0d10v5 w=1 l=0.5
XRn_71_12 BLN12 dn_71_12 sky130_fd_pr_reram__reram_cell area_ox=0.0676
XMp_71_13 dp_71_13 WL71 SL13 VSS sky130_fd_pr__nfet_g5v0d10v5 w=1 l=0.5
XRp_71_13 BLP13 dp_71_13 sky130_fd_pr_reram__reram_cell area_ox=0.0676
XMn_71_13 dn_71_13 WL71 SL13 VSS sky130_fd_pr__nfet_g5v0d10v5 w=1 l=0.5
XRn_71_13 BLN13 dn_71_13 sky130_fd_pr_reram__reram_cell area_ox=0.0676
XMp_71_14 dp_71_14 WL71 SL14 VSS sky130_fd_pr__nfet_g5v0d10v5 w=1 l=0.5
XRp_71_14 BLP14 dp_71_14 sky130_fd_pr_reram__reram_cell area_ox=0.0676
XMn_71_14 dn_71_14 WL71 SL14 VSS sky130_fd_pr__nfet_g5v0d10v5 w=1 l=0.5
XRn_71_14 BLN14 dn_71_14 sky130_fd_pr_reram__reram_cell area_ox=0.0676
XMp_71_15 dp_71_15 WL71 SL15 VSS sky130_fd_pr__nfet_g5v0d10v5 w=1 l=0.5
XRp_71_15 BLP15 dp_71_15 sky130_fd_pr_reram__reram_cell area_ox=0.0676
XMn_71_15 dn_71_15 WL71 SL15 VSS sky130_fd_pr__nfet_g5v0d10v5 w=1 l=0.5
XRn_71_15 BLN15 dn_71_15 sky130_fd_pr_reram__reram_cell area_ox=0.0676
XMp_71_16 dp_71_16 WL71 SL16 VSS sky130_fd_pr__nfet_g5v0d10v5 w=1 l=0.5
XRp_71_16 BLP16 dp_71_16 sky130_fd_pr_reram__reram_cell area_ox=0.0676
XMn_71_16 dn_71_16 WL71 SL16 VSS sky130_fd_pr__nfet_g5v0d10v5 w=1 l=0.5
XRn_71_16 BLN16 dn_71_16 sky130_fd_pr_reram__reram_cell area_ox=0.0676
XMp_71_17 dp_71_17 WL71 SL17 VSS sky130_fd_pr__nfet_g5v0d10v5 w=1 l=0.5
XRp_71_17 BLP17 dp_71_17 sky130_fd_pr_reram__reram_cell area_ox=0.0676
XMn_71_17 dn_71_17 WL71 SL17 VSS sky130_fd_pr__nfet_g5v0d10v5 w=1 l=0.5
XRn_71_17 BLN17 dn_71_17 sky130_fd_pr_reram__reram_cell area_ox=0.0676
XMp_71_18 dp_71_18 WL71 SL18 VSS sky130_fd_pr__nfet_g5v0d10v5 w=1 l=0.5
XRp_71_18 BLP18 dp_71_18 sky130_fd_pr_reram__reram_cell area_ox=0.0676
XMn_71_18 dn_71_18 WL71 SL18 VSS sky130_fd_pr__nfet_g5v0d10v5 w=1 l=0.5
XRn_71_18 BLN18 dn_71_18 sky130_fd_pr_reram__reram_cell area_ox=0.0676
XMp_71_19 dp_71_19 WL71 SL19 VSS sky130_fd_pr__nfet_g5v0d10v5 w=1 l=0.5
XRp_71_19 BLP19 dp_71_19 sky130_fd_pr_reram__reram_cell area_ox=0.0676
XMn_71_19 dn_71_19 WL71 SL19 VSS sky130_fd_pr__nfet_g5v0d10v5 w=1 l=0.5
XRn_71_19 BLN19 dn_71_19 sky130_fd_pr_reram__reram_cell area_ox=0.0676
XMp_71_20 dp_71_20 WL71 SL20 VSS sky130_fd_pr__nfet_g5v0d10v5 w=1 l=0.5
XRp_71_20 BLP20 dp_71_20 sky130_fd_pr_reram__reram_cell area_ox=0.0676
XMn_71_20 dn_71_20 WL71 SL20 VSS sky130_fd_pr__nfet_g5v0d10v5 w=1 l=0.5
XRn_71_20 BLN20 dn_71_20 sky130_fd_pr_reram__reram_cell area_ox=0.0676
XMp_71_21 dp_71_21 WL71 SL21 VSS sky130_fd_pr__nfet_g5v0d10v5 w=1 l=0.5
XRp_71_21 BLP21 dp_71_21 sky130_fd_pr_reram__reram_cell area_ox=0.0676
XMn_71_21 dn_71_21 WL71 SL21 VSS sky130_fd_pr__nfet_g5v0d10v5 w=1 l=0.5
XRn_71_21 BLN21 dn_71_21 sky130_fd_pr_reram__reram_cell area_ox=0.0676
XMp_71_22 dp_71_22 WL71 SL22 VSS sky130_fd_pr__nfet_g5v0d10v5 w=1 l=0.5
XRp_71_22 BLP22 dp_71_22 sky130_fd_pr_reram__reram_cell area_ox=0.0676
XMn_71_22 dn_71_22 WL71 SL22 VSS sky130_fd_pr__nfet_g5v0d10v5 w=1 l=0.5
XRn_71_22 BLN22 dn_71_22 sky130_fd_pr_reram__reram_cell area_ox=0.0676
XMp_71_23 dp_71_23 WL71 SL23 VSS sky130_fd_pr__nfet_g5v0d10v5 w=1 l=0.5
XRp_71_23 BLP23 dp_71_23 sky130_fd_pr_reram__reram_cell area_ox=0.0676
XMn_71_23 dn_71_23 WL71 SL23 VSS sky130_fd_pr__nfet_g5v0d10v5 w=1 l=0.5
XRn_71_23 BLN23 dn_71_23 sky130_fd_pr_reram__reram_cell area_ox=0.0676
.ends

.subckt rowslice sel_lv wl vwl vccd vdda vss
Xls_Xi1 Xls_inb sel_lv vccd vccd sky130_fd_pr__pfet_01v8 w=1 l=0.15
Xls_Xi2 Xls_inb sel_lv vss vss sky130_fd_pr__nfet_01v8 w=0.5 l=0.15
Xls_Xn1 Xls_xb sel_lv vss vss sky130_fd_pr__nfet_g5v0d10v5 w=4 l=0.5
Xls_Xn2 Xls_x Xls_inb vss vss sky130_fd_pr__nfet_g5v0d10v5 w=4 l=0.5
Xls_Xp1 Xls_xb Xls_x vdda vdda sky130_fd_pr__pfet_g5v0d10v5 w=0.42 l=1
Xls_Xp2 Xls_x Xls_xb vdda vdda sky130_fd_pr__pfet_g5v0d10v5 w=0.42 l=1
Xls_Xo1 sel Xls_xb vdda vdda sky130_fd_pr__pfet_g5v0d10v5 w=2 l=0.5
Xls_Xo2 sel Xls_xb vss vss sky130_fd_pr__nfet_g5v0d10v5 w=1 l=0.5
Xls_Xo3 selb Xls_x vdda vdda sky130_fd_pr__pfet_g5v0d10v5 w=2 l=0.5
Xls_Xo4 selb Xls_x vss vss sky130_fd_pr__nfet_g5v0d10v5 w=1 l=0.5
Xd_Xtg_Xn vwl sel wl vss sky130_fd_pr__nfet_g5v0d10v5 w=2 l=0.5
Xd_Xtg_Xp vwl selb wl vdda sky130_fd_pr__pfet_g5v0d10v5 w=4 l=0.5
Xd_Xpd wl selb vss vss sky130_fd_pr__nfet_g5v0d10v5 w=1 l=0.5
.ends
.subckt blslice prg_lv bl out vprg sen flt vbp vcl vccd vdda vss
Xls_Xi1 Xls_inb prg_lv vccd vccd sky130_fd_pr__pfet_01v8 w=1 l=0.15
Xls_Xi2 Xls_inb prg_lv vss vss sky130_fd_pr__nfet_01v8 w=0.5 l=0.15
Xls_Xn1 Xls_xb prg_lv vss vss sky130_fd_pr__nfet_g5v0d10v5 w=4 l=0.5
Xls_Xn2 Xls_x Xls_inb vss vss sky130_fd_pr__nfet_g5v0d10v5 w=4 l=0.5
Xls_Xp1 Xls_xb Xls_x vdda vdda sky130_fd_pr__pfet_g5v0d10v5 w=0.42 l=1
Xls_Xp2 Xls_x Xls_xb vdda vdda sky130_fd_pr__pfet_g5v0d10v5 w=0.42 l=1
Xls_Xo1 prg Xls_xb vdda vdda sky130_fd_pr__pfet_g5v0d10v5 w=2 l=0.5
Xls_Xo2 prg Xls_xb vss vss sky130_fd_pr__nfet_g5v0d10v5 w=1 l=0.5
Xls_Xo3 prgb Xls_x vdda vdda sky130_fd_pr__pfet_g5v0d10v5 w=2 l=0.5
Xls_Xo4 prgb Xls_x vss vss sky130_fd_pr__nfet_g5v0d10v5 w=1 l=0.5
Xnor_Xp1 Xnor_m1 prg vdda vdda sky130_fd_pr__pfet_g5v0d10v5 w=2 l=0.5
Xnor_Xp2 Xnor_m2 sen Xnor_m1 vdda sky130_fd_pr__pfet_g5v0d10v5 w=2 l=0.5
Xnor_Xp3 dn flt Xnor_m2 vdda sky130_fd_pr__pfet_g5v0d10v5 w=2 l=0.5
Xnor_Xn1 dn prg vss vss sky130_fd_pr__nfet_g5v0d10v5 w=1 l=0.5
Xnor_Xn2 dn sen vss vss sky130_fd_pr__nfet_g5v0d10v5 w=1 l=0.5
Xnor_Xn3 dn flt vss vss sky130_fd_pr__nfet_g5v0d10v5 w=1 l=0.5
Xd_Xtg_Xn vprg prg bl vss sky130_fd_pr__nfet_g5v0d10v5 w=4 l=0.5
Xd_Xtg_Xp vprg prgb bl vdda sky130_fd_pr__pfet_g5v0d10v5 w=8 l=0.5
Xd_Xpd bl dn vss vss sky130_fd_pr__nfet_g5v0d10v5 w=2 l=0.5
Xd_Xcs bl sen sa vss sky130_fd_pr__nfet_g5v0d10v5 w=2 l=0.5
Xsa_Xpm Xsa_sn vbp vccd vccd sky130_fd_pr__pfet_01v8 w=4 l=4
Xsa_Xcl Xsa_sn vcl sa vss sky130_fd_pr__nfet_01v8 w=2 l=1
Xsa_Xi1 out Xsa_sn vccd vccd sky130_fd_pr__pfet_01v8 w=1 l=0.15
Xsa_Xi2 out Xsa_sn vss vss sky130_fd_pr__nfet_01v8 w=0.5 l=0.15
.ends
.subckt sld vprg sl prg prgb dn vdda vss
Xtg_Xn vprg prg sl vss sky130_fd_pr__nfet_g5v0d10v5 w=8 l=0.5
Xtg_Xp vprg prgb sl vdda sky130_fd_pr__pfet_g5v0d10v5 w=16 l=0.5
Xpd sl dn vss vss sky130_fd_pr__nfet_g5v0d10v5 w=4 l=0.5
.ends
.subckt ctrlglob sen_lv flt_lv slprg_lv wlprog_lv r0 r1 r2 ib vref vwlr vwlp sen flt slprg slprgb sldn vwl vbp vcl vccd vdda vss
Xl1_Xi1 Xl1_inb sen_lv vccd vccd sky130_fd_pr__pfet_01v8 w=1 l=0.15
Xl1_Xi2 Xl1_inb sen_lv vss vss sky130_fd_pr__nfet_01v8 w=0.5 l=0.15
Xl1_Xn1 Xl1_xb sen_lv vss vss sky130_fd_pr__nfet_g5v0d10v5 w=4 l=0.5
Xl1_Xn2 Xl1_x Xl1_inb vss vss sky130_fd_pr__nfet_g5v0d10v5 w=4 l=0.5
Xl1_Xp1 Xl1_xb Xl1_x vdda vdda sky130_fd_pr__pfet_g5v0d10v5 w=0.42 l=1
Xl1_Xp2 Xl1_x Xl1_xb vdda vdda sky130_fd_pr__pfet_g5v0d10v5 w=0.42 l=1
Xl1_Xo1 sen Xl1_xb vdda vdda sky130_fd_pr__pfet_g5v0d10v5 w=2 l=0.5
Xl1_Xo2 sen Xl1_xb vss vss sky130_fd_pr__nfet_g5v0d10v5 w=1 l=0.5
Xl1_Xo3 senb Xl1_x vdda vdda sky130_fd_pr__pfet_g5v0d10v5 w=2 l=0.5
Xl1_Xo4 senb Xl1_x vss vss sky130_fd_pr__nfet_g5v0d10v5 w=1 l=0.5
Xl2_Xi1 Xl2_inb flt_lv vccd vccd sky130_fd_pr__pfet_01v8 w=1 l=0.15
Xl2_Xi2 Xl2_inb flt_lv vss vss sky130_fd_pr__nfet_01v8 w=0.5 l=0.15
Xl2_Xn1 Xl2_xb flt_lv vss vss sky130_fd_pr__nfet_g5v0d10v5 w=4 l=0.5
Xl2_Xn2 Xl2_x Xl2_inb vss vss sky130_fd_pr__nfet_g5v0d10v5 w=4 l=0.5
Xl2_Xp1 Xl2_xb Xl2_x vdda vdda sky130_fd_pr__pfet_g5v0d10v5 w=0.42 l=1
Xl2_Xp2 Xl2_x Xl2_xb vdda vdda sky130_fd_pr__pfet_g5v0d10v5 w=0.42 l=1
Xl2_Xo1 flt Xl2_xb vdda vdda sky130_fd_pr__pfet_g5v0d10v5 w=2 l=0.5
Xl2_Xo2 flt Xl2_xb vss vss sky130_fd_pr__nfet_g5v0d10v5 w=1 l=0.5
Xl2_Xo3 fltb Xl2_x vdda vdda sky130_fd_pr__pfet_g5v0d10v5 w=2 l=0.5
Xl2_Xo4 fltb Xl2_x vss vss sky130_fd_pr__nfet_g5v0d10v5 w=1 l=0.5
Xl3_Xi1 Xl3_inb slprg_lv vccd vccd sky130_fd_pr__pfet_01v8 w=1 l=0.15
Xl3_Xi2 Xl3_inb slprg_lv vss vss sky130_fd_pr__nfet_01v8 w=0.5 l=0.15
Xl3_Xn1 Xl3_xb slprg_lv vss vss sky130_fd_pr__nfet_g5v0d10v5 w=4 l=0.5
Xl3_Xn2 Xl3_x Xl3_inb vss vss sky130_fd_pr__nfet_g5v0d10v5 w=4 l=0.5
Xl3_Xp1 Xl3_xb Xl3_x vdda vdda sky130_fd_pr__pfet_g5v0d10v5 w=0.42 l=1
Xl3_Xp2 Xl3_x Xl3_xb vdda vdda sky130_fd_pr__pfet_g5v0d10v5 w=0.42 l=1
Xl3_Xo1 slprg Xl3_xb vdda vdda sky130_fd_pr__pfet_g5v0d10v5 w=2 l=0.5
Xl3_Xo2 slprg Xl3_xb vss vss sky130_fd_pr__nfet_g5v0d10v5 w=1 l=0.5
Xl3_Xo3 slprgb Xl3_x vdda vdda sky130_fd_pr__pfet_g5v0d10v5 w=2 l=0.5
Xl3_Xo4 slprgb Xl3_x vss vss sky130_fd_pr__nfet_g5v0d10v5 w=1 l=0.5
Xl4_Xi1 Xl4_inb wlprog_lv vccd vccd sky130_fd_pr__pfet_01v8 w=1 l=0.15
Xl4_Xi2 Xl4_inb wlprog_lv vss vss sky130_fd_pr__nfet_01v8 w=0.5 l=0.15
Xl4_Xn1 Xl4_xb wlprog_lv vss vss sky130_fd_pr__nfet_g5v0d10v5 w=4 l=0.5
Xl4_Xn2 Xl4_x Xl4_inb vss vss sky130_fd_pr__nfet_g5v0d10v5 w=4 l=0.5
Xl4_Xp1 Xl4_xb Xl4_x vdda vdda sky130_fd_pr__pfet_g5v0d10v5 w=0.42 l=1
Xl4_Xp2 Xl4_x Xl4_xb vdda vdda sky130_fd_pr__pfet_g5v0d10v5 w=0.42 l=1
Xl4_Xo1 wp Xl4_xb vdda vdda sky130_fd_pr__pfet_g5v0d10v5 w=2 l=0.5
Xl4_Xo2 wp Xl4_xb vss vss sky130_fd_pr__nfet_g5v0d10v5 w=1 l=0.5
Xl4_Xo3 wpb Xl4_x vdda vdda sky130_fd_pr__pfet_g5v0d10v5 w=2 l=0.5
Xl4_Xo4 wpb Xl4_x vss vss sky130_fd_pr__nfet_g5v0d10v5 w=1 l=0.5
Xn_Xp1 Xn_m1 slprg vdda vdda sky130_fd_pr__pfet_g5v0d10v5 w=8 l=0.5
Xn_Xp2 sldn flt Xn_m1 vdda sky130_fd_pr__pfet_g5v0d10v5 w=8 l=0.5
Xn_Xn1 sldn slprg vss vss sky130_fd_pr__nfet_g5v0d10v5 w=2 l=0.5
Xn_Xn2 sldn flt vss vss sky130_fd_pr__nfet_g5v0d10v5 w=2 l=0.5
Xt1_Xn vwlr wpb vwl vss sky130_fd_pr__nfet_g5v0d10v5 w=8 l=0.5
Xt1_Xp vwlr wp vwl vdda sky130_fd_pr__pfet_g5v0d10v5 w=16 l=0.5
Xt2_Xn vwlp wp vwl vss sky130_fd_pr__nfet_g5v0d10v5 w=8 l=0.5
Xt2_Xp vwlp wpb vwl vdda sky130_fd_pr__pfet_g5v0d10v5 w=16 l=0.5
Xr_Xm0 ib ib vss vss sky130_fd_pr__nfet_01v8 w=2 l=4
Xr_Xa1 Xr_a ib vss vss sky130_fd_pr__nfet_01v8 w=2 l=4 m=2
Xr_Xa2 Xr_a r0 vbp vss sky130_fd_pr__nfet_01v8 w=1 l=0.15
Xr_Xb1 Xr_b ib vss vss sky130_fd_pr__nfet_01v8 w=2 l=4 m=3
Xr_Xb2 Xr_b r1 vbp vss sky130_fd_pr__nfet_01v8 w=1 l=0.15
Xr_Xc1 Xr_c ib vss vss sky130_fd_pr__nfet_01v8 w=2 l=4 m=6
Xr_Xc2 Xr_c r2 vbp vss sky130_fd_pr__nfet_01v8 w=1 l=0.15
Xr_Xpd vbp vbp vccd vccd sky130_fd_pr__pfet_01v8 w=4 l=4
Xr_Xpr vcl vbp vccd vccd sky130_fd_pr__pfet_01v8 w=4 l=4
Xr_Xnr vcl vcl vref vss sky130_fd_pr__nfet_01v8 w=2 l=1
.ends
.subckt tcim_macro vwlr vwlp ib vref vss vdda vccd vprg sel_lv35 sel_lv34 sel_lv33 sel_lv32 sel_lv31 sel_lv30 sel_lv29 sel_lv28 sel_lv27 sel_lv26 sel_lv25 sel_lv24 sel_lv23 sel_lv22 sel_lv21 sel_lv20 sel_lv19 sel_lv18 sel_lv17 sel_lv16 sel_lv15 sel_lv14 sel_lv13 sel_lv12 sel_lv11 sel_lv10 sel_lv9 sel_lv8 sel_lv7 sel_lv6 sel_lv5 sel_lv4 sel_lv3 sel_lv2 sel_lv1 sel_lv0 sel_lv71 sel_lv70 sel_lv69 sel_lv68 sel_lv67 sel_lv66 sel_lv65 sel_lv64 sel_lv63 sel_lv62 sel_lv61 sel_lv60 sel_lv59 sel_lv58 sel_lv57 sel_lv56 sel_lv55 sel_lv54 sel_lv53 sel_lv52 sel_lv51 sel_lv50 sel_lv49 sel_lv48 sel_lv47 sel_lv46 sel_lv45 sel_lv44 sel_lv43 sel_lv42 sel_lv41 sel_lv40 sel_lv39 sel_lv38 sel_lv37 sel_lv36 prg_p0 out_p0 prg_n0 out_n0 prg_p1 out_p1 prg_n1 out_n1 prg_p2 out_p2 prg_n2 out_n2 prg_p3 out_p3 prg_n3 out_n3 prg_p4 out_p4 prg_n4 out_n4 prg_p5 out_p5 prg_n5 out_n5 prg_p6 out_p6 prg_n6 out_n6 prg_p7 out_p7 prg_n7 out_n7 prg_p8 out_p8 prg_n8 out_n8 prg_p9 out_p9 prg_n9 out_n9 prg_p10 out_p10 prg_n10 out_n10 prg_p11 out_p11 prg_n11 out_n11 prg_p12 out_p12 prg_n12 out_n12 prg_p13 out_p13 prg_n13 out_n13 prg_p14 out_p14 prg_n14 out_n14 prg_p15 out_p15 prg_n15 out_n15 prg_p16 out_p16 prg_n16 out_n16 prg_p17 out_p17 prg_n17 out_n17 prg_p18 out_p18 prg_n18 out_n18 prg_p19 out_p19 prg_n19 out_n19 prg_p20 out_p20 prg_n20 out_n20 prg_p21 out_p21 prg_n21 out_n21 prg_p22 out_p22 prg_n22 out_n22 prg_p23 out_p23 prg_n23 out_n23 sen_lv flt_lv slprg_lv wlprog_lv r0 r1 r2
Xarr WL0 WL1 WL2 WL3 WL4 WL5 WL6 WL7 WL8 WL9 WL10 WL11 WL12 WL13 WL14 WL15 WL16 WL17 WL18 WL19 WL20 WL21 WL22 WL23 WL24 WL25 WL26 WL27 WL28 WL29 WL30 WL31 WL32 WL33 WL34 WL35 WL36 WL37 WL38 WL39 WL40 WL41 WL42 WL43 WL44 WL45 WL46 WL47 WL48 WL49 WL50 WL51 WL52 WL53 WL54 WL55 WL56 WL57 WL58 WL59 WL60 WL61 WL62 WL63 WL64 WL65 WL66 WL67 WL68 WL69 WL70 WL71 BLP0 BLP1 BLP2 BLP3 BLP4 BLP5 BLP6 BLP7 BLP8 BLP9 BLP10 BLP11 BLP12 BLP13 BLP14 BLP15 BLP16 BLP17 BLP18 BLP19 BLP20 BLP21 BLP22 BLP23 BLN0 BLN1 BLN2 BLN3 BLN4 BLN5 BLN6 BLN7 BLN8 BLN9 BLN10 BLN11 BLN12 BLN13 BLN14 BLN15 BLN16 BLN17 BLN18 BLN19 BLN20 BLN21 BLN22 BLN23 SL0 SL1 SL2 SL3 SL4 SL5 SL6 SL7 SL8 SL9 SL10 SL11 SL12 SL13 SL14 SL15 SL16 SL17 SL18 SL19 SL20 SL21 SL22 SL23 vss tcim_sky130_array
Xr0 sel_lv0 WL0 vwl vccd vdda vss rowslice
Xr1 sel_lv1 WL1 vwl vccd vdda vss rowslice
Xr2 sel_lv2 WL2 vwl vccd vdda vss rowslice
Xr3 sel_lv3 WL3 vwl vccd vdda vss rowslice
Xr4 sel_lv4 WL4 vwl vccd vdda vss rowslice
Xr5 sel_lv5 WL5 vwl vccd vdda vss rowslice
Xr6 sel_lv6 WL6 vwl vccd vdda vss rowslice
Xr7 sel_lv7 WL7 vwl vccd vdda vss rowslice
Xr8 sel_lv8 WL8 vwl vccd vdda vss rowslice
Xr9 sel_lv9 WL9 vwl vccd vdda vss rowslice
Xr10 sel_lv10 WL10 vwl vccd vdda vss rowslice
Xr11 sel_lv11 WL11 vwl vccd vdda vss rowslice
Xr12 sel_lv12 WL12 vwl vccd vdda vss rowslice
Xr13 sel_lv13 WL13 vwl vccd vdda vss rowslice
Xr14 sel_lv14 WL14 vwl vccd vdda vss rowslice
Xr15 sel_lv15 WL15 vwl vccd vdda vss rowslice
Xr16 sel_lv16 WL16 vwl vccd vdda vss rowslice
Xr17 sel_lv17 WL17 vwl vccd vdda vss rowslice
Xr18 sel_lv18 WL18 vwl vccd vdda vss rowslice
Xr19 sel_lv19 WL19 vwl vccd vdda vss rowslice
Xr20 sel_lv20 WL20 vwl vccd vdda vss rowslice
Xr21 sel_lv21 WL21 vwl vccd vdda vss rowslice
Xr22 sel_lv22 WL22 vwl vccd vdda vss rowslice
Xr23 sel_lv23 WL23 vwl vccd vdda vss rowslice
Xr24 sel_lv24 WL24 vwl vccd vdda vss rowslice
Xr25 sel_lv25 WL25 vwl vccd vdda vss rowslice
Xr26 sel_lv26 WL26 vwl vccd vdda vss rowslice
Xr27 sel_lv27 WL27 vwl vccd vdda vss rowslice
Xr28 sel_lv28 WL28 vwl vccd vdda vss rowslice
Xr29 sel_lv29 WL29 vwl vccd vdda vss rowslice
Xr30 sel_lv30 WL30 vwl vccd vdda vss rowslice
Xr31 sel_lv31 WL31 vwl vccd vdda vss rowslice
Xr32 sel_lv32 WL32 vwl vccd vdda vss rowslice
Xr33 sel_lv33 WL33 vwl vccd vdda vss rowslice
Xr34 sel_lv34 WL34 vwl vccd vdda vss rowslice
Xr35 sel_lv35 WL35 vwl vccd vdda vss rowslice
Xr36 sel_lv36 WL36 vwl vccd vdda vss rowslice
Xr37 sel_lv37 WL37 vwl vccd vdda vss rowslice
Xr38 sel_lv38 WL38 vwl vccd vdda vss rowslice
Xr39 sel_lv39 WL39 vwl vccd vdda vss rowslice
Xr40 sel_lv40 WL40 vwl vccd vdda vss rowslice
Xr41 sel_lv41 WL41 vwl vccd vdda vss rowslice
Xr42 sel_lv42 WL42 vwl vccd vdda vss rowslice
Xr43 sel_lv43 WL43 vwl vccd vdda vss rowslice
Xr44 sel_lv44 WL44 vwl vccd vdda vss rowslice
Xr45 sel_lv45 WL45 vwl vccd vdda vss rowslice
Xr46 sel_lv46 WL46 vwl vccd vdda vss rowslice
Xr47 sel_lv47 WL47 vwl vccd vdda vss rowslice
Xr48 sel_lv48 WL48 vwl vccd vdda vss rowslice
Xr49 sel_lv49 WL49 vwl vccd vdda vss rowslice
Xr50 sel_lv50 WL50 vwl vccd vdda vss rowslice
Xr51 sel_lv51 WL51 vwl vccd vdda vss rowslice
Xr52 sel_lv52 WL52 vwl vccd vdda vss rowslice
Xr53 sel_lv53 WL53 vwl vccd vdda vss rowslice
Xr54 sel_lv54 WL54 vwl vccd vdda vss rowslice
Xr55 sel_lv55 WL55 vwl vccd vdda vss rowslice
Xr56 sel_lv56 WL56 vwl vccd vdda vss rowslice
Xr57 sel_lv57 WL57 vwl vccd vdda vss rowslice
Xr58 sel_lv58 WL58 vwl vccd vdda vss rowslice
Xr59 sel_lv59 WL59 vwl vccd vdda vss rowslice
Xr60 sel_lv60 WL60 vwl vccd vdda vss rowslice
Xr61 sel_lv61 WL61 vwl vccd vdda vss rowslice
Xr62 sel_lv62 WL62 vwl vccd vdda vss rowslice
Xr63 sel_lv63 WL63 vwl vccd vdda vss rowslice
Xr64 sel_lv64 WL64 vwl vccd vdda vss rowslice
Xr65 sel_lv65 WL65 vwl vccd vdda vss rowslice
Xr66 sel_lv66 WL66 vwl vccd vdda vss rowslice
Xr67 sel_lv67 WL67 vwl vccd vdda vss rowslice
Xr68 sel_lv68 WL68 vwl vccd vdda vss rowslice
Xr69 sel_lv69 WL69 vwl vccd vdda vss rowslice
Xr70 sel_lv70 WL70 vwl vccd vdda vss rowslice
Xr71 sel_lv71 WL71 vwl vccd vdda vss rowslice
Xbp0 prg_p0 BLP0 out_p0 vprg sen flt vbp vcl vccd vdda vss blslice
Xbn0 prg_n0 BLN0 out_n0 vprg sen flt vbp vcl vccd vdda vss blslice
Xs0 vprg SL0 slprg slprgb sldn vdda vss sld
Xbp1 prg_p1 BLP1 out_p1 vprg sen flt vbp vcl vccd vdda vss blslice
Xbn1 prg_n1 BLN1 out_n1 vprg sen flt vbp vcl vccd vdda vss blslice
Xs1 vprg SL1 slprg slprgb sldn vdda vss sld
Xbp2 prg_p2 BLP2 out_p2 vprg sen flt vbp vcl vccd vdda vss blslice
Xbn2 prg_n2 BLN2 out_n2 vprg sen flt vbp vcl vccd vdda vss blslice
Xs2 vprg SL2 slprg slprgb sldn vdda vss sld
Xbp3 prg_p3 BLP3 out_p3 vprg sen flt vbp vcl vccd vdda vss blslice
Xbn3 prg_n3 BLN3 out_n3 vprg sen flt vbp vcl vccd vdda vss blslice
Xs3 vprg SL3 slprg slprgb sldn vdda vss sld
Xbp4 prg_p4 BLP4 out_p4 vprg sen flt vbp vcl vccd vdda vss blslice
Xbn4 prg_n4 BLN4 out_n4 vprg sen flt vbp vcl vccd vdda vss blslice
Xs4 vprg SL4 slprg slprgb sldn vdda vss sld
Xbp5 prg_p5 BLP5 out_p5 vprg sen flt vbp vcl vccd vdda vss blslice
Xbn5 prg_n5 BLN5 out_n5 vprg sen flt vbp vcl vccd vdda vss blslice
Xs5 vprg SL5 slprg slprgb sldn vdda vss sld
Xbp6 prg_p6 BLP6 out_p6 vprg sen flt vbp vcl vccd vdda vss blslice
Xbn6 prg_n6 BLN6 out_n6 vprg sen flt vbp vcl vccd vdda vss blslice
Xs6 vprg SL6 slprg slprgb sldn vdda vss sld
Xbp7 prg_p7 BLP7 out_p7 vprg sen flt vbp vcl vccd vdda vss blslice
Xbn7 prg_n7 BLN7 out_n7 vprg sen flt vbp vcl vccd vdda vss blslice
Xs7 vprg SL7 slprg slprgb sldn vdda vss sld
Xbp8 prg_p8 BLP8 out_p8 vprg sen flt vbp vcl vccd vdda vss blslice
Xbn8 prg_n8 BLN8 out_n8 vprg sen flt vbp vcl vccd vdda vss blslice
Xs8 vprg SL8 slprg slprgb sldn vdda vss sld
Xbp9 prg_p9 BLP9 out_p9 vprg sen flt vbp vcl vccd vdda vss blslice
Xbn9 prg_n9 BLN9 out_n9 vprg sen flt vbp vcl vccd vdda vss blslice
Xs9 vprg SL9 slprg slprgb sldn vdda vss sld
Xbp10 prg_p10 BLP10 out_p10 vprg sen flt vbp vcl vccd vdda vss blslice
Xbn10 prg_n10 BLN10 out_n10 vprg sen flt vbp vcl vccd vdda vss blslice
Xs10 vprg SL10 slprg slprgb sldn vdda vss sld
Xbp11 prg_p11 BLP11 out_p11 vprg sen flt vbp vcl vccd vdda vss blslice
Xbn11 prg_n11 BLN11 out_n11 vprg sen flt vbp vcl vccd vdda vss blslice
Xs11 vprg SL11 slprg slprgb sldn vdda vss sld
Xbp12 prg_p12 BLP12 out_p12 vprg sen flt vbp vcl vccd vdda vss blslice
Xbn12 prg_n12 BLN12 out_n12 vprg sen flt vbp vcl vccd vdda vss blslice
Xs12 vprg SL12 slprg slprgb sldn vdda vss sld
Xbp13 prg_p13 BLP13 out_p13 vprg sen flt vbp vcl vccd vdda vss blslice
Xbn13 prg_n13 BLN13 out_n13 vprg sen flt vbp vcl vccd vdda vss blslice
Xs13 vprg SL13 slprg slprgb sldn vdda vss sld
Xbp14 prg_p14 BLP14 out_p14 vprg sen flt vbp vcl vccd vdda vss blslice
Xbn14 prg_n14 BLN14 out_n14 vprg sen flt vbp vcl vccd vdda vss blslice
Xs14 vprg SL14 slprg slprgb sldn vdda vss sld
Xbp15 prg_p15 BLP15 out_p15 vprg sen flt vbp vcl vccd vdda vss blslice
Xbn15 prg_n15 BLN15 out_n15 vprg sen flt vbp vcl vccd vdda vss blslice
Xs15 vprg SL15 slprg slprgb sldn vdda vss sld
Xbp16 prg_p16 BLP16 out_p16 vprg sen flt vbp vcl vccd vdda vss blslice
Xbn16 prg_n16 BLN16 out_n16 vprg sen flt vbp vcl vccd vdda vss blslice
Xs16 vprg SL16 slprg slprgb sldn vdda vss sld
Xbp17 prg_p17 BLP17 out_p17 vprg sen flt vbp vcl vccd vdda vss blslice
Xbn17 prg_n17 BLN17 out_n17 vprg sen flt vbp vcl vccd vdda vss blslice
Xs17 vprg SL17 slprg slprgb sldn vdda vss sld
Xbp18 prg_p18 BLP18 out_p18 vprg sen flt vbp vcl vccd vdda vss blslice
Xbn18 prg_n18 BLN18 out_n18 vprg sen flt vbp vcl vccd vdda vss blslice
Xs18 vprg SL18 slprg slprgb sldn vdda vss sld
Xbp19 prg_p19 BLP19 out_p19 vprg sen flt vbp vcl vccd vdda vss blslice
Xbn19 prg_n19 BLN19 out_n19 vprg sen flt vbp vcl vccd vdda vss blslice
Xs19 vprg SL19 slprg slprgb sldn vdda vss sld
Xbp20 prg_p20 BLP20 out_p20 vprg sen flt vbp vcl vccd vdda vss blslice
Xbn20 prg_n20 BLN20 out_n20 vprg sen flt vbp vcl vccd vdda vss blslice
Xs20 vprg SL20 slprg slprgb sldn vdda vss sld
Xbp21 prg_p21 BLP21 out_p21 vprg sen flt vbp vcl vccd vdda vss blslice
Xbn21 prg_n21 BLN21 out_n21 vprg sen flt vbp vcl vccd vdda vss blslice
Xs21 vprg SL21 slprg slprgb sldn vdda vss sld
Xbp22 prg_p22 BLP22 out_p22 vprg sen flt vbp vcl vccd vdda vss blslice
Xbn22 prg_n22 BLN22 out_n22 vprg sen flt vbp vcl vccd vdda vss blslice
Xs22 vprg SL22 slprg slprgb sldn vdda vss sld
Xbp23 prg_p23 BLP23 out_p23 vprg sen flt vbp vcl vccd vdda vss blslice
Xbn23 prg_n23 BLN23 out_n23 vprg sen flt vbp vcl vccd vdda vss blslice
Xs23 vprg SL23 slprg slprgb sldn vdda vss sld
Xg sen_lv flt_lv slprg_lv wlprog_lv r0 r1 r2 ib vref vwlr vwlp sen flt slprg slprgb sldn vwl vbp vcl vccd vdda vss ctrlglob
Xdr0 vss r0 sky130_fd_pr__diode_pw2nd_05v5 perim=1.2e+07 area=9e+12
Xdr1 vss r1 sky130_fd_pr__diode_pw2nd_05v5 perim=1.2e+07 area=9e+12
Xdr2 vss r2 sky130_fd_pr__diode_pw2nd_05v5 perim=1.2e+07 area=9e+12
.ends

.subckt tcim_chip_digital bl_sen clk cs_n flt irq miso mosi pk pstb rst_n sck sl_prg wl_prog bln_prg[0] bln_prg[1] bln_prg[2] bln_prg[3] bln_prg[4] bln_prg[5] bln_prg[6] bln_prg[7] bln_prg[8] bln_prg[9] bln_prg[10] bln_prg[11] bln_prg[12] bln_prg[13] bln_prg[14] bln_prg[15] bln_prg[16] bln_prg[17] bln_prg[18] bln_prg[19] bln_prg[20] bln_prg[21] bln_prg[22] bln_prg[23] blp_prg[0] blp_prg[1] blp_prg[2] blp_prg[3] blp_prg[4] blp_prg[5] blp_prg[6] blp_prg[7] blp_prg[8] blp_prg[9] blp_prg[10] blp_prg[11] blp_prg[12] blp_prg[13] blp_prg[14] blp_prg[15] blp_prg[16] blp_prg[17] blp_prg[18] blp_prg[19] blp_prg[20] blp_prg[21] blp_prg[22] blp_prg[23] cfg_tp[0] cfg_tp[1] cfg_tp[2] cfg_tr[0] cfg_tr[1] cfg_ts[0] cfg_ts[1] cfg_ts[2] pamp[0] pamp[1] pamp[2] pamp[3] pamp[4] ref_sel[0] ref_sel[1] ref_sel[2] sa_n[0] sa_n[1] sa_n[2] sa_n[3] sa_n[4] sa_n[5] sa_n[6] sa_n[7] sa_n[8] sa_n[9] sa_n[10] sa_n[11] sa_n[12] sa_n[13] sa_n[14] sa_n[15] sa_n[16] sa_n[17] sa_n[18] sa_n[19] sa_n[20] sa_n[21] sa_n[22] sa_n[23] sa_p[0] sa_p[1] sa_p[2] sa_p[3] sa_p[4] sa_p[5] sa_p[6] sa_p[7] sa_p[8] sa_p[9] sa_p[10] sa_p[11] sa_p[12] sa_p[13] sa_p[14] sa_p[15] sa_p[16] sa_p[17] sa_p[18] sa_p[19] sa_p[20] sa_p[21] sa_p[22] sa_p[23] tie_hi[0] tie_hi[1] tie_hi[2] tie_hi[3] tie_hi[4] tie_hi[5] tie_hi[6] tie_hi[7] tie_hi[8] tie_hi[9] tie_hi[10] tie_hi[11] tie_hi[12] tie_lo[0] tie_lo[1] tie_lo[2] tie_lo[3] tie_lo[4] tie_lo[5] tie_lo[6] tie_lo[7] tie_lo[8] tie_lo[9] tie_lo[10] tie_lo[11] tie_lo[12] tie_lo[13] tie_lo[14] tie_lo[15] tie_lo[16] tie_lo[17] tie_lo[18] tie_lo[19] tie_lo[20] tie_lo[21] wl_on[0] wl_on[1] wl_on[2] wl_on[3] wl_on[4] wl_on[5] wl_on[6] wl_on[7] wl_on[8] wl_on[9] wl_on[10] wl_on[11] wl_on[12] wl_on[13] wl_on[14] wl_on[15] wl_on[16] wl_on[17] wl_on[18] wl_on[19] wl_on[20] wl_on[21] wl_on[22] wl_on[23] wl_on[24] wl_on[25] wl_on[26] wl_on[27] wl_on[28] wl_on[29] wl_on[30] wl_on[31] wl_on[32] wl_on[33] wl_on[34] wl_on[35] wl_on[36] wl_on[37] wl_on[38] wl_on[39] wl_on[40] wl_on[41] wl_on[42] wl_on[43] wl_on[44] wl_on[45] wl_on[46] wl_on[47] wl_on[48] wl_on[49] wl_on[50] wl_on[51] wl_on[52] wl_on[53] wl_on[54] wl_on[55] wl_on[56] wl_on[57] wl_on[58] wl_on[59] wl_on[60] wl_on[61] wl_on[62] wl_on[63] wl_on[64] wl_on[65] wl_on[66] wl_on[67] wl_on[68] wl_on[69] wl_on[70] wl_on[71] VDD VSS
X_11540_ net882 _06105_ VSS VSS VDD VDD _06106_ sky130_fd_sc_hd__xnor2_1
X_11541_ net636 _06106_ VSS VSS VDD VDD _06107_ sky130_fd_sc_hd__nand2_1
X_11542_ u_core.u_top.u_core.acc[238] u_core.u_top.u_core.acc[237] _08139_ VSS VSS VDD VDD _06108_ sky130_fd_sc_hd__nand3_1
X_11543_ u_core.u_top.u_core.acc[238] u_core.u_top.u_core.acc[237] _08134_ VSS VSS VDD VDD _06109_ sky130_fd_sc_hd__or3_1
X_11544_ _06108_ _06109_ net706 VSS VSS VDD VDD _06110_ sky130_fd_sc_hd__mux2i_1
X_11545_ _06109_ _06108_ net706 VSS VSS VDD VDD _06111_ sky130_fd_sc_hd__mux2i_1
X_11546_ _0210_ _06110_ _06111_ _08112_ VSS VSS VDD VDD _06112_ sky130_fd_sc_hd__a22oi_1
X_11547_ net671 _06112_ VSS VSS VDD VDD _06113_ sky130_fd_sc_hd__nor2_1
X_11548_ u_core.u_top.u_core.acc[239] _06113_ VSS VSS VDD VDD _06114_ sky130_fd_sc_hd__xnor2_1
X_11549_ _06107_ _06114_ VSS VSS VDD VDD _06115_ sky130_fd_sc_hd__xnor2_1
X_11550_ net786 _06115_ _11233_ net635 VSS VSS VDD VDD _1042_[239] sky130_fd_sc_hd__o211ai_1
X_11551_ u_core.u_top.bus_wdata[47] u_core.u_top.u_core.r_pdata[47] net763 VSS VSS VDD VDD _06116_ sky130_fd_sc_hd__mux2i_1
X_11552_ net820 net856 VSS VSS VDD VDD _06117_ sky130_fd_sc_hd__nor2_1
X_11553_ net856 _06116_ _06117_ VSS VSS VDD VDD _1044_[47] sky130_fd_sc_hd__a21oi_1
X_11554_ _07720_ _10586_ u_core.u_top.u_core.r_piter[5] VSS VSS VDD VDD _06118_ sky130_fd_sc_hd__o21ai_0
X_11555_ u_core.u_top.u_core.r_piter[5] _07720_ _10586_ VSS VSS VDD VDD _06119_ sky130_fd_sc_hd__or3_1
X_11556_ _06118_ _06119_ net790 VSS VSS VDD VDD _1047_[5] sky130_fd_sc_hd__a21oi_1
X_11557_ u_core.u_top.u_core.r_cnt[5] _02901_ _10576_ VSS VSS VDD VDD _06120_ sky130_fd_sc_hd__nand3_1
X_11558_ u_core.u_top.u_core.r_cnt[6] _06120_ VSS VSS VDD VDD _06121_ sky130_fd_sc_hd__xor2_1
X_11559_ _10573_ _06121_ VSS VSS VDD VDD _1049_[6] sky130_fd_sc_hd__nor2_1
X_11560_ net862 _09854_ net857 _05913_ VSS VSS VDD VDD _1052_[23] sky130_fd_sc_hd__o22ai_1
X_11561_ _06065_ VSS VSS VDD VDD _06122_ sky130_fd_sc_hd__inv_1
X_11562_ _09910_ net702 _06122_ net721 net860 VSS VSS VDD VDD _06123_ sky130_fd_sc_hd__o221ai_1
X_11563_ net860 _06122_ _06123_ VSS VSS VDD VDD _06124_ sky130_fd_sc_hd__o21ai_0
X_11564_ u_core.arr_sa_p[23] _10217_ _06068_ VSS VSS VDD VDD _06125_ sky130_fd_sc_hd__a21oi_1
X_11565_ net789 _06124_ _06125_ VSS VSS VDD VDD _1056_[23] sky130_fd_sc_hd__o21ai_0
X_11566_ _09909_ net702 _06070_ net721 net860 VSS VSS VDD VDD _06126_ sky130_fd_sc_hd__o221ai_1
X_11567_ net860 _06070_ _06126_ VSS VSS VDD VDD _06127_ sky130_fd_sc_hd__o21ai_0
X_11568_ u_core.arr_sa_n[23] _10217_ _06073_ VSS VSS VDD VDD _06128_ sky130_fd_sc_hd__a21oi_1
X_11569_ net789 _06127_ _06128_ VSS VSS VDD VDD _1060_[23] sky130_fd_sc_hd__o21ai_0
X_11570_ u_core.u_top.u_core.amp[2] _02700_ u_core.u_top.u_core.amp[3] VSS VSS VDD VDD _06129_ sky130_fd_sc_hd__nand3_1
X_11571_ u_core.u_top.u_core.amp[4] _06129_ VSS VSS VDD VDD _06130_ sky130_fd_sc_hd__xor2_1
X_11572_ net790 _06130_ VSS VSS VDD VDD _1064_[4] sky130_fd_sc_hd__nor2_1
X_11573_ net896 net897 VSS VSS VDD VDD _06131_ sky130_fd_sc_hd__nor2_1
X_11574_ net1000 u_core.arr_req VSS VSS VDD VDD _06132_ sky130_fd_sc_hd__nor2b_1
X_11575_ _10215_ _06132_ VSS VSS VDD VDD _06133_ sky130_fd_sc_hd__nor2_1
X_11576_ _06131_ _06133_ net895 VSS VSS VDD VDD _06134_ sky130_fd_sc_hd__o21ba_1
X_11577_ net896 net898 net897 net895 _06134_ VSS VSS VDD VDD _06135_ sky130_fd_sc_hd__a221oi_1
X_11578_ net895 net885 net792 _05883_ VSS VSS VDD VDD _06136_ sky130_fd_sc_hd__a211oi_1
X_11579_ net896 net1000 _09963_ VSS VSS VDD VDD _06137_ sky130_fd_sc_hd__nor3_1
X_11580_ _06136_ _06137_ u_core.arr_req VSS VSS VDD VDD _06138_ sky130_fd_sc_hd__o21ai_0
X_11581_ net897 _06132_ net895 VSS VSS VDD VDD _06139_ sky130_fd_sc_hd__o21ai_0
X_11582_ net896 _10215_ _06139_ net886 _10236_ VSS VSS VDD VDD _06140_ sky130_fd_sc_hd__a32o_1
X_11583_ _05887_ net665 _06135_ VSS VSS VDD VDD _06141_ sky130_fd_sc_hd__a21oi_1
X_11584_ net886 _10572_ _06138_ _06140_ _06141_ VSS VSS VDD VDD _06142_ sky130_fd_sc_hd__a221oi_1
X_11585_ _10230_ _06135_ _06142_ VSS VSS VDD VDD _1073_ sky130_fd_sc_hd__o21a_1
X_11586_ _0296_ net884 _10206_ VSS VSS VDD VDD _06143_ sky130_fd_sc_hd__nand3_1
X_11587_ net895 _09959_ _05900_ VSS VSS VDD VDD _06144_ sky130_fd_sc_hd__o21ai_0
X_11588_ net898 _05931_ _08079_ VSS VSS VDD VDD _06145_ sky130_fd_sc_hd__a21oi_1
X_11589_ net895 _10572_ _06144_ net896 _06145_ VSS VSS VDD VDD _06146_ sky130_fd_sc_hd__a221o_1
X_11590_ _05887_ _06146_ VSS VSS VDD VDD _06147_ sky130_fd_sc_hd__nand2_1
X_11591_ net865 _10202_ _06143_ _06147_ VSS VSS VDD VDD _1085_[3] sky130_fd_sc_hd__a31o_1
X_11592_ u_core.u_actl.q1_p[23] net793 VSS VSS VDD VDD _1089_[23] sky130_fd_sc_hd__and2_1
X_11593_ u_core.u_actl.q1_n[23] net793 VSS VSS VDD VDD _1091_[23] sky130_fd_sc_hd__and2_1
X_11594_ _09691_ _09729_ net227 VSS VSS VDD VDD _06148_ sky130_fd_sc_hd__a21oi_1
X_11595_ net999 _06148_ VSS VSS VDD VDD _1093_[71] sky130_fd_sc_hd__nor2_1
X_11596_ u_core.u_actl.st[5] _09479_ VSS VSS VDD VDD _1095_ sky130_fd_sc_hd__nor2_1
X_11597_ u_core.u_actl.mp[23] net863 VSS VSS VDD VDD _06149_ sky130_fd_sc_hd__nor2_1
X_11598_ u_core.u_actl.mp[23] net864 _06149_ VSS VSS VDD VDD _06150_ sky130_fd_sc_hd__a21oi_1
X_11599_ net997 _06150_ VSS VSS VDD VDD _1097_[23] sky130_fd_sc_hd__nor2_1
X_11600_ u_core.u_actl.mn[23] net863 VSS VSS VDD VDD _06151_ sky130_fd_sc_hd__nor2_1
X_11601_ u_core.u_actl.mn[23] net864 _06151_ VSS VSS VDD VDD _06152_ sky130_fd_sc_hd__a21oi_1
X_11602_ net997 _06152_ VSS VSS VDD VDD _1099_[23] sky130_fd_sc_hd__nor2_1
X_11603_ u_core.u_actl.op[0] u_core.u_actl.op[1] u_core.u_actl.op[2] u_core.u_actl.st[5] VSS VSS VDD VDD _1101_ sky130_fd_sc_hd__a211oi_1
X_11604_ net997 net863 VSS VSS VDD VDD _1103_ sky130_fd_sc_hd__nor2_1
X_11605_ u_core.u_actl.st[8] VSS VSS VDD VDD _06153_ sky130_fd_sc_hd__inv_1
X_11606_ _06153_ u_core.u_actl.st[3] u_core.u_actl.st[10] VSS VSS VDD VDD _1107_ sky130_fd_sc_hd__a21oi_1
X_11607_ u_core.u_actl.st[5] u_core.u_actl.op[2] u_core.u_actl.op[1] u_core.u_actl.op[0] VSS VSS VDD VDD _1109_[2] sky130_fd_sc_hd__nor4b_1
X_11608_ net999 _09479_ VSS VSS VDD VDD _1111_ sky130_fd_sc_hd__nor2_1
X_11609_ u_core.u_actl.st[9] u_core.u_actl.cnt[8] VSS VSS VDD VDD _06154_ sky130_fd_sc_hd__nand2_1
X_11610_ u_core.u_actl.cnt[8] _09530_ VSS VSS VDD VDD _06155_ sky130_fd_sc_hd__xnor2_1
X_11611_ _03211_ _09485_ _09548_ VSS VSS VDD VDD _06156_ sky130_fd_sc_hd__nor3_1
X_11612_ _03211_ _09548_ _06156_ VSS VSS VDD VDD _06157_ sky130_fd_sc_hd__a21oi_1
X_11613_ _09485_ net794 _03211_ VSS VSS VDD VDD _06158_ sky130_fd_sc_hd__o21ai_0
X_11614_ net794 _06157_ _06158_ _09548_ VSS VSS VDD VDD _06159_ sky130_fd_sc_hd__o22ai_1
X_11615_ _09475_ _09531_ _06159_ VSS VSS VDD VDD _06160_ sky130_fd_sc_hd__o21ai_0
X_11616_ _09530_ _06154_ _06155_ _05870_ _06160_ VSS VSS VDD VDD _1114_[8] sky130_fd_sc_hd__o221ai_1
X_11617_ net989 net850 _05883_ _05885_ net792 VSS VSS VDD VDD _03520_ sky130_fd_sc_hd__a2111oi_4
X_11618_ _10215_ _10239_ VSS VSS VDD VDD _06161_ sky130_fd_sc_hd__nand2_1
X_11619_ net896 net1000 _06161_ VSS VSS VDD VDD _06162_ sky130_fd_sc_hd__nand3_1
X_11620_ net681 _06162_ net895 VSS VSS VDD VDD _03519_ sky130_fd_sc_hd__a21oi_1
X_11621_ _03234_ _05834_ VSS VSS VDD VDD _0344_[6] sky130_fd_sc_hd__xor2_1
X_11622_ u_core.u_top.u_core.r_off[3] VSS VSS VDD VDD _02495_ sky130_fd_sc_hd__inv_2
X_11623_ net989 net790 net681 VSS VSS VDD VDD _03518_ sky130_fd_sc_hd__o21ai_0
X_11624_ u_core.u_top.u_core.amp[1] VSS VSS VDD VDD _02697_ sky130_fd_sc_hd__inv_1
X_11625_ _08109_ _10206_ VSS VSS VDD VDD _2076_ sky130_fd_sc_hd__nor2_1
X_11626_ _10206_ _05875_ VSS VSS VDD VDD _2079_ sky130_fd_sc_hd__nor2_1
X_11627_ net884 _05919_ VSS VSS VDD VDD _2082_ sky130_fd_sc_hd__and2_1
X_11628_ u_core.u_top.u_spi.shift_out[47] VSS VSS VDD VDD _06163_ sky130_fd_sc_hd__inv_1
X_11629_ u_core.u_top.u_core.r_x[95] net818 VSS VSS VDD VDD _06164_ sky130_fd_sc_hd__nand2_1
X_11630_ u_core.u_top.u_core.r_x[47] net872 VSS VSS VDD VDD _06165_ sky130_fd_sc_hd__nand2_1
X_11631_ u_core.u_top.u_core.r_x[143] net809 VSS VSS VDD VDD _06166_ sky130_fd_sc_hd__nor2_1
X_11632_ net810 _06164_ _06165_ _06166_ net807 VSS VSS VDD VDD _06167_ sky130_fd_sc_hd__a311oi_2
X_11633_ u_core.u_top.u_core.r_pdata[47] net814 _06167_ VSS VSS VDD VDD _06168_ sky130_fd_sc_hd__a21oi_1
X_11634_ net996 _06163_ net749 _06168_ net815 VSS VSS VDD VDD _06169_ sky130_fd_sc_hd__o221ai_1
X_11635_ u_core.u_top.u_spi.shift_out[46] net815 _06169_ VSS VSS VDD VDD _2236_[47] sky130_fd_sc_hd__o21a_1
X_11636_ _06565_ _05879_ u_core.u_top.u_spi.bitcnt[6] VSS VSS VDD VDD _06170_ sky130_fd_sc_hd__o21ai_0
X_11637_ u_core.u_top.u_spi.bitcnt[6] _06565_ _05879_ VSS VSS VDD VDD _06171_ sky130_fd_sc_hd__or3_1
X_11638_ _06170_ _06171_ u_core.u_top.u_spi.cs_s[1] VSS VSS VDD VDD _2294_[6] sky130_fd_sc_hd__a21oi_1
X_11639_ _03082_ u_core.u_top.u_spi.err_latch _03081_ VSS VSS VDD VDD _06172_ sky130_fd_sc_hd__a21oi_1
X_11640_ _03081_ _06057_ _06172_ VSS VSS VDD VDD _06173_ sky130_fd_sc_hd__a21oi_1
X_11641_ u_core.u_top.u_spi.bitcnt[6] _05879_ VSS VSS VDD VDD _06174_ sky130_fd_sc_hd__nor2_1
X_11642_ _03083_ _06173_ _06174_ u_core.u_top.u_spi.bitcnt[3] u_core.u_top.u_spi.bitcnt[2] VSS VSS VDD VDD _06175_ sky130_fd_sc_hd__o2111ai_1
X_11643_ u_core.u_top.u_spi.cmd[7] _06163_ _06573_ VSS VSS VDD VDD _06176_ sky130_fd_sc_hd__or3_1
X_11644_ _06175_ _06176_ u_core.u_top.u_spi.cs_s[1] VSS VSS VDD VDD _2295_ sky130_fd_sc_hd__a21oi_1
X_11645_ u_core.u_top.u_spi.cmd[6] _1304_ VSS VSS VDD VDD _2296_ sky130_fd_sc_hd__nor2b_1
X_11646_ _05879_ _05878_ _05880_ VSS VSS VDD VDD _2297_ sky130_fd_sc_hd__nor3_1
X_11647_ u_core.u_top.u_core.lfsr[15] u_core.u_top.u_core.d_acc[159] VSS VSS VDD VDD _06177_ sky130_fd_sc_hd__xnor2_1
X_11648_ _03064_ VSS VSS VDD VDD _06178_ sky130_fd_sc_hd__inv_1
X_11649_ _06178_ _05078_ _03063_ VSS VSS VDD VDD _06179_ sky130_fd_sc_hd__o21bai_1
X_11650_ _02622_ _06179_ _02621_ VSS VSS VDD VDD _06180_ sky130_fd_sc_hd__a21oi_1
X_11651_ _06177_ _06180_ VSS VSS VDD VDD _0306_[9] sky130_fd_sc_hd__xnor2_1
X_11652_ _02405_ _03351_ VSS VSS VDD VDD _0243_[2] sky130_fd_sc_hd__xnor2_1
X_11654_ u_core.u_top.u_spi.cs_s[1] VSS VSS VDD VDD _0982_ sky130_fd_sc_hd__inv_1
X_11655_ u_core.u_top.u_core.acc[181] VSS VSS VDD VDD _02537_ sky130_fd_sc_hd__inv_1
X_11675_ u_core.u_top.bus_addr[4] u_core.u_top.bus_addr[5] u_core.u_top.bus_addr[0] u_core.u_top.bus_addr[1] VSS VSS VDD VDD _06201_ sky130_fd_sc_hd__nor4_1
X_11678_ u_core.u_top.bus_addr[2] _06201_ u_core.u_top.bus_addr[3] VSS VSS VDD VDD _06204_ sky130_fd_sc_hd__nand3b_4
X_11680_ _06204_ VSS VSS VDD VDD _06206_ sky130_fd_sc_hd__clkinv_1
X_11684_ u_core.u_top.u_core.r_prow[4] VSS VSS VDD VDD _06209_ sky130_fd_sc_hd__inv_2
X_11687_ net953 net955 VSS VSS VDD VDD _0892_[0] sky130_fd_sc_hd__xnor2_4
X_11688_ _06209_ _0892_[0] VSS VSS VDD VDD _0896_[0] sky130_fd_sc_hd__xnor2_1
X_11689_ _0896_[0] VSS VSS VDD VDD _0005_[0] sky130_fd_sc_hd__inv_1
X_11690_ u_core.arr_sa_n[6] VSS VSS VDD VDD _0522_ sky130_fd_sc_hd__inv_1
X_11691_ u_core.u_top.u_core.acc[230] VSS VSS VDD VDD _0211_[0] sky130_fd_sc_hd__inv_1
X_11692_ u_core.u_top.u_core.d_acc[131] VSS VSS VDD VDD _02392_ sky130_fd_sc_hd__inv_1
X_11693_ u_core.u_top.u_core.acc[111] VSS VSS VDD VDD _02923_ sky130_fd_sc_hd__inv_1
X_11694_ u_core.u_top.u_core.acc[21] VSS VSS VDD VDD _03041_ sky130_fd_sc_hd__inv_1
X_11695_ u_core.arr_sa_p[4] VSS VSS VDD VDD _0511_ sky130_fd_sc_hd__inv_1
X_11696_ u_core.u_top.u_core.acc[191] VSS VSS VDD VDD _02565_ sky130_fd_sc_hd__inv_1
X_11697_ u_core.u_top.u_core.d_acc[161] VSS VSS VDD VDD _02298_ sky130_fd_sc_hd__inv_1
X_11698_ u_core.arr_sa_n[21] VSS VSS VDD VDD _0621_ sky130_fd_sc_hd__inv_1
X_11699_ _03294_ VSS VSS VDD VDD _06212_ sky130_fd_sc_hd__inv_1
X_11700_ _03058_ u_core.u_top.u_core.d_acc[190] _03057_ VSS VSS VDD VDD _06213_ sky130_fd_sc_hd__a21o_1
X_11701_ _03366_ _06213_ _03365_ VSS VSS VDD VDD _06214_ sky130_fd_sc_hd__a21oi_1
X_11702_ _06212_ _06214_ _03293_ VSS VSS VDD VDD _06215_ sky130_fd_sc_hd__o21bai_1
X_11703_ _03456_ _06215_ _03455_ VSS VSS VDD VDD _06216_ sky130_fd_sc_hd__a21oi_1
X_11704_ _03173_ _06216_ VSS VSS VDD VDD _0327_[5] sky130_fd_sc_hd__xnor2_1
X_11705_ _02521_ VSS VSS VDD VDD _06217_ sky130_fd_sc_hd__inv_1
X_11706_ _03470_ VSS VSS VDD VDD _06218_ sky130_fd_sc_hd__inv_1
X_11707_ _02328_ VSS VSS VDD VDD _06219_ sky130_fd_sc_hd__inv_1
X_11708_ _02842_ _06219_ _02841_ VSS VSS VDD VDD _06220_ sky130_fd_sc_hd__a21oi_1
X_11709_ _03469_ VSS VSS VDD VDD _06221_ sky130_fd_sc_hd__inv_1
X_11710_ _06218_ _06220_ _06221_ VSS VSS VDD VDD _06222_ sky130_fd_sc_hd__o21ai_0
X_11711_ _02725_ _06222_ _02724_ VSS VSS VDD VDD _06223_ sky130_fd_sc_hd__a21oi_1
X_11712_ _06217_ _06223_ VSS VSS VDD VDD _06224_ sky130_fd_sc_hd__nor2_1
X_11713_ _02520_ _06224_ VSS VSS VDD VDD _06225_ sky130_fd_sc_hd__nor2_1
X_11714_ _03325_ _06225_ VSS VSS VDD VDD _0226_[6] sky130_fd_sc_hd__xnor2_1
X_11715_ _03274_ VSS VSS VDD VDD _06226_ sky130_fd_sc_hd__inv_1
X_11716_ u_core.u_top.u_core.d_acc[130] _02610_ _02609_ VSS VSS VDD VDD _06227_ sky130_fd_sc_hd__a21o_1
X_11717_ _03412_ _06227_ _03411_ VSS VSS VDD VDD _06228_ sky130_fd_sc_hd__a21oi_1
X_11718_ _06226_ _06228_ _03273_ VSS VSS VDD VDD _06229_ sky130_fd_sc_hd__o21bai_1
X_11719_ _03468_ _06229_ _03467_ VSS VSS VDD VDD _06230_ sky130_fd_sc_hd__a21oi_1
X_11720_ _02750_ _06230_ VSS VSS VDD VDD _0294_[5] sky130_fd_sc_hd__xnor2_1
X_11721_ u_core.u_top.u_core.acc[231] VSS VSS VDD VDD _02692_ sky130_fd_sc_hd__inv_1
X_11722_ u_core.u_top.u_core.acc[220] VSS VSS VDD VDD _0200_[0] sky130_fd_sc_hd__inv_1
X_11724_ u_core.arr_row[6] u_core.arr_row[4] VSS VSS VDD VDD _06232_ sky130_fd_sc_hd__nand2b_1
X_11729_ u_core.arr_row[6] u_core.arr_row[3] VSS VSS VDD VDD _06237_ sky130_fd_sc_hd__nand2b_2
X_11736_ u_core.arr_row[5] u_core.arr_row[4] u_core.arr_row[3] u_core.arr_row[6] VSS VSS VDD VDD _06244_ sky130_fd_sc_hd__o31ai_2
X_11737_ net985 net891 VSS VSS VDD VDD _06245_ sky130_fd_sc_hd__and2_0
X_11742_ u_core.arr_row[0] net891 VSS VSS VDD VDD _06250_ sky130_fd_sc_hd__nand2_2
X_11746_ u_core.arr_row[1] net891 VSS VSS VDD VDD _06254_ sky130_fd_sc_hd__nand2_1
X_11748_ u_core.u_top.u_core.r_x[14] net934 net939 net902 net869 net868 VSS VSS VDD VDD _06256_ sky130_fd_sc_hd__mux4_2
X_11749_ _06245_ _06256_ VSS VSS VDD VDD _06257_ sky130_fd_sc_hd__nand2_1
X_11750_ net985 net891 VSS VSS VDD VDD _06258_ sky130_fd_sc_hd__nand2_1
X_11755_ net908 net914 u_core.u_top.u_core.r_x[2] net945 net869 net868 VSS VSS VDD VDD _06263_ sky130_fd_sc_hd__mux4_2
X_11756_ net867 _06263_ VSS VSS VDD VDD _06264_ sky130_fd_sc_hd__nand2_1
X_11759_ u_core.u_top.u_core.r_x[22] net925 net926 net927 net869 net868 VSS VSS VDD VDD _06267_ sky130_fd_sc_hd__mux4_2
X_11762_ u_core.u_top.u_core.r_x[30] net923 u_core.u_top.u_core.r_x[26] net924 net869 net868 VSS VSS VDD VDD _06270_ sky130_fd_sc_hd__mux4_2
X_11763_ _06245_ _06270_ VSS VSS VDD VDD _06271_ sky130_fd_sc_hd__and2_1
X_11764_ net867 _06267_ _06271_ net892 VSS VSS VDD VDD _06272_ sky130_fd_sc_hd__a211oi_1
X_11765_ net892 _06257_ _06264_ _06272_ VSS VSS VDD VDD _06273_ sky130_fd_sc_hd__a31oi_1
X_11766_ u_core.u_top.u_core.r_x[54] net913 u_core.u_top.u_core.r_x[50] net915 net869 net868 VSS VSS VDD VDD _06274_ sky130_fd_sc_hd__mux4_2
X_11768_ net920 net921 u_core.u_top.u_core.r_x[34] net922 net869 net868 VSS VSS VDD VDD _06276_ sky130_fd_sc_hd__mux4_2
X_11769_ _06274_ _06276_ net892 VSS VSS VDD VDD _06277_ sky130_fd_sc_hd__mux2i_1
X_11775_ net916 net917 net918 net919 net869 net868 VSS VSS VDD VDD _06283_ sky130_fd_sc_hd__mux4_2
X_11778_ u_core.u_top.u_core.r_x[62] net911 u_core.u_top.u_core.r_x[58] net912 net869 net868 VSS VSS VDD VDD _06286_ sky130_fd_sc_hd__mux4_2
X_11779_ net892 _06286_ VSS VSS VDD VDD _06287_ sky130_fd_sc_hd__nor2b_1
X_11780_ net892 _06283_ _06287_ net867 VSS VSS VDD VDD _06288_ sky130_fd_sc_hd__a211oi_1
X_11781_ net867 _06277_ _06288_ net893 VSS VSS VDD VDD _06289_ sky130_fd_sc_hd__a211oi_1
X_11782_ net893 _06273_ _06289_ VSS VSS VDD VDD _06290_ sky130_fd_sc_hd__a21oi_1
X_11784_ u_core.u_top.u_core.r_x[110] net940 net941 net942 _06250_ _06254_ VSS VSS VDD VDD _06292_ sky130_fd_sc_hd__mux4_2
X_11789_ net943 u_core.u_top.u_core.r_x[100] u_core.u_top.u_core.r_x[98] net900 net869 _06254_ VSS VSS VDD VDD _06297_ sky130_fd_sc_hd__mux4_2
X_11792_ u_core.u_top.u_core.r_x[126] u_core.u_top.u_core.r_x[124] u_core.u_top.u_core.r_x[122] net935 _06250_ _06254_ VSS VSS VDD VDD _06300_ sky130_fd_sc_hd__mux4_2
X_11793_ net936 net937 u_core.u_top.u_core.r_x[114] net938 net869 _06254_ VSS VSS VDD VDD _06301_ sky130_fd_sc_hd__mux4_2
X_11796_ _06292_ _06297_ _06300_ _06301_ net867 net984 VSS VSS VDD VDD _06304_ sky130_fd_sc_hd__mux4_2
X_11801_ net906 u_core.u_top.u_core.r_x[76] u_core.u_top.u_core.r_x[74] net907 net869 net868 VSS VSS VDD VDD _06309_ sky130_fd_sc_hd__mux4_2
X_11805_ u_core.u_top.u_core.r_x[70] net909 u_core.u_top.u_core.r_x[66] net910 net869 net868 VSS VSS VDD VDD _06313_ sky130_fd_sc_hd__mux4_2
X_11808_ net901 u_core.u_top.u_core.r_x[92] u_core.u_top.u_core.r_x[90] net903 net869 net868 VSS VSS VDD VDD _06316_ sky130_fd_sc_hd__mux4_2
X_11809_ net904 net905 u_core.u_top.u_core.r_x[82] u_core.u_top.u_core.r_x[80] net869 net868 VSS VSS VDD VDD _06317_ sky130_fd_sc_hd__mux4_2
X_11810_ _06309_ _06313_ _06316_ _06317_ net867 net984 VSS VSS VDD VDD _06318_ sky130_fd_sc_hd__mux4_2
X_11811_ u_core.arr_row[4] VSS VSS VDD VDD _06319_ sky130_fd_sc_hd__clkinv_1
X_11812_ _06304_ _06318_ net890 VSS VSS VDD VDD _06320_ sky130_fd_sc_hd__mux2i_1
X_11814_ _06290_ _06320_ net982 VSS VSS VDD VDD _06322_ sky130_fd_sc_hd__mux2i_1
X_11816_ net982 net983 net984 VSS VSS VDD VDD _06324_ sky130_fd_sc_hd__nor3_2
X_11819_ u_core.u_top.u_core.r_x[142] net928 net929 u_core.u_top.u_core.r_x[136] _06250_ _06254_ VSS VSS VDD VDD _06327_ sky130_fd_sc_hd__mux4_2
X_11820_ _06245_ _06327_ VSS VSS VDD VDD _06328_ sky130_fd_sc_hd__nand2_1
X_11823_ net931 net932 u_core.u_top.u_core.r_x[130] u_core.u_top.u_core.r_x[128] _06250_ _06254_ VSS VSS VDD VDD _06331_ sky130_fd_sc_hd__mux4_2
X_11824_ _06258_ _06331_ VSS VSS VDD VDD _06332_ sky130_fd_sc_hd__nand2_1
X_11825_ _06328_ _06332_ VSS VSS VDD VDD _06333_ sky130_fd_sc_hd__nand2_1
X_11826_ net889 _06333_ VSS VSS VDD VDD _06334_ sky130_fd_sc_hd__nand2_1
X_11827_ net889 _06290_ _06334_ VSS VSS VDD VDD _06335_ sky130_fd_sc_hd__o21ai_0
X_11830_ _06322_ _06335_ net981 VSS VSS VDD VDD _06338_ sky130_fd_sc_hd__mux2_1
X_11834_ _0065_ _0070_ VSS VSS VDD VDD _06342_ sky130_fd_sc_hd__nor2b_1
X_11835_ u_core.arr_row[0] net891 VSS VSS VDD VDD _06343_ sky130_fd_sc_hd__and2_1
X_11836_ u_core.arr_row[1] net891 VSS VSS VDD VDD _06344_ sky130_fd_sc_hd__and2_1
X_11838_ u_core.u_top.u_core.r_x[45] VSS VSS VDD VDD _06346_ sky130_fd_sc_hd__inv_1
X_11839_ net892 u_core.u_top.u_core.r_x[61] u_core.u_top.u_core.r_x[60] VSS VSS VDD VDD _06347_ sky130_fd_sc_hd__nor3b_1
X_11840_ _06346_ u_core.u_top.u_core.r_x[44] net892 net893 _06347_ VSS VSS VDD VDD _06348_ sky130_fd_sc_hd__a311o_1
X_11841_ net923 VSS VSS VDD VDD _06349_ sky130_fd_sc_hd__inv_1
X_11843_ u_core.u_top.u_core.r_x[13] u_core.u_top.u_core.r_x[12] net892 VSS VSS VDD VDD _06351_ sky130_fd_sc_hd__nand3b_1
X_11844_ u_core.u_top.u_core.r_x[29] _06349_ net892 net893 _06351_ VSS VSS VDD VDD _06352_ sky130_fd_sc_hd__o311ai_0
X_11845_ net892 u_core.u_top.u_core.r_x[25] u_core.u_top.u_core.r_x[24] VSS VSS VDD VDD _06353_ sky130_fd_sc_hd__or3b_2
X_11846_ u_core.u_top.u_core.r_x[9] u_core.u_top.u_core.r_x[8] net892 VSS VSS VDD VDD _06354_ sky130_fd_sc_hd__nand3b_1
X_11847_ u_core.u_top.u_core.r_x[41] VSS VSS VDD VDD _06355_ sky130_fd_sc_hd__inv_1
X_11849_ u_core.arr_row[6] u_core.u_top.u_core.r_x[57] u_core.u_top.u_core.r_x[56] u_core.arr_row[3] VSS VSS VDD VDD _06357_ sky130_fd_sc_hd__nor4bb_1
X_11850_ _06355_ net919 net892 net893 _06357_ VSS VSS VDD VDD _06358_ sky130_fd_sc_hd__a311oi_1
X_11851_ net893 _06353_ _06354_ _06358_ _06344_ VSS VSS VDD VDD _06359_ sky130_fd_sc_hd__a311oi_1
X_11852_ _06344_ _06348_ _06352_ _06359_ net867 VSS VSS VDD VDD _06360_ sky130_fd_sc_hd__a311oi_1
X_11853_ u_core.u_top.u_core.r_x[33] VSS VSS VDD VDD _06361_ sky130_fd_sc_hd__inv_1
X_11854_ net892 u_core.u_top.u_core.r_x[49] u_core.u_top.u_core.r_x[48] VSS VSS VDD VDD _06362_ sky130_fd_sc_hd__nor3b_1
X_11855_ _06361_ net922 net892 net893 _06362_ VSS VSS VDD VDD _06363_ sky130_fd_sc_hd__a311o_1
X_11856_ u_core.u_top.u_core.r_x[16] VSS VSS VDD VDD _06364_ sky130_fd_sc_hd__inv_1
X_11857_ u_core.u_top.u_core.r_x[1] u_core.u_top.u_core.r_x[0] net892 VSS VSS VDD VDD _06365_ sky130_fd_sc_hd__nand3b_1
X_11858_ u_core.u_top.u_core.r_x[17] _06364_ net892 net893 _06365_ VSS VSS VDD VDD _06366_ sky130_fd_sc_hd__o311ai_0
X_11859_ u_core.u_top.u_core.r_x[5] VSS VSS VDD VDD _06367_ sky130_fd_sc_hd__inv_1
X_11860_ u_core.arr_row[6] u_core.u_top.u_core.r_x[21] u_core.u_top.u_core.r_x[20] u_core.arr_row[3] VSS VSS VDD VDD _06368_ sky130_fd_sc_hd__nor4bb_1
X_11861_ _06367_ u_core.u_top.u_core.r_x[4] net892 _06368_ VSS VSS VDD VDD _06369_ sky130_fd_sc_hd__a31oi_1
X_11862_ u_core.u_top.u_core.r_x[37] VSS VSS VDD VDD _06370_ sky130_fd_sc_hd__inv_1
X_11863_ u_core.arr_row[6] u_core.u_top.u_core.r_x[53] u_core.u_top.u_core.r_x[52] u_core.arr_row[3] VSS VSS VDD VDD _06371_ sky130_fd_sc_hd__nor4bb_1
X_11864_ _06370_ net921 net892 net893 _06371_ VSS VSS VDD VDD _06372_ sky130_fd_sc_hd__a311oi_1
X_11865_ net893 _06369_ _06372_ net868 VSS VSS VDD VDD _06373_ sky130_fd_sc_hd__a211oi_1
X_11866_ net868 _06363_ _06366_ _06373_ _06245_ VSS VSS VDD VDD _06374_ sky130_fd_sc_hd__a311oi_1
X_11867_ u_core.u_top.u_core.r_x[59] u_core.u_top.u_core.r_x[58] VSS VSS VDD VDD _06375_ sky130_fd_sc_hd__nor2b_1
X_11868_ u_core.u_top.u_core.r_x[43] u_core.u_top.u_core.r_x[42] VSS VSS VDD VDD _06376_ sky130_fd_sc_hd__nor2b_1
X_11869_ u_core.u_top.u_core.r_x[27] u_core.u_top.u_core.r_x[26] VSS VSS VDD VDD _06377_ sky130_fd_sc_hd__nor2b_1
X_11870_ u_core.u_top.u_core.r_x[11] u_core.u_top.u_core.r_x[10] VSS VSS VDD VDD _06378_ sky130_fd_sc_hd__nor2b_1
X_11871_ _06375_ _06376_ _06377_ _06378_ net892 net893 VSS VSS VDD VDD _06379_ sky130_fd_sc_hd__mux4_2
X_11872_ u_core.u_top.u_core.r_x[63] u_core.u_top.u_core.r_x[62] VSS VSS VDD VDD _06380_ sky130_fd_sc_hd__nor2b_1
X_11873_ u_core.u_top.u_core.r_x[47] u_core.u_top.u_core.r_x[46] VSS VSS VDD VDD _06381_ sky130_fd_sc_hd__nor2b_1
X_11874_ u_core.u_top.u_core.r_x[31] u_core.u_top.u_core.r_x[30] VSS VSS VDD VDD _06382_ sky130_fd_sc_hd__nor2b_1
X_11875_ u_core.u_top.u_core.r_x[15] u_core.u_top.u_core.r_x[14] VSS VSS VDD VDD _06383_ sky130_fd_sc_hd__nor2b_1
X_11876_ _06380_ _06381_ _06382_ _06383_ net892 net893 VSS VSS VDD VDD _06384_ sky130_fd_sc_hd__mux4_2
X_11877_ u_core.u_top.u_core.r_x[51] u_core.u_top.u_core.r_x[50] VSS VSS VDD VDD _06385_ sky130_fd_sc_hd__nor2b_1
X_11878_ u_core.u_top.u_core.r_x[35] u_core.u_top.u_core.r_x[34] VSS VSS VDD VDD _06386_ sky130_fd_sc_hd__nor2b_1
X_11879_ u_core.u_top.u_core.r_x[19] u_core.u_top.u_core.r_x[18] VSS VSS VDD VDD _06387_ sky130_fd_sc_hd__nor2b_1
X_11880_ u_core.u_top.u_core.r_x[3] u_core.u_top.u_core.r_x[2] VSS VSS VDD VDD _06388_ sky130_fd_sc_hd__nor2b_1
X_11881_ _06385_ _06386_ _06387_ _06388_ net892 net893 VSS VSS VDD VDD _06389_ sky130_fd_sc_hd__mux4_2
X_11882_ u_core.u_top.u_core.r_x[55] u_core.u_top.u_core.r_x[54] VSS VSS VDD VDD _06390_ sky130_fd_sc_hd__nor2b_1
X_11883_ u_core.u_top.u_core.r_x[39] u_core.u_top.u_core.r_x[38] VSS VSS VDD VDD _06391_ sky130_fd_sc_hd__nor2b_1
X_11884_ u_core.u_top.u_core.r_x[23] u_core.u_top.u_core.r_x[22] VSS VSS VDD VDD _06392_ sky130_fd_sc_hd__nor2b_1
X_11885_ u_core.u_top.u_core.r_x[7] u_core.u_top.u_core.r_x[6] VSS VSS VDD VDD _06393_ sky130_fd_sc_hd__nor2b_1
X_11886_ _06390_ _06391_ _06392_ _06393_ net892 net893 VSS VSS VDD VDD _06394_ sky130_fd_sc_hd__mux4_2
X_11887_ _06379_ _06384_ _06389_ _06394_ _06344_ net867 VSS VSS VDD VDD _06395_ sky130_fd_sc_hd__mux4_2
X_11888_ _06343_ _06395_ VSS VSS VDD VDD _06396_ sky130_fd_sc_hd__nand2_1
X_11889_ _06343_ _06360_ _06374_ _06396_ VSS VSS VDD VDD _06397_ sky130_fd_sc_hd__o31ai_1
X_11890_ u_core.u_top.u_core.r_x[109] VSS VSS VDD VDD _06398_ sky130_fd_sc_hd__inv_1
X_11891_ u_core.u_top.u_core.r_x[124] VSS VSS VDD VDD _06399_ sky130_fd_sc_hd__inv_1
X_11892_ u_core.u_top.u_core.r_x[125] _06399_ _06237_ VSS VSS VDD VDD _06400_ sky130_fd_sc_hd__nor3_1
X_11893_ _06398_ net940 _06237_ net893 _06400_ VSS VSS VDD VDD _06401_ sky130_fd_sc_hd__a311o_1
X_11894_ u_core.u_top.u_core.r_x[92] VSS VSS VDD VDD _06402_ sky130_fd_sc_hd__inv_1
X_11895_ u_core.u_top.u_core.r_x[77] u_core.u_top.u_core.r_x[76] _06237_ VSS VSS VDD VDD _06403_ sky130_fd_sc_hd__nand3b_1
X_11896_ u_core.u_top.u_core.r_x[93] _06402_ _06237_ net893 _06403_ VSS VSS VDD VDD _06404_ sky130_fd_sc_hd__o311ai_0
X_11897_ net892 u_core.u_top.u_core.r_x[89] net903 VSS VSS VDD VDD _06405_ sky130_fd_sc_hd__or3b_2
X_11898_ u_core.u_top.u_core.r_x[73] net907 net892 VSS VSS VDD VDD _06406_ sky130_fd_sc_hd__nand3b_1
X_11899_ u_core.u_top.u_core.r_x[105] VSS VSS VDD VDD _06407_ sky130_fd_sc_hd__inv_1
X_11900_ u_core.arr_row[6] u_core.u_top.u_core.r_x[121] u_core.u_top.u_core.r_x[120] u_core.arr_row[3] VSS VSS VDD VDD _06408_ sky130_fd_sc_hd__nor4bb_1
X_11901_ _06407_ u_core.u_top.u_core.r_x[104] _06237_ net893 _06408_ VSS VSS VDD VDD _06409_ sky130_fd_sc_hd__a311oi_1
X_11902_ net893 _06405_ _06406_ _06409_ _06344_ VSS VSS VDD VDD _06410_ sky130_fd_sc_hd__a311oi_1
X_11903_ _06344_ _06401_ _06404_ _06410_ net867 VSS VSS VDD VDD _06411_ sky130_fd_sc_hd__a311oi_1
X_11904_ u_core.u_top.u_core.r_x[97] VSS VSS VDD VDD _06412_ sky130_fd_sc_hd__inv_1
X_11905_ _06237_ u_core.u_top.u_core.r_x[113] net938 VSS VSS VDD VDD _06413_ sky130_fd_sc_hd__nor3b_1
X_11906_ _06412_ net900 _06237_ net893 _06413_ VSS VSS VDD VDD _06414_ sky130_fd_sc_hd__a311o_1
X_11907_ u_core.u_top.u_core.r_x[80] VSS VSS VDD VDD _06415_ sky130_fd_sc_hd__inv_1
X_11908_ u_core.u_top.u_core.r_x[65] net910 _06237_ VSS VSS VDD VDD _06416_ sky130_fd_sc_hd__nand3b_1
X_11909_ u_core.u_top.u_core.r_x[81] _06415_ _06237_ net893 _06416_ VSS VSS VDD VDD _06417_ sky130_fd_sc_hd__o311ai_0
X_11910_ u_core.u_top.u_core.r_x[69] VSS VSS VDD VDD _06418_ sky130_fd_sc_hd__inv_1
X_11911_ u_core.arr_row[6] u_core.u_top.u_core.r_x[85] net905 u_core.arr_row[3] VSS VSS VDD VDD _06419_ sky130_fd_sc_hd__nor4bb_1
X_11912_ _06418_ u_core.u_top.u_core.r_x[68] _06237_ _06419_ VSS VSS VDD VDD _06420_ sky130_fd_sc_hd__a31oi_1
X_11913_ u_core.u_top.u_core.r_x[101] VSS VSS VDD VDD _06421_ sky130_fd_sc_hd__inv_1
X_11914_ u_core.arr_row[6] u_core.u_top.u_core.r_x[117] net937 u_core.arr_row[3] VSS VSS VDD VDD _06422_ sky130_fd_sc_hd__nor4bb_1
X_11915_ _06421_ u_core.u_top.u_core.r_x[100] _06237_ net893 _06422_ VSS VSS VDD VDD _06423_ sky130_fd_sc_hd__a311oi_1
X_11916_ net893 _06420_ _06423_ _06254_ VSS VSS VDD VDD _06424_ sky130_fd_sc_hd__a211oi_1
X_11917_ _06254_ _06414_ _06417_ _06424_ _06245_ VSS VSS VDD VDD _06425_ sky130_fd_sc_hd__a311oi_1
X_11918_ u_core.u_top.u_core.r_x[123] u_core.u_top.u_core.r_x[122] VSS VSS VDD VDD _06426_ sky130_fd_sc_hd__nor2b_1
X_11919_ u_core.u_top.u_core.r_x[107] net941 VSS VSS VDD VDD _06427_ sky130_fd_sc_hd__nor2b_1
X_11920_ u_core.u_top.u_core.r_x[91] u_core.u_top.u_core.r_x[90] VSS VSS VDD VDD _06428_ sky130_fd_sc_hd__nor2b_1
X_11921_ u_core.u_top.u_core.r_x[75] u_core.u_top.u_core.r_x[74] VSS VSS VDD VDD _06429_ sky130_fd_sc_hd__nor2b_1
X_11922_ _06426_ _06427_ _06428_ _06429_ net892 net893 VSS VSS VDD VDD _06430_ sky130_fd_sc_hd__mux4_2
X_11923_ u_core.u_top.u_core.r_x[127] u_core.u_top.u_core.r_x[126] VSS VSS VDD VDD _06431_ sky130_fd_sc_hd__nor2b_1
X_11924_ u_core.u_top.u_core.r_x[111] u_core.u_top.u_core.r_x[110] VSS VSS VDD VDD _06432_ sky130_fd_sc_hd__nor2b_1
X_11925_ u_core.u_top.u_core.r_x[95] net901 VSS VSS VDD VDD _06433_ sky130_fd_sc_hd__nor2b_1
X_11926_ u_core.u_top.u_core.r_x[79] net906 VSS VSS VDD VDD _06434_ sky130_fd_sc_hd__nor2b_1
X_11927_ _06431_ _06432_ _06433_ _06434_ _06237_ net893 VSS VSS VDD VDD _06435_ sky130_fd_sc_hd__mux4_2
X_11928_ u_core.u_top.u_core.r_x[115] u_core.u_top.u_core.r_x[114] VSS VSS VDD VDD _06436_ sky130_fd_sc_hd__nor2b_1
X_11929_ u_core.u_top.u_core.r_x[99] u_core.u_top.u_core.r_x[98] VSS VSS VDD VDD _06437_ sky130_fd_sc_hd__nor2b_1
X_11930_ u_core.u_top.u_core.r_x[83] u_core.u_top.u_core.r_x[82] VSS VSS VDD VDD _06438_ sky130_fd_sc_hd__nor2b_1
X_11931_ u_core.u_top.u_core.r_x[67] u_core.u_top.u_core.r_x[66] VSS VSS VDD VDD _06439_ sky130_fd_sc_hd__nor2b_1
X_11932_ _06436_ _06437_ _06438_ _06439_ net892 net893 VSS VSS VDD VDD _06440_ sky130_fd_sc_hd__mux4_2
X_11933_ u_core.u_top.u_core.r_x[119] net936 VSS VSS VDD VDD _06441_ sky130_fd_sc_hd__nor2b_1
X_11934_ u_core.u_top.u_core.r_x[103] u_core.u_top.u_core.r_x[102] VSS VSS VDD VDD _06442_ sky130_fd_sc_hd__nor2b_1
X_11935_ u_core.u_top.u_core.r_x[87] u_core.u_top.u_core.r_x[86] VSS VSS VDD VDD _06443_ sky130_fd_sc_hd__nor2b_1
X_11936_ u_core.u_top.u_core.r_x[71] u_core.u_top.u_core.r_x[70] VSS VSS VDD VDD _06444_ sky130_fd_sc_hd__nor2b_1
X_11937_ _06441_ _06442_ _06443_ _06444_ net892 net893 VSS VSS VDD VDD _06445_ sky130_fd_sc_hd__mux4_2
X_11938_ _06430_ _06435_ _06440_ _06445_ _06344_ net867 VSS VSS VDD VDD _06446_ sky130_fd_sc_hd__mux4_2
X_11939_ _06343_ _06446_ VSS VSS VDD VDD _06447_ sky130_fd_sc_hd__nand2_1
X_11940_ _06343_ _06411_ _06425_ _06447_ net982 VSS VSS VDD VDD _06448_ sky130_fd_sc_hd__o311ai_0
X_11941_ net982 _06397_ _06448_ VSS VSS VDD VDD _06449_ sky130_fd_sc_hd__o21ai_1
X_11942_ u_core.u_top.u_core.r_x[135] VSS VSS VDD VDD _06450_ sky130_fd_sc_hd__inv_1
X_11943_ u_core.u_top.u_core.r_x[143] _06258_ u_core.u_top.u_core.r_x[142] VSS VSS VDD VDD _06451_ sky130_fd_sc_hd__nor3b_1
X_11944_ _06450_ net931 net867 _06250_ _06451_ VSS VSS VDD VDD _06452_ sky130_fd_sc_hd__a311oi_1
X_11945_ net928 VSS VSS VDD VDD _06453_ sky130_fd_sc_hd__inv_1
X_11946_ net932 VSS VSS VDD VDD _06454_ sky130_fd_sc_hd__inv_1
X_11947_ u_core.u_top.u_core.r_x[133] _06454_ _06245_ VSS VSS VDD VDD _06455_ sky130_fd_sc_hd__or3_1
X_11948_ u_core.u_top.u_core.r_x[141] _06453_ _06258_ _06250_ _06455_ VSS VSS VDD VDD _06456_ sky130_fd_sc_hd__o311a_1
X_11949_ u_core.u_top.u_core.r_x[139] net929 VSS VSS VDD VDD _06457_ sky130_fd_sc_hd__nor2b_1
X_11950_ u_core.u_top.u_core.r_x[137] u_core.u_top.u_core.r_x[136] VSS VSS VDD VDD _06458_ sky130_fd_sc_hd__nor2b_1
X_11951_ u_core.u_top.u_core.r_x[131] u_core.u_top.u_core.r_x[130] VSS VSS VDD VDD _06459_ sky130_fd_sc_hd__nor2b_1
X_11952_ u_core.u_top.u_core.r_x[128] VSS VSS VDD VDD _06460_ sky130_fd_sc_hd__inv_1
X_11953_ u_core.u_top.u_core.r_x[129] _06460_ VSS VSS VDD VDD _06461_ sky130_fd_sc_hd__nor2_1
X_11954_ _06457_ _06458_ _06459_ _06461_ _06250_ net867 VSS VSS VDD VDD _06462_ sky130_fd_sc_hd__mux4_2
X_11955_ _06254_ _06462_ VSS VSS VDD VDD _06463_ sky130_fd_sc_hd__nand2_1
X_11956_ _06254_ _06452_ _06456_ _06463_ _06324_ VSS VSS VDD VDD _06464_ sky130_fd_sc_hd__o311ai_0
X_11957_ net889 _06397_ _06464_ net981 VSS VSS VDD VDD _06465_ sky130_fd_sc_hd__o211ai_1
X_11958_ net981 _06449_ _06465_ VSS VSS VDD VDD _06466_ sky130_fd_sc_hd__o21ai_4
X_11961_ _0065_ _06342_ net712 VSS VSS VDD VDD _06469_ sky130_fd_sc_hd__mux2i_1
X_11962_ net981 _06449_ _06465_ VSS VSS VDD VDD _06470_ sky130_fd_sc_hd__o21a_2
X_11965_ _0065_ _06342_ net711 VSS VSS VDD VDD _06473_ sky130_fd_sc_hd__mux2_1
X_11966_ _0066_[1] _06473_ VSS VSS VDD VDD _06474_ sky130_fd_sc_hd__nand2_1
X_11967_ _02815_ _06469_ _06474_ VSS VSS VDD VDD _06475_ sky130_fd_sc_hd__o21ai_0
X_11969_ _0065_ net834 net679 VSS VSS VDD VDD _06477_ sky130_fd_sc_hd__o21ai_0
X_11970_ net679 _06475_ _06477_ u_core.u_top.u_core.acc[101] VSS VSS VDD VDD _02311_ sky130_fd_sc_hd__a22oi_1
X_11971_ _02311_ VSS VSS VDD VDD u_core.u_top.u_core.acc_upd[101] sky130_fd_sc_hd__inv_1
X_11972_ u_core.arr_sa_n[18] VSS VSS VDD VDD _0601_ sky130_fd_sc_hd__inv_1
X_11973_ _02300_ VSS VSS VDD VDD _0311_[1] sky130_fd_sc_hd__inv_1
X_11975_ u_core.u_top.u_core.r_prow[6] VSS VSS VDD VDD _06479_ sky130_fd_sc_hd__inv_1
X_11976_ u_core.u_top.u_core.r_prow[2] VSS VSS VDD VDD _06480_ sky130_fd_sc_hd__inv_1
X_11978_ _0888_[1] _0890_[1] u_core.u_top.u_core.r_prow[3] VSS VSS VDD VDD _06482_ sky130_fd_sc_hd__mux2_4
X_11979_ u_core.u_top.u_core.r_prow[1] net955 u_core.u_top.u_core.r_prow[2] VSS VSS VDD VDD _06483_ sky130_fd_sc_hd__a21oi_1
X_11980_ _06480_ _06482_ _06483_ VSS VSS VDD VDD _0003_[1] sky130_fd_sc_hd__o21ba_1
X_11982_ _0896_[1] _0898_[1] u_core.u_top.u_core.r_prow[7] VSS VSS VDD VDD _06485_ sky130_fd_sc_hd__mux2i_1
X_11984_ net950 _0892_[1] VSS VSS VDD VDD _06487_ sky130_fd_sc_hd__xnor2_1
X_11985_ u_core.u_top.u_core.r_prow[6] net951 VSS VSS VDD VDD _06488_ sky130_fd_sc_hd__nand2b_1
X_11986_ _06479_ _06485_ _06487_ _06488_ VSS VSS VDD VDD _06489_ sky130_fd_sc_hd__o22ai_1
X_11987_ _06479_ _06209_ _0003_[1] _06489_ VSS VSS VDD VDD _0007_[1] sky130_fd_sc_hd__a31o_1
X_11989_ net946 _0900_[1] VSS VSS VDD VDD _06491_ sky130_fd_sc_hd__xnor2_1
X_11990_ net947 _06491_ VSS VSS VDD VDD _06492_ sky130_fd_sc_hd__nand2_1
X_11991_ net947 _0007_[1] _06492_ VSS VSS VDD VDD _02586_ sky130_fd_sc_hd__o21ai_0
X_11992_ _02586_ VSS VSS VDD VDD _0009_[1] sky130_fd_sc_hd__inv_1
X_11993_ _0175_ _0180_ VSS VSS VDD VDD _06493_ sky130_fd_sc_hd__nor2b_1
X_11994_ _0175_ _06493_ net715 VSS VSS VDD VDD _06494_ sky130_fd_sc_hd__mux2i_1
X_11996_ _0175_ _06493_ net708 VSS VSS VDD VDD _06496_ sky130_fd_sc_hd__mux2_2
X_11997_ _0176_[1] _06496_ VSS VSS VDD VDD _06497_ sky130_fd_sc_hd__nand2_1
X_11998_ _02603_ net699 _06497_ VSS VSS VDD VDD _06498_ sky130_fd_sc_hd__o21ai_0
X_11999_ _06322_ _06335_ net981 VSS VSS VDD VDD _06499_ sky130_fd_sc_hd__mux2i_1
X_12001_ _0175_ _0180_ VSS VSS VDD VDD _06501_ sky130_fd_sc_hd__nor2_1
X_12002_ net674 _06501_ VSS VSS VDD VDD _06502_ sky130_fd_sc_hd__nor2_1
X_12003_ net663 VSS VSS VDD VDD _06503_ sky130_fd_sc_hd__inv_1
X_12004_ net677 _06498_ _06503_ u_core.u_top.u_core.acc[201] VSS VSS VDD VDD _02315_ sky130_fd_sc_hd__a22oi_1
X_12005_ _02315_ VSS VSS VDD VDD u_core.u_top.u_core.acc_upd[201] sky130_fd_sc_hd__inv_1
X_12006_ u_core.u_top.u_core.acc[91] VSS VSS VDD VDD _02595_ sky130_fd_sc_hd__inv_1
X_12007_ u_core.u_top.u_core.d_acc[210] VSS VSS VDD VDD _0338_[0] sky130_fd_sc_hd__inv_1
X_12008_ _0892_[0] VSS VSS VDD VDD _0003_[0] sky130_fd_sc_hd__inv_1
X_12009_ _02842_ _02328_ VSS VSS VDD VDD _0226_[2] sky130_fd_sc_hd__xnor2_1
X_12010_ u_core.u_top.u_core.acc[170] VSS VSS VDD VDD _0141_[0] sky130_fd_sc_hd__inv_1
X_12013_ _0434_ net839 VSS VSS VDD VDD _06506_ sky130_fd_sc_hd__nor2_1
X_12014_ net674 _06506_ VSS VSS VDD VDD _06507_ sky130_fd_sc_hd__nor2_1
X_12015_ u_core.u_top.u_core.acc[50] _06507_ VSS VSS VDD VDD _03437_ sky130_fd_sc_hd__xnor2_1
X_12016_ u_core.u_top.u_core.acc[110] VSS VSS VDD VDD _0077_[0] sky130_fd_sc_hd__inv_1
X_12017_ u_core.u_top.u_core.acc[51] VSS VSS VDD VDD _02845_ sky130_fd_sc_hd__inv_1
X_12018_ u_core.u_top.u_core.acc[201] VSS VSS VDD VDD _02601_ sky130_fd_sc_hd__inv_1
X_12019_ net947 VSS VSS VDD VDD _06508_ sky130_fd_sc_hd__clkinv_1
X_12020_ _06479_ _0896_[0] VSS VSS VDD VDD _0900_[0] sky130_fd_sc_hd__xnor2_1
X_12021_ _06508_ _0900_[0] VSS VSS VDD VDD _0905_[0] sky130_fd_sc_hd__xnor2_1
X_12022_ _0905_[0] VSS VSS VDD VDD _0009_[0] sky130_fd_sc_hd__inv_1
X_12023_ u_core.u_top.u_core.acc[200] net663 VSS VSS VDD VDD _03124_ sky130_fd_sc_hd__xnor2_1
X_12024_ _02362_ VSS VSS VDD VDD _0259_[1] sky130_fd_sc_hd__inv_1
X_12025_ _03138_ _02389_ VSS VSS VDD VDD _0306_[2] sky130_fd_sc_hd__xnor2_1
X_12026_ u_core.u_top.u_core.acc[1] VSS VSS VDD VDD _02689_ sky130_fd_sc_hd__inv_1
X_12027_ _02466_ VSS VSS VDD VDD _0289_[1] sky130_fd_sc_hd__inv_1
X_12028_ _02557_ VSS VSS VDD VDD _06509_ sky130_fd_sc_hd__inv_1
X_12029_ u_core.u_top.u_core.d_acc[120] _03261_ _03260_ VSS VSS VDD VDD _06510_ sky130_fd_sc_hd__a21o_1
X_12030_ _02840_ _06510_ _02839_ VSS VSS VDD VDD _06511_ sky130_fd_sc_hd__a21oi_1
X_12031_ _06509_ _06511_ _02556_ VSS VSS VDD VDD _06512_ sky130_fd_sc_hd__o21bai_1
X_12032_ _03278_ _06512_ _03277_ VSS VSS VDD VDD _06513_ sky130_fd_sc_hd__a21oi_1
X_12033_ _03078_ _06513_ VSS VSS VDD VDD _0289_[5] sky130_fd_sc_hd__xnor2_1
X_12034_ u_core.u_top.u_core.d_acc[121] VSS VSS VDD VDD _02464_ sky130_fd_sc_hd__inv_1
X_12037_ net992 VSS VSS VDD VDD _0725_[3] sky130_fd_sc_hd__inv_1
X_12038_ net995 u_core.u_top.u_core.d_acc[9] VSS VSS VDD VDD _06515_ sky130_fd_sc_hd__xnor2_1
X_12039_ _03416_ VSS VSS VDD VDD _06516_ sky130_fd_sc_hd__inv_1
X_12040_ u_core.u_top.u_core.d_acc[0] _02640_ _02743_ VSS VSS VDD VDD _06517_ sky130_fd_sc_hd__a21o_1
X_12041_ _02842_ _06517_ _02841_ VSS VSS VDD VDD _06518_ sky130_fd_sc_hd__a21oi_1
X_12042_ _06218_ _06518_ _06221_ VSS VSS VDD VDD _06519_ sky130_fd_sc_hd__o21ai_0
X_12043_ _02725_ _06519_ _02724_ VSS VSS VDD VDD _06520_ sky130_fd_sc_hd__a21oi_1
X_12044_ _06217_ _06520_ _02520_ VSS VSS VDD VDD _06521_ sky130_fd_sc_hd__o21bai_1
X_12045_ _03325_ _06521_ _03324_ VSS VSS VDD VDD _06522_ sky130_fd_sc_hd__a21oi_1
X_12046_ _06516_ _06522_ _03415_ VSS VSS VDD VDD _06523_ sky130_fd_sc_hd__o21bai_1
X_12047_ _02508_ _06523_ _02507_ VSS VSS VDD VDD _06524_ sky130_fd_sc_hd__a21oi_1
X_12048_ _06515_ _06524_ VSS VSS VDD VDD _0226_[9] sky130_fd_sc_hd__xnor2_1
X_12049_ _02521_ _06520_ VSS VSS VDD VDD _0226_[5] sky130_fd_sc_hd__xnor2_1
X_12050_ _02985_ VSS VSS VDD VDD _06525_ sky130_fd_sc_hd__inv_1
X_12051_ u_core.u_top.u_core.d_acc[160] _02502_ _03155_ VSS VSS VDD VDD _06526_ sky130_fd_sc_hd__a21o_1
X_12052_ _02817_ _06526_ _02816_ VSS VSS VDD VDD _06527_ sky130_fd_sc_hd__a21oi_1
X_12053_ _06525_ _06527_ _02984_ VSS VSS VDD VDD _06528_ sky130_fd_sc_hd__o21bai_1
X_12054_ _03018_ _06528_ _03017_ VSS VSS VDD VDD _06529_ sky130_fd_sc_hd__a21oi_1
X_12055_ _03292_ _06529_ VSS VSS VDD VDD _0311_[5] sky130_fd_sc_hd__xnor2_1
X_12056_ u_core.u_top.u_core.acc[211] VSS VSS VDD VDD _02644_ sky130_fd_sc_hd__inv_1
X_12057_ u_core.arr_sa_n[4] VSS VSS VDD VDD _0509_ sky130_fd_sc_hd__inv_1
X_12058_ _02299_ VSS VSS VDD VDD _06530_ sky130_fd_sc_hd__inv_1
X_12059_ _02817_ _06530_ _02816_ VSS VSS VDD VDD _06531_ sky130_fd_sc_hd__a21oi_1
X_12060_ _06525_ _06531_ _02984_ VSS VSS VDD VDD _06532_ sky130_fd_sc_hd__o21bai_1
X_12061_ _03018_ _06532_ VSS VSS VDD VDD _0311_[4] sky130_fd_sc_hd__xor2_1
X_12062_ u_core.u_top.u_core.acc[81] VSS VSS VDD VDD _03126_ sky130_fd_sc_hd__inv_1
X_12063_ _0003_[1] VSS VSS VDD VDD _03072_ sky130_fd_sc_hd__inv_1
X_12064_ _02512_ VSS VSS VDD VDD _06533_ sky130_fd_sc_hd__inv_1
X_12065_ _02506_ VSS VSS VDD VDD _06534_ sky130_fd_sc_hd__inv_1
X_12066_ _02343_ VSS VSS VDD VDD _06535_ sky130_fd_sc_hd__inv_1
X_12067_ _02650_ _06535_ _02649_ VSS VSS VDD VDD _06536_ sky130_fd_sc_hd__a21oi_1
X_12068_ _02505_ VSS VSS VDD VDD _06537_ sky130_fd_sc_hd__inv_1
X_12069_ _06534_ _06536_ _06537_ VSS VSS VDD VDD _06538_ sky130_fd_sc_hd__o21ai_0
X_12070_ _02825_ _06538_ _02824_ VSS VSS VDD VDD _06539_ sky130_fd_sc_hd__a21oi_1
X_12071_ _06533_ _06539_ VSS VSS VDD VDD _06540_ sky130_fd_sc_hd__nor2_1
X_12072_ _02511_ _06540_ VSS VSS VDD VDD _06541_ sky130_fd_sc_hd__nor2_1
X_12073_ _02863_ _06541_ VSS VSS VDD VDD _0232_[6] sky130_fd_sc_hd__xnor2_1
X_12074_ net995 u_core.u_top.u_core.d_acc[169] VSS VSS VDD VDD _06542_ sky130_fd_sc_hd__xnor2_1
X_12075_ _03179_ VSS VSS VDD VDD _06543_ sky130_fd_sc_hd__inv_1
X_12076_ _03292_ VSS VSS VDD VDD _06544_ sky130_fd_sc_hd__inv_1
X_12077_ _06544_ _06529_ _03291_ VSS VSS VDD VDD _06545_ sky130_fd_sc_hd__o21bai_1
X_12078_ _02775_ _06545_ _02774_ VSS VSS VDD VDD _06546_ sky130_fd_sc_hd__a21oi_1
X_12079_ _06543_ _06546_ _03178_ VSS VSS VDD VDD _06547_ sky130_fd_sc_hd__o21bai_1
X_12080_ _03148_ _06547_ _03147_ VSS VSS VDD VDD _06548_ sky130_fd_sc_hd__a21oi_1
X_12081_ _06542_ _06548_ VSS VSS VDD VDD _0311_[9] sky130_fd_sc_hd__xnor2_1
X_12082_ _02650_ _02343_ VSS VSS VDD VDD _0232_[2] sky130_fd_sc_hd__xnor2_1
X_12083_ u_core.u_top.u_core.acc[20] VSS VSS VDD VDD _0926_[0] sky130_fd_sc_hd__inv_1
X_12084_ u_core.u_top.u_core.lfsr[8] VSS VSS VDD VDD _02422_ sky130_fd_sc_hd__inv_1
X_12086_ net951 _0003_[1] VSS VSS VDD VDD _06550_ sky130_fd_sc_hd__nor2_1
X_12087_ net951 _06487_ _06550_ VSS VSS VDD VDD _02628_ sky130_fd_sc_hd__a21o_1
X_12088_ _02628_ VSS VSS VDD VDD _0005_[1] sky130_fd_sc_hd__inv_1
X_12089_ u_core.u_top.u_core.acc[221] VSS VSS VDD VDD _02672_ sky130_fd_sc_hd__inv_1
X_12090_ u_core.u_top.u_core.acc[161] VSS VSS VDD VDD _02890_ sky130_fd_sc_hd__inv_1
X_12091_ _02421_ VSS VSS VDD VDD _0269_[1] sky130_fd_sc_hd__inv_1
X_12092_ u_core.u_top.u_core.d_acc[60] VSS VSS VDD VDD _0259_[0] sky130_fd_sc_hd__inv_1
X_12093_ u_core.u_top.u_core.lfsr[11] VSS VSS VDD VDD _02371_ sky130_fd_sc_hd__inv_1
X_12094_ u_core.arr_sa_n[17] VSS VSS VDD VDD _0595_ sky130_fd_sc_hd__inv_1
X_12095_ u_core.u_top.u_core.acc[71] VSS VSS VDD VDD _02878_ sky130_fd_sc_hd__inv_1
X_12096_ u_core.u_top.u_core.d_acc[120] VSS VSS VDD VDD _0289_[0] sky130_fd_sc_hd__inv_1
X_12097_ _02459_ VSS VSS VDD VDD _0327_[1] sky130_fd_sc_hd__inv_1
X_12098_ _02443_ _02620_ VSS VSS VDD VDD _0300_[2] sky130_fd_sc_hd__xnor2_1
X_12100_ _0076_ _0081_ VSS VSS VDD VDD _06552_ sky130_fd_sc_hd__nor2_1
X_12101_ net669 _06552_ VSS VSS VDD VDD _06553_ sky130_fd_sc_hd__nor2_1
X_12102_ u_core.u_top.u_core.acc[110] _06553_ VSS VSS VDD VDD _03160_ sky130_fd_sc_hd__xnor2_1
X_12103_ u_core.u_top.u_core.acc[40] VSS VSS VDD VDD _0938_[0] sky130_fd_sc_hd__inv_1
X_12104_ _0900_[0] VSS VSS VDD VDD _0007_[0] sky130_fd_sc_hd__inv_2
X_12105_ u_core.u_top.u_core.d_acc[199] u_core.u_top.u_core.lfsr[3] VSS VSS VDD VDD _06554_ sky130_fd_sc_hd__xnor2_1
X_12106_ _03175_ VSS VSS VDD VDD _06555_ sky130_fd_sc_hd__inv_1
X_12107_ _03173_ VSS VSS VDD VDD _06556_ sky130_fd_sc_hd__inv_1
X_12108_ _06556_ _06216_ _03172_ VSS VSS VDD VDD _06557_ sky130_fd_sc_hd__o21bai_1
X_12109_ _03205_ _06557_ _03204_ VSS VSS VDD VDD _06558_ sky130_fd_sc_hd__a21oi_1
X_12110_ _06555_ _06558_ _03174_ VSS VSS VDD VDD _06559_ sky130_fd_sc_hd__o21bai_1
X_12111_ _03171_ _06559_ _03170_ VSS VSS VDD VDD _06560_ sky130_fd_sc_hd__a21oi_1
X_12112_ _06554_ _06560_ VSS VSS VDD VDD _0327_[9] sky130_fd_sc_hd__xnor2_1
X_12113_ u_core.u_top.u_core.acc[61] VSS VSS VDD VDD _02707_ sky130_fd_sc_hd__inv_1
X_12114_ u_core.u_top.u_core.d_acc[211] VSS VSS VDD VDD _02427_ sky130_fd_sc_hd__inv_1
X_12115_ u_core.u_top.u_core.lfsr[13] VSS VSS VDD VDD _02395_ sky130_fd_sc_hd__inv_1
X_12116_ u_core.u_top.u_core.d_acc[100] VSS VSS VDD VDD _0279_[0] sky130_fd_sc_hd__inv_1
X_12117_ u_core.u_top.u_core.d_acc[151] VSS VSS VDD VDD _02388_ sky130_fd_sc_hd__inv_1
X_12118_ u_core.u_top.u_core.acc[0] VSS VSS VDD VDD _0912_[0] sky130_fd_sc_hd__inv_1
X_12119_ u_core.u_top.u_core.acc[10] VSS VSS VDD VDD _0919_[0] sky130_fd_sc_hd__inv_1
X_12120_ u_core.u_top.u_core.acc[30] VSS VSS VDD VDD _0932_[0] sky130_fd_sc_hd__inv_1
X_12121_ u_core.u_top.u_core.acc[50] VSS VSS VDD VDD _0013_[0] sky130_fd_sc_hd__inv_1
X_12122_ u_core.u_top.u_core.acc[60] VSS VSS VDD VDD _0021_[0] sky130_fd_sc_hd__inv_1
X_12123_ u_core.u_top.u_core.acc[70] VSS VSS VDD VDD _0032_[0] sky130_fd_sc_hd__inv_1
X_12124_ u_core.u_top.u_core.acc[80] VSS VSS VDD VDD _0044_[0] sky130_fd_sc_hd__inv_1
X_12125_ u_core.u_top.u_core.acc[90] VSS VSS VDD VDD _0055_[0] sky130_fd_sc_hd__inv_1
X_12126_ u_core.u_top.u_core.acc[100] VSS VSS VDD VDD _0066_[0] sky130_fd_sc_hd__inv_1
X_12127_ u_core.u_top.u_core.acc[120] VSS VSS VDD VDD _0088_[0] sky130_fd_sc_hd__inv_1
X_12128_ u_core.u_top.u_core.acc[130] VSS VSS VDD VDD _0098_[0] sky130_fd_sc_hd__inv_1
X_12129_ u_core.u_top.u_core.acc[140] VSS VSS VDD VDD _0109_[0] sky130_fd_sc_hd__inv_1
X_12130_ u_core.u_top.u_core.acc[150] VSS VSS VDD VDD _0119_[0] sky130_fd_sc_hd__inv_1
X_12131_ u_core.u_top.u_core.acc[160] VSS VSS VDD VDD _0130_[0] sky130_fd_sc_hd__inv_1
X_12132_ u_core.u_top.u_core.acc[180] VSS VSS VDD VDD _0152_[0] sky130_fd_sc_hd__inv_1
X_12133_ u_core.u_top.u_core.acc[190] VSS VSS VDD VDD _0164_[0] sky130_fd_sc_hd__inv_1
X_12134_ u_core.u_top.u_core.acc[200] VSS VSS VDD VDD _0176_[0] sky130_fd_sc_hd__inv_1
X_12135_ u_core.u_top.u_core.acc[210] VSS VSS VDD VDD _0188_[0] sky130_fd_sc_hd__inv_1
X_12137_ u_core.u_top.u_spi.bitcnt[1] u_core.u_top.u_spi.bitcnt[0] u_core.u_top.u_spi.bitcnt[4] VSS VSS VDD VDD _06562_ sky130_fd_sc_hd__and3_1
X_12138_ u_core.u_top.u_spi.bitcnt[2] u_core.u_top.u_spi.bitcnt[3] _06562_ VSS VSS VDD VDD _06563_ sky130_fd_sc_hd__nand3_1
X_12139_ u_core.u_top.u_spi.bitcnt[5] _06563_ VSS VSS VDD VDD _06564_ sky130_fd_sc_hd__xor2_1
X_12140_ u_core.u_top.u_spi.cs_s[1] _06564_ VSS VSS VDD VDD _2294_[5] sky130_fd_sc_hd__nor2_1
X_12141_ u_core.u_top.u_spi.bitcnt[2] _03084_ u_core.u_top.u_spi.bitcnt[3] VSS VSS VDD VDD _06565_ sky130_fd_sc_hd__nand3_1
X_12142_ u_core.u_top.u_spi.bitcnt[4] _06565_ VSS VSS VDD VDD _06566_ sky130_fd_sc_hd__xor2_1
X_12143_ u_core.u_top.u_spi.cs_s[1] _06566_ VSS VSS VDD VDD _2294_[4] sky130_fd_sc_hd__nor2_1
X_12144_ u_core.u_top.u_spi.bitcnt[2] u_core.u_top.u_spi.bitcnt[1] u_core.u_top.u_spi.bitcnt[0] VSS VSS VDD VDD _06567_ sky130_fd_sc_hd__nand3_1
X_12145_ u_core.u_top.u_spi.bitcnt[3] _06567_ VSS VSS VDD VDD _06568_ sky130_fd_sc_hd__xor2_1
X_12146_ u_core.u_top.u_spi.cs_s[1] _06568_ VSS VSS VDD VDD _2294_[3] sky130_fd_sc_hd__nor2_1
X_12147_ u_core.u_top.u_spi.bitcnt[2] _03084_ VSS VSS VDD VDD _06569_ sky130_fd_sc_hd__xnor2_1
X_12148_ u_core.u_top.u_spi.cs_s[1] _06569_ VSS VSS VDD VDD _2294_[2] sky130_fd_sc_hd__nor2_1
X_12149_ u_core.u_top.u_spi.cs_s[1] _0717_[1] VSS VSS VDD VDD _2294_[1] sky130_fd_sc_hd__nor2b_1
X_12150_ u_core.u_top.u_spi.bitcnt[0] VSS VSS VDD VDD _0717_[0] sky130_fd_sc_hd__inv_1
X_12151_ u_core.u_top.u_spi.cs_s[1] u_core.u_top.u_spi.bitcnt[0] VSS VSS VDD VDD _2294_[0] sky130_fd_sc_hd__nor2_1
X_12152_ u_core.u_top.u_spi.sck_s[2] VSS VSS VDD VDD _06570_ sky130_fd_sc_hd__inv_1
X_12153_ u_core.u_top.u_spi.bitcnt[5] u_core.u_top.u_spi.bitcnt[3] u_core.u_top.u_spi.bitcnt[4] VSS VSS VDD VDD _06571_ sky130_fd_sc_hd__and3_1
X_12154_ u_core.u_top.u_spi.bitcnt[5] u_core.u_top.u_spi.bitcnt[3] u_core.u_top.u_spi.bitcnt[4] VSS VSS VDD VDD _06572_ sky130_fd_sc_hd__nor3_1
X_12155_ u_core.u_top.u_spi.bitcnt[6] _06571_ _06572_ VSS VSS VDD VDD _06573_ sky130_fd_sc_hd__or3_1
X_12156_ u_core.u_top.u_spi.sck_s[1] _06570_ _06573_ VSS VSS VDD VDD _06574_ sky130_fd_sc_hd__or3_1
X_12160_ net996 VSS VSS VDD VDD _06578_ sky130_fd_sc_hd__clkinv_1
X_12162_ u_core.u_top.bus_addr[2] u_core.u_top.bus_word VSS VSS VDD VDD _06580_ sky130_fd_sc_hd__nor2_1
X_12163_ u_core.u_top.bus_addr[3] _06201_ _06580_ VSS VSS VDD VDD _06581_ sky130_fd_sc_hd__nand3b_1
X_12165_ u_core.u_top.bus_addr[3] u_core.u_top.bus_addr[4] VSS VSS VDD VDD _06583_ sky130_fd_sc_hd__or2_2
X_12167_ u_core.u_top.bus_addr[5] u_core.u_top.bus_addr[2] u_core.u_top.bus_word _06583_ VSS VSS VDD VDD _06585_ sky130_fd_sc_hd__nor4_2
X_12169_ u_core.u_top.bus_addr[1] net866 u_core.u_top.bus_addr[0] VSS VSS VDD VDD _06587_ sky130_fd_sc_hd__nand3b_1
X_12170_ u_core.u_top.bus_re _06581_ _06587_ VSS VSS VDD VDD _06588_ sky130_fd_sc_hd__and3_1
X_12171_ u_core.u_top.bus_addr[1] net866 VSS VSS VDD VDD _06589_ sky130_fd_sc_hd__nand2_1
X_12172_ _06588_ _06589_ VSS VSS VDD VDD _06590_ sky130_fd_sc_hd__nand2_2
X_12175_ u_core.u_top.bus_addr[5] u_core.u_top.bus_addr[2] u_core.u_top.bus_word VSS VSS VDD VDD _06593_ sky130_fd_sc_hd__nand3_1
X_12176_ u_core.u_top.bus_addr[4] u_core.u_top.bus_addr[0] u_core.u_top.bus_addr[1] VSS VSS VDD VDD _06594_ sky130_fd_sc_hd__nor3_1
X_12177_ u_core.u_top.bus_addr[3] _06594_ VSS VSS VDD VDD _06595_ sky130_fd_sc_hd__nand2_1
X_12178_ _06593_ _06595_ VSS VSS VDD VDD _06596_ sky130_fd_sc_hd__nor2_4
X_12181_ u_core.u_top.bus_addr[0] u_core.u_top.bus_addr[1] VSS VSS VDD VDD _06599_ sky130_fd_sc_hd__nor2_1
X_12182_ u_core.u_top.bus_addr[3] u_core.u_top.bus_addr[4] VSS VSS VDD VDD _06600_ sky130_fd_sc_hd__nor2b_1
X_12183_ _06599_ _06600_ VSS VSS VDD VDD _06601_ sky130_fd_sc_hd__nand2_1
X_12184_ _06593_ _06601_ VSS VSS VDD VDD _06602_ sky130_fd_sc_hd__nor2_2
X_12186_ u_core.u_top.bus_addr[5] _06594_ VSS VSS VDD VDD _06604_ sky130_fd_sc_hd__nand2b_1
X_12187_ u_core.u_top.bus_addr[3] u_core.u_top.bus_addr[2] u_core.u_top.bus_word VSS VSS VDD VDD _06605_ sky130_fd_sc_hd__o21ai_0
X_12188_ _06604_ _06605_ VSS VSS VDD VDD _06606_ sky130_fd_sc_hd__nor2_8
X_12190_ u_core.u_top.bus_addr[3] u_core.u_top.bus_addr[2] VSS VSS VDD VDD _06608_ sky130_fd_sc_hd__xnor2_1
X_12191_ _06604_ _06608_ VSS VSS VDD VDD _06609_ sky130_fd_sc_hd__nor2_2
X_12194_ net901 net818 VSS VSS VDD VDD _06612_ sky130_fd_sc_hd__nand2_1
X_12196_ net916 net872 VSS VSS VDD VDD _06614_ sky130_fd_sc_hd__nand2_1
X_12198_ u_core.u_top.u_core.r_x[142] net809 VSS VSS VDD VDD _06616_ sky130_fd_sc_hd__nor2_1
X_12199_ net809 _06612_ _06614_ _06616_ VSS VSS VDD VDD _06617_ sky130_fd_sc_hd__a31oi_1
X_12200_ u_core.u_top.u_core.r_pdata[46] net813 net812 u_core.u_top.u_core.m_fail[23] net811 _06617_ VSS VSS VDD VDD _06618_ sky130_fd_sc_hd__a222oi_1
X_12201_ net749 _06618_ VSS VSS VDD VDD _06619_ sky130_fd_sc_hd__nor2_1
X_12202_ u_core.u_top.u_spi.shift_out[46] net990 _06619_ VSS VSS VDD VDD _06620_ sky130_fd_sc_hd__a21oi_1
X_12204_ u_core.u_top.u_spi.shift_out[45] net815 VSS VSS VDD VDD _06622_ sky130_fd_sc_hd__nor2_1
X_12205_ net815 _06620_ _06622_ VSS VSS VDD VDD _2236_[46] sky130_fd_sc_hd__a21oi_1
X_12209_ u_core.u_top.u_spi.shift_out[45] VSS VSS VDD VDD _06626_ sky130_fd_sc_hd__inv_1
X_12213_ u_core.u_top.u_core.r_x[93] net818 VSS VSS VDD VDD _06630_ sky130_fd_sc_hd__nand2_1
X_12215_ u_core.u_top.u_core.r_x[45] net871 VSS VSS VDD VDD _06632_ sky130_fd_sc_hd__nand2_1
X_12217_ u_core.u_top.u_core.r_x[141] net809 VSS VSS VDD VDD _06634_ sky130_fd_sc_hd__nor2_1
X_12218_ _06604_ _06605_ VSS VSS VDD VDD _06635_ sky130_fd_sc_hd__or2_2
X_12221_ net809 _06630_ _06632_ _06634_ net807 VSS VSS VDD VDD _06638_ sky130_fd_sc_hd__a311oi_1
X_12222_ u_core.u_top.u_core.r_pdata[45] net814 net748 VSS VSS VDD VDD _06639_ sky130_fd_sc_hd__a21oi_1
X_12224_ net996 _06626_ net749 _06639_ net815 VSS VSS VDD VDD _06641_ sky130_fd_sc_hd__o221ai_1
X_12225_ u_core.u_top.u_spi.shift_out[44] net815 _06641_ VSS VSS VDD VDD _2236_[45] sky130_fd_sc_hd__o21a_1
X_12229_ u_core.u_top.u_core.r_x[92] net818 VSS VSS VDD VDD _06645_ sky130_fd_sc_hd__nand2_1
X_12231_ net917 net871 VSS VSS VDD VDD _06647_ sky130_fd_sc_hd__nand2_1
X_12233_ net928 net809 VSS VSS VDD VDD _06649_ sky130_fd_sc_hd__nor2_1
X_12234_ net809 _06645_ _06647_ _06649_ VSS VSS VDD VDD _06650_ sky130_fd_sc_hd__a31oi_1
X_12235_ u_core.u_top.u_core.r_pdata[44] net813 net812 u_core.u_top.u_core.m_fail[22] net747 net811 VSS VSS VDD VDD _06651_ sky130_fd_sc_hd__a222oi_1
X_12236_ net749 _06651_ VSS VSS VDD VDD _06652_ sky130_fd_sc_hd__nor2_1
X_12237_ net990 u_core.u_top.u_spi.shift_out[44] _06652_ VSS VSS VDD VDD _06653_ sky130_fd_sc_hd__a21oi_1
X_12238_ u_core.u_top.u_spi.shift_out[43] net816 VSS VSS VDD VDD _06654_ sky130_fd_sc_hd__nor2_1
X_12239_ net816 _06653_ _06654_ VSS VSS VDD VDD _2236_[44] sky130_fd_sc_hd__a21oi_1
X_12241_ u_core.u_top.u_spi.shift_out[43] VSS VSS VDD VDD _06656_ sky130_fd_sc_hd__inv_1
X_12243_ u_core.u_top.u_core.r_x[91] net818 VSS VSS VDD VDD _06658_ sky130_fd_sc_hd__nand2_1
X_12244_ u_core.u_top.u_core.r_x[43] net872 VSS VSS VDD VDD _06659_ sky130_fd_sc_hd__nand2_1
X_12245_ u_core.u_top.u_core.r_x[139] net810 VSS VSS VDD VDD _06660_ sky130_fd_sc_hd__nor2_1
X_12246_ net810 _06658_ _06659_ _06660_ net807 VSS VSS VDD VDD _06661_ sky130_fd_sc_hd__a311oi_2
X_12247_ u_core.u_top.u_core.r_pdata[43] net813 _06661_ VSS VSS VDD VDD _06662_ sky130_fd_sc_hd__a21oi_1
X_12248_ u_core.u_top.bus_re _06656_ _06590_ _06662_ net816 VSS VSS VDD VDD _06663_ sky130_fd_sc_hd__o221ai_1
X_12249_ u_core.u_top.u_spi.shift_out[42] net816 _06663_ VSS VSS VDD VDD _2236_[43] sky130_fd_sc_hd__o21a_1
X_12251_ u_core.u_top.u_core.r_x[90] net818 VSS VSS VDD VDD _06665_ sky130_fd_sc_hd__nand2_1
X_12252_ net918 net870 VSS VSS VDD VDD _06666_ sky130_fd_sc_hd__nand2_1
X_12253_ net929 net808 VSS VSS VDD VDD _06667_ sky130_fd_sc_hd__nor2_1
X_12254_ net808 _06665_ _06666_ _06667_ VSS VSS VDD VDD _06668_ sky130_fd_sc_hd__a31oi_1
X_12255_ u_core.u_top.u_core.r_pdata[42] net813 net812 u_core.u_top.u_core.m_fail[21] net746 net811 VSS VSS VDD VDD _06669_ sky130_fd_sc_hd__a222oi_1
X_12256_ _06590_ _06669_ VSS VSS VDD VDD _06670_ sky130_fd_sc_hd__nor2_1
X_12257_ net990 u_core.u_top.u_spi.shift_out[42] _06670_ VSS VSS VDD VDD _06671_ sky130_fd_sc_hd__a21oi_1
X_12258_ u_core.u_top.u_spi.shift_out[41] net816 VSS VSS VDD VDD _06672_ sky130_fd_sc_hd__nor2_1
X_12259_ net816 _06671_ _06672_ VSS VSS VDD VDD _2236_[42] sky130_fd_sc_hd__a21oi_1
X_12260_ u_core.u_top.u_spi.shift_out[41] VSS VSS VDD VDD _06673_ sky130_fd_sc_hd__inv_1
X_12261_ u_core.u_top.u_core.r_x[89] net819 VSS VSS VDD VDD _06674_ sky130_fd_sc_hd__nand2_1
X_12262_ u_core.u_top.u_core.r_x[41] net872 VSS VSS VDD VDD _06675_ sky130_fd_sc_hd__nand2_1
X_12263_ u_core.u_top.u_core.r_x[137] net810 VSS VSS VDD VDD _06676_ sky130_fd_sc_hd__nor2_1
X_12264_ net810 _06674_ _06675_ _06676_ net807 VSS VSS VDD VDD _06677_ sky130_fd_sc_hd__a311oi_1
X_12265_ u_core.u_top.u_core.r_pdata[41] net813 net745 VSS VSS VDD VDD _06678_ sky130_fd_sc_hd__a21oi_1
X_12266_ u_core.u_top.bus_re _06673_ _06590_ _06678_ net816 VSS VSS VDD VDD _06679_ sky130_fd_sc_hd__o221ai_1
X_12267_ u_core.u_top.u_spi.shift_out[40] net816 _06679_ VSS VSS VDD VDD _2236_[41] sky130_fd_sc_hd__o21a_1
X_12268_ net903 net817 VSS VSS VDD VDD _06680_ sky130_fd_sc_hd__nand2_1
X_12269_ net919 _06204_ VSS VSS VDD VDD _06681_ sky130_fd_sc_hd__nand2_1
X_12270_ net930 net808 VSS VSS VDD VDD _06682_ sky130_fd_sc_hd__nor2_1
X_12271_ net808 _06680_ _06681_ _06682_ VSS VSS VDD VDD _06683_ sky130_fd_sc_hd__a31oi_1
X_12272_ u_core.u_top.u_core.r_pdata[40] net813 net812 u_core.u_top.u_core.m_fail[20] _06683_ net811 VSS VSS VDD VDD _06684_ sky130_fd_sc_hd__a222oi_1
X_12273_ _06590_ _06684_ VSS VSS VDD VDD _06685_ sky130_fd_sc_hd__nor2_1
X_12274_ net990 u_core.u_top.u_spi.shift_out[40] _06685_ VSS VSS VDD VDD _06686_ sky130_fd_sc_hd__a21oi_1
X_12275_ u_core.u_top.u_spi.shift_out[39] net816 VSS VSS VDD VDD _06687_ sky130_fd_sc_hd__nor2_1
X_12276_ net816 _06686_ _06687_ VSS VSS VDD VDD _2236_[40] sky130_fd_sc_hd__a21oi_1
X_12277_ u_core.u_top.u_spi.shift_out[39] VSS VSS VDD VDD _06688_ sky130_fd_sc_hd__inv_1
X_12279_ u_core.u_top.u_core.r_x[87] net817 VSS VSS VDD VDD _06690_ sky130_fd_sc_hd__nand2_1
X_12281_ u_core.u_top.u_core.r_x[39] _06204_ VSS VSS VDD VDD _06692_ sky130_fd_sc_hd__nand2_1
X_12282_ u_core.u_top.u_core.r_x[135] net808 VSS VSS VDD VDD _06693_ sky130_fd_sc_hd__nor2_1
X_12283_ net808 _06690_ _06692_ _06693_ _06635_ VSS VSS VDD VDD _06694_ sky130_fd_sc_hd__a311oi_1
X_12284_ u_core.u_top.u_core.r_pdata[39] net813 net744 VSS VSS VDD VDD _06695_ sky130_fd_sc_hd__a21oi_1
X_12285_ u_core.u_top.bus_re _06688_ _06590_ _06695_ net816 VSS VSS VDD VDD _06696_ sky130_fd_sc_hd__o221ai_1
X_12286_ u_core.u_top.u_spi.shift_out[38] net816 _06696_ VSS VSS VDD VDD _2236_[39] sky130_fd_sc_hd__o21a_1
X_12287_ net904 net817 VSS VSS VDD VDD _06697_ sky130_fd_sc_hd__nand2_1
X_12288_ net920 net870 VSS VSS VDD VDD _06698_ sky130_fd_sc_hd__nand2_1
X_12289_ net931 net808 VSS VSS VDD VDD _06699_ sky130_fd_sc_hd__nor2_1
X_12290_ net808 _06697_ _06698_ _06699_ VSS VSS VDD VDD _06700_ sky130_fd_sc_hd__a31oi_2
X_12291_ u_core.u_top.u_core.r_pdata[38] net813 net812 u_core.u_top.u_core.m_fail[19] _06700_ net811 VSS VSS VDD VDD _06701_ sky130_fd_sc_hd__a222oi_1
X_12292_ _06590_ _06701_ VSS VSS VDD VDD _06702_ sky130_fd_sc_hd__nor2_1
X_12293_ net990 u_core.u_top.u_spi.shift_out[38] _06702_ VSS VSS VDD VDD _06703_ sky130_fd_sc_hd__a21oi_1
X_12295_ u_core.u_top.u_spi.shift_out[37] net816 VSS VSS VDD VDD _06705_ sky130_fd_sc_hd__nor2_1
X_12296_ net816 _06703_ _06705_ VSS VSS VDD VDD _2236_[38] sky130_fd_sc_hd__a21oi_1
X_12298_ u_core.u_top.u_spi.shift_out[37] VSS VSS VDD VDD _06707_ sky130_fd_sc_hd__inv_1
X_12299_ u_core.u_top.u_core.r_x[85] net818 VSS VSS VDD VDD _06708_ sky130_fd_sc_hd__nand2_1
X_12300_ u_core.u_top.u_core.r_x[37] net871 VSS VSS VDD VDD _06709_ sky130_fd_sc_hd__nand2_1
X_12301_ u_core.u_top.u_core.r_x[133] net809 VSS VSS VDD VDD _06710_ sky130_fd_sc_hd__nor2_1
X_12302_ net809 _06708_ _06709_ _06710_ net807 VSS VSS VDD VDD _06711_ sky130_fd_sc_hd__a311oi_4
X_12303_ u_core.u_top.u_core.r_pdata[37] net813 _06711_ VSS VSS VDD VDD _06712_ sky130_fd_sc_hd__a21oi_1
X_12304_ u_core.u_top.bus_re _06707_ _06590_ _06712_ net816 VSS VSS VDD VDD _06713_ sky130_fd_sc_hd__o221ai_1
X_12305_ u_core.u_top.u_spi.shift_out[36] net816 _06713_ VSS VSS VDD VDD _2236_[37] sky130_fd_sc_hd__o21a_1
X_12307_ net905 net819 VSS VSS VDD VDD _06715_ sky130_fd_sc_hd__nand2_1
X_12308_ net921 net870 VSS VSS VDD VDD _06716_ sky130_fd_sc_hd__nand2_1
X_12309_ net932 net810 VSS VSS VDD VDD _06717_ sky130_fd_sc_hd__nor2_1
X_12310_ net810 _06715_ _06716_ _06717_ VSS VSS VDD VDD _06718_ sky130_fd_sc_hd__a31oi_1
X_12311_ u_core.u_top.u_core.r_pdata[36] net813 net812 u_core.u_top.u_core.m_fail[18] net743 net811 VSS VSS VDD VDD _06719_ sky130_fd_sc_hd__a222oi_1
X_12312_ _06590_ _06719_ VSS VSS VDD VDD _06720_ sky130_fd_sc_hd__nor2_1
X_12313_ net990 u_core.u_top.u_spi.shift_out[36] _06720_ VSS VSS VDD VDD _06721_ sky130_fd_sc_hd__a21oi_1
X_12314_ u_core.u_top.u_spi.shift_out[35] net816 VSS VSS VDD VDD _06722_ sky130_fd_sc_hd__nor2_1
X_12315_ net816 _06721_ _06722_ VSS VSS VDD VDD _2236_[36] sky130_fd_sc_hd__a21oi_1
X_12316_ u_core.u_top.u_spi.shift_out[35] VSS VSS VDD VDD _06723_ sky130_fd_sc_hd__inv_1
X_12317_ u_core.u_top.u_core.r_x[83] net817 VSS VSS VDD VDD _06724_ sky130_fd_sc_hd__nand2_1
X_12318_ u_core.u_top.u_core.r_x[35] _06204_ VSS VSS VDD VDD _06725_ sky130_fd_sc_hd__nand2_1
X_12319_ u_core.u_top.u_core.r_x[131] net808 VSS VSS VDD VDD _06726_ sky130_fd_sc_hd__nor2_1
X_12321_ net808 _06724_ _06725_ _06726_ _06635_ VSS VSS VDD VDD _06728_ sky130_fd_sc_hd__a311oi_1
X_12322_ u_core.u_top.u_core.r_pdata[35] net813 net742 VSS VSS VDD VDD _06729_ sky130_fd_sc_hd__a21oi_1
X_12324_ u_core.u_top.bus_re _06723_ _06590_ _06729_ net816 VSS VSS VDD VDD _06731_ sky130_fd_sc_hd__o221ai_1
X_12325_ u_core.u_top.u_spi.shift_out[34] net816 _06731_ VSS VSS VDD VDD _2236_[35] sky130_fd_sc_hd__o21a_1
X_12326_ u_core.u_top.u_core.r_x[82] net818 VSS VSS VDD VDD _06732_ sky130_fd_sc_hd__nand2_1
X_12327_ u_core.u_top.u_core.r_x[34] _06204_ VSS VSS VDD VDD _06733_ sky130_fd_sc_hd__nand2_1
X_12328_ net933 net808 VSS VSS VDD VDD _06734_ sky130_fd_sc_hd__nor2_1
X_12329_ net808 _06732_ _06733_ _06734_ VSS VSS VDD VDD _06735_ sky130_fd_sc_hd__a31oi_1
X_12330_ u_core.u_top.u_core.r_pdata[34] net813 net812 u_core.u_top.u_core.m_fail[17] _06735_ net811 VSS VSS VDD VDD _06736_ sky130_fd_sc_hd__a222oi_1
X_12331_ _06590_ _06736_ VSS VSS VDD VDD _06737_ sky130_fd_sc_hd__nor2_1
X_12332_ net990 u_core.u_top.u_spi.shift_out[34] _06737_ VSS VSS VDD VDD _06738_ sky130_fd_sc_hd__a21oi_1
X_12333_ u_core.u_top.u_spi.shift_out[33] net816 VSS VSS VDD VDD _06739_ sky130_fd_sc_hd__nor2_1
X_12334_ net816 _06738_ _06739_ VSS VSS VDD VDD _2236_[34] sky130_fd_sc_hd__a21oi_1
X_12335_ u_core.u_top.u_spi.shift_out[33] VSS VSS VDD VDD _06740_ sky130_fd_sc_hd__inv_1
X_12336_ u_core.u_top.u_core.r_x[81] net818 VSS VSS VDD VDD _06741_ sky130_fd_sc_hd__nand2_1
X_12337_ u_core.u_top.u_core.r_x[33] net871 VSS VSS VDD VDD _06742_ sky130_fd_sc_hd__nand2_1
X_12339_ u_core.u_top.u_core.r_x[129] net809 VSS VSS VDD VDD _06744_ sky130_fd_sc_hd__nor2_1
X_12340_ net809 _06741_ _06742_ _06744_ net807 VSS VSS VDD VDD _06745_ sky130_fd_sc_hd__a311oi_1
X_12341_ u_core.u_top.u_core.r_pdata[33] net814 _06745_ VSS VSS VDD VDD _06746_ sky130_fd_sc_hd__a21oi_1
X_12342_ net996 _06740_ net749 _06746_ net815 VSS VSS VDD VDD _06747_ sky130_fd_sc_hd__o221ai_1
X_12343_ u_core.u_top.u_spi.shift_out[32] net815 _06747_ VSS VSS VDD VDD _2236_[33] sky130_fd_sc_hd__o21a_1
X_12344_ u_core.u_top.u_core.r_x[80] net818 VSS VSS VDD VDD _06748_ sky130_fd_sc_hd__nand2_1
X_12345_ net922 net871 VSS VSS VDD VDD _06749_ sky130_fd_sc_hd__nand2_1
X_12346_ u_core.u_top.u_core.r_x[128] net809 VSS VSS VDD VDD _06750_ sky130_fd_sc_hd__nor2_1
X_12347_ net809 _06748_ _06749_ _06750_ VSS VSS VDD VDD _06751_ sky130_fd_sc_hd__a31oi_1
X_12349_ u_core.u_top.u_core.r_pdata[32] net813 net812 u_core.u_top.u_core.m_fail[16] net741 net811 VSS VSS VDD VDD _06753_ sky130_fd_sc_hd__a222oi_1
X_12350_ net749 _06753_ VSS VSS VDD VDD _06754_ sky130_fd_sc_hd__nor2_1
X_12351_ net990 u_core.u_top.u_spi.shift_out[32] _06754_ VSS VSS VDD VDD _06755_ sky130_fd_sc_hd__a21oi_1
X_12352_ u_core.u_top.u_spi.shift_out[31] net815 VSS VSS VDD VDD _06756_ sky130_fd_sc_hd__nor2_1
X_12353_ net815 _06755_ _06756_ VSS VSS VDD VDD _2236_[32] sky130_fd_sc_hd__a21oi_1
X_12354_ u_core.u_top.u_spi.shift_out[31] VSS VSS VDD VDD _06757_ sky130_fd_sc_hd__inv_1
X_12355_ u_core.u_top.u_core.r_x[79] net818 VSS VSS VDD VDD _06758_ sky130_fd_sc_hd__nand2_1
X_12356_ u_core.u_top.u_core.r_x[31] net872 VSS VSS VDD VDD _06759_ sky130_fd_sc_hd__nand2_1
X_12357_ u_core.u_top.u_core.r_x[127] net810 VSS VSS VDD VDD _06760_ sky130_fd_sc_hd__nor2_1
X_12358_ net810 _06758_ _06759_ _06760_ net807 VSS VSS VDD VDD _06761_ sky130_fd_sc_hd__a311oi_1
X_12359_ u_core.u_top.u_core.r_pdata[31] net814 _06761_ VSS VSS VDD VDD _06762_ sky130_fd_sc_hd__a21oi_1
X_12360_ net996 _06757_ net749 _06762_ net815 VSS VSS VDD VDD _06763_ sky130_fd_sc_hd__o221ai_1
X_12361_ u_core.u_top.u_spi.shift_out[30] net815 _06763_ VSS VSS VDD VDD _2236_[31] sky130_fd_sc_hd__o21a_1
X_12362_ net906 net818 VSS VSS VDD VDD _06764_ sky130_fd_sc_hd__nand2_1
X_12363_ u_core.u_top.u_core.r_x[30] net872 VSS VSS VDD VDD _06765_ sky130_fd_sc_hd__nand2_1
X_12364_ u_core.u_top.u_core.r_x[126] net810 VSS VSS VDD VDD _06766_ sky130_fd_sc_hd__nor2_1
X_12365_ net810 _06764_ _06765_ _06766_ VSS VSS VDD VDD _06767_ sky130_fd_sc_hd__a31oi_1
X_12366_ u_core.u_top.u_core.r_pdata[30] net813 net812 u_core.u_top.u_core.m_fail[15] _06767_ net811 VSS VSS VDD VDD _06768_ sky130_fd_sc_hd__a222oi_1
X_12367_ net749 _06768_ VSS VSS VDD VDD _06769_ sky130_fd_sc_hd__nor2_1
X_12368_ net990 u_core.u_top.u_spi.shift_out[30] _06769_ VSS VSS VDD VDD _06770_ sky130_fd_sc_hd__a21oi_1
X_12369_ u_core.u_top.u_spi.shift_out[29] net815 VSS VSS VDD VDD _06771_ sky130_fd_sc_hd__nor2_1
X_12370_ net815 _06770_ _06771_ VSS VSS VDD VDD _2236_[30] sky130_fd_sc_hd__a21oi_1
X_12371_ u_core.u_top.u_spi.shift_out[29] VSS VSS VDD VDD _06772_ sky130_fd_sc_hd__inv_1
X_12373_ u_core.u_top.u_core.r_x[77] net818 VSS VSS VDD VDD _06774_ sky130_fd_sc_hd__nand2_1
X_12374_ u_core.u_top.u_core.r_x[29] net871 VSS VSS VDD VDD _06775_ sky130_fd_sc_hd__nand2_1
X_12375_ u_core.u_top.u_core.r_x[125] net809 VSS VSS VDD VDD _06776_ sky130_fd_sc_hd__nor2_1
X_12376_ net809 _06774_ _06775_ _06776_ net807 VSS VSS VDD VDD _06777_ sky130_fd_sc_hd__a311oi_1
X_12377_ u_core.u_top.u_core.r_pdata[29] net814 _06777_ VSS VSS VDD VDD _06778_ sky130_fd_sc_hd__a21oi_1
X_12378_ net996 _06772_ net749 _06778_ net815 VSS VSS VDD VDD _06779_ sky130_fd_sc_hd__o221ai_1
X_12379_ u_core.u_top.u_spi.shift_out[28] net815 _06779_ VSS VSS VDD VDD _2236_[29] sky130_fd_sc_hd__o21a_1
X_12380_ u_core.u_top.u_core.r_x[76] net818 VSS VSS VDD VDD _06780_ sky130_fd_sc_hd__nand2_1
X_12381_ net923 net871 VSS VSS VDD VDD _06781_ sky130_fd_sc_hd__nand2_1
X_12383_ u_core.u_top.u_core.r_x[124] net809 VSS VSS VDD VDD _06783_ sky130_fd_sc_hd__nor2_1
X_12384_ net809 _06780_ _06781_ _06783_ VSS VSS VDD VDD _06784_ sky130_fd_sc_hd__a31oi_1
X_12385_ u_core.u_top.u_core.r_pdata[28] _06596_ net812 u_core.u_top.u_core.m_fail[14] _06784_ net811 VSS VSS VDD VDD _06785_ sky130_fd_sc_hd__a222oi_1
X_12386_ net749 _06785_ VSS VSS VDD VDD _06786_ sky130_fd_sc_hd__nor2_1
X_12387_ net990 u_core.u_top.u_spi.shift_out[28] _06786_ VSS VSS VDD VDD _06787_ sky130_fd_sc_hd__a21oi_1
X_12388_ u_core.u_top.u_spi.shift_out[27] net815 VSS VSS VDD VDD _06788_ sky130_fd_sc_hd__nor2_1
X_12389_ net815 _06787_ _06788_ VSS VSS VDD VDD _2236_[28] sky130_fd_sc_hd__a21oi_1
X_12390_ u_core.u_top.u_spi.shift_out[27] VSS VSS VDD VDD _06789_ sky130_fd_sc_hd__inv_1
X_12391_ u_core.u_top.u_core.r_x[75] net818 VSS VSS VDD VDD _06790_ sky130_fd_sc_hd__nand2_1
X_12392_ u_core.u_top.u_core.r_x[27] net872 VSS VSS VDD VDD _06791_ sky130_fd_sc_hd__nand2_1
X_12393_ u_core.u_top.u_core.r_x[123] net810 VSS VSS VDD VDD _06792_ sky130_fd_sc_hd__nor2_1
X_12394_ net810 _06790_ _06791_ _06792_ net807 VSS VSS VDD VDD _06793_ sky130_fd_sc_hd__a311oi_1
X_12395_ u_core.u_top.u_core.r_pdata[27] net814 _06793_ VSS VSS VDD VDD _06794_ sky130_fd_sc_hd__a21oi_1
X_12396_ net996 _06789_ net749 _06794_ net815 VSS VSS VDD VDD _06795_ sky130_fd_sc_hd__o221ai_1
X_12397_ u_core.u_top.u_spi.shift_out[26] net815 _06795_ VSS VSS VDD VDD _2236_[27] sky130_fd_sc_hd__o21a_1
X_12400_ u_core.u_top.u_core.r_x[74] net818 VSS VSS VDD VDD _06798_ sky130_fd_sc_hd__nand2_1
X_12401_ u_core.u_top.u_core.r_x[26] net870 VSS VSS VDD VDD _06799_ sky130_fd_sc_hd__nand2_1
X_12402_ u_core.u_top.u_core.r_x[122] net810 VSS VSS VDD VDD _06800_ sky130_fd_sc_hd__nor2_1
X_12403_ net808 _06798_ _06799_ _06800_ VSS VSS VDD VDD _06801_ sky130_fd_sc_hd__a31oi_1
X_12404_ u_core.u_top.u_core.r_pdata[26] net813 net812 u_core.u_top.u_core.m_fail[13] net740 net811 VSS VSS VDD VDD _06802_ sky130_fd_sc_hd__a222oi_1
X_12405_ net749 _06802_ VSS VSS VDD VDD _06803_ sky130_fd_sc_hd__nor2_1
X_12406_ net990 u_core.u_top.u_spi.shift_out[26] _06803_ VSS VSS VDD VDD _06804_ sky130_fd_sc_hd__a21oi_1
X_12407_ u_core.u_top.u_spi.shift_out[25] net815 VSS VSS VDD VDD _06805_ sky130_fd_sc_hd__nor2_1
X_12408_ net815 _06804_ _06805_ VSS VSS VDD VDD _2236_[26] sky130_fd_sc_hd__a21oi_1
X_12409_ u_core.u_top.u_spi.shift_out[25] VSS VSS VDD VDD _06806_ sky130_fd_sc_hd__inv_1
X_12410_ u_core.u_top.u_core.r_x[73] net819 VSS VSS VDD VDD _06807_ sky130_fd_sc_hd__nand2_1
X_12411_ u_core.u_top.u_core.r_x[25] net872 VSS VSS VDD VDD _06808_ sky130_fd_sc_hd__nand2_1
X_12412_ u_core.u_top.u_core.r_x[121] net810 VSS VSS VDD VDD _06809_ sky130_fd_sc_hd__nor2_1
X_12413_ net810 _06807_ _06808_ _06809_ net807 VSS VSS VDD VDD _06810_ sky130_fd_sc_hd__a311oi_1
X_12414_ u_core.u_top.u_core.r_pdata[25] net813 _06810_ VSS VSS VDD VDD _06811_ sky130_fd_sc_hd__a21oi_1
X_12415_ net996 _06806_ net749 _06811_ net815 VSS VSS VDD VDD _06812_ sky130_fd_sc_hd__o221ai_1
X_12416_ u_core.u_top.u_spi.shift_out[24] net815 _06812_ VSS VSS VDD VDD _2236_[25] sky130_fd_sc_hd__o21a_1
X_12417_ net907 net817 VSS VSS VDD VDD _06813_ sky130_fd_sc_hd__nand2_1
X_12418_ net924 net870 VSS VSS VDD VDD _06814_ sky130_fd_sc_hd__nand2_1
X_12419_ net935 net808 VSS VSS VDD VDD _06815_ sky130_fd_sc_hd__nor2_1
X_12420_ net808 _06813_ _06814_ _06815_ VSS VSS VDD VDD _06816_ sky130_fd_sc_hd__a31oi_1
X_12421_ u_core.u_top.u_core.r_pdata[24] net813 net812 u_core.u_top.u_core.m_fail[12] _06816_ net811 VSS VSS VDD VDD _06817_ sky130_fd_sc_hd__a222oi_1
X_12422_ net749 _06817_ VSS VSS VDD VDD _06818_ sky130_fd_sc_hd__nor2_1
X_12423_ net990 u_core.u_top.u_spi.shift_out[24] _06818_ VSS VSS VDD VDD _06819_ sky130_fd_sc_hd__a21oi_1
X_12424_ u_core.u_top.u_spi.shift_out[23] net815 VSS VSS VDD VDD _06820_ sky130_fd_sc_hd__nor2_1
X_12425_ net816 _06819_ _06820_ VSS VSS VDD VDD _2236_[24] sky130_fd_sc_hd__a21oi_1
X_12427_ u_core.u_top.u_spi.shift_out[23] VSS VSS VDD VDD _06822_ sky130_fd_sc_hd__inv_1
X_12428_ u_core.u_top.u_core.r_x[71] net817 VSS VSS VDD VDD _06823_ sky130_fd_sc_hd__nand2_1
X_12429_ u_core.u_top.u_core.r_x[23] net870 VSS VSS VDD VDD _06824_ sky130_fd_sc_hd__nand2_1
X_12430_ u_core.u_top.u_core.r_x[119] net808 VSS VSS VDD VDD _06825_ sky130_fd_sc_hd__nor2_1
X_12431_ net808 _06823_ _06824_ _06825_ _06635_ VSS VSS VDD VDD _06826_ sky130_fd_sc_hd__a311oi_1
X_12432_ u_core.u_top.u_core.r_pdata[23] net813 net739 VSS VSS VDD VDD _06827_ sky130_fd_sc_hd__a21oi_1
X_12433_ net996 _06822_ net749 _06827_ net815 VSS VSS VDD VDD _06828_ sky130_fd_sc_hd__o221ai_1
X_12434_ u_core.u_top.u_spi.shift_out[22] net815 _06828_ VSS VSS VDD VDD _2236_[23] sky130_fd_sc_hd__o21a_1
X_12436_ u_core.u_top.u_core.r_x[70] net817 VSS VSS VDD VDD _06830_ sky130_fd_sc_hd__nand2_1
X_12437_ u_core.u_top.u_core.r_x[22] net870 VSS VSS VDD VDD _06831_ sky130_fd_sc_hd__nand2_1
X_12438_ net936 net808 VSS VSS VDD VDD _06832_ sky130_fd_sc_hd__nor2_1
X_12439_ net808 _06830_ _06831_ _06832_ VSS VSS VDD VDD _06833_ sky130_fd_sc_hd__a31oi_1
X_12440_ u_core.u_top.u_core.r_pdata[22] net813 net812 u_core.u_top.u_core.m_fail[11] _06833_ net811 VSS VSS VDD VDD _06834_ sky130_fd_sc_hd__a222oi_1
X_12441_ net749 _06834_ VSS VSS VDD VDD _06835_ sky130_fd_sc_hd__nor2_1
X_12442_ net990 u_core.u_top.u_spi.shift_out[22] _06835_ VSS VSS VDD VDD _06836_ sky130_fd_sc_hd__a21oi_1
X_12443_ u_core.u_top.u_spi.shift_out[21] net815 VSS VSS VDD VDD _06837_ sky130_fd_sc_hd__nor2_1
X_12444_ net815 _06836_ _06837_ VSS VSS VDD VDD _2236_[22] sky130_fd_sc_hd__a21oi_1
X_12445_ u_core.u_top.u_spi.shift_out[21] VSS VSS VDD VDD _06838_ sky130_fd_sc_hd__inv_1
X_12446_ u_core.u_top.u_core.r_x[69] net818 VSS VSS VDD VDD _06839_ sky130_fd_sc_hd__nand2_1
X_12447_ u_core.u_top.u_core.r_x[21] net871 VSS VSS VDD VDD _06840_ sky130_fd_sc_hd__nand2_1
X_12448_ u_core.u_top.u_core.r_x[117] net809 VSS VSS VDD VDD _06841_ sky130_fd_sc_hd__nor2_1
X_12449_ net809 _06839_ _06840_ _06841_ net807 VSS VSS VDD VDD _06842_ sky130_fd_sc_hd__a311oi_1
X_12450_ u_core.u_top.u_core.r_pdata[21] net814 _06842_ VSS VSS VDD VDD _06843_ sky130_fd_sc_hd__a21oi_1
X_12451_ net996 _06838_ net749 _06843_ net815 VSS VSS VDD VDD _06844_ sky130_fd_sc_hd__o221ai_1
X_12452_ u_core.u_top.u_spi.shift_out[20] net815 _06844_ VSS VSS VDD VDD _2236_[21] sky130_fd_sc_hd__o21a_1
X_12453_ net909 net818 VSS VSS VDD VDD _06845_ sky130_fd_sc_hd__nand2_1
X_12454_ net925 net871 VSS VSS VDD VDD _06846_ sky130_fd_sc_hd__nand2_1
X_12455_ net937 net809 VSS VSS VDD VDD _06847_ sky130_fd_sc_hd__nor2_1
X_12456_ net809 _06845_ _06846_ _06847_ VSS VSS VDD VDD _06848_ sky130_fd_sc_hd__a31oi_1
X_12457_ u_core.u_top.u_core.r_pdata[20] _06596_ net812 u_core.u_top.u_core.m_fail[10] _06848_ net811 VSS VSS VDD VDD _06849_ sky130_fd_sc_hd__a222oi_1
X_12458_ net749 _06849_ VSS VSS VDD VDD _06850_ sky130_fd_sc_hd__nor2_1
X_12459_ net990 u_core.u_top.u_spi.shift_out[20] _06850_ VSS VSS VDD VDD _06851_ sky130_fd_sc_hd__a21oi_1
X_12460_ u_core.u_top.u_spi.shift_out[19] net815 VSS VSS VDD VDD _06852_ sky130_fd_sc_hd__nor2_1
X_12461_ net815 _06851_ _06852_ VSS VSS VDD VDD _2236_[20] sky130_fd_sc_hd__a21oi_1
X_12462_ u_core.u_top.u_spi.shift_out[19] VSS VSS VDD VDD _06853_ sky130_fd_sc_hd__inv_1
X_12463_ u_core.u_top.u_core.r_x[67] net817 VSS VSS VDD VDD _06854_ sky130_fd_sc_hd__nand2_1
X_12465_ u_core.u_top.u_core.r_x[19] net870 VSS VSS VDD VDD _06856_ sky130_fd_sc_hd__nand2_1
X_12466_ u_core.u_top.u_core.r_x[115] net808 VSS VSS VDD VDD _06857_ sky130_fd_sc_hd__nor2_1
X_12467_ net808 _06854_ _06856_ _06857_ _06635_ VSS VSS VDD VDD _06858_ sky130_fd_sc_hd__a311oi_2
X_12468_ u_core.u_top.u_core.r_pdata[19] net814 _06858_ VSS VSS VDD VDD _06859_ sky130_fd_sc_hd__a21oi_1
X_12469_ net996 _06853_ net749 _06859_ net815 VSS VSS VDD VDD _06860_ sky130_fd_sc_hd__o221ai_1
X_12470_ u_core.u_top.u_spi.shift_out[18] net815 _06860_ VSS VSS VDD VDD _2236_[19] sky130_fd_sc_hd__o21a_1
X_12471_ u_core.u_top.u_core.r_x[66] net818 VSS VSS VDD VDD _06861_ sky130_fd_sc_hd__nand2_1
X_12472_ net926 net870 VSS VSS VDD VDD _06862_ sky130_fd_sc_hd__nand2_1
X_12473_ u_core.u_top.u_core.r_x[114] net808 VSS VSS VDD VDD _06863_ sky130_fd_sc_hd__nor2_1
X_12474_ net808 _06861_ _06862_ _06863_ VSS VSS VDD VDD _06864_ sky130_fd_sc_hd__a31oi_1
X_12475_ u_core.u_top.u_core.r_pdata[18] net814 net812 u_core.u_top.u_core.m_fail[9] _06864_ net811 VSS VSS VDD VDD _06865_ sky130_fd_sc_hd__a222oi_1
X_12476_ net749 _06865_ VSS VSS VDD VDD _06866_ sky130_fd_sc_hd__nor2_1
X_12477_ net990 u_core.u_top.u_spi.shift_out[18] _06866_ VSS VSS VDD VDD _06867_ sky130_fd_sc_hd__a21oi_1
X_12478_ u_core.u_top.u_spi.shift_out[17] net815 VSS VSS VDD VDD _06868_ sky130_fd_sc_hd__nor2_1
X_12479_ net815 _06867_ _06868_ VSS VSS VDD VDD _2236_[18] sky130_fd_sc_hd__a21oi_1
X_12480_ u_core.u_top.u_spi.shift_out[17] VSS VSS VDD VDD _06869_ sky130_fd_sc_hd__inv_1
X_12481_ u_core.u_top.u_core.r_x[65] net818 VSS VSS VDD VDD _06870_ sky130_fd_sc_hd__nand2_1
X_12482_ u_core.u_top.u_core.r_x[17] net871 VSS VSS VDD VDD _06871_ sky130_fd_sc_hd__nand2_1
X_12483_ u_core.u_top.u_core.r_x[113] net809 VSS VSS VDD VDD _06872_ sky130_fd_sc_hd__nor2_1
X_12484_ net809 _06870_ _06871_ _06872_ net807 VSS VSS VDD VDD _06873_ sky130_fd_sc_hd__a311oi_1
X_12485_ u_core.u_top.u_core.r_pdata[17] net814 _06873_ VSS VSS VDD VDD _06874_ sky130_fd_sc_hd__a21oi_1
X_12486_ net996 _06869_ net749 _06874_ net815 VSS VSS VDD VDD _06875_ sky130_fd_sc_hd__o221ai_1
X_12487_ u_core.u_top.u_spi.shift_out[16] net815 _06875_ VSS VSS VDD VDD _2236_[17] sky130_fd_sc_hd__o21a_1
X_12488_ net910 net819 VSS VSS VDD VDD _06876_ sky130_fd_sc_hd__nand2_1
X_12489_ net927 net871 VSS VSS VDD VDD _06877_ sky130_fd_sc_hd__nand2_1
X_12490_ net938 net809 VSS VSS VDD VDD _06878_ sky130_fd_sc_hd__nor2_1
X_12491_ net810 _06876_ _06877_ _06878_ VSS VSS VDD VDD _06879_ sky130_fd_sc_hd__a31oi_1
X_12492_ u_core.u_top.u_core.r_pdata[16] net814 net812 u_core.u_top.u_core.m_fail[8] _06879_ net811 VSS VSS VDD VDD _06880_ sky130_fd_sc_hd__a222oi_1
X_12493_ net749 _06880_ VSS VSS VDD VDD _06881_ sky130_fd_sc_hd__nor2_1
X_12494_ net990 u_core.u_top.u_spi.shift_out[16] _06881_ VSS VSS VDD VDD _06882_ sky130_fd_sc_hd__a21oi_1
X_12495_ u_core.u_top.u_spi.shift_out[15] net815 VSS VSS VDD VDD _06883_ sky130_fd_sc_hd__nor2_1
X_12496_ net815 _06882_ _06883_ VSS VSS VDD VDD _2236_[16] sky130_fd_sc_hd__a21oi_1
X_12497_ u_core.u_top.u_spi.shift_out[15] VSS VSS VDD VDD _06884_ sky130_fd_sc_hd__inv_1
X_12498_ u_core.u_top.u_core.r_x[63] net818 VSS VSS VDD VDD _06885_ sky130_fd_sc_hd__nand2_1
X_12499_ u_core.u_top.u_core.r_x[15] net872 VSS VSS VDD VDD _06886_ sky130_fd_sc_hd__nand2_1
X_12500_ u_core.u_top.u_core.r_x[111] net810 VSS VSS VDD VDD _06887_ sky130_fd_sc_hd__nor2_1
X_12501_ net810 _06885_ _06886_ _06887_ net807 VSS VSS VDD VDD _06888_ sky130_fd_sc_hd__a311oi_1
X_12502_ u_core.u_top.u_core.r_pdata[15] net814 _06888_ VSS VSS VDD VDD _06889_ sky130_fd_sc_hd__a21oi_1
X_12503_ net996 _06884_ net749 _06889_ net815 VSS VSS VDD VDD _06890_ sky130_fd_sc_hd__o221ai_1
X_12504_ u_core.u_top.u_spi.shift_out[14] net815 _06890_ VSS VSS VDD VDD _2236_[15] sky130_fd_sc_hd__o21a_1
X_12505_ u_core.u_top.u_core.r_x[62] net818 VSS VSS VDD VDD _06891_ sky130_fd_sc_hd__nand2_1
X_12506_ u_core.u_top.u_core.r_x[14] net872 VSS VSS VDD VDD _06892_ sky130_fd_sc_hd__nand2_1
X_12507_ u_core.u_top.u_core.r_x[110] net810 VSS VSS VDD VDD _06893_ sky130_fd_sc_hd__nor2_1
X_12508_ net810 _06891_ _06892_ _06893_ VSS VSS VDD VDD _06894_ sky130_fd_sc_hd__a31oi_1
X_12509_ u_core.u_top.u_core.r_pdata[14] net814 net812 u_core.u_top.u_core.m_fail[7] _06894_ net811 VSS VSS VDD VDD _06895_ sky130_fd_sc_hd__a222oi_1
X_12510_ net749 _06895_ VSS VSS VDD VDD _06896_ sky130_fd_sc_hd__nor2_1
X_12511_ net990 u_core.u_top.u_spi.shift_out[14] _06896_ VSS VSS VDD VDD _06897_ sky130_fd_sc_hd__a21oi_1
X_12512_ u_core.u_top.u_spi.shift_out[13] net815 VSS VSS VDD VDD _06898_ sky130_fd_sc_hd__nor2_1
X_12513_ net815 _06897_ _06898_ VSS VSS VDD VDD _2236_[14] sky130_fd_sc_hd__a21oi_1
X_12514_ u_core.u_top.u_spi.shift_out[13] VSS VSS VDD VDD _06899_ sky130_fd_sc_hd__inv_1
X_12515_ u_core.u_top.u_core.r_x[61] net818 VSS VSS VDD VDD _06900_ sky130_fd_sc_hd__nand2_1
X_12516_ u_core.u_top.u_core.r_x[13] net871 VSS VSS VDD VDD _06901_ sky130_fd_sc_hd__nand2_1
X_12517_ u_core.u_top.u_core.r_x[109] net809 VSS VSS VDD VDD _06902_ sky130_fd_sc_hd__nor2_1
X_12518_ net809 _06900_ _06901_ _06902_ net807 VSS VSS VDD VDD _06903_ sky130_fd_sc_hd__a311oi_1
X_12519_ u_core.u_top.u_core.r_pdata[13] net814 _06903_ VSS VSS VDD VDD _06904_ sky130_fd_sc_hd__a21oi_1
X_12520_ net996 _06899_ net749 _06904_ net815 VSS VSS VDD VDD _06905_ sky130_fd_sc_hd__o221ai_1
X_12521_ u_core.u_top.u_spi.shift_out[12] net815 _06905_ VSS VSS VDD VDD _2236_[13] sky130_fd_sc_hd__o21a_1
X_12522_ net911 net818 VSS VSS VDD VDD _06906_ sky130_fd_sc_hd__nand2_1
X_12523_ net934 net871 VSS VSS VDD VDD _06907_ sky130_fd_sc_hd__nand2_1
X_12524_ net940 net809 VSS VSS VDD VDD _06908_ sky130_fd_sc_hd__nor2_1
X_12525_ net809 _06906_ _06907_ _06908_ VSS VSS VDD VDD _06909_ sky130_fd_sc_hd__a31oi_1
X_12526_ u_core.u_top.u_core.r_pdata[12] _06596_ net812 u_core.u_top.u_core.m_fail[6] _06909_ net811 VSS VSS VDD VDD _06910_ sky130_fd_sc_hd__a222oi_1
X_12527_ net749 _06910_ VSS VSS VDD VDD _06911_ sky130_fd_sc_hd__nor2_1
X_12528_ net990 u_core.u_top.u_spi.shift_out[12] _06911_ VSS VSS VDD VDD _06912_ sky130_fd_sc_hd__a21oi_1
X_12529_ u_core.u_top.u_spi.shift_out[11] net815 VSS VSS VDD VDD _06913_ sky130_fd_sc_hd__nor2_1
X_12530_ net815 _06912_ _06913_ VSS VSS VDD VDD _2236_[12] sky130_fd_sc_hd__a21oi_1
X_12531_ net996 _06581_ _06587_ VSS VSS VDD VDD _06914_ sky130_fd_sc_hd__nand3_1
X_12532_ u_core.u_top.bus_addr[0] _06914_ _06589_ VSS VSS VDD VDD _06915_ sky130_fd_sc_hd__nor3_1
X_12533_ u_core.u_top.bus_addr[3] u_core.u_top.bus_addr[4] VSS VSS VDD VDD _06916_ sky130_fd_sc_hd__nor2_1
X_12534_ u_core.u_top.bus_addr[4] net888 u_core.u_top.bus_addr[5] VSS VSS VDD VDD _06917_ sky130_fd_sc_hd__mux2i_1
X_12535_ u_core.u_top.bus_word _06917_ VSS VSS VDD VDD _06918_ sky130_fd_sc_hd__or2_2
X_12538_ u_core.u_top.u_core.acc[168] net962 u_core.u_top.u_core.acc[188] u_core.u_top.u_core.acc[198] net977 u_core.u_top.bus_addr[1] VSS VSS VDD VDD _06921_ sky130_fd_sc_hd__mux4_2
X_12539_ u_core.u_top.u_core.acc[208] u_core.u_top.u_core.acc[228] u_core.u_top.u_core.acc[218] u_core.u_top.u_core.acc[238] net974 net976 VSS VSS VDD VDD _06922_ sky130_fd_sc_hd__mux4_2
X_12540_ _06921_ _06922_ net973 VSS VSS VDD VDD _06923_ sky130_fd_sc_hd__mux2i_1
X_12542_ u_core.u_top.u_core.acc[8] u_core.u_top.u_core.acc[28] u_core.u_top.u_core.acc[18] u_core.u_top.u_core.acc[38] u_core.u_top.bus_addr[1] u_core.u_top.bus_addr[0] VSS VSS VDD VDD _06925_ sky130_fd_sc_hd__mux4_2
X_12546_ u_core.u_top.u_core.acc[88] u_core.u_top.u_core.acc[98] u_core.u_top.u_core.acc[108] u_core.u_top.u_core.acc[118] net977 net975 VSS VSS VDD VDD _06929_ sky130_fd_sc_hd__mux4_2
X_12549_ u_core.u_top.u_core.acc[48] u_core.u_top.u_core.acc[58] u_core.u_top.u_core.acc[68] u_core.u_top.u_core.acc[78] net976 net974 VSS VSS VDD VDD _06932_ sky130_fd_sc_hd__mux4_2
X_12551_ u_core.u_top.u_core.acc[128] u_core.u_top.u_core.acc[138] u_core.u_top.u_core.acc[148] u_core.u_top.u_core.acc[158] net977 net974 VSS VSS VDD VDD _06934_ sky130_fd_sc_hd__mux4_2
X_12552_ _06925_ _06929_ _06932_ _06934_ u_core.u_top.bus_addr[3] net973 VSS VSS VDD VDD _06935_ sky130_fd_sc_hd__mux4_2
X_12553_ u_core.u_top.bus_addr[4] _06935_ VSS VSS VDD VDD _06936_ sky130_fd_sc_hd__nand2_1
X_12554_ _06583_ _06923_ _06936_ VSS VSS VDD VDD _06937_ sky130_fd_sc_hd__o21ai_4
X_12557_ u_core.u_top.u_core.acc[6] u_core.u_top.u_core.acc[26] u_core.u_top.u_core.acc[16] u_core.u_top.u_core.acc[36] net975 net977 VSS VSS VDD VDD _06940_ sky130_fd_sc_hd__mux4_2
X_12562_ u_core.u_top.u_core.acc[86] u_core.u_top.u_core.acc[106] u_core.u_top.u_core.acc[96] u_core.u_top.u_core.acc[116] net975 net977 VSS VSS VDD VDD _06945_ sky130_fd_sc_hd__mux4_2
X_12567_ u_core.u_top.u_core.acc[46] u_core.u_top.u_core.acc[66] u_core.u_top.u_core.acc[56] u_core.u_top.u_core.acc[76] net974 net976 VSS VSS VDD VDD _06950_ sky130_fd_sc_hd__mux4_2
X_12571_ u_core.u_top.u_core.acc[126] u_core.u_top.u_core.acc[136] u_core.u_top.u_core.acc[146] u_core.u_top.u_core.acc[156] net977 net974 VSS VSS VDD VDD _06954_ sky130_fd_sc_hd__mux4_2
X_12572_ _06940_ _06945_ _06950_ _06954_ u_core.u_top.bus_addr[3] net973 VSS VSS VDD VDD _06955_ sky130_fd_sc_hd__mux4_2
X_12577_ u_core.u_top.u_core.acc[166] u_core.u_top.u_core.acc[176] u_core.u_top.u_core.acc[186] u_core.u_top.u_core.acc[196] net977 u_core.u_top.bus_addr[1] VSS VSS VDD VDD _06960_ sky130_fd_sc_hd__mux4_2
X_12581_ u_core.u_top.u_core.acc[206] u_core.u_top.u_core.acc[226] u_core.u_top.u_core.acc[216] u_core.u_top.u_core.acc[236] net974 net976 VSS VSS VDD VDD _06964_ sky130_fd_sc_hd__mux4_2
X_12582_ _06960_ _06964_ net973 VSS VSS VDD VDD _06965_ sky130_fd_sc_hd__mux2i_1
X_12583_ _06583_ _06965_ VSS VSS VDD VDD _06966_ sky130_fd_sc_hd__nor2_1
X_12584_ u_core.u_top.bus_addr[4] _06955_ _06966_ VSS VSS VDD VDD _06967_ sky130_fd_sc_hd__a21oi_4
X_12585_ _06967_ VSS VSS VDD VDD _06968_ sky130_fd_sc_hd__inv_1
X_12590_ u_core.u_top.u_core.acc[165] u_core.u_top.u_core.acc[175] u_core.u_top.u_core.acc[185] u_core.u_top.u_core.acc[195] net977 u_core.u_top.bus_addr[1] VSS VSS VDD VDD _06973_ sky130_fd_sc_hd__mux4_2
X_12595_ u_core.u_top.u_core.acc[205] u_core.u_top.u_core.acc[225] u_core.u_top.u_core.acc[215] u_core.u_top.u_core.acc[235] net974 net976 VSS VSS VDD VDD _06978_ sky130_fd_sc_hd__mux4_2
X_12596_ _06973_ _06978_ net973 VSS VSS VDD VDD _06979_ sky130_fd_sc_hd__mux2i_1
X_12600_ u_core.u_top.u_core.acc[5] u_core.u_top.u_core.acc[25] u_core.u_top.u_core.acc[15] u_core.u_top.u_core.acc[35] net975 net977 VSS VSS VDD VDD _06983_ sky130_fd_sc_hd__mux4_2
X_12605_ u_core.u_top.u_core.acc[85] u_core.u_top.u_core.acc[95] u_core.u_top.u_core.acc[105] u_core.u_top.u_core.acc[115] net977 net975 VSS VSS VDD VDD _06988_ sky130_fd_sc_hd__mux4_2
X_12609_ u_core.u_top.u_core.acc[45] u_core.u_top.u_core.acc[55] u_core.u_top.u_core.acc[65] u_core.u_top.u_core.acc[75] net976 net974 VSS VSS VDD VDD _06992_ sky130_fd_sc_hd__mux4_2
X_12612_ u_core.u_top.u_core.acc[125] u_core.u_top.u_core.acc[135] u_core.u_top.u_core.acc[145] u_core.u_top.u_core.acc[155] net977 net974 VSS VSS VDD VDD _06995_ sky130_fd_sc_hd__mux4_2
X_12613_ _06983_ _06988_ _06992_ _06995_ u_core.u_top.bus_addr[3] net973 VSS VSS VDD VDD _06996_ sky130_fd_sc_hd__mux4_2
X_12614_ u_core.u_top.bus_addr[4] _06996_ VSS VSS VDD VDD _06997_ sky130_fd_sc_hd__nand2_1
X_12615_ _06583_ _06979_ _06997_ VSS VSS VDD VDD _06998_ sky130_fd_sc_hd__o21ai_4
X_12619_ net738 net770 VSS VSS VDD VDD _07002_ sky130_fd_sc_hd__nor2_1
X_12624_ u_core.u_top.u_core.acc[2] u_core.u_top.u_core.acc[22] u_core.u_top.u_core.acc[12] u_core.u_top.u_core.acc[32] u_core.u_top.bus_addr[1] u_core.u_top.bus_addr[0] VSS VSS VDD VDD _07007_ sky130_fd_sc_hd__mux4_2
X_12629_ u_core.u_top.u_core.acc[82] u_core.u_top.u_core.acc[92] u_core.u_top.u_core.acc[102] u_core.u_top.u_core.acc[112] net977 net975 VSS VSS VDD VDD _07012_ sky130_fd_sc_hd__mux4_2
X_12634_ u_core.u_top.u_core.acc[42] u_core.u_top.u_core.acc[62] u_core.u_top.u_core.acc[52] u_core.u_top.u_core.acc[72] net974 net976 VSS VSS VDD VDD _07017_ sky130_fd_sc_hd__mux4_2
X_12637_ u_core.u_top.u_core.acc[122] u_core.u_top.u_core.acc[132] u_core.u_top.u_core.acc[142] u_core.u_top.u_core.acc[152] net977 net974 VSS VSS VDD VDD _07020_ sky130_fd_sc_hd__mux4_2
X_12638_ _07007_ _07012_ _07017_ _07020_ u_core.u_top.bus_addr[3] net973 VSS VSS VDD VDD _07021_ sky130_fd_sc_hd__mux4_2
X_12643_ u_core.u_top.u_core.acc[162] u_core.u_top.u_core.acc[172] u_core.u_top.u_core.acc[182] u_core.u_top.u_core.acc[192] net977 u_core.u_top.bus_addr[1] VSS VSS VDD VDD _07026_ sky130_fd_sc_hd__mux4_2
X_12647_ u_core.u_top.u_core.acc[202] u_core.u_top.u_core.acc[222] u_core.u_top.u_core.acc[212] u_core.u_top.u_core.acc[232] net974 net976 VSS VSS VDD VDD _07030_ sky130_fd_sc_hd__mux4_2
X_12648_ _07026_ _07030_ net973 VSS VSS VDD VDD _07031_ sky130_fd_sc_hd__mux2_1
X_12649_ u_core.u_top.bus_addr[4] _07021_ _07031_ net888 VSS VSS VDD VDD _07032_ sky130_fd_sc_hd__a22o_1
X_12650_ u_core.u_top.u_core.acc[1] u_core.u_top.u_core.acc[21] u_core.u_top.u_core.acc[11] u_core.u_top.u_core.acc[31] u_core.u_top.bus_addr[1] u_core.u_top.bus_addr[0] VSS VSS VDD VDD _07033_ sky130_fd_sc_hd__mux4_2
X_12651_ u_core.u_top.u_core.acc[81] u_core.u_top.u_core.acc[101] u_core.u_top.u_core.acc[91] u_core.u_top.u_core.acc[111] net975 net977 VSS VSS VDD VDD _07034_ sky130_fd_sc_hd__mux4_2
X_12652_ u_core.u_top.u_core.acc[41] u_core.u_top.u_core.acc[51] u_core.u_top.u_core.acc[61] u_core.u_top.u_core.acc[71] net976 net974 VSS VSS VDD VDD _07035_ sky130_fd_sc_hd__mux4_2
X_12653_ u_core.u_top.u_core.acc[121] u_core.u_top.u_core.acc[131] u_core.u_top.u_core.acc[141] u_core.u_top.u_core.acc[151] net977 net974 VSS VSS VDD VDD _07036_ sky130_fd_sc_hd__mux4_2
X_12654_ _07033_ _07034_ _07035_ _07036_ u_core.u_top.bus_addr[3] net973 VSS VSS VDD VDD _07037_ sky130_fd_sc_hd__mux4_2
X_12655_ u_core.u_top.u_core.acc[161] u_core.u_top.u_core.acc[171] u_core.u_top.u_core.acc[181] u_core.u_top.u_core.acc[191] net977 u_core.u_top.bus_addr[1] VSS VSS VDD VDD _07038_ sky130_fd_sc_hd__mux4_2
X_12656_ u_core.u_top.u_core.acc[201] u_core.u_top.u_core.acc[211] u_core.u_top.u_core.acc[221] u_core.u_top.u_core.acc[231] net976 net974 VSS VSS VDD VDD _07039_ sky130_fd_sc_hd__mux4_2
X_12657_ _07038_ _07039_ net973 VSS VSS VDD VDD _07040_ sky130_fd_sc_hd__mux2i_1
X_12658_ u_core.u_top.bus_addr[4] _07037_ _07040_ _06583_ VSS VSS VDD VDD _07041_ sky130_fd_sc_hd__o2bb2ai_2
X_12659_ u_core.u_top.u_core.acc[0] u_core.u_top.u_core.acc[10] u_core.u_top.u_core.acc[20] u_core.u_top.u_core.acc[30] net977 net975 VSS VSS VDD VDD _07042_ sky130_fd_sc_hd__mux4_2
X_12660_ u_core.u_top.u_core.acc[80] u_core.u_top.u_core.acc[90] u_core.u_top.u_core.acc[100] u_core.u_top.u_core.acc[110] net977 net975 VSS VSS VDD VDD _07043_ sky130_fd_sc_hd__mux4_2
X_12661_ u_core.u_top.u_core.acc[40] u_core.u_top.u_core.acc[60] u_core.u_top.u_core.acc[50] u_core.u_top.u_core.acc[70] net974 net976 VSS VSS VDD VDD _07044_ sky130_fd_sc_hd__mux4_2
X_12662_ u_core.u_top.u_core.acc[120] u_core.u_top.u_core.acc[130] u_core.u_top.u_core.acc[140] u_core.u_top.u_core.acc[150] net977 net974 VSS VSS VDD VDD _07045_ sky130_fd_sc_hd__mux4_2
X_12663_ _07042_ _07043_ _07044_ _07045_ u_core.u_top.bus_addr[3] net973 VSS VSS VDD VDD _07046_ sky130_fd_sc_hd__mux4_2
X_12664_ u_core.u_top.u_core.acc[160] u_core.u_top.u_core.acc[170] u_core.u_top.u_core.acc[180] u_core.u_top.u_core.acc[190] net977 u_core.u_top.bus_addr[1] VSS VSS VDD VDD _07047_ sky130_fd_sc_hd__mux4_2
X_12665_ u_core.u_top.u_core.acc[200] u_core.u_top.u_core.acc[210] u_core.u_top.u_core.acc[220] u_core.u_top.u_core.acc[230] net976 net974 VSS VSS VDD VDD _07048_ sky130_fd_sc_hd__mux4_2
X_12666_ _07047_ _07048_ net973 VSS VSS VDD VDD _07049_ sky130_fd_sc_hd__mux2i_1
X_12667_ u_core.u_top.bus_addr[4] _07046_ _07049_ _06583_ VSS VSS VDD VDD _07050_ sky130_fd_sc_hd__o2bb2ai_2
X_12669_ net805 net804 VSS VSS VDD VDD _07052_ sky130_fd_sc_hd__and2_1
X_12670_ net806 _07052_ VSS VSS VDD VDD _07053_ sky130_fd_sc_hd__nand2_1
X_12673_ u_core.u_top.u_core.acc[4] u_core.u_top.u_core.acc[24] u_core.u_top.u_core.acc[14] u_core.u_top.u_core.acc[34] u_core.u_top.bus_addr[1] u_core.u_top.bus_addr[0] VSS VSS VDD VDD _07056_ sky130_fd_sc_hd__mux4_2
X_12676_ u_core.u_top.u_core.acc[84] u_core.u_top.u_core.acc[104] u_core.u_top.u_core.acc[94] u_core.u_top.u_core.acc[114] net975 net977 VSS VSS VDD VDD _07059_ sky130_fd_sc_hd__mux4_2
X_12679_ u_core.u_top.u_core.acc[44] u_core.u_top.u_core.acc[54] net960 u_core.u_top.u_core.acc[74] net976 net974 VSS VSS VDD VDD _07062_ sky130_fd_sc_hd__mux4_2
X_12681_ u_core.u_top.u_core.acc[124] u_core.u_top.u_core.acc[134] u_core.u_top.u_core.acc[144] u_core.u_top.u_core.acc[154] net977 net974 VSS VSS VDD VDD _07064_ sky130_fd_sc_hd__mux4_2
X_12682_ _07056_ _07059_ _07062_ _07064_ u_core.u_top.bus_addr[3] net973 VSS VSS VDD VDD _07065_ sky130_fd_sc_hd__mux4_2
X_12685_ u_core.u_top.u_core.acc[164] u_core.u_top.u_core.acc[174] u_core.u_top.u_core.acc[184] u_core.u_top.u_core.acc[194] net977 u_core.u_top.bus_addr[1] VSS VSS VDD VDD _07068_ sky130_fd_sc_hd__mux4_2
X_12688_ u_core.u_top.u_core.acc[204] u_core.u_top.u_core.acc[224] u_core.u_top.u_core.acc[214] u_core.u_top.u_core.acc[234] net974 net976 VSS VSS VDD VDD _07071_ sky130_fd_sc_hd__mux4_2
X_12689_ _07068_ _07071_ net973 VSS VSS VDD VDD _07072_ sky130_fd_sc_hd__mux2_1
X_12690_ u_core.u_top.bus_addr[4] _07065_ _07072_ net888 VSS VSS VDD VDD _07073_ sky130_fd_sc_hd__a22o_2
X_12692_ u_core.u_top.u_core.acc[3] u_core.u_top.u_core.acc[23] u_core.u_top.u_core.acc[13] u_core.u_top.u_core.acc[33] net975 net977 VSS VSS VDD VDD _07075_ sky130_fd_sc_hd__mux4_2
X_12695_ u_core.u_top.u_core.acc[83] u_core.u_top.u_core.acc[103] u_core.u_top.u_core.acc[93] u_core.u_top.u_core.acc[113] net975 net977 VSS VSS VDD VDD _07078_ sky130_fd_sc_hd__mux4_2
X_12696_ u_core.u_top.u_core.acc[43] net961 u_core.u_top.u_core.acc[53] u_core.u_top.u_core.acc[73] net974 net976 VSS VSS VDD VDD _07079_ sky130_fd_sc_hd__mux4_2
X_12698_ u_core.u_top.u_core.acc[123] u_core.u_top.u_core.acc[133] u_core.u_top.u_core.acc[143] u_core.u_top.u_core.acc[153] net977 net974 VSS VSS VDD VDD _07081_ sky130_fd_sc_hd__mux4_2
X_12699_ _07075_ _07078_ _07079_ _07081_ u_core.u_top.bus_addr[3] net973 VSS VSS VDD VDD _07082_ sky130_fd_sc_hd__mux4_2
X_12700_ u_core.u_top.u_core.acc[163] u_core.u_top.u_core.acc[173] u_core.u_top.u_core.acc[183] u_core.u_top.u_core.acc[193] net977 u_core.u_top.bus_addr[1] VSS VSS VDD VDD _07083_ sky130_fd_sc_hd__mux4_2
X_12702_ u_core.u_top.u_core.acc[203] u_core.u_top.u_core.acc[223] u_core.u_top.u_core.acc[213] u_core.u_top.u_core.acc[233] net974 net976 VSS VSS VDD VDD _07085_ sky130_fd_sc_hd__mux4_2
X_12703_ _07083_ _07085_ net973 VSS VSS VDD VDD _07086_ sky130_fd_sc_hd__mux2_1
X_12704_ u_core.u_top.bus_addr[4] _07082_ _07086_ net888 VSS VSS VDD VDD _07087_ sky130_fd_sc_hd__a22o_1
X_12706_ _07073_ net802 VSS VSS VDD VDD _07089_ sky130_fd_sc_hd__nor2_1
X_12712_ u_core.u_top.u_core.acc[7] u_core.u_top.u_core.acc[27] u_core.u_top.u_core.acc[17] u_core.u_top.u_core.acc[37] net974 net977 VSS VSS VDD VDD _07095_ sky130_fd_sc_hd__mux4_2
X_12717_ u_core.u_top.u_core.acc[87] u_core.u_top.u_core.acc[97] u_core.u_top.u_core.acc[107] u_core.u_top.u_core.acc[117] net977 net975 VSS VSS VDD VDD _07100_ sky130_fd_sc_hd__mux4_2
X_12721_ u_core.u_top.u_core.acc[47] net959 u_core.u_top.u_core.acc[57] u_core.u_top.u_core.acc[77] net974 net976 VSS VSS VDD VDD _07104_ sky130_fd_sc_hd__mux4_2
X_12726_ u_core.u_top.u_core.acc[127] u_core.u_top.u_core.acc[137] u_core.u_top.u_core.acc[147] u_core.u_top.u_core.acc[157] net977 net974 VSS VSS VDD VDD _07109_ sky130_fd_sc_hd__mux4_2
X_12727_ _07095_ _07100_ _07104_ _07109_ u_core.u_top.bus_addr[3] net973 VSS VSS VDD VDD _07110_ sky130_fd_sc_hd__mux4_2
X_12732_ u_core.u_top.u_core.acc[167] u_core.u_top.u_core.acc[177] u_core.u_top.u_core.acc[187] u_core.u_top.u_core.acc[197] net977 u_core.u_top.bus_addr[1] VSS VSS VDD VDD _07115_ sky130_fd_sc_hd__mux4_2
X_12737_ u_core.u_top.u_core.acc[207] u_core.u_top.u_core.acc[227] u_core.u_top.u_core.acc[217] u_core.u_top.u_core.acc[237] net974 net976 VSS VSS VDD VDD _07120_ sky130_fd_sc_hd__mux4_2
X_12738_ _07115_ _07120_ net973 VSS VSS VDD VDD _07121_ sky130_fd_sc_hd__mux2i_1
X_12739_ _06583_ _07121_ VSS VSS VDD VDD _07122_ sky130_fd_sc_hd__nor2_1
X_12740_ u_core.u_top.bus_addr[4] _07110_ _07122_ VSS VSS VDD VDD _07123_ sky130_fd_sc_hd__a21oi_4
X_12742_ _07002_ _07053_ net769 net768 VSS VSS VDD VDD _07125_ sky130_fd_sc_hd__a31oi_1
X_12743_ u_core.u_top.bus_addr[4] _07021_ _07031_ net888 VSS VSS VDD VDD _07126_ sky130_fd_sc_hd__a22oi_2
X_12745_ u_core.u_top.bus_addr[4] _07082_ _07086_ net888 VSS VSS VDD VDD _07128_ sky130_fd_sc_hd__a22oi_4
X_12748_ net801 net800 VSS VSS VDD VDD _07131_ sky130_fd_sc_hd__nor2_1
X_12749_ net805 net804 VSS VSS VDD VDD _07132_ sky130_fd_sc_hd__or2_2
X_12752_ _07131_ _07132_ net803 VSS VSS VDD VDD _07135_ sky130_fd_sc_hd__a21oi_1
X_12753_ _06583_ _06979_ _06997_ VSS VSS VDD VDD _07136_ sky130_fd_sc_hd__o21a_1
X_12756_ net771 net767 VSS VSS VDD VDD _07139_ sky130_fd_sc_hd__nor2_1
X_12757_ _07135_ _07139_ VSS VSS VDD VDD _07140_ sky130_fd_sc_hd__nand2b_1
X_12758_ net768 _07140_ VSS VSS VDD VDD _07141_ sky130_fd_sc_hd__and2_1
X_12760_ u_core.u_top.u_core.acc[9] u_core.u_top.u_core.acc[19] u_core.u_top.u_core.acc[29] u_core.u_top.u_core.acc[39] net977 net974 VSS VSS VDD VDD _07143_ sky130_fd_sc_hd__mux4_2
X_12762_ u_core.u_top.u_core.acc[89] u_core.u_top.u_core.acc[99] u_core.u_top.u_core.acc[109] u_core.u_top.u_core.acc[119] net977 net975 VSS VSS VDD VDD _07145_ sky130_fd_sc_hd__mux4_2
X_12763_ u_core.u_top.u_core.acc[49] u_core.u_top.u_core.acc[59] u_core.u_top.u_core.acc[69] u_core.u_top.u_core.acc[79] net976 net974 VSS VSS VDD VDD _07146_ sky130_fd_sc_hd__mux4_2
X_12766_ u_core.u_top.u_core.acc[129] u_core.u_top.u_core.acc[149] u_core.u_top.u_core.acc[139] u_core.u_top.u_core.acc[159] net974 net977 VSS VSS VDD VDD _07149_ sky130_fd_sc_hd__mux4_2
X_12767_ _07143_ _07145_ _07146_ _07149_ u_core.u_top.bus_addr[3] net973 VSS VSS VDD VDD _07150_ sky130_fd_sc_hd__mux4_2
X_12770_ u_core.u_top.u_core.acc[169] u_core.u_top.u_core.acc[179] u_core.u_top.u_core.acc[189] u_core.u_top.u_core.acc[199] net977 u_core.u_top.bus_addr[1] VSS VSS VDD VDD _07153_ sky130_fd_sc_hd__mux4_2
X_12773_ u_core.u_top.u_core.acc[209] u_core.u_top.u_core.acc[219] u_core.u_top.u_core.acc[229] u_core.u_top.u_core.acc[239] net976 net974 VSS VSS VDD VDD _07156_ sky130_fd_sc_hd__mux4_2
X_12774_ _07153_ _07156_ net973 VSS VSS VDD VDD _07157_ sky130_fd_sc_hd__mux2i_1
X_12775_ _06583_ _07157_ VSS VSS VDD VDD _07158_ sky130_fd_sc_hd__nor2_1
X_12776_ u_core.u_top.bus_addr[4] _07150_ _07158_ VSS VSS VDD VDD _07159_ sky130_fd_sc_hd__a21oi_2
X_12777_ _07125_ _07141_ net766 VSS VSS VDD VDD _07160_ sky130_fd_sc_hd__mux2i_1
X_12781_ u_core.u_top.bus_addr[4] _07065_ _07072_ net888 VSS VSS VDD VDD _07164_ sky130_fd_sc_hd__a22oi_4
X_12784_ net801 net800 net799 VSS VSS VDD VDD _07167_ sky130_fd_sc_hd__a21oi_1
X_12785_ net772 net768 VSS VSS VDD VDD _07168_ sky130_fd_sc_hd__nor2_1
X_12786_ net738 net770 _07167_ _07168_ VSS VSS VDD VDD _07169_ sky130_fd_sc_hd__o31ai_1
X_12787_ net766 _07169_ VSS VSS VDD VDD _07170_ sky130_fd_sc_hd__nor2_1
X_12788_ net772 _07160_ _07170_ VSS VSS VDD VDD _07171_ sky130_fd_sc_hd__a21oi_1
X_12789_ u_core.u_top.bus_addr[5] _06580_ VSS VSS VDD VDD _07172_ sky130_fd_sc_hd__nand2_1
X_12790_ _06595_ _07172_ VSS VSS VDD VDD _07173_ sky130_fd_sc_hd__nor2_1
X_12793_ u_core.u_top.u_core.r_pdata[11] net814 net798 u_core.u_top.u_core.r_prow[11] net811 VSS VSS VDD VDD _07176_ sky130_fd_sc_hd__a221oi_1
X_12794_ _06918_ _07171_ _07176_ VSS VSS VDD VDD _07177_ sky130_fd_sc_hd__o21ai_0
X_12796_ u_core.u_top.u_core.r_x[59] net818 VSS VSS VDD VDD _07178_ sky130_fd_sc_hd__nand2_1
X_12797_ u_core.u_top.u_core.r_x[11] net872 VSS VSS VDD VDD _07179_ sky130_fd_sc_hd__nand2_1
X_12798_ net810 _07178_ _07179_ VSS VSS VDD VDD _07180_ sky130_fd_sc_hd__nand3_1
X_12799_ u_core.u_top.u_core.r_x[107] net810 _07180_ VSS VSS VDD VDD _07181_ sky130_fd_sc_hd__o21ai_0
X_12800_ net811 _07181_ net749 VSS VSS VDD VDD _07182_ sky130_fd_sc_hd__a21oi_1
X_12801_ _06578_ u_core.u_top.u_spi.shift_out[11] u_core.u_top.u_core.r_tile[11] _06915_ _07177_ _07182_ VSS VSS VDD VDD _07183_ sky130_fd_sc_hd__a222oi_1
X_12802_ u_core.u_top.u_spi.shift_out[10] net816 VSS VSS VDD VDD _07184_ sky130_fd_sc_hd__nor2_1
X_12803_ net816 _07183_ _07184_ VSS VSS VDD VDD _2236_[11] sky130_fd_sc_hd__a21oi_1
X_12804_ u_core.u_top.u_core.r_x[58] net818 VSS VSS VDD VDD _07185_ sky130_fd_sc_hd__nand2_1
X_12805_ net939 net870 VSS VSS VDD VDD _07186_ sky130_fd_sc_hd__nand2_1
X_12806_ net810 _07185_ _07186_ VSS VSS VDD VDD _07187_ sky130_fd_sc_hd__nand3_1
X_12807_ net941 net810 _07187_ net811 VSS VSS VDD VDD _07188_ sky130_fd_sc_hd__o211ai_1
X_12808_ u_core.u_top.bus_addr[0] _06589_ VSS VSS VDD VDD _07189_ sky130_fd_sc_hd__nor2_1
X_12809_ u_core.u_top.u_core.r_tile[10] net765 VSS VSS VDD VDD _07190_ sky130_fd_sc_hd__nand2_1
X_12811_ u_core.u_top.u_core.r_pdata[10] net813 net812 u_core.u_top.u_core.m_fail[5] net798 net954 VSS VSS VDD VDD _07192_ sky130_fd_sc_hd__a222oi_1
X_12812_ _07188_ _07190_ _07192_ VSS VSS VDD VDD _07193_ sky130_fd_sc_hd__nand3_1
X_12818_ net806 net805 VSS VSS VDD VDD _07199_ sky130_fd_sc_hd__nor2_1
X_12819_ _07073_ net802 VSS VSS VDD VDD _07200_ sky130_fd_sc_hd__nand2_1
X_12821_ net771 net767 _07199_ _07200_ VSS VSS VDD VDD _07202_ sky130_fd_sc_hd__nor4_1
X_12822_ net772 _07123_ VSS VSS VDD VDD _07203_ sky130_fd_sc_hd__nand2b_1
X_12823_ _07202_ _07203_ VSS VSS VDD VDD _07204_ sky130_fd_sc_hd__nor2_1
X_12824_ net766 VSS VSS VDD VDD _07205_ sky130_fd_sc_hd__inv_1
X_12826_ _07205_ net772 VSS VSS VDD VDD _07207_ sky130_fd_sc_hd__and2_1
X_12827_ net766 _07204_ _07207_ _07125_ _06918_ VSS VSS VDD VDD _07208_ sky130_fd_sc_hd__a221oi_1
X_12828_ _07193_ _07208_ _06588_ VSS VSS VDD VDD _07209_ sky130_fd_sc_hd__o21ai_0
X_12829_ _06578_ u_core.u_top.u_spi.shift_out[10] VSS VSS VDD VDD _07210_ sky130_fd_sc_hd__nand2_1
X_12830_ u_core.u_top.u_spi.shift_out[9] net816 VSS VSS VDD VDD _07211_ sky130_fd_sc_hd__nor2_1
X_12831_ net816 _07209_ _07210_ _07211_ VSS VSS VDD VDD _2236_[10] sky130_fd_sc_hd__a31oi_1
X_12832_ u_core.u_top.bus_word _06917_ VSS VSS VDD VDD _07212_ sky130_fd_sc_hd__nor2_1
X_12837_ net767 _07200_ net771 VSS VSS VDD VDD _07217_ sky130_fd_sc_hd__a21oi_1
X_12838_ _07217_ VSS VSS VDD VDD _07218_ sky130_fd_sc_hd__inv_1
X_12841_ net806 _07132_ VSS VSS VDD VDD _07221_ sky130_fd_sc_hd__nand2_1
X_12842_ net769 _07221_ net767 VSS VSS VDD VDD _07222_ sky130_fd_sc_hd__a21oi_1
X_12843_ net738 _07222_ _07169_ VSS VSS VDD VDD _07223_ sky130_fd_sc_hd__a21oi_1
X_12844_ net772 _07125_ _07218_ _07223_ VSS VSS VDD VDD _07224_ sky130_fd_sc_hd__a31oi_1
X_12845_ net767 net799 VSS VSS VDD VDD _07225_ sky130_fd_sc_hd__nor2_1
X_12846_ net806 net805 VSS VSS VDD VDD _07226_ sky130_fd_sc_hd__nand2_1
X_12847_ net800 _07226_ VSS VSS VDD VDD _07227_ sky130_fd_sc_hd__nor2_1
X_12848_ _07225_ _07227_ VSS VSS VDD VDD _07228_ sky130_fd_sc_hd__nand2_1
X_12850_ net771 _07228_ net768 VSS VSS VDD VDD _07230_ sky130_fd_sc_hd__a21oi_1
X_12851_ _07141_ _07230_ net772 VSS VSS VDD VDD _07231_ sky130_fd_sc_hd__o21ai_0
X_12854_ net805 net804 VSS VSS VDD VDD _07234_ sky130_fd_sc_hd__nand2_1
X_12855_ net801 _07234_ VSS VSS VDD VDD _07235_ sky130_fd_sc_hd__nand2_1
X_12856_ _07136_ _07164_ VSS VSS VDD VDD _07236_ sky130_fd_sc_hd__nand2_1
X_12857_ net802 _07235_ _07236_ VSS VSS VDD VDD _07237_ sky130_fd_sc_hd__a21o_1
X_12859_ net768 net771 VSS VSS VDD VDD _07239_ sky130_fd_sc_hd__nor2_1
X_12860_ _07237_ _07239_ VSS VSS VDD VDD _07240_ sky130_fd_sc_hd__nand2_1
X_12861_ _07204_ _07231_ _07240_ net766 VSS VSS VDD VDD _07241_ sky130_fd_sc_hd__nand4b_1
X_12862_ net766 _07224_ _07241_ VSS VSS VDD VDD _07242_ sky130_fd_sc_hd__o21ai_0
X_12863_ net797 _07242_ VSS VSS VDD VDD _07243_ sky130_fd_sc_hd__nand2_1
X_12864_ u_core.u_top.u_core.r_x[57] net819 VSS VSS VDD VDD _07244_ sky130_fd_sc_hd__nand2_1
X_12865_ u_core.u_top.u_core.r_x[9] net870 VSS VSS VDD VDD _07245_ sky130_fd_sc_hd__nand2_1
X_12866_ u_core.u_top.u_core.r_x[105] net810 VSS VSS VDD VDD _07246_ sky130_fd_sc_hd__nor2_1
X_12867_ net810 _07244_ _07245_ _07246_ VSS VSS VDD VDD _07247_ sky130_fd_sc_hd__a31oi_1
X_12868_ u_core.u_top.u_core.r_pdata[9] net813 _07247_ net811 net798 net946 VSS VSS VDD VDD _07248_ sky130_fd_sc_hd__a222oi_1
X_12869_ _07243_ _07248_ net749 VSS VSS VDD VDD _07249_ sky130_fd_sc_hd__a21oi_1
X_12870_ _06578_ u_core.u_top.u_spi.shift_out[9] u_core.u_top.u_core.r_tile[9] _06915_ _07249_ VSS VSS VDD VDD _07250_ sky130_fd_sc_hd__a221oi_1
X_12871_ u_core.u_top.u_spi.shift_out[8] net816 VSS VSS VDD VDD _07251_ sky130_fd_sc_hd__nor2_1
X_12872_ net816 _07250_ _07251_ VSS VSS VDD VDD _2236_[9] sky130_fd_sc_hd__a21oi_1
X_12873_ u_core.u_top.bus_addr[3] u_core.u_top.bus_addr[5] _06594_ _06580_ VSS VSS VDD VDD _07252_ sky130_fd_sc_hd__nand4_1
X_12875_ net772 _07222_ _07217_ VSS VSS VDD VDD _07254_ sky130_fd_sc_hd__o21ai_0
X_12876_ net806 _07052_ VSS VSS VDD VDD _07255_ sky130_fd_sc_hd__nor2_1
X_12877_ net767 net769 net737 VSS VSS VDD VDD _07256_ sky130_fd_sc_hd__nand3_1
X_12878_ net738 _07256_ net772 VSS VSS VDD VDD _07257_ sky130_fd_sc_hd__a21oi_1
X_12881_ net800 _07226_ net799 VSS VSS VDD VDD _07260_ sky130_fd_sc_hd__a21oi_1
X_12882_ net770 _07260_ net738 VSS VSS VDD VDD _07261_ sky130_fd_sc_hd__a21oi_1
X_12883_ _07257_ _07261_ net768 VSS VSS VDD VDD _07262_ sky130_fd_sc_hd__o21ai_0
X_12884_ net768 _07254_ _07262_ VSS VSS VDD VDD _07263_ sky130_fd_sc_hd__o21ai_0
X_12885_ net801 _07200_ net768 _07002_ VSS VSS VDD VDD _07264_ sky130_fd_sc_hd__o211ai_1
X_12886_ net772 _07264_ VSS VSS VDD VDD _07265_ sky130_fd_sc_hd__nand2_1
X_12888_ net805 net804 VSS VSS VDD VDD _07267_ sky130_fd_sc_hd__nor2_1
X_12889_ net801 net764 net800 VSS VSS VDD VDD _07268_ sky130_fd_sc_hd__a21oi_1
X_12890_ _07073_ _07268_ VSS VSS VDD VDD _07269_ sky130_fd_sc_hd__nor2_1
X_12891_ net767 _07269_ VSS VSS VDD VDD _07270_ sky130_fd_sc_hd__nor2_1
X_12892_ net768 net771 VSS VSS VDD VDD _07271_ sky130_fd_sc_hd__nand2_1
X_12893_ _07270_ _07271_ _07240_ VSS VSS VDD VDD _07272_ sky130_fd_sc_hd__o21ai_0
X_12894_ _07230_ _07265_ _07272_ net772 VSS VSS VDD VDD _07273_ sky130_fd_sc_hd__o22ai_1
X_12895_ net766 _07273_ VSS VSS VDD VDD _07274_ sky130_fd_sc_hd__nand2_1
X_12896_ net766 _07263_ _07274_ VSS VSS VDD VDD _07275_ sky130_fd_sc_hd__o21ai_0
X_12898_ u_core.u_top.bus_addr[0] VSS VSS VDD VDD _07277_ sky130_fd_sc_hd__inv_1
X_12899_ u_core.u_top.bus_addr[5] _06580_ _06600_ VSS VSS VDD VDD _07278_ sky130_fd_sc_hd__nand3_1
X_12900_ net958 _07277_ u_core.u_top.bus_addr[1] _07278_ VSS VSS VDD VDD _07279_ sky130_fd_sc_hd__or4_1
X_12903_ u_core.u_top.u_core.r_piter[3] VSS VSS VDD VDD _07282_ sky130_fd_sc_hd__inv_1
X_12907_ _0969_[1070] u_core.u_top.u_core.r_piter[2] u_core.u_top.u_core.r_piter[0] VSS VSS VDD VDD _07286_ sky130_fd_sc_hd__nor3_1
X_12908_ _07282_ _07286_ VSS VSS VDD VDD _07287_ sky130_fd_sc_hd__nor2_1
X_12910_ u_core.u_top.u_core.r_piter[4] _07287_ u_core.u_top.u_core.r_piter[5] VSS VSS VDD VDD _07289_ sky130_fd_sc_hd__o21ai_1
X_12911_ net796 _07289_ VSS VSS VDD VDD _07290_ sky130_fd_sc_hd__or2_2
X_12912_ u_core.u_top.u_core.r_pdata[8] net813 net812 u_core.u_top.u_core.m_fail[4] net797 VSS VSS VDD VDD _07291_ sky130_fd_sc_hd__a221oi_1
X_12913_ _07252_ _07290_ _07291_ VSS VSS VDD VDD _07292_ sky130_fd_sc_hd__nand3_1
X_12914_ net947 _07252_ _06918_ _07275_ _07292_ VSS VSS VDD VDD _07293_ sky130_fd_sc_hd__o221ai_1
X_12915_ net912 net817 VSS VSS VDD VDD _07294_ sky130_fd_sc_hd__nand2_1
X_12916_ net902 _06204_ VSS VSS VDD VDD _07295_ sky130_fd_sc_hd__nand2_1
X_12917_ net942 net808 VSS VSS VDD VDD _07296_ sky130_fd_sc_hd__nor2_1
X_12918_ net808 _07294_ _07295_ _07296_ net807 VSS VSS VDD VDD _07297_ sky130_fd_sc_hd__a311oi_1
X_12919_ u_core.u_top.u_core.r_tile[8] net765 _07297_ VSS VSS VDD VDD _07298_ sky130_fd_sc_hd__a21oi_1
X_12920_ _07293_ _07298_ _06914_ VSS VSS VDD VDD _07299_ sky130_fd_sc_hd__a21oi_1
X_12921_ _06578_ u_core.u_top.u_spi.shift_out[8] _07299_ VSS VSS VDD VDD _07300_ sky130_fd_sc_hd__a21oi_1
X_12922_ u_core.u_top.u_spi.shift_out[7] net816 VSS VSS VDD VDD _07301_ sky130_fd_sc_hd__nor2_1
X_12923_ net816 _07300_ _07301_ VSS VSS VDD VDD _2236_[8] sky130_fd_sc_hd__a21oi_1
X_12924_ u_core.u_top.u_core.r_x[55] net817 VSS VSS VDD VDD _07302_ sky130_fd_sc_hd__nand2_1
X_12925_ u_core.u_top.u_core.r_x[7] _06204_ VSS VSS VDD VDD _07303_ sky130_fd_sc_hd__nand2_1
X_12926_ net808 _07302_ _07303_ VSS VSS VDD VDD _07304_ sky130_fd_sc_hd__nand3_1
X_12927_ u_core.u_top.u_core.r_x[103] net808 _07304_ VSS VSS VDD VDD _07305_ sky130_fd_sc_hd__o21ai_0
X_12928_ u_core.u_top.u_core.r_tile[7] net765 net798 net948 u_core.u_top.u_core.r_pdata[7] net813 VSS VSS VDD VDD _07306_ sky130_fd_sc_hd__a222oi_1
X_12931_ net771 _07270_ VSS VSS VDD VDD _07309_ sky130_fd_sc_hd__nand2_1
X_12932_ net771 net770 VSS VSS VDD VDD _07310_ sky130_fd_sc_hd__nor2_1
X_12933_ net801 net769 _07310_ _07202_ VSS VSS VDD VDD _07311_ sky130_fd_sc_hd__a31oi_1
X_12934_ net800 _07221_ VSS VSS VDD VDD _07312_ sky130_fd_sc_hd__nand2_1
X_12935_ _07073_ _07312_ net770 VSS VSS VDD VDD _07313_ sky130_fd_sc_hd__a21oi_1
X_12936_ _07226_ net769 net767 VSS VSS VDD VDD _07314_ sky130_fd_sc_hd__a21oi_1
X_12937_ net771 _07314_ VSS VSS VDD VDD _07315_ sky130_fd_sc_hd__nor2_1
X_12938_ net771 _07313_ _07315_ _07237_ net768 VSS VSS VDD VDD _07316_ sky130_fd_sc_hd__a221oi_1
X_12939_ net768 _07309_ _07311_ _07316_ net772 VSS VSS VDD VDD _07317_ sky130_fd_sc_hd__a311oi_1
X_12940_ _07164_ net800 VSS VSS VDD VDD _07318_ sky130_fd_sc_hd__nand2_1
X_12941_ net771 _07318_ _07268_ _07073_ VSS VSS VDD VDD _07319_ sky130_fd_sc_hd__a22o_1
X_12942_ net771 _07227_ VSS VSS VDD VDD _07320_ sky130_fd_sc_hd__nand2_1
X_12944_ net770 _07073_ VSS VSS VDD VDD _07322_ sky130_fd_sc_hd__nand2_1
X_12945_ net770 _07319_ _07320_ _07322_ VSS VSS VDD VDD _07323_ sky130_fd_sc_hd__o22ai_1
X_12946_ net800 _07053_ VSS VSS VDD VDD _07324_ sky130_fd_sc_hd__nand2_1
X_12947_ _07073_ _07324_ net767 VSS VSS VDD VDD _07325_ sky130_fd_sc_hd__a21oi_1
X_12949_ net806 net802 VSS VSS VDD VDD _07327_ sky130_fd_sc_hd__nand2_1
X_12950_ net767 net803 VSS VSS VDD VDD _07328_ sky130_fd_sc_hd__nand2_1
X_12951_ _07327_ _07328_ VSS VSS VDD VDD _07329_ sky130_fd_sc_hd__nor2_1
X_12952_ _07325_ _07329_ net771 VSS VSS VDD VDD _07330_ sky130_fd_sc_hd__o21ai_0
X_12953_ net768 _07140_ _07330_ VSS VSS VDD VDD _07331_ sky130_fd_sc_hd__nand3_1
X_12954_ net768 _07323_ _07331_ net772 VSS VSS VDD VDD _07332_ sky130_fd_sc_hd__o211a_1
X_12955_ net800 net737 _07322_ VSS VSS VDD VDD _07333_ sky130_fd_sc_hd__a21oi_1
X_12956_ net767 _07200_ _07333_ VSS VSS VDD VDD _07334_ sky130_fd_sc_hd__a21oi_1
X_12957_ net806 net805 VSS VSS VDD VDD _07335_ sky130_fd_sc_hd__or2_2
X_12959_ net801 _07234_ VSS VSS VDD VDD _07337_ sky130_fd_sc_hd__nor2_1
X_12960_ _07337_ _07318_ net767 VSS VSS VDD VDD _07338_ sky130_fd_sc_hd__o21ai_0
X_12961_ net767 _07318_ _07335_ _07338_ net771 VSS VSS VDD VDD _07339_ sky130_fd_sc_hd__o311ai_0
X_12962_ net771 _07334_ _07339_ VSS VSS VDD VDD _07340_ sky130_fd_sc_hd__o21ai_0
X_12963_ net738 _07136_ VSS VSS VDD VDD _07341_ sky130_fd_sc_hd__nor2_1
X_12965_ net806 net802 _07132_ net803 VSS VSS VDD VDD _07343_ sky130_fd_sc_hd__o31ai_1
X_12966_ _07260_ _07341_ _07310_ _07343_ VSS VSS VDD VDD _07344_ sky130_fd_sc_hd__a22oi_1
X_12967_ _07340_ _07344_ net768 VSS VSS VDD VDD _07345_ sky130_fd_sc_hd__mux2i_1
X_12968_ net772 _07345_ VSS VSS VDD VDD _07346_ sky130_fd_sc_hd__nand2_1
X_12969_ net738 _07222_ VSS VSS VDD VDD _07347_ sky130_fd_sc_hd__nand2_1
X_12970_ net802 _07337_ _07073_ VSS VSS VDD VDD _07348_ sky130_fd_sc_hd__a21oi_1
X_12971_ net767 _07348_ net771 VSS VSS VDD VDD _07349_ sky130_fd_sc_hd__o21ai_0
X_12972_ _07347_ _07349_ _07169_ VSS VSS VDD VDD _07350_ sky130_fd_sc_hd__a21oi_1
X_12974_ net738 net800 VSS VSS VDD VDD _07352_ sky130_fd_sc_hd__nand2_1
X_12975_ _07235_ _07352_ VSS VSS VDD VDD _07353_ sky130_fd_sc_hd__nor2_1
X_12976_ net738 _07135_ _07200_ _07226_ net767 VSS VSS VDD VDD _07354_ sky130_fd_sc_hd__o221ai_1
X_12977_ net799 _07353_ _07354_ _07203_ VSS VSS VDD VDD _07355_ sky130_fd_sc_hd__a211oi_1
X_12978_ net766 _07350_ _07355_ VSS VSS VDD VDD _07356_ sky130_fd_sc_hd__nor3_1
X_12979_ _07346_ _07356_ _06918_ VSS VSS VDD VDD _07357_ sky130_fd_sc_hd__a21oi_1
X_12980_ _07205_ _07317_ _07332_ _07357_ VSS VSS VDD VDD _07358_ sky130_fd_sc_hd__o31ai_1
X_12981_ net807 _07305_ _07306_ _07290_ net650 VSS VSS VDD VDD _07359_ sky130_fd_sc_hd__o2111ai_1
X_12982_ _06578_ u_core.u_top.u_spi.shift_out[7] _06588_ _07359_ VSS VSS VDD VDD _07360_ sky130_fd_sc_hd__a22oi_1
X_12983_ u_core.u_top.u_spi.shift_out[6] net816 VSS VSS VDD VDD _07361_ sky130_fd_sc_hd__nor2_1
X_12984_ net816 _07360_ _07361_ VSS VSS VDD VDD _2236_[7] sky130_fd_sc_hd__a21oi_1
X_12985_ u_core.u_top.u_spi.shift_out[5] VSS VSS VDD VDD _07362_ sky130_fd_sc_hd__inv_1
X_12986_ u_core.u_top.u_core.r_x[54] net817 VSS VSS VDD VDD _07363_ sky130_fd_sc_hd__nand2_1
X_12988_ net908 net870 VSS VSS VDD VDD _07365_ sky130_fd_sc_hd__nand2_1
X_12989_ net808 _07363_ _07365_ VSS VSS VDD VDD _07366_ sky130_fd_sc_hd__nand3_1
X_12990_ net943 net808 _07366_ VSS VSS VDD VDD _07367_ sky130_fd_sc_hd__o21ai_0
X_12991_ _06606_ _07367_ VSS VSS VDD VDD _07368_ sky130_fd_sc_hd__nand2_1
X_12992_ net802 _07335_ _07236_ VSS VSS VDD VDD _07369_ sky130_fd_sc_hd__a21oi_1
X_12993_ net771 _07369_ _07349_ VSS VSS VDD VDD _07370_ sky130_fd_sc_hd__o21ai_0
X_12994_ net770 _07319_ VSS VSS VDD VDD _07371_ sky130_fd_sc_hd__nand2_1
X_12995_ net768 _07354_ _07371_ net772 VSS VSS VDD VDD _07372_ sky130_fd_sc_hd__a31oi_1
X_12996_ net768 _07370_ _07372_ VSS VSS VDD VDD _07373_ sky130_fd_sc_hd__o21ai_0
X_12997_ _07205_ _07373_ VSS VSS VDD VDD _07374_ sky130_fd_sc_hd__nand2_1
X_12998_ net802 _07337_ net771 VSS VSS VDD VDD _07375_ sky130_fd_sc_hd__a21oi_1
X_12999_ net799 _07375_ VSS VSS VDD VDD _07376_ sky130_fd_sc_hd__nor2_1
X_13000_ net801 net800 VSS VSS VDD VDD _07377_ sky130_fd_sc_hd__nand2_1
X_13001_ net771 _07073_ _07377_ _07320_ net767 VSS VSS VDD VDD _07378_ sky130_fd_sc_hd__o311ai_0
X_13002_ net772 net768 VSS VSS VDD VDD _07379_ sky130_fd_sc_hd__nor2b_1
X_13003_ _07376_ _07378_ _07379_ VSS VSS VDD VDD _07380_ sky130_fd_sc_hd__o21ai_0
X_13004_ _07073_ _07312_ VSS VSS VDD VDD _07381_ sky130_fd_sc_hd__nand2_1
X_13005_ net771 _07225_ _07381_ net767 _07315_ VSS VSS VDD VDD _07382_ sky130_fd_sc_hd__a221o_1
X_13006_ _07168_ _07382_ _07205_ VSS VSS VDD VDD _07383_ sky130_fd_sc_hd__a21oi_1
X_13007_ _07380_ _07383_ VSS VSS VDD VDD _07384_ sky130_fd_sc_hd__nand2_1
X_13008_ _07374_ _07384_ net772 VSS VSS VDD VDD _07385_ sky130_fd_sc_hd__a21oi_1
X_13009_ _07377_ net805 net771 VSS VSS VDD VDD _07386_ sky130_fd_sc_hd__o21ai_0
X_13010_ net803 net806 VSS VSS VDD VDD _07387_ sky130_fd_sc_hd__nand2_1
X_13011_ net738 net800 net764 _07387_ VSS VSS VDD VDD _07388_ sky130_fd_sc_hd__nor4_1
X_13012_ net799 _07386_ _07388_ _07353_ net767 VSS VSS VDD VDD _07389_ sky130_fd_sc_hd__a2111oi_0
X_13013_ _07200_ net737 net767 VSS VSS VDD VDD _07390_ sky130_fd_sc_hd__o21ai_0
X_13014_ net770 _07164_ VSS VSS VDD VDD _07391_ sky130_fd_sc_hd__nand2_1
X_13015_ net770 _07343_ _07391_ _07131_ net738 VSS VSS VDD VDD _07392_ sky130_fd_sc_hd__o221a_2
X_13016_ net771 _07390_ _07392_ VSS VSS VDD VDD _07393_ sky130_fd_sc_hd__a21oi_1
X_13017_ _07389_ _07393_ net768 VSS VSS VDD VDD _07394_ sky130_fd_sc_hd__mux2i_1
X_13018_ net801 _07267_ VSS VSS VDD VDD _07395_ sky130_fd_sc_hd__nand2_1
X_13019_ net770 _07318_ _07395_ VSS VSS VDD VDD _07396_ sky130_fd_sc_hd__nor3_1
X_13020_ _07225_ _07324_ _07396_ VSS VSS VDD VDD _07397_ sky130_fd_sc_hd__a21oi_1
X_13021_ _07377_ net805 VSS VSS VDD VDD _07398_ sky130_fd_sc_hd__nor2_1
X_13022_ net799 _07398_ VSS VSS VDD VDD _07399_ sky130_fd_sc_hd__nor2_1
X_13023_ net738 net767 VSS VSS VDD VDD _07400_ sky130_fd_sc_hd__nand2_1
X_13024_ net738 _07397_ _07399_ _07400_ VSS VSS VDD VDD _07401_ sky130_fd_sc_hd__o22ai_1
X_13025_ net767 _07318_ VSS VSS VDD VDD _07402_ sky130_fd_sc_hd__nand2_1
X_13026_ net770 net769 net737 VSS VSS VDD VDD _07403_ sky130_fd_sc_hd__nand3_1
X_13027_ net767 _07167_ VSS VSS VDD VDD _07404_ sky130_fd_sc_hd__nor2_1
X_13028_ net767 _07073_ _07268_ _07404_ net771 VSS VSS VDD VDD _07405_ sky130_fd_sc_hd__a311oi_1
X_13029_ net771 _07402_ _07403_ _07405_ net768 VSS VSS VDD VDD _07406_ sky130_fd_sc_hd__a311oi_1
X_13030_ net768 _07401_ _07406_ VSS VSS VDD VDD _07407_ sky130_fd_sc_hd__a21oi_1
X_13031_ _07374_ _07394_ _07407_ _07384_ net797 VSS VSS VDD VDD _07408_ sky130_fd_sc_hd__o221ai_1
X_13037_ u_core.u_top.u_core.r_piter[3] _0969_[1070] u_core.u_top.u_core.r_piter[2] u_core.u_top.u_core.r_piter[4] u_core.u_top.u_core.r_piter[5] VSS VSS VDD VDD _07414_ sky130_fd_sc_hd__a311oi_2
X_13038_ u_core.u_top.u_core.m_fail[3] net812 net798 net949 _06606_ VSS VSS VDD VDD _07415_ sky130_fd_sc_hd__a221oi_1
X_13039_ net796 _07414_ _07415_ VSS VSS VDD VDD _07416_ sky130_fd_sc_hd__o21ai_0
X_13040_ u_core.u_top.u_core.r_pdata[6] _06596_ _07416_ VSS VSS VDD VDD _07417_ sky130_fd_sc_hd__a21oi_1
X_13041_ _07385_ _07408_ _07417_ VSS VSS VDD VDD _07418_ sky130_fd_sc_hd__o21ai_0
X_13042_ u_core.u_top.u_core.s_sat net958 u_core.u_top.bus_addr[1] VSS VSS VDD VDD _07419_ sky130_fd_sc_hd__mux2i_1
X_13043_ u_core.u_top.bus_addr[0] u_core.u_top.bus_addr[1] VSS VSS VDD VDD _07420_ sky130_fd_sc_hd__nor2b_1
X_13044_ u_core.u_top.u_core.r_tile[6] _07420_ VSS VSS VDD VDD _07421_ sky130_fd_sc_hd__nand2_1
X_13045_ _07277_ _07419_ _07421_ VSS VSS VDD VDD _07422_ sky130_fd_sc_hd__o21ai_0
X_13046_ _07368_ _07418_ _07422_ net866 _06578_ VSS VSS VDD VDD _07423_ sky130_fd_sc_hd__a221oi_1
X_13047_ net996 u_core.u_top.u_spi.shift_out[6] net816 VSS VSS VDD VDD _07424_ sky130_fd_sc_hd__o21ai_0
X_13048_ _07362_ net816 _07423_ _07424_ VSS VSS VDD VDD _2236_[6] sky130_fd_sc_hd__o22ai_1
X_13049_ net803 net800 VSS VSS VDD VDD _07425_ sky130_fd_sc_hd__nand2_1
X_13050_ _07164_ net802 VSS VSS VDD VDD _07426_ sky130_fd_sc_hd__nand2_1
X_13051_ _07395_ _07425_ _07426_ VSS VSS VDD VDD _07427_ sky130_fd_sc_hd__o21ai_0
X_13052_ net801 net802 VSS VSS VDD VDD _07428_ sky130_fd_sc_hd__nand2_1
X_13053_ net803 _07227_ _07235_ net769 VSS VSS VDD VDD _07429_ sky130_fd_sc_hd__a22oi_1
X_13054_ net803 _07428_ _07429_ _07136_ VSS VSS VDD VDD _07430_ sky130_fd_sc_hd__o22ai_1
X_13055_ _07136_ _07427_ _07430_ VSS VSS VDD VDD _07431_ sky130_fd_sc_hd__a21oi_1
X_13056_ net770 _07268_ _07377_ VSS VSS VDD VDD _07432_ sky130_fd_sc_hd__o21ai_0
X_13057_ net803 _07432_ VSS VSS VDD VDD _07433_ sky130_fd_sc_hd__nand2_1
X_13058_ net770 net805 net802 VSS VSS VDD VDD _07434_ sky130_fd_sc_hd__a21oi_1
X_13059_ _07136_ _07234_ net803 VSS VSS VDD VDD _07435_ sky130_fd_sc_hd__a21oi_1
X_13060_ _07136_ net800 _07267_ VSS VSS VDD VDD _07436_ sky130_fd_sc_hd__nor3_1
X_13061_ _07435_ _07436_ net806 VSS VSS VDD VDD _07437_ sky130_fd_sc_hd__o21ai_0
X_13062_ net803 _07434_ _07437_ VSS VSS VDD VDD _07438_ sky130_fd_sc_hd__o21a_1
X_13063_ _07433_ _07438_ net771 VSS VSS VDD VDD _07439_ sky130_fd_sc_hd__a21oi_1
X_13064_ net771 _07431_ _07439_ VSS VSS VDD VDD _07440_ sky130_fd_sc_hd__a21oi_1
X_13065_ net801 net764 net770 VSS VSS VDD VDD _07441_ sky130_fd_sc_hd__a21oi_1
X_13066_ net770 _07221_ _07441_ VSS VSS VDD VDD _07442_ sky130_fd_sc_hd__a21oi_1
X_13067_ net802 _07442_ VSS VSS VDD VDD _07443_ sky130_fd_sc_hd__nor2_1
X_13068_ net767 net802 _07199_ _07443_ VSS VSS VDD VDD _07444_ sky130_fd_sc_hd__a31oi_1
X_13069_ net770 _07324_ VSS VSS VDD VDD _07445_ sky130_fd_sc_hd__nand2_1
X_13070_ _07327_ _07445_ VSS VSS VDD VDD _07446_ sky130_fd_sc_hd__nand2_1
X_13071_ net799 _07446_ net771 VSS VSS VDD VDD _07447_ sky130_fd_sc_hd__o21ai_0
X_13072_ net799 _07444_ _07447_ VSS VSS VDD VDD _07448_ sky130_fd_sc_hd__a21oi_1
X_13073_ net800 _07235_ VSS VSS VDD VDD _07449_ sky130_fd_sc_hd__nor2_1
X_13074_ net800 _07335_ _07449_ VSS VSS VDD VDD _07450_ sky130_fd_sc_hd__a21oi_1
X_13075_ _07073_ _07310_ VSS VSS VDD VDD _07451_ sky130_fd_sc_hd__nand2_1
X_13076_ _07140_ _07260_ _07450_ _07451_ net768 VSS VSS VDD VDD _07452_ sky130_fd_sc_hd__o221ai_1
X_13077_ net768 _07440_ _07448_ _07452_ net772 VSS VSS VDD VDD _07453_ sky130_fd_sc_hd__o221ai_1
X_13078_ net767 net802 _07226_ VSS VSS VDD VDD _07454_ sky130_fd_sc_hd__nand3_1
X_13079_ net802 _07221_ _07268_ net767 _07454_ VSS VSS VDD VDD _07455_ sky130_fd_sc_hd__o221ai_1
X_13080_ _07073_ _07455_ VSS VSS VDD VDD _07456_ sky130_fd_sc_hd__nand2_1
X_13081_ _07136_ _07053_ VSS VSS VDD VDD _07457_ sky130_fd_sc_hd__nor2_1
X_13082_ _07136_ net737 _07457_ net800 VSS VSS VDD VDD _07458_ sky130_fd_sc_hd__a211oi_1
X_13083_ net806 _07328_ _07391_ _07226_ VSS VSS VDD VDD _07459_ sky130_fd_sc_hd__o22ai_1
X_13084_ net799 _07458_ _07459_ net800 net771 VSS VSS VDD VDD _07460_ sky130_fd_sc_hd__a221oi_1
X_13085_ net771 _07256_ _07456_ _07460_ VSS VSS VDD VDD _07461_ sky130_fd_sc_hd__a31oi_1
X_13086_ net801 _07267_ VSS VSS VDD VDD _07462_ sky130_fd_sc_hd__nor2_1
X_13087_ net770 _07335_ _07337_ VSS VSS VDD VDD _07463_ sky130_fd_sc_hd__a21oi_1
X_13088_ _07462_ _07236_ _07463_ net799 VSS VSS VDD VDD _07464_ sky130_fd_sc_hd__o22ai_1
X_13089_ net767 net801 VSS VSS VDD VDD _07465_ sky130_fd_sc_hd__nand2_1
X_13090_ net802 _07464_ _07465_ net769 net771 VSS VSS VDD VDD _07466_ sky130_fd_sc_hd__a221oi_1
X_13091_ _07136_ _07226_ _07267_ net801 VSS VSS VDD VDD _07467_ sky130_fd_sc_hd__a22oi_1
X_13092_ _07426_ VSS VSS VDD VDD _07468_ sky130_fd_sc_hd__inv_1
X_13093_ net799 net802 VSS VSS VDD VDD _07469_ sky130_fd_sc_hd__nor2_1
X_13094_ _07467_ _07468_ _07469_ _07463_ net738 VSS VSS VDD VDD _07470_ sky130_fd_sc_hd__a221oi_1
X_13095_ _07203_ _07466_ _07470_ net766 VSS VSS VDD VDD _07471_ sky130_fd_sc_hd__o31ai_1
X_13096_ _07168_ _07461_ _07471_ VSS VSS VDD VDD _07472_ sky130_fd_sc_hd__a21oi_1
X_13097_ _07453_ _07472_ VSS VSS VDD VDD _07473_ sky130_fd_sc_hd__nand2_1
X_13098_ _07053_ _07426_ _07425_ VSS VSS VDD VDD _07474_ sky130_fd_sc_hd__o21ai_0
X_13099_ net770 _07474_ VSS VSS VDD VDD _07475_ sky130_fd_sc_hd__nand2_1
X_13100_ _07335_ _07236_ _07387_ VSS VSS VDD VDD _07476_ sky130_fd_sc_hd__o21ai_0
X_13101_ net770 _07200_ _07462_ VSS VSS VDD VDD _07477_ sky130_fd_sc_hd__nor3_1
X_13102_ net800 _07476_ _07477_ VSS VSS VDD VDD _07478_ sky130_fd_sc_hd__a21oi_1
X_13103_ _07475_ _07478_ VSS VSS VDD VDD _07479_ sky130_fd_sc_hd__nand2_1
X_13104_ net800 net737 _07164_ VSS VSS VDD VDD _07480_ sky130_fd_sc_hd__a21oi_1
X_13105_ net806 net805 VSS VSS VDD VDD _07481_ sky130_fd_sc_hd__and2_1
X_13106_ net802 _07481_ VSS VSS VDD VDD _07482_ sky130_fd_sc_hd__nand2_1
X_13107_ _07312_ _07482_ _07136_ VSS VSS VDD VDD _07483_ sky130_fd_sc_hd__a21oi_1
X_13108_ _07480_ _07369_ _07483_ VSS VSS VDD VDD _07484_ sky130_fd_sc_hd__nor3_1
X_13109_ _07479_ _07484_ net738 VSS VSS VDD VDD _07485_ sky130_fd_sc_hd__mux2i_1
X_13110_ net770 _07462_ _07468_ VSS VSS VDD VDD _07486_ sky130_fd_sc_hd__o21ai_0
X_13111_ _07467_ _07425_ _07486_ VSS VSS VDD VDD _07487_ sky130_fd_sc_hd__o21ai_0
X_13112_ net770 net805 net802 VSS VSS VDD VDD _07488_ sky130_fd_sc_hd__o21ai_0
X_13113_ _07136_ _07267_ net803 VSS VSS VDD VDD _07489_ sky130_fd_sc_hd__o21ai_0
X_13114_ _07136_ net800 _07234_ VSS VSS VDD VDD _07490_ sky130_fd_sc_hd__nand3_1
X_13115_ _07489_ _07490_ net806 VSS VSS VDD VDD _07491_ sky130_fd_sc_hd__a21oi_1
X_13116_ net803 _07488_ _07491_ VSS VSS VDD VDD _07492_ sky130_fd_sc_hd__a21o_1
X_13117_ net799 _07446_ _07492_ VSS VSS VDD VDD _07493_ sky130_fd_sc_hd__a21oi_1
X_13118_ _07487_ _07493_ net738 VSS VSS VDD VDD _07494_ sky130_fd_sc_hd__mux2i_1
X_13119_ _07136_ net802 VSS VSS VDD VDD _07495_ sky130_fd_sc_hd__nor2_1
X_13120_ _07136_ _07324_ _07495_ _07335_ _07449_ VSS VSS VDD VDD _07496_ sky130_fd_sc_hd__a221oi_1
X_13121_ net800 _07221_ _07322_ _07496_ _07073_ VSS VSS VDD VDD _07497_ sky130_fd_sc_hd__o32ai_1
X_13122_ _07322_ net737 _07467_ _07073_ VSS VSS VDD VDD _07498_ sky130_fd_sc_hd__o22ai_1
X_13123_ _07136_ net801 VSS VSS VDD VDD _07499_ sky130_fd_sc_hd__nor2_1
X_13124_ _07200_ _07499_ VSS VSS VDD VDD _07500_ sky130_fd_sc_hd__nor2_1
X_13125_ net800 _07498_ _07500_ VSS VSS VDD VDD _07501_ sky130_fd_sc_hd__a21oi_1
X_13126_ net771 _07501_ VSS VSS VDD VDD _07502_ sky130_fd_sc_hd__nor2_1
X_13127_ net771 _07497_ _07502_ VSS VSS VDD VDD _07503_ sky130_fd_sc_hd__a21oi_1
X_13128_ _07481_ _07495_ _07458_ VSS VSS VDD VDD _07504_ sky130_fd_sc_hd__a21oi_1
X_13129_ net803 _07432_ VSS VSS VDD VDD _07505_ sky130_fd_sc_hd__nor2_1
X_13130_ net803 _07504_ _07505_ VSS VSS VDD VDD _07506_ sky130_fd_sc_hd__a21oi_1
X_13131_ _07327_ _07391_ _07444_ net799 VSS VSS VDD VDD _07507_ sky130_fd_sc_hd__o22ai_1
X_13132_ _07506_ _07507_ net738 VSS VSS VDD VDD _07508_ sky130_fd_sc_hd__mux2i_1
X_13133_ _07485_ _07494_ _07503_ _07508_ net768 net772 VSS VSS VDD VDD _07509_ sky130_fd_sc_hd__mux4_2
X_13134_ _07205_ _07509_ _06918_ VSS VSS VDD VDD _07510_ sky130_fd_sc_hd__a21oi_1
X_13135_ u_core.u_top.u_core.r_x[53] net818 VSS VSS VDD VDD _07511_ sky130_fd_sc_hd__nand2_1
X_13136_ _06367_ net818 net809 _07511_ VSS VSS VDD VDD _07512_ sky130_fd_sc_hd__o211ai_1
X_13137_ u_core.u_top.u_core.r_x[101] net809 _07512_ VSS VSS VDD VDD _07513_ sky130_fd_sc_hd__o21ai_0
X_13138_ _0969_[1070] u_core.u_top.u_core.r_piter[2] u_core.u_top.u_core.r_piter[0] VSS VSS VDD VDD _07514_ sky130_fd_sc_hd__and3_1
X_13139_ u_core.u_top.u_core.r_piter[3] _07514_ VSS VSS VDD VDD _07515_ sky130_fd_sc_hd__nor2_1
X_13140_ _0969_[1070] u_core.u_top.u_core.r_piter[2] u_core.u_top.u_core.r_piter[5] VSS VSS VDD VDD _07516_ sky130_fd_sc_hd__o21ai_0
X_13141_ _0969_[1070] u_core.u_top.u_core.r_piter[2] u_core.u_top.u_core.r_piter[5] VSS VSS VDD VDD _07517_ sky130_fd_sc_hd__a21oi_1
X_13142_ u_core.u_top.u_core.r_piter[4] u_core.u_top.u_core.r_piter[3] VSS VSS VDD VDD _07518_ sky130_fd_sc_hd__nand2b_1
X_13143_ _07286_ _07517_ _07518_ VSS VSS VDD VDD _07519_ sky130_fd_sc_hd__nor3_1
X_13144_ u_core.u_top.u_core.r_piter[4] _07515_ _07516_ _07519_ VSS VSS VDD VDD _07520_ sky130_fd_sc_hd__a31oi_1
X_13146_ u_core.u_top.u_core.r_tile[5] _07189_ net798 net950 u_core.u_top.u_core.r_pdata[5] _06596_ VSS VSS VDD VDD _07522_ sky130_fd_sc_hd__a222oi_1
X_13147_ net807 _07513_ _07520_ net796 _07522_ VSS VSS VDD VDD _07523_ sky130_fd_sc_hd__o221ai_2
X_13148_ _07473_ _07510_ _07523_ VSS VSS VDD VDD _07524_ sky130_fd_sc_hd__a21oi_1
X_13149_ _06914_ _07524_ VSS VSS VDD VDD _07525_ sky130_fd_sc_hd__nor2_1
X_13150_ net996 _07362_ net816 VSS VSS VDD VDD _07526_ sky130_fd_sc_hd__o21ai_0
X_13151_ u_core.u_top.u_spi.shift_out[4] net816 _07525_ _07526_ VSS VSS VDD VDD _2236_[5] sky130_fd_sc_hd__o22a_1
X_13152_ u_core.u_top.u_spi.shift_out[3] VSS VSS VDD VDD _07527_ sky130_fd_sc_hd__inv_1
X_13153_ net800 net737 _07391_ _07433_ VSS VSS VDD VDD _07528_ sky130_fd_sc_hd__o31ai_1
X_13154_ net767 net806 VSS VSS VDD VDD _07529_ sky130_fd_sc_hd__nand2_1
X_13155_ _07199_ _07391_ _07529_ _07234_ VSS VSS VDD VDD _07530_ sky130_fd_sc_hd__o22ai_1
X_13156_ _07164_ _07467_ net802 VSS VSS VDD VDD _07531_ sky130_fd_sc_hd__a21oi_1
X_13157_ _07164_ _07499_ VSS VSS VDD VDD _07532_ sky130_fd_sc_hd__nor2_1
X_13158_ net802 _07530_ _07531_ _07532_ net771 VSS VSS VDD VDD _07533_ sky130_fd_sc_hd__a2111oi_0
X_13159_ net771 _07528_ _07533_ VSS VSS VDD VDD _07534_ sky130_fd_sc_hd__a21oi_1
X_13160_ _07199_ _07200_ VSS VSS VDD VDD _07535_ sky130_fd_sc_hd__nor2_1
X_13161_ _07234_ _07200_ _07318_ VSS VSS VDD VDD _07536_ sky130_fd_sc_hd__o21ai_0
X_13162_ net806 _07536_ VSS VSS VDD VDD _07537_ sky130_fd_sc_hd__nand2_1
X_13163_ _07462_ _07426_ _07537_ _07341_ VSS VSS VDD VDD _07538_ sky130_fd_sc_hd__o211ai_1
X_13164_ net769 _07535_ _07400_ _07538_ net768 VSS VSS VDD VDD _07539_ sky130_fd_sc_hd__o311ai_0
X_13165_ _07073_ _07226_ net800 VSS VSS VDD VDD _07540_ sky130_fd_sc_hd__a21oi_1
X_13166_ net799 _07235_ _07540_ VSS VSS VDD VDD _07541_ sky130_fd_sc_hd__a21oi_1
X_13167_ net799 _07312_ _07541_ VSS VSS VDD VDD _07542_ sky130_fd_sc_hd__o21ai_0
X_13168_ _07139_ _07542_ VSS VSS VDD VDD _07543_ sky130_fd_sc_hd__nand2_1
X_13169_ _07269_ _07399_ _07002_ VSS VSS VDD VDD _07544_ sky130_fd_sc_hd__o21ai_0
X_13170_ _07543_ _07544_ VSS VSS VDD VDD _07545_ sky130_fd_sc_hd__nand2_1
X_13171_ net768 _07534_ _07539_ _07545_ net772 VSS VSS VDD VDD _07546_ sky130_fd_sc_hd__o221ai_1
X_13172_ net770 net801 VSS VSS VDD VDD _07547_ sky130_fd_sc_hd__nand2_1
X_13173_ _07481_ _07328_ _07547_ _07132_ VSS VSS VDD VDD _07548_ sky130_fd_sc_hd__o22ai_1
X_13174_ net803 _07463_ net800 VSS VSS VDD VDD _07549_ sky130_fd_sc_hd__a21oi_1
X_13175_ net799 _07465_ _07548_ net800 _07549_ VSS VSS VDD VDD _07550_ sky130_fd_sc_hd__a221oi_1
X_13176_ net799 _07446_ VSS VSS VDD VDD _07551_ sky130_fd_sc_hd__nand2_1
X_13177_ _07312_ _07328_ _07551_ net738 VSS VSS VDD VDD _07552_ sky130_fd_sc_hd__o211ai_1
X_13178_ net738 _07550_ _07552_ VSS VSS VDD VDD _07553_ sky130_fd_sc_hd__o21ai_0
X_13179_ _07395_ _07352_ _07450_ net738 net799 VSS VSS VDD VDD _07554_ sky130_fd_sc_hd__o221ai_1
X_13180_ net771 net806 VSS VSS VDD VDD _07555_ sky130_fd_sc_hd__nor2_1
X_13181_ net771 _07462_ _07555_ VSS VSS VDD VDD _07556_ sky130_fd_sc_hd__a21oi_1
X_13182_ net737 _07352_ _07556_ net800 net803 VSS VSS VDD VDD _07557_ sky130_fd_sc_hd__o221ai_1
X_13183_ net803 net800 _07053_ VSS VSS VDD VDD _07558_ sky130_fd_sc_hd__nand3_1
X_13184_ net803 _07482_ _07558_ VSS VSS VDD VDD _07559_ sky130_fd_sc_hd__o21ai_0
X_13185_ _07481_ _07318_ _07200_ net771 VSS VSS VDD VDD _07560_ sky130_fd_sc_hd__o211ai_1
X_13186_ net771 _07559_ _07560_ VSS VSS VDD VDD _07561_ sky130_fd_sc_hd__o21ai_0
X_13187_ _07136_ _07561_ VSS VSS VDD VDD _07562_ sky130_fd_sc_hd__nor2_1
X_13188_ net767 _07554_ _07557_ _07562_ VSS VSS VDD VDD _07563_ sky130_fd_sc_hd__a31oi_1
X_13189_ _07379_ _07553_ _07563_ _07168_ net766 VSS VSS VDD VDD _07564_ sky130_fd_sc_hd__a221oi_1
X_13190_ _07479_ _07493_ net771 VSS VSS VDD VDD _07565_ sky130_fd_sc_hd__mux2_1
X_13191_ _07312_ _07236_ _07496_ _07164_ net771 VSS VSS VDD VDD _07566_ sky130_fd_sc_hd__o221ai_1
X_13192_ net771 _07487_ _07566_ VSS VSS VDD VDD _07567_ sky130_fd_sc_hd__o21ai_0
X_13193_ net768 _07567_ VSS VSS VDD VDD _07568_ sky130_fd_sc_hd__nand2_1
X_13194_ net768 _07565_ _07568_ VSS VSS VDD VDD _07569_ sky130_fd_sc_hd__o21ai_0
X_13195_ _07507_ _07484_ _07497_ _07506_ net768 net738 VSS VSS VDD VDD _07570_ sky130_fd_sc_hd__mux4_2
X_13196_ net772 _07570_ VSS VSS VDD VDD _07571_ sky130_fd_sc_hd__nand2_1
X_13197_ net772 _07569_ _07571_ VSS VSS VDD VDD _07572_ sky130_fd_sc_hd__o21ai_0
X_13198_ _07546_ _07564_ _07572_ net766 _06918_ VSS VSS VDD VDD _07573_ sky130_fd_sc_hd__a221oi_1
X_13199_ u_core.u_top.bus_addr[3] u_core.u_top.bus_addr[2] u_core.u_top.bus_word _06604_ VSS VSS VDD VDD _07574_ sky130_fd_sc_hd__nor4_1
X_13200_ net899 u_core.u_top.u_core.r_noshuf u_core.u_top.bus_addr[1] VSS VSS VDD VDD _07575_ sky130_fd_sc_hd__mux2i_1
X_13201_ _07277_ _07575_ VSS VSS VDD VDD _07576_ sky130_fd_sc_hd__nor2_1
X_13202_ u_core.u_top.u_core.r_mode _07574_ net866 _07576_ _06578_ VSS VSS VDD VDD _07577_ sky130_fd_sc_hd__a221o_1
X_13203_ net913 VSS VSS VDD VDD _07578_ sky130_fd_sc_hd__inv_1
X_13204_ net914 _06204_ VSS VSS VDD VDD _07579_ sky130_fd_sc_hd__nand2_1
X_13205_ _07578_ _06204_ net808 _07579_ VSS VSS VDD VDD _07580_ sky130_fd_sc_hd__o211ai_1
X_13206_ net944 net808 _07580_ VSS VSS VDD VDD _07581_ sky130_fd_sc_hd__o21ai_0
X_13207_ u_core.u_top.u_core.r_pdata[4] _06596_ net812 u_core.u_top.u_core.m_fail[2] net798 VSS VSS VDD VDD _07582_ sky130_fd_sc_hd__a221o_1
X_13208_ _0969_[1070] u_core.u_top.u_core.r_piter[0] VSS VSS VDD VDD _07583_ sky130_fd_sc_hd__nand2_1
X_13209_ u_core.u_top.u_core.r_piter[2] _07583_ u_core.u_top.u_core.r_piter[3] VSS VSS VDD VDD _07584_ sky130_fd_sc_hd__nand3b_1
X_13210_ u_core.u_top.u_core.r_piter[5] _07515_ _07516_ u_core.u_top.u_core.r_piter[3] _07584_ VSS VSS VDD VDD _07585_ sky130_fd_sc_hd__o221ai_1
X_13213_ _0969_[1070] u_core.u_top.u_core.r_piter[0] u_core.u_top.u_core.r_piter[2] VSS VSS VDD VDD _07588_ sky130_fd_sc_hd__o21ai_0
X_13214_ u_core.u_top.u_core.r_piter[5] u_core.u_top.u_core.r_piter[4] u_core.u_top.u_core.r_piter[3] VSS VSS VDD VDD _07589_ sky130_fd_sc_hd__nor3_1
X_13215_ u_core.u_top.u_core.r_piter[4] _07585_ _07588_ _07589_ net796 VSS VSS VDD VDD _07590_ sky130_fd_sc_hd__a221oi_2
X_13216_ net951 _07252_ _07582_ _07590_ _06918_ VSS VSS VDD VDD _07591_ sky130_fd_sc_hd__o221ai_1
X_13217_ net807 _07581_ _07591_ VSS VSS VDD VDD _07592_ sky130_fd_sc_hd__o21ai_0
X_13218_ u_core.u_top.u_core.r_tile[4] net765 _07573_ _07577_ _07592_ VSS VSS VDD VDD _07593_ sky130_fd_sc_hd__a2111oi_0
X_13219_ net996 u_core.u_top.u_spi.shift_out[4] net816 VSS VSS VDD VDD _07594_ sky130_fd_sc_hd__o21ai_0
X_13220_ _07527_ net816 _07593_ _07594_ VSS VSS VDD VDD _2236_[4] sky130_fd_sc_hd__o22ai_1
X_13221_ u_core.u_top.u_core.r_tile[3] _06915_ VSS VSS VDD VDD _07595_ sky130_fd_sc_hd__nand2_1
X_13222_ u_core.u_top.bus_re _07527_ net816 _07595_ VSS VSS VDD VDD _07596_ sky130_fd_sc_hd__o211ai_1
X_13223_ _07164_ net806 VSS VSS VDD VDD _07597_ sky130_fd_sc_hd__nand2_1
X_13224_ net800 net804 net805 VSS VSS VDD VDD _07598_ sky130_fd_sc_hd__o21a_1
X_13225_ _07598_ VSS VSS VDD VDD _07599_ sky130_fd_sc_hd__inv_1
X_13226_ net800 _07132_ VSS VSS VDD VDD _07600_ sky130_fd_sc_hd__nor2_1
X_13227_ _07164_ _07598_ VSS VSS VDD VDD _07601_ sky130_fd_sc_hd__nor2_1
X_13228_ _07600_ _07601_ net801 VSS VSS VDD VDD _07602_ sky130_fd_sc_hd__o21ai_0
X_13229_ _07597_ _07599_ _07602_ VSS VSS VDD VDD _07603_ sky130_fd_sc_hd__o21ai_0
X_13230_ net800 net804 net805 VSS VSS VDD VDD _07604_ sky130_fd_sc_hd__a21oi_1
X_13231_ _07604_ _07598_ net801 VSS VSS VDD VDD _07605_ sky130_fd_sc_hd__mux2i_1
X_13232_ net800 _07052_ VSS VSS VDD VDD _07606_ sky130_fd_sc_hd__nand2_1
X_13233_ net802 net764 VSS VSS VDD VDD _07607_ sky130_fd_sc_hd__nand2_1
X_13234_ _07606_ _07607_ VSS VSS VDD VDD _07608_ sky130_fd_sc_hd__nand2_1
X_13235_ net803 _07605_ _07608_ _07387_ net767 VSS VSS VDD VDD _07609_ sky130_fd_sc_hd__o221ai_1
X_13236_ net767 _07603_ _07609_ VSS VSS VDD VDD _07610_ sky130_fd_sc_hd__o21ai_0
X_13237_ _06968_ _07610_ VSS VSS VDD VDD _07611_ sky130_fd_sc_hd__nor2_1
X_13238_ net802 _07234_ VSS VSS VDD VDD _07612_ sky130_fd_sc_hd__nor2_1
X_13239_ net803 _07604_ VSS VSS VDD VDD _07613_ sky130_fd_sc_hd__nor2_1
X_13240_ _07612_ _07613_ VSS VSS VDD VDD _07614_ sky130_fd_sc_hd__nor2_1
X_13241_ net803 net801 _07604_ VSS VSS VDD VDD _07615_ sky130_fd_sc_hd__nand3_1
X_13242_ net801 _07614_ _07615_ VSS VSS VDD VDD _07616_ sky130_fd_sc_hd__o21ai_0
X_13243_ net801 _07600_ _07601_ VSS VSS VDD VDD _07617_ sky130_fd_sc_hd__nor3_1
X_13244_ net801 _07614_ _07617_ VSS VSS VDD VDD _07618_ sky130_fd_sc_hd__a21oi_1
X_13245_ _07616_ _07618_ net767 VSS VSS VDD VDD _07619_ sky130_fd_sc_hd__mux2_1
X_13246_ _06968_ _07619_ VSS VSS VDD VDD _07620_ sky130_fd_sc_hd__and2_1
X_13247_ net803 _07604_ VSS VSS VDD VDD _07621_ sky130_fd_sc_hd__nand2_1
X_13248_ net803 _07599_ _07621_ VSS VSS VDD VDD _07622_ sky130_fd_sc_hd__o21ai_0
X_13249_ _07387_ _07607_ _07622_ net806 VSS VSS VDD VDD _07623_ sky130_fd_sc_hd__o22ai_1
X_13250_ net805 net769 _07600_ _07601_ VSS VSS VDD VDD _07624_ sky130_fd_sc_hd__a211o_1
X_13251_ net806 net800 VSS VSS VDD VDD _07625_ sky130_fd_sc_hd__nand2_1
X_13252_ net803 _07625_ VSS VSS VDD VDD _07626_ sky130_fd_sc_hd__nor2_1
X_13253_ net803 net802 _07199_ _07626_ VSS VSS VDD VDD _07627_ sky130_fd_sc_hd__a31oi_1
X_13254_ net801 _07624_ _07627_ net804 net767 VSS VSS VDD VDD _07628_ sky130_fd_sc_hd__o221ai_1
X_13255_ net767 _07623_ _07628_ VSS VSS VDD VDD _07629_ sky130_fd_sc_hd__o21ai_0
X_13256_ _07164_ net801 VSS VSS VDD VDD _07630_ sky130_fd_sc_hd__nand2_1
X_13257_ _07630_ _07606_ _07622_ net801 VSS VSS VDD VDD _07631_ sky130_fd_sc_hd__o22ai_1
X_13258_ net799 net800 net805 net804 VSS VSS VDD VDD _07632_ sky130_fd_sc_hd__nor4_1
X_13259_ _07612_ _07613_ _07632_ VSS VSS VDD VDD _07633_ sky130_fd_sc_hd__nor3_1
X_13260_ _07337_ net769 _07633_ net801 net767 VSS VSS VDD VDD _07634_ sky130_fd_sc_hd__a221o_1
X_13261_ net770 _07631_ _07634_ VSS VSS VDD VDD _07635_ sky130_fd_sc_hd__o21ai_0
X_13262_ _07629_ _07635_ _06968_ VSS VSS VDD VDD _07636_ sky130_fd_sc_hd__mux2_1
X_13263_ _07123_ _07636_ VSS VSS VDD VDD _07637_ sky130_fd_sc_hd__nand2_1
X_13264_ _07123_ _07611_ _07620_ _07637_ VSS VSS VDD VDD _07638_ sky130_fd_sc_hd__o31ai_1
X_13265_ _07635_ _07610_ _06968_ VSS VSS VDD VDD _07639_ sky130_fd_sc_hd__mux2i_1
X_13266_ net799 _07605_ _07608_ _07630_ net770 VSS VSS VDD VDD _07640_ sky130_fd_sc_hd__o221ai_1
X_13267_ net770 _07616_ _07640_ VSS VSS VDD VDD _07641_ sky130_fd_sc_hd__o21ai_0
X_13268_ _07641_ _07629_ _06968_ VSS VSS VDD VDD _07642_ sky130_fd_sc_hd__mux2i_1
X_13269_ _07639_ _07642_ _07123_ VSS VSS VDD VDD _07643_ sky130_fd_sc_hd__mux2_1
X_13270_ net766 _07643_ VSS VSS VDD VDD _07644_ sky130_fd_sc_hd__nand2_1
X_13271_ net766 _07638_ _07644_ VSS VSS VDD VDD _07645_ sky130_fd_sc_hd__o21ai_0
X_13272_ net766 net772 VSS VSS VDD VDD _07646_ sky130_fd_sc_hd__and2_1
X_13273_ _07623_ _07631_ net770 VSS VSS VDD VDD _07647_ sky130_fd_sc_hd__mux2_1
X_13274_ _07529_ _07612_ _07598_ _07547_ VSS VSS VDD VDD _07648_ sky130_fd_sc_hd__o22ai_1
X_13275_ _07547_ _07606_ _07607_ net799 VSS VSS VDD VDD _07649_ sky130_fd_sc_hd__a31oi_1
X_13276_ _07529_ _07547_ _07613_ _07648_ _07649_ VSS VSS VDD VDD _07650_ sky130_fd_sc_hd__a311oi_1
X_13277_ _07647_ _07650_ _06968_ VSS VSS VDD VDD _07651_ sky130_fd_sc_hd__mux2_1
X_13278_ _07529_ VSS VSS VDD VDD _07652_ sky130_fd_sc_hd__inv_1
X_13279_ _07652_ _07608_ net799 VSS VSS VDD VDD _07653_ sky130_fd_sc_hd__o21ai_0
X_13280_ net804 _07652_ VSS VSS VDD VDD _07654_ sky130_fd_sc_hd__nand2_1
X_13281_ _07547_ _07654_ net802 VSS VSS VDD VDD _07655_ sky130_fd_sc_hd__a21o_1
X_13282_ net770 _07226_ net764 _07547_ VSS VSS VDD VDD _07656_ sky130_fd_sc_hd__o22ai_1
X_13283_ _07529_ _07547_ _07601_ _07656_ VSS VSS VDD VDD _07657_ sky130_fd_sc_hd__a31oi_1
X_13284_ _07653_ _07655_ _07657_ VSS VSS VDD VDD _07658_ sky130_fd_sc_hd__nand3_1
X_13285_ _06967_ _07619_ VSS VSS VDD VDD _07659_ sky130_fd_sc_hd__nand2_1
X_13286_ _06967_ _07658_ _07659_ VSS VSS VDD VDD _07660_ sky130_fd_sc_hd__o21ai_0
X_13287_ _07651_ _07660_ _07123_ VSS VSS VDD VDD _07661_ sky130_fd_sc_hd__mux2i_1
X_13288_ _07603_ _07618_ net770 VSS VSS VDD VDD _07662_ sky130_fd_sc_hd__mux2_1
X_13289_ _07650_ _07662_ _06968_ VSS VSS VDD VDD _07663_ sky130_fd_sc_hd__mux2_1
X_13290_ _06968_ _07647_ VSS VSS VDD VDD _07664_ sky130_fd_sc_hd__nand2_1
X_13291_ _06968_ _07658_ _07664_ _07123_ VSS VSS VDD VDD _07665_ sky130_fd_sc_hd__o211ai_1
X_13292_ _07123_ _07663_ _07665_ VSS VSS VDD VDD _07666_ sky130_fd_sc_hd__o21ai_0
X_13293_ _07646_ _07661_ _07666_ _07207_ _06918_ VSS VSS VDD VDD _07667_ sky130_fd_sc_hd__a221oi_1
X_13294_ net772 _07645_ _07667_ VSS VSS VDD VDD _07668_ sky130_fd_sc_hd__o21ai_0
X_13295_ u_core.u_top.u_core.r_x[51] net817 VSS VSS VDD VDD _07669_ sky130_fd_sc_hd__nand2_1
X_13297_ u_core.u_top.u_core.r_x[3] _06204_ VSS VSS VDD VDD _07671_ sky130_fd_sc_hd__nand2_1
X_13298_ net808 _07669_ _07671_ VSS VSS VDD VDD _07672_ sky130_fd_sc_hd__nand3_1
X_13299_ u_core.u_top.u_core.r_x[99] net808 _07672_ _06606_ VSS VSS VDD VDD _07673_ sky130_fd_sc_hd__o211ai_1
X_13300_ u_core.u_top.u_core.r_piter[3] u_core.u_top.u_core.r_piter[0] VSS VSS VDD VDD _07674_ sky130_fd_sc_hd__nor2b_1
X_13301_ _0969_[1070] u_core.u_top.u_core.r_piter[2] VSS VSS VDD VDD _07675_ sky130_fd_sc_hd__nand2b_1
X_13302_ _07282_ u_core.u_top.u_core.r_piter[0] VSS VSS VDD VDD _07676_ sky130_fd_sc_hd__nor2_1
X_13303_ u_core.u_top.u_core.r_piter[2] _0969_[1070] VSS VSS VDD VDD _07677_ sky130_fd_sc_hd__nand2b_1
X_13304_ _07674_ _07675_ _07676_ _07677_ VSS VSS VDD VDD _07678_ sky130_fd_sc_hd__o22ai_1
X_13305_ _0969_[1070] u_core.u_top.u_core.r_piter[0] VSS VSS VDD VDD _07679_ sky130_fd_sc_hd__nor2_1
X_13306_ u_core.u_top.u_core.r_piter[3] _07583_ VSS VSS VDD VDD _07680_ sky130_fd_sc_hd__nor2_1
X_13307_ u_core.u_top.u_core.r_piter[3] _07679_ _07680_ u_core.u_top.u_core.r_piter[2] u_core.u_top.u_core.r_piter[4] VSS VSS VDD VDD _07681_ sky130_fd_sc_hd__a2111oi_0
X_13308_ u_core.u_top.u_core.r_piter[4] _07678_ _07681_ VSS VSS VDD VDD _07682_ sky130_fd_sc_hd__a21oi_1
X_13309_ _0969_[1070] _07674_ VSS VSS VDD VDD _07683_ sky130_fd_sc_hd__nor2_1
X_13310_ u_core.u_top.u_core.r_piter[3] _07583_ _07683_ u_core.u_top.u_core.r_piter[4] u_core.u_top.u_core.r_piter[2] VSS VSS VDD VDD _07684_ sky130_fd_sc_hd__o221ai_1
X_13311_ u_core.u_top.u_core.r_piter[4] _07683_ VSS VSS VDD VDD _07685_ sky130_fd_sc_hd__nand2_1
X_13312_ u_core.u_top.u_core.r_piter[2] _07685_ VSS VSS VDD VDD _07686_ sky130_fd_sc_hd__nand2b_1
X_13313_ _07684_ _07686_ u_core.u_top.u_core.r_piter[5] VSS VSS VDD VDD _07687_ sky130_fd_sc_hd__a21oi_1
X_13314_ u_core.u_top.u_core.r_piter[5] _07682_ _07687_ net796 VSS VSS VDD VDD _07688_ sky130_fd_sc_hd__a211oi_2
X_13315_ u_core.u_top.u_core.r_pdata[3] net814 net798 net952 _07688_ VSS VSS VDD VDD _07689_ sky130_fd_sc_hd__a221oi_1
X_13316_ _07668_ _07673_ _07689_ _06590_ VSS VSS VDD VDD _07690_ sky130_fd_sc_hd__a31oi_1
X_13317_ u_core.u_top.u_spi.shift_out[2] net816 _07596_ _07690_ VSS VSS VDD VDD _2236_[3] sky130_fd_sc_hd__o22a_1
X_13318_ u_core.u_top.bus_re u_core.u_top.u_spi.shift_out[2] VSS VSS VDD VDD _07691_ sky130_fd_sc_hd__nor2_1
X_13319_ u_core.u_top.u_spi.shift_out[1] net816 VSS VSS VDD VDD _07692_ sky130_fd_sc_hd__nor2_1
X_13320_ _06967_ _07662_ VSS VSS VDD VDD _07693_ sky130_fd_sc_hd__nand2_1
X_13321_ _07641_ _06968_ VSS VSS VDD VDD _07694_ sky130_fd_sc_hd__nand2b_1
X_13322_ _07693_ _07694_ _07123_ VSS VSS VDD VDD _07695_ sky130_fd_sc_hd__a21oi_1
X_13323_ _07123_ _07651_ _07695_ net772 VSS VSS VDD VDD _07696_ sky130_fd_sc_hd__a211oi_1
X_13324_ net772 _07638_ _07696_ VSS VSS VDD VDD _07697_ sky130_fd_sc_hd__a21oi_1
X_13325_ _07660_ _07639_ _07123_ VSS VSS VDD VDD _07698_ sky130_fd_sc_hd__mux2i_1
X_13326_ _07642_ _07663_ _07123_ VSS VSS VDD VDD _07699_ sky130_fd_sc_hd__mux2i_1
X_13327_ net766 net772 VSS VSS VDD VDD _07700_ sky130_fd_sc_hd__nor2_1
X_13328_ _07207_ _07698_ _07699_ _07700_ VSS VSS VDD VDD _07701_ sky130_fd_sc_hd__a22oi_1
X_13329_ _07205_ _07697_ _07701_ VSS VSS VDD VDD _07702_ sky130_fd_sc_hd__o21ai_0
X_13331_ u_core.u_top.u_core.r_tile[2] u_core.u_top.u_core.r_varprog u_core.u_top.bus_addr[0] VSS VSS VDD VDD _07704_ sky130_fd_sc_hd__mux2i_1
X_13332_ u_core.u_top.u_core.m_fail[1] net812 VSS VSS VDD VDD _07705_ sky130_fd_sc_hd__nand2_1
X_13333_ _06589_ _07704_ _07705_ net996 VSS VSS VDD VDD _07706_ sky130_fd_sc_hd__o211ai_1
X_13334_ u_core.u_top.u_core.r_pdata[2] net813 net798 net953 _07706_ VSS VSS VDD VDD _07707_ sky130_fd_sc_hd__a221oi_1
X_13335_ u_core.u_top.u_core.s_done VSS VSS VDD VDD _07708_ sky130_fd_sc_hd__inv_1
X_13336_ u_core.u_top.u_core.r_ie _07574_ _06587_ _07708_ VSS VSS VDD VDD _07709_ sky130_fd_sc_hd__o2bb2a_1
X_13337_ net816 _07707_ _07709_ VSS VSS VDD VDD _07710_ sky130_fd_sc_hd__nand3_1
X_13338_ u_core.u_top.u_core.r_x[50] net818 VSS VSS VDD VDD _07711_ sky130_fd_sc_hd__nand2_1
X_13339_ u_core.u_top.u_core.r_x[2] net870 VSS VSS VDD VDD _07712_ sky130_fd_sc_hd__nand2_1
X_13340_ net808 _07711_ _07712_ VSS VSS VDD VDD _07713_ sky130_fd_sc_hd__nand3_1
X_13341_ u_core.u_top.u_core.r_x[98] net808 _07713_ VSS VSS VDD VDD _07714_ sky130_fd_sc_hd__o21ai_0
X_13342_ _07282_ u_core.u_top.u_core.r_piter[0] _0969_[1070] VSS VSS VDD VDD _07715_ sky130_fd_sc_hd__o21ai_0
X_13343_ u_core.u_top.u_core.r_piter[4] _07715_ _07685_ VSS VSS VDD VDD _07716_ sky130_fd_sc_hd__o21ai_0
X_13344_ _07716_ VSS VSS VDD VDD _07717_ sky130_fd_sc_hd__inv_1
X_13345_ u_core.u_top.u_core.r_piter[4] u_core.u_top.u_core.r_piter[3] u_core.u_top.u_core.r_piter[2] _07583_ VSS VSS VDD VDD _07718_ sky130_fd_sc_hd__nor4_1
X_13346_ u_core.u_top.u_core.r_piter[2] _07717_ _07718_ VSS VSS VDD VDD _07719_ sky130_fd_sc_hd__a21oi_1
X_13347_ u_core.u_top.u_core.r_piter[4] u_core.u_top.u_core.r_piter[3] VSS VSS VDD VDD _07720_ sky130_fd_sc_hd__nand2_1
X_13348_ u_core.u_top.u_core.r_piter[2] _07679_ VSS VSS VDD VDD _07721_ sky130_fd_sc_hd__nand2_1
X_13349_ u_core.u_top.u_core.r_piter[2] _07716_ _07720_ _07721_ VSS VSS VDD VDD _07722_ sky130_fd_sc_hd__o22ai_1
X_13350_ u_core.u_top.u_core.r_piter[5] _07722_ VSS VSS VDD VDD _07723_ sky130_fd_sc_hd__nor2_1
X_13351_ u_core.u_top.u_core.r_piter[5] _07719_ _07723_ VSS VSS VDD VDD _07724_ sky130_fd_sc_hd__a21oi_1
X_13352_ net807 _07714_ _07724_ net796 VSS VSS VDD VDD _07725_ sky130_fd_sc_hd__o22ai_1
X_13353_ net797 net648 _07710_ _07725_ VSS VSS VDD VDD _07726_ sky130_fd_sc_hd__a211oi_1
X_13354_ net816 _07691_ _07692_ _07726_ VSS VSS VDD VDD _2236_[2] sky130_fd_sc_hd__a211oi_1
X_13355_ u_core.u_top.u_core.r_tile[1] net765 net798 u_core.u_top.u_core.r_prow[1] u_core.u_top.u_core.r_pdata[1] net813 VSS VSS VDD VDD _07727_ sky130_fd_sc_hd__a222oi_1
X_13356_ u_core.u_top.u_core.r_x[49] net818 VSS VSS VDD VDD _07728_ sky130_fd_sc_hd__nand2_1
X_13357_ u_core.u_top.u_core.r_x[1] net871 VSS VSS VDD VDD _07729_ sky130_fd_sc_hd__nand2_1
X_13358_ u_core.u_top.u_core.r_x[97] net809 VSS VSS VDD VDD _07730_ sky130_fd_sc_hd__nor2_1
X_13359_ net809 _07728_ _07729_ _07730_ VSS VSS VDD VDD _07731_ sky130_fd_sc_hd__a31oi_1
X_13360_ u_core.u_top.u_core.r_piter[4] u_core.u_top.u_core.r_piter[3] u_core.u_top.u_core.r_piter[0] _07677_ VSS VSS VDD VDD _07732_ sky130_fd_sc_hd__nor4_1
X_13361_ u_core.u_top.u_core.r_piter[4] u_core.u_top.u_core.r_piter[3] u_core.u_top.u_core.r_piter[0] VSS VSS VDD VDD _07733_ sky130_fd_sc_hd__nand3_1
X_13362_ _07675_ _07733_ VSS VSS VDD VDD _07734_ sky130_fd_sc_hd__nor2_1
X_13363_ u_core.u_top.u_core.r_piter[5] _07732_ _07734_ VSS VSS VDD VDD _07735_ sky130_fd_sc_hd__nor3_1
X_13364_ _07675_ _07677_ VSS VSS VDD VDD _07736_ sky130_fd_sc_hd__and2_1
X_13365_ u_core.u_top.u_core.r_piter[4] _07282_ VSS VSS VDD VDD _07737_ sky130_fd_sc_hd__nand2_1
X_13366_ _07518_ _07737_ u_core.u_top.u_core.r_piter[0] VSS VSS VDD VDD _07738_ sky130_fd_sc_hd__mux2i_1
X_13367_ _07675_ _07677_ u_core.u_top.u_core.r_piter[3] VSS VSS VDD VDD _07739_ sky130_fd_sc_hd__mux2i_1
X_13368_ u_core.u_top.u_core.r_piter[4] u_core.u_top.u_core.r_piter[0] VSS VSS VDD VDD _07740_ sky130_fd_sc_hd__xor2_1
X_13369_ _07736_ _07738_ _07739_ _07740_ VSS VSS VDD VDD _07741_ sky130_fd_sc_hd__a22oi_1
X_13370_ u_core.u_top.u_core.r_piter[3] _07677_ VSS VSS VDD VDD _07742_ sky130_fd_sc_hd__nor2_1
X_13371_ u_core.u_top.u_core.r_piter[3] _07736_ _07742_ VSS VSS VDD VDD _07743_ sky130_fd_sc_hd__a21oi_1
X_13372_ u_core.u_top.u_core.r_piter[4] _07739_ VSS VSS VDD VDD _07744_ sky130_fd_sc_hd__nand2_1
X_13373_ u_core.u_top.u_core.r_piter[4] _07743_ _07744_ u_core.u_top.u_core.r_piter[0] VSS VSS VDD VDD _07745_ sky130_fd_sc_hd__o211ai_1
X_13374_ _07518_ _07675_ _07677_ _07737_ VSS VSS VDD VDD _07746_ sky130_fd_sc_hd__o22ai_1
X_13375_ _07518_ _07736_ _07737_ _07746_ u_core.u_top.u_core.r_piter[0] VSS VSS VDD VDD _07747_ sky130_fd_sc_hd__a311o_1
X_13376_ _07745_ _07747_ VSS VSS VDD VDD _07748_ sky130_fd_sc_hd__nand2_1
X_13377_ _07735_ _07741_ _07748_ u_core.u_top.u_core.r_piter[5] net796 VSS VSS VDD VDD _07749_ sky130_fd_sc_hd__a221oi_1
X_13378_ net811 _07731_ _07749_ VSS VSS VDD VDD _07750_ sky130_fd_sc_hd__a21oi_1
X_13379_ _07727_ _07750_ _06914_ VSS VSS VDD VDD _07751_ sky130_fd_sc_hd__a21oi_1
X_13380_ _06578_ u_core.u_top.u_spi.shift_out[1] _07751_ VSS VSS VDD VDD _07752_ sky130_fd_sc_hd__a21oi_1
X_13381_ net805 net804 VSS VSS VDD VDD _07753_ sky130_fd_sc_hd__nand2b_1
X_13382_ net802 _07753_ VSS VSS VDD VDD _07754_ sky130_fd_sc_hd__nor2_1
X_13383_ net804 net805 VSS VSS VDD VDD _07755_ sky130_fd_sc_hd__nand2b_1
X_13384_ net800 _07755_ VSS VSS VDD VDD _07756_ sky130_fd_sc_hd__nor2_1
X_13385_ _07754_ _07756_ VSS VSS VDD VDD _07757_ sky130_fd_sc_hd__nor2_1
X_13386_ net803 net801 VSS VSS VDD VDD _07758_ sky130_fd_sc_hd__nand2_1
X_13387_ _07758_ _07597_ VSS VSS VDD VDD _07759_ sky130_fd_sc_hd__and2_1
X_13388_ net806 _07236_ _07759_ net767 VSS VSS VDD VDD _07760_ sky130_fd_sc_hd__o22a_1
X_13389_ _07428_ _07625_ VSS VSS VDD VDD _07761_ sky130_fd_sc_hd__and2_1
X_13390_ net803 _07761_ _07626_ VSS VSS VDD VDD _07762_ sky130_fd_sc_hd__a21oi_1
X_13391_ net803 net806 net800 VSS VSS VDD VDD _07763_ sky130_fd_sc_hd__nand3_1
X_13392_ net803 _07428_ _07763_ VSS VSS VDD VDD _07764_ sky130_fd_sc_hd__o21ai_0
X_13393_ net767 _07764_ VSS VSS VDD VDD _07765_ sky130_fd_sc_hd__nor2_1
X_13394_ _07753_ _07755_ VSS VSS VDD VDD _07766_ sky130_fd_sc_hd__nand2_1
X_13395_ net767 _07762_ _07765_ _07766_ VSS VSS VDD VDD _07767_ sky130_fd_sc_hd__a211o_1
X_13396_ net802 _07755_ VSS VSS VDD VDD _07768_ sky130_fd_sc_hd__or2_2
X_13397_ net800 _07387_ _07753_ _07768_ _07630_ VSS VSS VDD VDD _07769_ sky130_fd_sc_hd__o32ai_1
X_13398_ _07428_ _07753_ _07755_ _07625_ VSS VSS VDD VDD _07770_ sky130_fd_sc_hd__o22ai_1
X_13399_ net803 _07770_ VSS VSS VDD VDD _07771_ sky130_fd_sc_hd__nand2_1
X_13400_ net800 _07597_ _07753_ _07771_ net767 VSS VSS VDD VDD _07772_ sky130_fd_sc_hd__o311ai_0
X_13401_ net767 _07769_ _07772_ VSS VSS VDD VDD _07773_ sky130_fd_sc_hd__o21ai_0
X_13402_ _07757_ _07760_ _07767_ _07773_ VSS VSS VDD VDD _07774_ sky130_fd_sc_hd__o211ai_1
X_13403_ _07328_ _07428_ _07625_ _07391_ VSS VSS VDD VDD _07775_ sky130_fd_sc_hd__o22ai_1
X_13404_ _07328_ _07391_ _07761_ _07775_ VSS VSS VDD VDD _07776_ sky130_fd_sc_hd__a31oi_1
X_13405_ _07758_ _07768_ VSS VSS VDD VDD _07777_ sky130_fd_sc_hd__nor2_1
X_13406_ net767 net800 _07597_ _07753_ VSS VSS VDD VDD _07778_ sky130_fd_sc_hd__nor4_1
X_13407_ _07164_ net801 VSS VSS VDD VDD _07779_ sky130_fd_sc_hd__nor2_1
X_13408_ net767 _07630_ VSS VSS VDD VDD _07780_ sky130_fd_sc_hd__nor2_1
X_13409_ net767 _07779_ _07780_ VSS VSS VDD VDD _07781_ sky130_fd_sc_hd__a21oi_1
X_13410_ _07328_ _07391_ _07770_ VSS VSS VDD VDD _07782_ sky130_fd_sc_hd__nand3_1
X_13411_ _07757_ _07781_ _07782_ VSS VSS VDD VDD _07783_ sky130_fd_sc_hd__o21ai_0
X_13412_ net767 _07777_ _07778_ _07783_ VSS VSS VDD VDD _07784_ sky130_fd_sc_hd__a211oi_1
X_13413_ _07766_ _07776_ _07784_ VSS VSS VDD VDD _07785_ sky130_fd_sc_hd__o21ai_0
X_13414_ _07774_ _07785_ _06968_ VSS VSS VDD VDD _07786_ sky130_fd_sc_hd__mux2i_1
X_13415_ _07123_ _07786_ VSS VSS VDD VDD _07787_ sky130_fd_sc_hd__nand2_1
X_13416_ net770 _07759_ VSS VSS VDD VDD _07788_ sky130_fd_sc_hd__nor2_1
X_13417_ net770 _07779_ _07788_ VSS VSS VDD VDD _07789_ sky130_fd_sc_hd__a21oi_1
X_13418_ net770 _07764_ VSS VSS VDD VDD _07790_ sky130_fd_sc_hd__nor2_1
X_13419_ _07164_ _07428_ VSS VSS VDD VDD _07791_ sky130_fd_sc_hd__nor2_1
X_13420_ _07164_ _07761_ _07791_ net767 VSS VSS VDD VDD _07792_ sky130_fd_sc_hd__a211oi_1
X_13421_ _07766_ _07790_ _07792_ VSS VSS VDD VDD _07793_ sky130_fd_sc_hd__nor3_1
X_13422_ _07164_ _07770_ _07777_ VSS VSS VDD VDD _07794_ sky130_fd_sc_hd__a21oi_1
X_13423_ net767 _07794_ VSS VSS VDD VDD _07795_ sky130_fd_sc_hd__nor2_1
X_13424_ net767 _07769_ _07793_ _07795_ VSS VSS VDD VDD _07796_ sky130_fd_sc_hd__a211oi_1
X_13425_ _07757_ _07789_ _07796_ VSS VSS VDD VDD _07797_ sky130_fd_sc_hd__o21ai_0
X_13426_ _07785_ _07797_ _06968_ VSS VSS VDD VDD _07798_ sky130_fd_sc_hd__mux2i_1
X_13427_ _07786_ _07798_ _07123_ VSS VSS VDD VDD _07799_ sky130_fd_sc_hd__mux2i_1
X_13428_ _07787_ _07799_ net772 VSS VSS VDD VDD _07800_ sky130_fd_sc_hd__mux2i_1
X_13429_ _07774_ _07797_ _06967_ VSS VSS VDD VDD _07801_ sky130_fd_sc_hd__mux2i_1
X_13430_ _07646_ _07700_ _07801_ VSS VSS VDD VDD _07802_ sky130_fd_sc_hd__o21ai_0
X_13431_ _07205_ net772 VSS VSS VDD VDD _07803_ sky130_fd_sc_hd__nor2_1
X_13432_ _07803_ _07798_ VSS VSS VDD VDD _07804_ sky130_fd_sc_hd__nand2_1
X_13433_ _07802_ _07804_ _07123_ VSS VSS VDD VDD _07805_ sky130_fd_sc_hd__a21oi_1
X_13434_ net766 _07379_ _07801_ VSS VSS VDD VDD _07806_ sky130_fd_sc_hd__nand3_1
X_13435_ _07123_ _07646_ _07786_ VSS VSS VDD VDD _07807_ sky130_fd_sc_hd__nand3_1
X_13436_ _06588_ net797 _07806_ _07807_ VSS VSS VDD VDD _07808_ sky130_fd_sc_hd__nand4_1
X_13437_ _07205_ _07800_ _07805_ _07808_ VSS VSS VDD VDD _07809_ sky130_fd_sc_hd__a211o_1
X_13438_ u_core.u_top.u_spi.shift_out[0] net816 VSS VSS VDD VDD _07810_ sky130_fd_sc_hd__nor2_1
X_13439_ net816 _07752_ _07809_ _07810_ VSS VSS VDD VDD _2236_[1] sky130_fd_sc_hd__a31oi_1
X_13440_ _07801_ _07786_ _07123_ VSS VSS VDD VDD _07811_ sky130_fd_sc_hd__mux2i_1
X_13441_ _07803_ _07799_ _07811_ _07207_ VSS VSS VDD VDD _07812_ sky130_fd_sc_hd__a22oi_1
X_13442_ _07798_ _07801_ _07123_ VSS VSS VDD VDD _07813_ sky130_fd_sc_hd__mux2i_1
X_13443_ _07646_ _07700_ _07813_ VSS VSS VDD VDD _07814_ sky130_fd_sc_hd__o21ai_0
X_13444_ net958 _07278_ VSS VSS VDD VDD _07815_ sky130_fd_sc_hd__nor2_1
X_13445_ u_core.u_top.u_core.d_acc[21] u_core.u_top.u_core.d_acc[20] VSS VSS VDD VDD _07816_ sky130_fd_sc_hd__xnor2_1
X_13446_ u_core.u_top.u_core.d_acc[211] u_core.u_top.u_core.d_acc[100] VSS VSS VDD VDD _07817_ sky130_fd_sc_hd__xnor2_1
X_13447_ _07816_ _07817_ VSS VSS VDD VDD _07818_ sky130_fd_sc_hd__xnor2_1
X_13448_ u_core.u_top.u_core.d_acc[235] u_core.u_top.u_core.d_acc[227] VSS VSS VDD VDD _07819_ sky130_fd_sc_hd__xnor2_1
X_13449_ u_core.u_top.u_core.d_acc[237] u_core.u_top.u_core.d_acc[234] VSS VSS VDD VDD _07820_ sky130_fd_sc_hd__xnor2_1
X_13450_ _07819_ _07820_ VSS VSS VDD VDD _07821_ sky130_fd_sc_hd__xnor2_1
X_13451_ _07818_ _07821_ VSS VSS VDD VDD _07822_ sky130_fd_sc_hd__xnor2_1
X_13452_ u_core.u_top.u_core.d_acc[156] u_core.u_top.u_core.d_acc[157] VSS VSS VDD VDD _07823_ sky130_fd_sc_hd__xor2_1
X_13453_ u_core.u_top.u_core.d_acc[158] u_core.u_top.u_core.d_acc[159] VSS VSS VDD VDD _07824_ sky130_fd_sc_hd__xnor2_1
X_13454_ _07823_ _07824_ VSS VSS VDD VDD _07825_ sky130_fd_sc_hd__xnor2_1
X_13455_ u_core.u_top.u_core.d_acc[137] u_core.u_top.u_core.d_acc[134] VSS VSS VDD VDD _07826_ sky130_fd_sc_hd__xnor2_1
X_13456_ u_core.u_top.u_core.d_acc[60] u_core.u_top.u_core.d_acc[141] VSS VSS VDD VDD _07827_ sky130_fd_sc_hd__xnor2_1
X_13457_ _07826_ _07827_ VSS VSS VDD VDD _07828_ sky130_fd_sc_hd__xnor2_1
X_13458_ _07825_ _07828_ VSS VSS VDD VDD _07829_ sky130_fd_sc_hd__xnor2_1
X_13459_ _07822_ _07829_ VSS VSS VDD VDD _07830_ sky130_fd_sc_hd__xnor2_1
X_13460_ u_core.u_top.u_core.d_acc[181] u_core.u_top.u_core.d_acc[162] VSS VSS VDD VDD _07831_ sky130_fd_sc_hd__xor2_1
X_13461_ u_core.u_top.u_core.d_acc[223] u_core.u_top.u_core.d_acc[214] VSS VSS VDD VDD _07832_ sky130_fd_sc_hd__xnor2_1
X_13462_ _07831_ _07832_ VSS VSS VDD VDD _07833_ sky130_fd_sc_hd__xnor2_1
X_13463_ u_core.u_top.u_core.d_acc[169] u_core.u_top.u_core.d_acc[163] VSS VSS VDD VDD _07834_ sky130_fd_sc_hd__xnor2_1
X_13464_ u_core.u_top.u_core.d_acc[224] u_core.u_top.u_core.d_acc[175] VSS VSS VDD VDD _07835_ sky130_fd_sc_hd__xnor2_1
X_13465_ _07834_ _07835_ VSS VSS VDD VDD _07836_ sky130_fd_sc_hd__xnor2_1
X_13466_ _07833_ _07836_ VSS VSS VDD VDD _07837_ sky130_fd_sc_hd__xnor2_1
X_13467_ u_core.u_top.u_core.d_acc[61] u_core.u_top.u_core.d_acc[58] VSS VSS VDD VDD _07838_ sky130_fd_sc_hd__xor2_1
X_13468_ u_core.u_top.u_core.d_acc[62] u_core.u_top.u_core.d_acc[63] VSS VSS VDD VDD _07839_ sky130_fd_sc_hd__xnor2_1
X_13469_ _07838_ _07839_ VSS VSS VDD VDD _07840_ sky130_fd_sc_hd__xnor2_1
X_13470_ u_core.u_top.u_core.d_acc[236] u_core.u_top.u_core.d_acc[231] VSS VSS VDD VDD _07841_ sky130_fd_sc_hd__xnor2_1
X_13471_ u_core.u_top.u_core.d_acc[238] u_core.u_top.u_core.d_acc[239] VSS VSS VDD VDD _07842_ sky130_fd_sc_hd__xnor2_1
X_13472_ _07841_ _07842_ VSS VSS VDD VDD _07843_ sky130_fd_sc_hd__xnor2_1
X_13473_ _07840_ _07843_ VSS VSS VDD VDD _07844_ sky130_fd_sc_hd__xnor2_1
X_13474_ _07837_ _07844_ VSS VSS VDD VDD _07845_ sky130_fd_sc_hd__xnor2_1
X_13475_ _07830_ _07845_ VSS VSS VDD VDD _07846_ sky130_fd_sc_hd__xnor2_1
X_13476_ u_core.u_top.u_core.d_acc[97] u_core.u_top.u_core.d_acc[94] VSS VSS VDD VDD _07847_ sky130_fd_sc_hd__xor2_1
X_13477_ u_core.u_top.u_core.d_acc[99] u_core.u_top.u_core.d_acc[96] VSS VSS VDD VDD _07848_ sky130_fd_sc_hd__xnor2_1
X_13478_ _07847_ _07848_ VSS VSS VDD VDD _07849_ sky130_fd_sc_hd__xnor2_1
X_13479_ u_core.u_top.u_core.d_acc[65] u_core.u_top.u_core.d_acc[59] VSS VSS VDD VDD _07850_ sky130_fd_sc_hd__xnor2_1
X_13480_ u_core.u_top.u_core.d_acc[93] u_core.u_top.u_core.d_acc[67] VSS VSS VDD VDD _07851_ sky130_fd_sc_hd__xnor2_1
X_13481_ _07850_ _07851_ VSS VSS VDD VDD _07852_ sky130_fd_sc_hd__xnor2_1
X_13482_ _07849_ _07852_ VSS VSS VDD VDD _07853_ sky130_fd_sc_hd__xnor2_1
X_13483_ u_core.u_top.u_core.d_acc[107] u_core.u_top.u_core.d_acc[103] VSS VSS VDD VDD _07854_ sky130_fd_sc_hd__xor2_1
X_13484_ u_core.u_top.u_core.d_acc[135] u_core.u_top.u_core.d_acc[106] VSS VSS VDD VDD _07855_ sky130_fd_sc_hd__xnor2_1
X_13485_ _07854_ _07855_ VSS VSS VDD VDD _07856_ sky130_fd_sc_hd__xnor2_1
X_13486_ u_core.u_top.u_core.d_acc[101] u_core.u_top.u_core.d_acc[95] VSS VSS VDD VDD _07857_ sky130_fd_sc_hd__xnor2_1
X_13487_ u_core.u_top.u_core.d_acc[104] u_core.u_top.u_core.d_acc[105] VSS VSS VDD VDD _07858_ sky130_fd_sc_hd__xnor2_1
X_13488_ _07857_ _07858_ VSS VSS VDD VDD _07859_ sky130_fd_sc_hd__xnor2_1
X_13489_ _07856_ _07859_ VSS VSS VDD VDD _07860_ sky130_fd_sc_hd__xnor2_1
X_13490_ _07853_ _07860_ VSS VSS VDD VDD _07861_ sky130_fd_sc_hd__xnor2_1
X_13491_ u_core.u_top.u_core.d_acc[55] u_core.u_top.u_core.d_acc[53] VSS VSS VDD VDD _07862_ sky130_fd_sc_hd__xor2_1
X_13492_ u_core.u_top.u_core.d_acc[92] u_core.u_top.u_core.d_acc[54] VSS VSS VDD VDD _07863_ sky130_fd_sc_hd__xnor2_1
X_13493_ _07862_ _07863_ VSS VSS VDD VDD _07864_ sky130_fd_sc_hd__xnor2_1
X_13494_ u_core.u_top.u_core.d_acc[42] u_core.u_top.u_core.d_acc[19] VSS VSS VDD VDD _07865_ sky130_fd_sc_hd__xnor2_1
X_13495_ u_core.u_top.u_core.d_acc[51] u_core.u_top.u_core.d_acc[45] VSS VSS VDD VDD _07866_ sky130_fd_sc_hd__xnor2_1
X_13496_ _07865_ _07866_ VSS VSS VDD VDD _07867_ sky130_fd_sc_hd__xnor2_1
X_13497_ _07864_ _07867_ VSS VSS VDD VDD _07868_ sky130_fd_sc_hd__xnor2_1
X_13498_ u_core.u_top.u_core.d_acc[229] u_core.u_top.u_core.d_acc[226] VSS VSS VDD VDD _07869_ sky130_fd_sc_hd__xor2_1
X_13499_ u_core.u_top.u_core.d_acc[70] u_core.u_top.u_core.d_acc[228] VSS VSS VDD VDD _07870_ sky130_fd_sc_hd__xnor2_1
X_13500_ _07869_ _07870_ VSS VSS VDD VDD _07871_ sky130_fd_sc_hd__xnor2_1
X_13501_ u_core.u_top.u_core.d_acc[57] u_core.u_top.u_core.d_acc[52] VSS VSS VDD VDD _07872_ sky130_fd_sc_hd__xnor2_1
X_13502_ u_core.u_top.u_core.d_acc[64] u_core.u_top.u_core.d_acc[56] VSS VSS VDD VDD _07873_ sky130_fd_sc_hd__xnor2_1
X_13503_ _07872_ _07873_ VSS VSS VDD VDD _07874_ sky130_fd_sc_hd__xnor2_1
X_13504_ _07871_ _07874_ VSS VSS VDD VDD _07875_ sky130_fd_sc_hd__xnor2_1
X_13505_ _07868_ _07875_ VSS VSS VDD VDD _07876_ sky130_fd_sc_hd__xnor2_1
X_13506_ _07861_ _07876_ VSS VSS VDD VDD _07877_ sky130_fd_sc_hd__xnor2_1
X_13507_ _07846_ _07877_ VSS VSS VDD VDD _07878_ sky130_fd_sc_hd__xnor2_1
X_13508_ u_core.u_top.u_core.d_acc[50] u_core.u_top.u_core.d_acc[90] VSS VSS VDD VDD _07879_ sky130_fd_sc_hd__xor2_1
X_13509_ u_core.u_top.u_core.d_acc[10] u_core.u_top.u_core.d_acc[0] VSS VSS VDD VDD _07880_ sky130_fd_sc_hd__xnor2_1
X_13510_ _07879_ _07880_ VSS VSS VDD VDD _07881_ sky130_fd_sc_hd__xnor2_1
X_13511_ u_core.u_top.u_core.d_acc[80] u_core.u_top.u_core.d_acc[195] VSS VSS VDD VDD _07882_ sky130_fd_sc_hd__xnor2_1
X_13512_ u_core.u_top.u_core.d_acc[30] u_core.u_top.u_core.d_acc[40] VSS VSS VDD VDD _07883_ sky130_fd_sc_hd__xnor2_1
X_13513_ _07882_ _07883_ VSS VSS VDD VDD _07884_ sky130_fd_sc_hd__xnor2_1
X_13514_ _07881_ _07884_ VSS VSS VDD VDD _07885_ sky130_fd_sc_hd__xnor2_1
X_13515_ u_core.u_top.u_core.d_acc[176] u_core.u_top.u_core.d_acc[164] VSS VSS VDD VDD _07886_ sky130_fd_sc_hd__xor2_1
X_13516_ u_core.u_top.u_core.d_acc[178] u_core.u_top.u_core.d_acc[179] VSS VSS VDD VDD _07887_ sky130_fd_sc_hd__xnor2_1
X_13517_ _07886_ _07887_ VSS VSS VDD VDD _07888_ sky130_fd_sc_hd__xnor2_1
X_13518_ u_core.u_top.u_core.d_acc[108] u_core.u_top.u_core.d_acc[109] VSS VSS VDD VDD _07889_ sky130_fd_sc_hd__xnor2_1
X_13519_ u_core.u_top.u_core.d_acc[121] u_core.u_top.u_core.d_acc[120] VSS VSS VDD VDD _07890_ sky130_fd_sc_hd__xnor2_1
X_13520_ _07889_ _07890_ VSS VSS VDD VDD _07891_ sky130_fd_sc_hd__xnor2_1
X_13521_ _07888_ _07891_ VSS VSS VDD VDD _07892_ sky130_fd_sc_hd__xnor2_1
X_13522_ _07885_ _07892_ VSS VSS VDD VDD _07893_ sky130_fd_sc_hd__xnor2_1
X_13523_ u_core.u_top.u_core.d_acc[191] u_core.u_top.u_core.d_acc[187] VSS VSS VDD VDD _07894_ sky130_fd_sc_hd__xor2_1
X_13524_ u_core.u_top.u_core.d_acc[193] u_core.u_top.u_core.d_acc[190] VSS VSS VDD VDD _07895_ sky130_fd_sc_hd__xnor2_1
X_13525_ _07894_ _07895_ VSS VSS VDD VDD _07896_ sky130_fd_sc_hd__xnor2_1
X_13526_ u_core.u_top.u_core.d_acc[186] u_core.u_top.u_core.d_acc[184] VSS VSS VDD VDD _07897_ sky130_fd_sc_hd__xnor2_1
X_13527_ u_core.u_top.u_core.d_acc[192] u_core.u_top.u_core.d_acc[188] VSS VSS VDD VDD _07898_ sky130_fd_sc_hd__xnor2_1
X_13528_ _07897_ _07898_ VSS VSS VDD VDD _07899_ sky130_fd_sc_hd__xnor2_1
X_13529_ _07896_ _07899_ VSS VSS VDD VDD _07900_ sky130_fd_sc_hd__xnor2_1
X_13530_ u_core.u_top.u_core.d_acc[46] u_core.u_top.u_core.d_acc[47] VSS VSS VDD VDD _07901_ sky130_fd_sc_hd__xor2_1
X_13531_ u_core.u_top.u_core.d_acc[76] u_core.u_top.u_core.d_acc[77] VSS VSS VDD VDD _07902_ sky130_fd_sc_hd__xnor2_1
X_13532_ _07901_ _07902_ VSS VSS VDD VDD _07903_ sky130_fd_sc_hd__xnor2_1
X_13533_ u_core.u_top.u_core.d_acc[81] u_core.u_top.u_core.d_acc[78] VSS VSS VDD VDD _07904_ sky130_fd_sc_hd__xnor2_1
X_13534_ u_core.u_top.u_core.d_acc[85] u_core.u_top.u_core.d_acc[82] VSS VSS VDD VDD _07905_ sky130_fd_sc_hd__xnor2_1
X_13535_ _07904_ _07905_ VSS VSS VDD VDD _07906_ sky130_fd_sc_hd__xnor2_1
X_13536_ _07903_ _07906_ VSS VSS VDD VDD _07907_ sky130_fd_sc_hd__xnor2_1
X_13537_ _07900_ _07907_ VSS VSS VDD VDD _07908_ sky130_fd_sc_hd__xnor2_1
X_13538_ _07893_ _07908_ VSS VSS VDD VDD _07909_ sky130_fd_sc_hd__xnor2_1
X_13539_ u_core.u_top.u_core.d_acc[68] u_core.u_top.u_core.d_acc[69] VSS VSS VDD VDD _07910_ sky130_fd_sc_hd__xor2_1
X_13540_ u_core.u_top.u_core.d_acc[73] u_core.u_top.u_core.d_acc[71] VSS VSS VDD VDD _07911_ sky130_fd_sc_hd__xnor2_1
X_13541_ _07910_ _07911_ VSS VSS VDD VDD _07912_ sky130_fd_sc_hd__xnor2_1
X_13542_ u_core.u_top.u_core.d_acc[79] u_core.u_top.u_core.d_acc[44] VSS VSS VDD VDD _07913_ sky130_fd_sc_hd__xnor2_1
X_13543_ u_core.u_top.u_core.d_acc[86] u_core.u_top.u_core.d_acc[87] VSS VSS VDD VDD _07914_ sky130_fd_sc_hd__xnor2_1
X_13544_ _07913_ _07914_ VSS VSS VDD VDD _07915_ sky130_fd_sc_hd__xnor2_1
X_13545_ _07912_ _07915_ VSS VSS VDD VDD _07916_ sky130_fd_sc_hd__xnor2_1
X_13546_ u_core.u_top.u_core.d_acc[89] u_core.u_top.u_core.d_acc[75] VSS VSS VDD VDD _07917_ sky130_fd_sc_hd__xor2_1
X_13547_ u_core.u_top.u_core.d_acc[91] u_core.u_top.u_core.d_acc[88] VSS VSS VDD VDD _07918_ sky130_fd_sc_hd__xnor2_1
X_13548_ _07917_ _07918_ VSS VSS VDD VDD _07919_ sky130_fd_sc_hd__xnor2_1
X_13549_ u_core.u_top.u_core.d_acc[72] u_core.u_top.u_core.d_acc[66] VSS VSS VDD VDD _07920_ sky130_fd_sc_hd__xnor2_1
X_13550_ u_core.u_top.u_core.d_acc[84] u_core.u_top.u_core.d_acc[74] VSS VSS VDD VDD _07921_ sky130_fd_sc_hd__xnor2_1
X_13551_ _07920_ _07921_ VSS VSS VDD VDD _07922_ sky130_fd_sc_hd__xnor2_1
X_13552_ _07919_ _07922_ VSS VSS VDD VDD _07923_ sky130_fd_sc_hd__xnor2_1
X_13553_ _07916_ _07923_ VSS VSS VDD VDD _07924_ sky130_fd_sc_hd__xnor2_1
X_13554_ u_core.u_top.u_core.d_acc[35] u_core.u_top.u_core.d_acc[32] VSS VSS VDD VDD _07925_ sky130_fd_sc_hd__xor2_1
X_13555_ u_core.u_top.u_core.d_acc[43] u_core.u_top.u_core.d_acc[37] VSS VSS VDD VDD _07926_ sky130_fd_sc_hd__xnor2_1
X_13556_ _07925_ _07926_ VSS VSS VDD VDD _07927_ sky130_fd_sc_hd__xnor2_1
X_13557_ u_core.u_top.u_core.d_acc[31] u_core.u_top.u_core.d_acc[28] VSS VSS VDD VDD _07928_ sky130_fd_sc_hd__xnor2_1
X_13558_ u_core.u_top.u_core.d_acc[102] u_core.u_top.u_core.d_acc[33] VSS VSS VDD VDD _07929_ sky130_fd_sc_hd__xnor2_1
X_13559_ _07928_ _07929_ VSS VSS VDD VDD _07930_ sky130_fd_sc_hd__xnor2_1
X_13560_ _07927_ _07930_ VSS VSS VDD VDD _07931_ sky130_fd_sc_hd__xnor2_1
X_13561_ u_core.u_top.u_core.d_acc[197] u_core.u_top.u_core.d_acc[34] VSS VSS VDD VDD _07932_ sky130_fd_sc_hd__xor2_1
X_13562_ u_core.u_top.u_core.d_acc[131] u_core.u_top.u_core.d_acc[199] VSS VSS VDD VDD _07933_ sky130_fd_sc_hd__xnor2_1
X_13563_ _07932_ _07933_ VSS VSS VDD VDD _07934_ sky130_fd_sc_hd__xnor2_1
X_13564_ u_core.u_top.u_core.d_acc[39] u_core.u_top.u_core.d_acc[36] VSS VSS VDD VDD _07935_ sky130_fd_sc_hd__xnor2_1
X_13565_ u_core.u_top.u_core.d_acc[41] u_core.u_top.u_core.d_acc[38] VSS VSS VDD VDD _07936_ sky130_fd_sc_hd__xnor2_1
X_13566_ _07935_ _07936_ VSS VSS VDD VDD _07937_ sky130_fd_sc_hd__xnor2_1
X_13567_ _07934_ _07937_ VSS VSS VDD VDD _07938_ sky130_fd_sc_hd__xnor2_1
X_13568_ _07931_ _07938_ VSS VSS VDD VDD _07939_ sky130_fd_sc_hd__xnor2_1
X_13569_ _07924_ _07939_ VSS VSS VDD VDD _07940_ sky130_fd_sc_hd__xnor2_1
X_13570_ _07909_ _07940_ VSS VSS VDD VDD _07941_ sky130_fd_sc_hd__xnor2_1
X_13571_ _07878_ _07941_ VSS VSS VDD VDD _07942_ sky130_fd_sc_hd__xnor2_1
X_13572_ u_core.u_top.u_core.d_acc[215] u_core.u_top.u_core.d_acc[212] VSS VSS VDD VDD _07943_ sky130_fd_sc_hd__xnor2_1
X_13573_ u_core.u_top.u_core.d_acc[233] u_core.u_top.u_core.d_acc[230] VSS VSS VDD VDD _07944_ sky130_fd_sc_hd__xnor2_1
X_13574_ _07943_ _07944_ VSS VSS VDD VDD _07945_ sky130_fd_sc_hd__xnor2_1
X_13575_ u_core.u_top.u_core.d_acc[205] u_core.u_top.u_core.d_acc[198] VSS VSS VDD VDD _07946_ sky130_fd_sc_hd__xnor2_1
X_13576_ u_core.u_top.u_core.d_acc[207] u_core.u_top.u_core.d_acc[204] VSS VSS VDD VDD _07947_ sky130_fd_sc_hd__xnor2_1
X_13577_ _07946_ _07947_ VSS VSS VDD VDD _07948_ sky130_fd_sc_hd__xnor2_1
X_13578_ _07945_ _07948_ VSS VSS VDD VDD _07949_ sky130_fd_sc_hd__xnor2_1
X_13579_ u_core.u_top.u_core.d_acc[152] u_core.u_top.u_core.d_acc[98] VSS VSS VDD VDD _07950_ sky130_fd_sc_hd__xor2_1
X_13580_ u_core.u_top.u_core.d_acc[154] u_core.u_top.u_core.d_acc[155] VSS VSS VDD VDD _07951_ sky130_fd_sc_hd__xnor2_1
X_13581_ _07950_ _07951_ VSS VSS VDD VDD _07952_ sky130_fd_sc_hd__xnor2_1
X_13582_ u_core.u_top.u_core.d_acc[48] u_core.u_top.u_core.d_acc[49] VSS VSS VDD VDD _07953_ sky130_fd_sc_hd__xnor2_1
X_13583_ u_core.u_top.u_core.d_acc[232] u_core.u_top.u_core.d_acc[206] VSS VSS VDD VDD _07954_ sky130_fd_sc_hd__xnor2_1
X_13584_ _07953_ _07954_ VSS VSS VDD VDD _07955_ sky130_fd_sc_hd__xnor2_1
X_13585_ _07952_ _07955_ VSS VSS VDD VDD _07956_ sky130_fd_sc_hd__xnor2_1
X_13586_ _07949_ _07956_ VSS VSS VDD VDD _07957_ sky130_fd_sc_hd__xnor2_1
X_13587_ u_core.u_top.u_core.d_acc[172] u_core.u_top.u_core.d_acc[168] VSS VSS VDD VDD _07958_ sky130_fd_sc_hd__xor2_1
X_13588_ u_core.u_top.u_core.d_acc[177] u_core.u_top.u_core.d_acc[174] VSS VSS VDD VDD _07959_ sky130_fd_sc_hd__xnor2_1
X_13589_ _07958_ _07959_ VSS VSS VDD VDD _07960_ sky130_fd_sc_hd__xnor2_1
X_13590_ u_core.u_top.u_core.d_acc[171] u_core.u_top.u_core.d_acc[165] VSS VSS VDD VDD _07961_ sky130_fd_sc_hd__xnor2_1
X_13591_ u_core.u_top.u_core.d_acc[194] u_core.u_top.u_core.d_acc[173] VSS VSS VDD VDD _07962_ sky130_fd_sc_hd__xnor2_1
X_13592_ _07961_ _07962_ VSS VSS VDD VDD _07963_ sky130_fd_sc_hd__xnor2_1
X_13593_ _07960_ _07963_ VSS VSS VDD VDD _07964_ sky130_fd_sc_hd__xnor2_1
X_13594_ u_core.u_top.u_core.d_acc[153] u_core.u_top.u_core.d_acc[148] VSS VSS VDD VDD _07965_ sky130_fd_sc_hd__xor2_1
X_13595_ u_core.u_top.u_core.d_acc[182] u_core.u_top.u_core.d_acc[183] VSS VSS VDD VDD _07966_ sky130_fd_sc_hd__xnor2_1
X_13596_ _07965_ _07966_ VSS VSS VDD VDD _07967_ sky130_fd_sc_hd__xnor2_1
X_13597_ u_core.u_top.u_core.d_acc[189] u_core.u_top.u_core.d_acc[185] VSS VSS VDD VDD _07968_ sky130_fd_sc_hd__xnor2_1
X_13598_ u_core.u_top.u_core.d_acc[209] u_core.u_top.u_core.d_acc[196] VSS VSS VDD VDD _07969_ sky130_fd_sc_hd__xnor2_1
X_13599_ _07968_ _07969_ VSS VSS VDD VDD _07970_ sky130_fd_sc_hd__xnor2_1
X_13600_ _07967_ _07970_ VSS VSS VDD VDD _07971_ sky130_fd_sc_hd__xnor2_1
X_13601_ _07964_ _07971_ VSS VSS VDD VDD _07972_ sky130_fd_sc_hd__xnor2_1
X_13602_ _07957_ _07972_ VSS VSS VDD VDD _07973_ sky130_fd_sc_hd__xnor2_1
X_13603_ u_core.u_top.u_core.d_acc[118] u_core.u_top.u_core.d_acc[119] VSS VSS VDD VDD _07974_ sky130_fd_sc_hd__xor2_1
X_13604_ u_core.u_top.u_core.d_acc[126] u_core.u_top.u_core.d_acc[123] VSS VSS VDD VDD _07975_ sky130_fd_sc_hd__xnor2_1
X_13605_ _07974_ _07975_ VSS VSS VDD VDD _07976_ sky130_fd_sc_hd__xnor2_1
X_13606_ u_core.u_top.u_core.d_acc[125] u_core.u_top.u_core.d_acc[122] VSS VSS VDD VDD _07977_ sky130_fd_sc_hd__xnor2_1
X_13607_ u_core.u_top.u_core.d_acc[127] u_core.u_top.u_core.d_acc[124] VSS VSS VDD VDD _07978_ sky130_fd_sc_hd__xnor2_1
X_13608_ _07977_ _07978_ VSS VSS VDD VDD _07979_ sky130_fd_sc_hd__xnor2_1
X_13609_ _07976_ _07979_ VSS VSS VDD VDD _07980_ sky130_fd_sc_hd__xnor2_1
X_13610_ u_core.u_top.u_core.d_acc[111] u_core.u_top.u_core.d_acc[83] VSS VSS VDD VDD _07981_ sky130_fd_sc_hd__xor2_1
X_13611_ u_core.u_top.u_core.d_acc[116] u_core.u_top.u_core.d_acc[113] VSS VSS VDD VDD _07982_ sky130_fd_sc_hd__xnor2_1
X_13612_ _07981_ _07982_ VSS VSS VDD VDD _07983_ sky130_fd_sc_hd__xnor2_1
X_13613_ u_core.u_top.u_core.d_acc[115] u_core.u_top.u_core.d_acc[112] VSS VSS VDD VDD _07984_ sky130_fd_sc_hd__xnor2_1
X_13614_ u_core.u_top.u_core.d_acc[117] u_core.u_top.u_core.d_acc[114] VSS VSS VDD VDD _07985_ sky130_fd_sc_hd__xnor2_1
X_13615_ _07984_ _07985_ VSS VSS VDD VDD _07986_ sky130_fd_sc_hd__xnor2_1
X_13616_ _07983_ _07986_ VSS VSS VDD VDD _07987_ sky130_fd_sc_hd__xnor2_1
X_13617_ _07980_ _07987_ VSS VSS VDD VDD _07988_ sky130_fd_sc_hd__xnor2_1
X_13618_ u_core.u_top.u_core.d_acc[213] u_core.u_top.u_core.d_acc[129] VSS VSS VDD VDD _07989_ sky130_fd_sc_hd__xor2_1
X_13619_ u_core.u_top.u_core.d_acc[221] u_core.u_top.u_core.d_acc[217] VSS VSS VDD VDD _07990_ sky130_fd_sc_hd__xnor2_1
X_13620_ _07989_ _07990_ VSS VSS VDD VDD _07991_ sky130_fd_sc_hd__xnor2_1
X_13621_ u_core.u_top.u_core.d_acc[170] u_core.u_top.u_core.d_acc[180] VSS VSS VDD VDD _07992_ sky130_fd_sc_hd__xnor2_1
X_13622_ u_core.u_top.u_core.d_acc[110] u_core.u_top.u_core.d_acc[220] VSS VSS VDD VDD _07993_ sky130_fd_sc_hd__xnor2_1
X_13623_ _07992_ _07993_ VSS VSS VDD VDD _07994_ sky130_fd_sc_hd__xnor2_1
X_13624_ _07991_ _07994_ VSS VSS VDD VDD _07995_ sky130_fd_sc_hd__xnor2_1
X_13625_ u_core.u_top.u_core.d_acc[133] u_core.u_top.u_core.d_acc[128] VSS VSS VDD VDD _07996_ sky130_fd_sc_hd__xor2_1
X_13626_ u_core.u_top.u_core.d_acc[143] u_core.u_top.u_core.d_acc[132] VSS VSS VDD VDD _07997_ sky130_fd_sc_hd__xnor2_1
X_13627_ _07996_ _07997_ VSS VSS VDD VDD _07998_ sky130_fd_sc_hd__xnor2_1
X_13628_ u_core.u_top.u_core.d_acc[139] u_core.u_top.u_core.d_acc[136] VSS VSS VDD VDD _07999_ sky130_fd_sc_hd__xnor2_1
X_13629_ u_core.u_top.u_core.d_acc[140] u_core.u_top.u_core.d_acc[138] VSS VSS VDD VDD _08000_ sky130_fd_sc_hd__xnor2_1
X_13630_ _07999_ _08000_ VSS VSS VDD VDD _08001_ sky130_fd_sc_hd__xnor2_1
X_13631_ _07998_ _08001_ VSS VSS VDD VDD _08002_ sky130_fd_sc_hd__xnor2_1
X_13632_ _07995_ _08002_ VSS VSS VDD VDD _08003_ sky130_fd_sc_hd__xnor2_1
X_13633_ _07988_ _08003_ VSS VSS VDD VDD _08004_ sky130_fd_sc_hd__xnor2_1
X_13634_ _07973_ _08004_ VSS VSS VDD VDD _08005_ sky130_fd_sc_hd__xnor2_1
X_13635_ u_core.u_top.u_core.d_acc[149] u_core.u_top.u_core.d_acc[142] VSS VSS VDD VDD _08006_ sky130_fd_sc_hd__xnor2_1
X_13636_ u_core.u_top.u_core.d_acc[216] u_core.u_top.u_core.d_acc[208] VSS VSS VDD VDD _08007_ sky130_fd_sc_hd__xnor2_1
X_13637_ _08006_ _08007_ VSS VSS VDD VDD _08008_ sky130_fd_sc_hd__xnor2_1
X_13638_ u_core.u_top.u_core.d_acc[144] u_core.u_top.u_core.d_acc[145] VSS VSS VDD VDD _08009_ sky130_fd_sc_hd__xnor2_1
X_13639_ u_core.u_top.u_core.d_acc[146] u_core.u_top.u_core.d_acc[147] VSS VSS VDD VDD _08010_ sky130_fd_sc_hd__xnor2_1
X_13640_ _08009_ _08010_ VSS VSS VDD VDD _08011_ sky130_fd_sc_hd__xnor2_1
X_13641_ _08008_ _08011_ VSS VSS VDD VDD _08012_ sky130_fd_sc_hd__xnor2_1
X_13642_ u_core.u_top.u_core.d_acc[150] u_core.u_top.u_core.d_acc[219] VSS VSS VDD VDD _08013_ sky130_fd_sc_hd__xor2_1
X_13643_ u_core.u_top.u_core.d_acc[130] u_core.u_top.u_core.d_acc[210] VSS VSS VDD VDD _08014_ sky130_fd_sc_hd__xnor2_1
X_13644_ _08013_ _08014_ VSS VSS VDD VDD _08015_ sky130_fd_sc_hd__xnor2_1
X_13645_ u_core.u_top.u_core.d_acc[222] u_core.u_top.u_core.d_acc[218] VSS VSS VDD VDD _08016_ sky130_fd_sc_hd__xnor2_1
X_13646_ u_core.u_top.u_core.d_acc[151] u_core.u_top.u_core.d_acc[225] VSS VSS VDD VDD _08017_ sky130_fd_sc_hd__xnor2_1
X_13647_ _08016_ _08017_ VSS VSS VDD VDD _08018_ sky130_fd_sc_hd__xnor2_1
X_13648_ _08015_ _08018_ VSS VSS VDD VDD _08019_ sky130_fd_sc_hd__xnor2_1
X_13649_ _08012_ _08019_ VSS VSS VDD VDD _08020_ sky130_fd_sc_hd__xnor2_1
X_13650_ u_core.u_top.u_core.d_acc[17] u_core.u_top.u_core.d_acc[14] VSS VSS VDD VDD _08021_ sky130_fd_sc_hd__xor2_1
X_13651_ u_core.u_top.u_core.d_acc[18] u_core.u_top.u_core.d_acc[16] VSS VSS VDD VDD _08022_ sky130_fd_sc_hd__xnor2_1
X_13652_ _08021_ _08022_ VSS VSS VDD VDD _08023_ sky130_fd_sc_hd__xnor2_1
X_13653_ u_core.u_top.u_core.d_acc[166] u_core.u_top.u_core.d_acc[167] VSS VSS VDD VDD _08024_ sky130_fd_sc_hd__xnor2_1
X_13654_ u_core.u_top.u_core.d_acc[161] u_core.u_top.u_core.d_acc[160] VSS VSS VDD VDD _08025_ sky130_fd_sc_hd__xnor2_1
X_13655_ _08024_ _08025_ VSS VSS VDD VDD _08026_ sky130_fd_sc_hd__xnor2_1
X_13656_ _08023_ _08026_ VSS VSS VDD VDD _08027_ sky130_fd_sc_hd__xnor2_1
X_13657_ u_core.u_top.u_core.d_acc[27] u_core.u_top.u_core.d_acc[22] VSS VSS VDD VDD _08028_ sky130_fd_sc_hd__xor2_1
X_13658_ u_core.u_top.u_core.d_acc[29] u_core.u_top.u_core.d_acc[26] VSS VSS VDD VDD _08029_ sky130_fd_sc_hd__xnor2_1
X_13659_ _08028_ _08029_ VSS VSS VDD VDD _08030_ sky130_fd_sc_hd__xnor2_1
X_13660_ u_core.u_top.u_core.d_acc[23] u_core.u_top.u_core.d_acc[15] VSS VSS VDD VDD _08031_ sky130_fd_sc_hd__xnor2_1
X_13661_ u_core.u_top.u_core.d_acc[24] u_core.u_top.u_core.d_acc[25] VSS VSS VDD VDD _08032_ sky130_fd_sc_hd__xnor2_1
X_13662_ _08031_ _08032_ VSS VSS VDD VDD _08033_ sky130_fd_sc_hd__xnor2_1
X_13663_ _08030_ _08033_ VSS VSS VDD VDD _08034_ sky130_fd_sc_hd__xnor2_1
X_13664_ _08027_ _08034_ VSS VSS VDD VDD _08035_ sky130_fd_sc_hd__xnor2_1
X_13665_ u_core.u_top.u_core.d_acc[6] u_core.u_top.u_core.d_acc[4] VSS VSS VDD VDD _08036_ sky130_fd_sc_hd__xor2_1
X_13666_ u_core.u_top.u_core.d_acc[12] u_core.u_top.u_core.d_acc[9] VSS VSS VDD VDD _08037_ sky130_fd_sc_hd__xnor2_1
X_13667_ _08036_ _08037_ VSS VSS VDD VDD _08038_ sky130_fd_sc_hd__xnor2_1
X_13668_ u_core.u_top.u_core.d_acc[3] u_core.u_top.u_core.d_acc[1] VSS VSS VDD VDD _08039_ sky130_fd_sc_hd__xnor2_1
X_13669_ u_core.u_top.u_core.d_acc[5] u_core.u_top.u_core.d_acc[2] VSS VSS VDD VDD _08040_ sky130_fd_sc_hd__xnor2_1
X_13670_ _08039_ _08040_ VSS VSS VDD VDD _08041_ sky130_fd_sc_hd__xnor2_1
X_13671_ _08038_ _08041_ VSS VSS VDD VDD _08042_ sky130_fd_sc_hd__xnor2_1
X_13672_ u_core.u_top.u_core.d_acc[203] u_core.u_top.u_core.d_acc[201] VSS VSS VDD VDD _08043_ sky130_fd_sc_hd__xor2_1
X_13673_ u_core.u_top.u_core.d_acc[200] u_core.u_top.u_core.d_acc[202] VSS VSS VDD VDD _08044_ sky130_fd_sc_hd__xnor2_1
X_13674_ _08043_ _08044_ VSS VSS VDD VDD _08045_ sky130_fd_sc_hd__xnor2_1
X_13675_ u_core.u_top.u_core.d_acc[8] u_core.u_top.u_core.d_acc[7] VSS VSS VDD VDD _08046_ sky130_fd_sc_hd__xnor2_1
X_13676_ u_core.u_top.u_core.d_acc[13] u_core.u_top.u_core.d_acc[11] VSS VSS VDD VDD _08047_ sky130_fd_sc_hd__xnor2_1
X_13677_ _08046_ _08047_ VSS VSS VDD VDD _08048_ sky130_fd_sc_hd__xnor2_1
X_13678_ _08045_ _08048_ VSS VSS VDD VDD _08049_ sky130_fd_sc_hd__xnor2_1
X_13679_ _08042_ _08049_ VSS VSS VDD VDD _08050_ sky130_fd_sc_hd__xnor2_1
X_13680_ _08035_ _08050_ VSS VSS VDD VDD _08051_ sky130_fd_sc_hd__xnor2_1
X_13681_ _08020_ _08051_ VSS VSS VDD VDD _08052_ sky130_fd_sc_hd__xnor2_1
X_13682_ _08005_ _08052_ VSS VSS VDD VDD _08053_ sky130_fd_sc_hd__xnor2_1
X_13683_ _07942_ _08053_ VSS VSS VDD VDD _08054_ sky130_fd_sc_hd__xnor2_1
X_13684_ _07420_ _07815_ net698 VSS VSS VDD VDD _08055_ sky130_fd_sc_hd__nand3_1
X_13685_ u_core.u_top.u_core.r_pdata[0] _06596_ net812 u_core.u_top.u_core.m_fail[0] net798 VSS VSS VDD VDD _08056_ sky130_fd_sc_hd__a221oi_1
X_13686_ u_core.u_top.u_core.r_piter[5] _07720_ VSS VSS VDD VDD _08057_ sky130_fd_sc_hd__nor2_1
X_13687_ u_core.u_top.u_core.r_piter[5] u_core.u_top.u_core.r_piter[4] VSS VSS VDD VDD _08058_ sky130_fd_sc_hd__xor2_1
X_13688_ u_core.u_top.u_core.r_piter[3] _0969_[1070] VSS VSS VDD VDD _08059_ sky130_fd_sc_hd__xnor2_1
X_13689_ u_core.u_top.u_core.r_piter[4] u_core.u_top.u_core.r_piter[3] VSS VSS VDD VDD _08060_ sky130_fd_sc_hd__nor2_1
X_13690_ u_core.u_top.u_core.r_piter[5] _08060_ VSS VSS VDD VDD _08061_ sky130_fd_sc_hd__nand2_1
X_13691_ _08058_ _08059_ _08061_ _0969_[1070] VSS VSS VDD VDD _08062_ sky130_fd_sc_hd__o22ai_1
X_13692_ _0969_[1070] _08057_ _08062_ VSS VSS VDD VDD _08063_ sky130_fd_sc_hd__a21oi_1
X_13693_ u_core.u_top.u_core.r_piter[2] u_core.u_top.u_core.r_piter[0] VSS VSS VDD VDD _08064_ sky130_fd_sc_hd__xnor2_1
X_13694_ _07286_ _07514_ u_core.u_top.u_core.r_piter[3] VSS VSS VDD VDD _08065_ sky130_fd_sc_hd__mux2i_1
X_13695_ u_core.u_top.u_core.r_piter[2] u_core.u_top.u_core.r_piter[0] _0969_[1070] VSS VSS VDD VDD _08066_ sky130_fd_sc_hd__o21ai_0
X_13696_ u_core.u_top.u_core.r_piter[2] u_core.u_top.u_core.r_piter[0] _0969_[1070] VSS VSS VDD VDD _08067_ sky130_fd_sc_hd__a21o_1
X_13697_ _07737_ _07518_ u_core.u_top.u_core.r_piter[5] VSS VSS VDD VDD _08068_ sky130_fd_sc_hd__mux2i_1
X_13698_ u_core.u_top.u_core.r_piter[5] _07514_ _08060_ _08057_ _07286_ VSS VSS VDD VDD _08069_ sky130_fd_sc_hd__a32o_1
X_13699_ _08066_ _08067_ _08068_ _08069_ net796 VSS VSS VDD VDD _08070_ sky130_fd_sc_hd__a311oi_1
X_13700_ _08063_ _08064_ _08065_ _08058_ _08070_ VSS VSS VDD VDD _08071_ sky130_fd_sc_hd__o221ai_1
X_13701_ net955 VSS VSS VDD VDD _0888_[0] sky130_fd_sc_hd__inv_1
X_13702_ _08055_ _08056_ _08071_ net798 _0888_[0] VSS VSS VDD VDD _08072_ sky130_fd_sc_hd__a32oi_1
X_13703_ net915 net819 VSS VSS VDD VDD _08073_ sky130_fd_sc_hd__nand2_1
X_13704_ net945 net872 VSS VSS VDD VDD _08074_ sky130_fd_sc_hd__nand2_1
X_13705_ net810 _08073_ _08074_ VSS VSS VDD VDD _08075_ sky130_fd_sc_hd__nand3_1
X_13706_ net900 net810 _08075_ VSS VSS VDD VDD _08076_ sky130_fd_sc_hd__o21ai_1
X_13709_ net896 net895 VSS VSS VDD VDD _08079_ sky130_fd_sc_hd__or2_2
X_13711_ net898 net897 _08079_ VSS VSS VDD VDD _08081_ sky130_fd_sc_hd__nor3_4
X_13712_ u_core.u_top.bus_addr[1] net865 VSS VSS VDD VDD _08082_ sky130_fd_sc_hd__nor2_1
X_13713_ u_core.u_top.u_core.r_zskip u_core.u_top.bus_addr[1] _08082_ VSS VSS VDD VDD _08083_ sky130_fd_sc_hd__a21oi_1
X_13714_ u_core.u_top.u_core.r_tile[0] _07420_ VSS VSS VDD VDD _08084_ sky130_fd_sc_hd__nand2_1
X_13715_ _07277_ _08083_ _08084_ VSS VSS VDD VDD _08085_ sky130_fd_sc_hd__o21ai_0
X_13716_ net866 _08085_ VSS VSS VDD VDD _08086_ sky130_fd_sc_hd__nand2_1
X_13717_ u_core.u_top.u_core.r_en _07574_ VSS VSS VDD VDD _08087_ sky130_fd_sc_hd__nand2_1
X_13718_ _06635_ _08076_ _08086_ _08087_ net996 VSS VSS VDD VDD _08088_ sky130_fd_sc_hd__o2111ai_1
X_13719_ net797 _07812_ _07814_ _08072_ _08088_ VSS VSS VDD VDD _08089_ sky130_fd_sc_hd__a311oi_1
X_13720_ u_core.u_top.bus_re u_core.u_top.u_spi.shift_out[0] net816 VSS VSS VDD VDD _08090_ sky130_fd_sc_hd__o21ai_0
X_13721_ _08089_ _08090_ VSS VSS VDD VDD _2236_[0] sky130_fd_sc_hd__nor2_1
X_13722_ u_core.arr_sa_n[1] VSS VSS VDD VDD _0490_ sky130_fd_sc_hd__inv_1
X_13723_ u_core.arr_sa_n[2] VSS VSS VDD VDD _0496_ sky130_fd_sc_hd__inv_1
X_13724_ u_core.u_top.u_core.d_acc[21] VSS VSS VDD VDD _02302_ sky130_fd_sc_hd__inv_1
X_13726_ _02819_ VSS VSS VDD VDD _08091_ sky130_fd_sc_hd__inv_1
X_13727_ _03298_ VSS VSS VDD VDD _08092_ sky130_fd_sc_hd__inv_1
X_13728_ u_core.u_top.u_core.d_acc[20] _02562_ _03239_ VSS VSS VDD VDD _08093_ sky130_fd_sc_hd__a21o_1
X_13729_ _03436_ _08093_ _03435_ VSS VSS VDD VDD _08094_ sky130_fd_sc_hd__a21oi_1
X_13730_ _08092_ _08094_ _03297_ VSS VSS VDD VDD _08095_ sky130_fd_sc_hd__o21bai_1
X_13731_ _02806_ _08095_ _02805_ VSS VSS VDD VDD _08096_ sky130_fd_sc_hd__a21oi_1
X_13732_ _08091_ _08096_ _02818_ VSS VSS VDD VDD _08097_ sky130_fd_sc_hd__o21bai_1
X_13733_ _03241_ _08097_ _03240_ VSS VSS VDD VDD _08098_ sky130_fd_sc_hd__a21oi_1
X_13734_ _03296_ _08098_ VSS VSS VDD VDD _0238_[7] sky130_fd_sc_hd__xnor2_1
X_13735_ _03394_ VSS VSS VDD VDD _08099_ sky130_fd_sc_hd__inv_1
X_13736_ _03066_ VSS VSS VDD VDD _08100_ sky130_fd_sc_hd__inv_1
X_13737_ _02354_ VSS VSS VDD VDD _08101_ sky130_fd_sc_hd__inv_1
X_13738_ _02769_ _08101_ _02768_ VSS VSS VDD VDD _08102_ sky130_fd_sc_hd__a21oi_1
X_13739_ _03065_ VSS VSS VDD VDD _08103_ sky130_fd_sc_hd__inv_1
X_13740_ _08100_ _08102_ _08103_ VSS VSS VDD VDD _08104_ sky130_fd_sc_hd__o21ai_0
X_13741_ _03368_ _08104_ _03367_ VSS VSS VDD VDD _08105_ sky130_fd_sc_hd__a21oi_1
X_13742_ _08099_ _08105_ _03393_ VSS VSS VDD VDD _08106_ sky130_fd_sc_hd__o21bai_1
X_13743_ _02945_ _08106_ _02944_ VSS VSS VDD VDD _08107_ sky130_fd_sc_hd__a21o_1
X_13744_ _03022_ _08107_ _03021_ VSS VSS VDD VDD _08108_ sky130_fd_sc_hd__a21oi_1
X_13745_ _03392_ _08108_ VSS VSS VDD VDD _0264_[8] sky130_fd_sc_hd__xnor2_1
X_13746_ _03298_ _08094_ VSS VSS VDD VDD _0238_[3] sky130_fd_sc_hd__xnor2_1
X_13747_ u_core.u_top.u_core.d_acc[220] VSS VSS VDD VDD _0344_[0] sky130_fd_sc_hd__inv_1
X_13748_ net966 u_core.u_top.bus_wdata[4] VSS VSS VDD VDD _08109_ sky130_fd_sc_hd__nand2b_1
X_13749_ _08109_ VSS VSS VDD VDD _2033_[1] sky130_fd_sc_hd__inv_1
X_13750_ u_core.u_top.u_core.r_prow[1] net955 VSS VSS VDD VDD _02629_ sky130_fd_sc_hd__nand2_1
X_13751_ _02629_ VSS VSS VDD VDD _0001_[1] sky130_fd_sc_hd__inv_1
X_13754_ _0210_ _0215_ VSS VSS VDD VDD _08112_ sky130_fd_sc_hd__nor2b_1
X_13755_ _0210_ _08112_ net706 VSS VSS VDD VDD _08113_ sky130_fd_sc_hd__mux2i_1
X_13756_ u_core.u_top.u_core.acc[232] _03323_ u_core.u_top.u_core.acc[233] VSS VSS VDD VDD _08114_ sky130_fd_sc_hd__nand3_1
X_13758_ u_core.u_top.u_core.acc[235] u_core.u_top.u_core.acc[234] VSS VSS VDD VDD _08116_ sky130_fd_sc_hd__nand2_1
X_13759_ _08114_ _08116_ VSS VSS VDD VDD _08117_ sky130_fd_sc_hd__or2_2
X_13760_ _08117_ VSS VSS VDD VDD _08118_ sky130_fd_sc_hd__inv_1
X_13761_ u_core.u_top.u_core.acc[236] u_core.u_top.u_core.acc[237] _08118_ VSS VSS VDD VDD _08119_ sky130_fd_sc_hd__nand3_1
X_13762_ _0210_ _08112_ net715 VSS VSS VDD VDD _08120_ sky130_fd_sc_hd__mux2i_1
X_13763_ u_core.u_top.u_core.acc[232] u_core.u_top.u_core.acc[233] VSS VSS VDD VDD _08121_ sky130_fd_sc_hd__nor2_1
X_13764_ _03322_ _08121_ VSS VSS VDD VDD _08122_ sky130_fd_sc_hd__nand2_1
X_13765_ u_core.u_top.u_core.acc[236] u_core.u_top.u_core.acc[235] VSS VSS VDD VDD _08123_ sky130_fd_sc_hd__nor2_1
X_13766_ u_core.u_top.u_core.acc[237] u_core.u_top.u_core.acc[234] _08122_ _08123_ VSS VSS VDD VDD _08124_ sky130_fd_sc_hd__or4b_2
X_13767_ _08113_ _08119_ _08120_ _08124_ u_core.u_top.u_core.acc[238] VSS VSS VDD VDD _08125_ sky130_fd_sc_hd__o221a_2
X_13769_ _0210_ _08112_ net706 VSS VSS VDD VDD _08127_ sky130_fd_sc_hd__mux2_1
X_13770_ _0210_ _08112_ net715 VSS VSS VDD VDD _08128_ sky130_fd_sc_hd__mux2_1
X_13771_ _08127_ _08119_ _08128_ _08124_ u_core.u_top.u_core.acc[238] VSS VSS VDD VDD _08129_ sky130_fd_sc_hd__a221oi_1
X_13772_ _0210_ net820 VSS VSS VDD VDD _08130_ sky130_fd_sc_hd__nor2_1
X_13773_ net671 _08130_ VSS VSS VDD VDD _08131_ sky130_fd_sc_hd__nor2_1
X_13774_ net671 _08125_ _08129_ _08131_ u_core.u_top.u_core.acc[238] VSS VSS VDD VDD u_core.u_top.u_core.acc_upd[238] sky130_fd_sc_hd__o32a_1
X_13776_ u_core.u_top.u_core.acc[230] u_core.u_top.u_core.acc[231] u_core.u_top.u_core.acc[234] VSS VSS VDD VDD _08133_ sky130_fd_sc_hd__nor3_1
X_13777_ _08121_ _08123_ _08133_ VSS VSS VDD VDD _08134_ sky130_fd_sc_hd__nand3_1
X_13778_ u_core.u_top.u_core.acc[232] u_core.u_top.u_core.acc[233] VSS VSS VDD VDD _08135_ sky130_fd_sc_hd__nand2_1
X_13779_ u_core.u_top.u_core.acc[230] u_core.u_top.u_core.acc[231] u_core.u_top.u_core.acc[234] VSS VSS VDD VDD _08136_ sky130_fd_sc_hd__nand3_1
X_13780_ _08135_ _08136_ VSS VSS VDD VDD _08137_ sky130_fd_sc_hd__or2_2
X_13781_ u_core.u_top.u_core.acc[236] u_core.u_top.u_core.acc[235] VSS VSS VDD VDD _08138_ sky130_fd_sc_hd__nand2_1
X_13782_ _08137_ _08138_ VSS VSS VDD VDD _08139_ sky130_fd_sc_hd__nor2_1
X_13783_ _08127_ _08139_ VSS VSS VDD VDD _08140_ sky130_fd_sc_hd__nand2_1
X_13784_ _08120_ _08134_ _08140_ u_core.u_top.u_core.acc[237] VSS VSS VDD VDD _08141_ sky130_fd_sc_hd__o211ai_1
X_13785_ _08113_ _08139_ VSS VSS VDD VDD _08142_ sky130_fd_sc_hd__nor2_1
X_13786_ _08128_ _08134_ _08142_ u_core.u_top.u_core.acc[237] VSS VSS VDD VDD _08143_ sky130_fd_sc_hd__a211o_1
X_13787_ u_core.u_top.u_core.acc[237] _08131_ VSS VSS VDD VDD _08144_ sky130_fd_sc_hd__nor2_1
X_13788_ net677 _08141_ _08143_ _08144_ VSS VSS VDD VDD u_core.u_top.u_core.acc_upd[237] sky130_fd_sc_hd__a31oi_1
X_13789_ u_core.u_top.u_core.acc[235] u_core.u_top.u_core.acc[234] _08122_ VSS VSS VDD VDD _08145_ sky130_fd_sc_hd__or3_1
X_13790_ _08113_ _08117_ _08120_ _08145_ u_core.u_top.u_core.acc[236] VSS VSS VDD VDD _08146_ sky130_fd_sc_hd__o221a_2
X_13791_ _08127_ _08117_ _08128_ _08145_ u_core.u_top.u_core.acc[236] VSS VSS VDD VDD _08147_ sky130_fd_sc_hd__a221oi_1
X_13792_ net671 _08146_ _08147_ _08131_ u_core.u_top.u_core.acc[236] VSS VSS VDD VDD u_core.u_top.u_core.acc_upd[236] sky130_fd_sc_hd__o32a_1
X_13793_ _08121_ _08133_ VSS VSS VDD VDD _08148_ sky130_fd_sc_hd__nand2_1
X_13794_ _08120_ _08148_ _08137_ _08113_ u_core.u_top.u_core.acc[235] VSS VSS VDD VDD _08149_ sky130_fd_sc_hd__o221a_2
X_13795_ _08128_ _08148_ _08137_ _08127_ u_core.u_top.u_core.acc[235] VSS VSS VDD VDD _08150_ sky130_fd_sc_hd__a221oi_1
X_13796_ net671 _08149_ _08150_ _08131_ u_core.u_top.u_core.acc[235] VSS VSS VDD VDD u_core.u_top.u_core.acc_upd[235] sky130_fd_sc_hd__o32a_1
X_13797_ _08113_ _08114_ _08120_ _08122_ u_core.u_top.u_core.acc[234] VSS VSS VDD VDD _08151_ sky130_fd_sc_hd__o221a_2
X_13798_ _08127_ _08114_ _08128_ _08122_ u_core.u_top.u_core.acc[234] VSS VSS VDD VDD _08152_ sky130_fd_sc_hd__a221oi_1
X_13799_ net671 _08151_ _08152_ _08131_ u_core.u_top.u_core.acc[234] VSS VSS VDD VDD u_core.u_top.u_core.acc_upd[234] sky130_fd_sc_hd__o32a_1
X_13800_ u_core.u_top.u_core.acc[230] u_core.u_top.u_core.acc[231] u_core.u_top.u_core.acc[232] _08127_ VSS VSS VDD VDD _08153_ sky130_fd_sc_hd__nand4_1
X_13801_ u_core.u_top.u_core.acc[230] u_core.u_top.u_core.acc[231] u_core.u_top.u_core.acc[232] _08120_ VSS VSS VDD VDD _08154_ sky130_fd_sc_hd__or4_1
X_13804_ _08153_ _08154_ net671 VSS VSS VDD VDD _08157_ sky130_fd_sc_hd__a21oi_1
X_13805_ u_core.u_top.u_core.acc[233] _08157_ VSS VSS VDD VDD u_core.u_top.u_core.acc_upd[233] sky130_fd_sc_hd__xor2_1
X_13807_ _03323_ _08113_ _08120_ _03322_ u_core.u_top.u_core.acc[232] VSS VSS VDD VDD _08159_ sky130_fd_sc_hd__o221ai_1
X_13808_ _03323_ _08127_ _08128_ _03322_ u_core.u_top.u_core.acc[232] VSS VSS VDD VDD _08160_ sky130_fd_sc_hd__a221o_1
X_13809_ _08159_ _08160_ VSS VSS VDD VDD _08161_ sky130_fd_sc_hd__nand2_1
X_13812_ net672 _08130_ u_core.u_top.u_core.acc[232] VSS VSS VDD VDD _08164_ sky130_fd_sc_hd__o21ai_0
X_13813_ net671 _08161_ _08164_ VSS VSS VDD VDD u_core.u_top.u_core.acc_upd[232] sky130_fd_sc_hd__o21ai_0
X_13818_ _0211_[1] net715 VSS VSS VDD VDD _08169_ sky130_fd_sc_hd__nor2_1
X_13819_ _02694_ net715 _08169_ VSS VSS VDD VDD _08170_ sky130_fd_sc_hd__a21o_1
X_13824_ _02694_ net706 VSS VSS VDD VDD _08175_ sky130_fd_sc_hd__nand2_1
X_13825_ _0211_[1] net706 _08175_ VSS VSS VDD VDD _08176_ sky130_fd_sc_hd__o21ai_0
X_13826_ _08112_ _08170_ _08176_ _0210_ VSS VSS VDD VDD _08177_ sky130_fd_sc_hd__a22oi_1
X_13828_ u_core.u_top.u_core.acc[231] _08131_ _08177_ net671 VSS VSS VDD VDD u_core.u_top.u_core.acc_upd[231] sky130_fd_sc_hd__o22a_1
X_13829_ _0198_ net821 VSS VSS VDD VDD _08179_ sky130_fd_sc_hd__nor2b_1
X_13830_ _0198_ _08179_ net706 VSS VSS VDD VDD _08180_ sky130_fd_sc_hd__mux2i_1
X_13831_ u_core.u_top.u_core.acc[224] VSS VSS VDD VDD _08181_ sky130_fd_sc_hd__inv_1
X_13833_ u_core.u_top.u_core.acc[223] u_core.u_top.u_core.acc[222] _02676_ VSS VSS VDD VDD _08183_ sky130_fd_sc_hd__nand3_1
X_13834_ _08181_ _08183_ VSS VSS VDD VDD _08184_ sky130_fd_sc_hd__nor2_1
X_13835_ u_core.u_top.u_core.acc[226] u_core.u_top.u_core.acc[225] u_core.u_top.u_core.acc[227] _08184_ VSS VSS VDD VDD _08185_ sky130_fd_sc_hd__nand4_1
X_13836_ _0198_ _08179_ net715 VSS VSS VDD VDD _08186_ sky130_fd_sc_hd__mux2i_1
X_13837_ u_core.u_top.u_core.acc[223] u_core.u_top.u_core.acc[222] VSS VSS VDD VDD _08187_ sky130_fd_sc_hd__nor2_1
X_13838_ _02675_ _08187_ VSS VSS VDD VDD _08188_ sky130_fd_sc_hd__nand2_1
X_13839_ u_core.u_top.u_core.acc[226] u_core.u_top.u_core.acc[225] VSS VSS VDD VDD _08189_ sky130_fd_sc_hd__nor2_1
X_13840_ u_core.u_top.u_core.acc[224] u_core.u_top.u_core.acc[227] _08188_ _08189_ VSS VSS VDD VDD _08190_ sky130_fd_sc_hd__or4b_2
X_13841_ _08180_ _08185_ net697 _08190_ u_core.u_top.u_core.acc[228] VSS VSS VDD VDD _08191_ sky130_fd_sc_hd__o221ai_1
X_13843_ _0198_ _08179_ net706 VSS VSS VDD VDD _08193_ sky130_fd_sc_hd__mux2_2
X_13844_ _0198_ _08179_ net715 VSS VSS VDD VDD _08194_ sky130_fd_sc_hd__mux2_1
X_13845_ _08193_ _08185_ _08194_ _08190_ u_core.u_top.u_core.acc[228] VSS VSS VDD VDD _08195_ sky130_fd_sc_hd__a221oi_1
X_13846_ net671 _08195_ VSS VSS VDD VDD _08196_ sky130_fd_sc_hd__nor2_1
X_13847_ _0198_ net821 VSS VSS VDD VDD _08197_ sky130_fd_sc_hd__nor2_1
X_13848_ net671 _08197_ VSS VSS VDD VDD _08198_ sky130_fd_sc_hd__nor2_1
X_13849_ u_core.u_top.u_core.acc[228] net662 VSS VSS VDD VDD _08199_ sky130_fd_sc_hd__nor2_1
X_13850_ _08191_ _08196_ _08199_ VSS VSS VDD VDD u_core.u_top.u_core.acc_upd[228] sky130_fd_sc_hd__a21oi_1
X_13851_ u_core.u_top.u_core.acc[226] u_core.u_top.u_core.acc[225] VSS VSS VDD VDD _08200_ sky130_fd_sc_hd__nand2_1
X_13852_ _0200_[0] _02672_ VSS VSS VDD VDD _08201_ sky130_fd_sc_hd__nor2_1
X_13853_ u_core.u_top.u_core.acc[224] u_core.u_top.u_core.acc[223] u_core.u_top.u_core.acc[222] _08201_ VSS VSS VDD VDD _08202_ sky130_fd_sc_hd__nand4_1
X_13854_ _08200_ _08202_ VSS VSS VDD VDD _08203_ sky130_fd_sc_hd__nor2_1
X_13855_ _08203_ VSS VSS VDD VDD _08204_ sky130_fd_sc_hd__inv_1
X_13856_ _0200_[0] _02672_ VSS VSS VDD VDD _08205_ sky130_fd_sc_hd__nand2_1
X_13857_ u_core.u_top.u_core.acc[224] u_core.u_top.u_core.acc[223] u_core.u_top.u_core.acc[222] _08205_ VSS VSS VDD VDD _08206_ sky130_fd_sc_hd__nor4_1
X_13858_ _08189_ _08206_ VSS VSS VDD VDD _08207_ sky130_fd_sc_hd__nand2_1
X_13859_ _08180_ _08204_ _08207_ net697 u_core.u_top.u_core.acc[227] VSS VSS VDD VDD _08208_ sky130_fd_sc_hd__o221a_2
X_13860_ _08193_ _08204_ _08207_ _08194_ u_core.u_top.u_core.acc[227] VSS VSS VDD VDD _08209_ sky130_fd_sc_hd__a221oi_1
X_13861_ net671 _08208_ _08209_ net662 u_core.u_top.u_core.acc[227] VSS VSS VDD VDD u_core.u_top.u_core.acc_upd[227] sky130_fd_sc_hd__o32a_1
X_13862_ u_core.u_top.u_core.acc[225] _08184_ VSS VSS VDD VDD _08210_ sky130_fd_sc_hd__nand2_1
X_13863_ u_core.u_top.u_core.acc[224] u_core.u_top.u_core.acc[225] _08188_ VSS VSS VDD VDD _08211_ sky130_fd_sc_hd__or3_1
X_13864_ _08180_ _08210_ _08211_ net697 u_core.u_top.u_core.acc[226] VSS VSS VDD VDD _08212_ sky130_fd_sc_hd__o221ai_1
X_13865_ _08193_ _08210_ _08211_ _08194_ u_core.u_top.u_core.acc[226] VSS VSS VDD VDD _08213_ sky130_fd_sc_hd__a221oi_1
X_13866_ net671 _08213_ VSS VSS VDD VDD _08214_ sky130_fd_sc_hd__nor2_1
X_13867_ u_core.u_top.u_core.acc[226] net662 VSS VSS VDD VDD _08215_ sky130_fd_sc_hd__nor2_1
X_13868_ _08212_ _08214_ _08215_ VSS VSS VDD VDD u_core.u_top.u_core.acc_upd[226] sky130_fd_sc_hd__a21oi_1
X_13869_ _08194_ _08206_ VSS VSS VDD VDD _08216_ sky130_fd_sc_hd__nand2_1
X_13870_ _08180_ _08202_ _08216_ u_core.u_top.u_core.acc[225] VSS VSS VDD VDD _08217_ sky130_fd_sc_hd__o211a_1
X_13871_ net697 _08206_ VSS VSS VDD VDD _08218_ sky130_fd_sc_hd__nor2_1
X_13872_ _08193_ _08202_ _08218_ u_core.u_top.u_core.acc[225] VSS VSS VDD VDD _08219_ sky130_fd_sc_hd__a211oi_1
X_13873_ net671 _08217_ _08219_ net662 u_core.u_top.u_core.acc[225] VSS VSS VDD VDD u_core.u_top.u_core.acc_upd[225] sky130_fd_sc_hd__o32a_1
X_13875_ _08180_ _08183_ net697 _08188_ VSS VSS VDD VDD _08221_ sky130_fd_sc_hd__o22ai_1
X_13876_ _08181_ _08221_ VSS VSS VDD VDD _08222_ sky130_fd_sc_hd__nor2_1
X_13877_ _08193_ _08183_ _08194_ _08188_ u_core.u_top.u_core.acc[224] VSS VSS VDD VDD _08223_ sky130_fd_sc_hd__a221oi_1
X_13878_ net671 _08222_ _08223_ net662 u_core.u_top.u_core.acc[224] VSS VSS VDD VDD u_core.u_top.u_core.acc_upd[224] sky130_fd_sc_hd__o32a_1
X_13880_ u_core.u_top.u_core.acc[222] net697 _08205_ VSS VSS VDD VDD _08225_ sky130_fd_sc_hd__nor3_1
X_13881_ u_core.u_top.u_core.acc[222] _08193_ _08201_ _08225_ VSS VSS VDD VDD _08226_ sky130_fd_sc_hd__a31oi_1
X_13882_ net671 _08226_ VSS VSS VDD VDD _08227_ sky130_fd_sc_hd__nor2_1
X_13883_ u_core.u_top.u_core.acc[223] _08227_ VSS VSS VDD VDD u_core.u_top.u_core.acc_upd[223] sky130_fd_sc_hd__xor2_1
X_13884_ _02676_ _08180_ net697 _02675_ u_core.u_top.u_core.acc[222] VSS VSS VDD VDD _08228_ sky130_fd_sc_hd__o221ai_1
X_13885_ _02676_ _08193_ _08194_ _02675_ u_core.u_top.u_core.acc[222] VSS VSS VDD VDD _08229_ sky130_fd_sc_hd__a221o_1
X_13886_ _08228_ _08229_ VSS VSS VDD VDD _08230_ sky130_fd_sc_hd__nand2_1
X_13887_ net671 _08197_ u_core.u_top.u_core.acc[222] VSS VSS VDD VDD _08231_ sky130_fd_sc_hd__o21ai_0
X_13888_ net671 _08230_ _08231_ VSS VSS VDD VDD u_core.u_top.u_core.acc_upd[222] sky130_fd_sc_hd__o21ai_0
X_13892_ _02674_ net706 VSS VSS VDD VDD _08235_ sky130_fd_sc_hd__nor2_1
X_13893_ _0200_[1] net706 _08235_ VSS VSS VDD VDD _08236_ sky130_fd_sc_hd__a21oi_1
X_13894_ _02674_ net706 VSS VSS VDD VDD _08237_ sky130_fd_sc_hd__nand2_1
X_13895_ _0200_[1] net706 _08237_ VSS VSS VDD VDD _08238_ sky130_fd_sc_hd__o21ai_0
X_13896_ _08179_ _08236_ _08238_ _0198_ VSS VSS VDD VDD _08239_ sky130_fd_sc_hd__a22oi_1
X_13897_ u_core.u_top.u_core.acc[221] net662 _08239_ net671 VSS VSS VDD VDD u_core.u_top.u_core.acc_upd[221] sky130_fd_sc_hd__o22a_1
X_13898_ u_core.u_top.u_core.acc[218] VSS VSS VDD VDD _08240_ sky130_fd_sc_hd__inv_1
X_13899_ net823 _0192_ VSS VSS VDD VDD _08241_ sky130_fd_sc_hd__nor2b_1
X_13900_ net823 _08241_ net708 VSS VSS VDD VDD _08242_ sky130_fd_sc_hd__mux2i_1
X_13901_ u_core.u_top.u_core.acc[213] u_core.u_top.u_core.acc[212] _02660_ VSS VSS VDD VDD _08243_ sky130_fd_sc_hd__nand3_1
X_13902_ u_core.u_top.u_core.acc[215] u_core.u_top.u_core.acc[214] VSS VSS VDD VDD _08244_ sky130_fd_sc_hd__nand2_1
X_13903_ _08243_ _08244_ VSS VSS VDD VDD _08245_ sky130_fd_sc_hd__nor2_1
X_13904_ u_core.u_top.u_core.acc[216] u_core.u_top.u_core.acc[217] _08245_ VSS VSS VDD VDD _08246_ sky130_fd_sc_hd__nand3_1
X_13905_ net823 _08241_ net715 VSS VSS VDD VDD _08247_ sky130_fd_sc_hd__mux2i_1
X_13906_ u_core.u_top.u_core.acc[213] u_core.u_top.u_core.acc[212] VSS VSS VDD VDD _08248_ sky130_fd_sc_hd__nor2_1
X_13907_ _02659_ _08248_ VSS VSS VDD VDD _08249_ sky130_fd_sc_hd__nand2_1
X_13908_ u_core.u_top.u_core.acc[215] u_core.u_top.u_core.acc[214] _08249_ VSS VSS VDD VDD _08250_ sky130_fd_sc_hd__or3_1
X_13909_ u_core.u_top.u_core.acc[216] u_core.u_top.u_core.acc[217] _08250_ VSS VSS VDD VDD _08251_ sky130_fd_sc_hd__or3_1
X_13910_ net696 _08246_ _08247_ _08251_ VSS VSS VDD VDD _08252_ sky130_fd_sc_hd__o22ai_1
X_13911_ _08240_ _08252_ VSS VSS VDD VDD _08253_ sky130_fd_sc_hd__nor2_1
X_13912_ net823 _08241_ net708 VSS VSS VDD VDD _08254_ sky130_fd_sc_hd__mux2_2
X_13913_ net823 _08241_ net715 VSS VSS VDD VDD _08255_ sky130_fd_sc_hd__mux2_1
X_13914_ _08254_ _08246_ _08255_ _08251_ u_core.u_top.u_core.acc[218] VSS VSS VDD VDD _08256_ sky130_fd_sc_hd__a221oi_1
X_13915_ net823 net822 VSS VSS VDD VDD _08257_ sky130_fd_sc_hd__nor2_1
X_13916_ net673 _08257_ VSS VSS VDD VDD _08258_ sky130_fd_sc_hd__nor2_1
X_13917_ net673 _08253_ _08256_ _08258_ u_core.u_top.u_core.acc[218] VSS VSS VDD VDD u_core.u_top.u_core.acc_upd[218] sky130_fd_sc_hd__o32a_1
X_13918_ u_core.u_top.u_core.acc[214] u_core.u_top.u_core.acc[211] u_core.u_top.u_core.acc[210] VSS VSS VDD VDD _08259_ sky130_fd_sc_hd__nor3_1
X_13919_ _08248_ _08259_ VSS VSS VDD VDD _08260_ sky130_fd_sc_hd__nand2_1
X_13920_ u_core.u_top.u_core.acc[216] u_core.u_top.u_core.acc[215] _08260_ VSS VSS VDD VDD _08261_ sky130_fd_sc_hd__or3_1
X_13921_ u_core.u_top.u_core.acc[213] u_core.u_top.u_core.acc[212] VSS VSS VDD VDD _08262_ sky130_fd_sc_hd__nand2_1
X_13922_ u_core.u_top.u_core.acc[214] u_core.u_top.u_core.acc[211] u_core.u_top.u_core.acc[210] VSS VSS VDD VDD _08263_ sky130_fd_sc_hd__nand3_1
X_13923_ _08262_ _08263_ VSS VSS VDD VDD _08264_ sky130_fd_sc_hd__or2_2
X_13924_ u_core.u_top.u_core.acc[216] u_core.u_top.u_core.acc[215] VSS VSS VDD VDD _08265_ sky130_fd_sc_hd__nand2_1
X_13925_ _08264_ _08265_ VSS VSS VDD VDD _08266_ sky130_fd_sc_hd__nor2_1
X_13926_ _08266_ VSS VSS VDD VDD _08267_ sky130_fd_sc_hd__inv_1
X_13927_ _08247_ _08261_ _08267_ net696 u_core.u_top.u_core.acc[217] VSS VSS VDD VDD _08268_ sky130_fd_sc_hd__o221a_2
X_13928_ _08255_ _08261_ _08267_ _08254_ u_core.u_top.u_core.acc[217] VSS VSS VDD VDD _08269_ sky130_fd_sc_hd__a221oi_1
X_13929_ net673 _08268_ _08269_ _08258_ u_core.u_top.u_core.acc[217] VSS VSS VDD VDD u_core.u_top.u_core.acc_upd[217] sky130_fd_sc_hd__o32a_1
X_13930_ _08243_ _08244_ VSS VSS VDD VDD _08270_ sky130_fd_sc_hd__or2_2
X_13931_ net696 _08270_ _08247_ _08250_ u_core.u_top.u_core.acc[216] VSS VSS VDD VDD _08271_ sky130_fd_sc_hd__o221a_2
X_13932_ _08254_ _08270_ _08255_ _08250_ u_core.u_top.u_core.acc[216] VSS VSS VDD VDD _08272_ sky130_fd_sc_hd__a221oi_1
X_13933_ net673 _08271_ _08272_ _08258_ u_core.u_top.u_core.acc[216] VSS VSS VDD VDD u_core.u_top.u_core.acc_upd[216] sky130_fd_sc_hd__o32a_1
X_13934_ _08247_ _08260_ _08264_ net696 u_core.u_top.u_core.acc[215] VSS VSS VDD VDD _08273_ sky130_fd_sc_hd__o221a_2
X_13935_ _08255_ _08260_ _08264_ _08254_ u_core.u_top.u_core.acc[215] VSS VSS VDD VDD _08274_ sky130_fd_sc_hd__a221oi_1
X_13936_ net673 _08273_ _08274_ _08258_ u_core.u_top.u_core.acc[215] VSS VSS VDD VDD u_core.u_top.u_core.acc_upd[215] sky130_fd_sc_hd__o32a_1
X_13937_ net696 _08243_ _08247_ _08249_ u_core.u_top.u_core.acc[214] VSS VSS VDD VDD _08275_ sky130_fd_sc_hd__o221a_2
X_13938_ _08254_ _08243_ _08255_ _08249_ u_core.u_top.u_core.acc[214] VSS VSS VDD VDD _08276_ sky130_fd_sc_hd__a221oi_1
X_13939_ net673 _08275_ _08276_ _08258_ u_core.u_top.u_core.acc[214] VSS VSS VDD VDD u_core.u_top.u_core.acc_upd[214] sky130_fd_sc_hd__o32a_1
X_13940_ u_core.u_top.u_core.acc[212] u_core.u_top.u_core.acc[211] u_core.u_top.u_core.acc[210] _08254_ VSS VSS VDD VDD _08277_ sky130_fd_sc_hd__nand4_1
X_13941_ u_core.u_top.u_core.acc[212] u_core.u_top.u_core.acc[211] u_core.u_top.u_core.acc[210] _08247_ VSS VSS VDD VDD _08278_ sky130_fd_sc_hd__or4_1
X_13942_ _08277_ _08278_ net673 VSS VSS VDD VDD _08279_ sky130_fd_sc_hd__a21oi_1
X_13943_ u_core.u_top.u_core.acc[213] _08279_ VSS VSS VDD VDD u_core.u_top.u_core.acc_upd[213] sky130_fd_sc_hd__xor2_1
X_13944_ _02660_ net696 _08247_ _02659_ u_core.u_top.u_core.acc[212] VSS VSS VDD VDD _08280_ sky130_fd_sc_hd__o221ai_1
X_13945_ _02660_ _08254_ _08255_ _02659_ u_core.u_top.u_core.acc[212] VSS VSS VDD VDD _08281_ sky130_fd_sc_hd__a221o_1
X_13946_ _08280_ _08281_ VSS VSS VDD VDD _08282_ sky130_fd_sc_hd__nand2_1
X_13947_ net673 _08257_ u_core.u_top.u_core.acc[212] VSS VSS VDD VDD _08283_ sky130_fd_sc_hd__o21ai_0
X_13948_ net673 _08282_ _08283_ VSS VSS VDD VDD u_core.u_top.u_core.acc_upd[212] sky130_fd_sc_hd__o21ai_0
X_13949_ _0188_[1] net715 VSS VSS VDD VDD _08284_ sky130_fd_sc_hd__nor2_1
X_13950_ _02646_ net715 _08284_ VSS VSS VDD VDD _08285_ sky130_fd_sc_hd__a21o_1
X_13951_ _02646_ net708 VSS VSS VDD VDD _08286_ sky130_fd_sc_hd__nand2_1
X_13952_ _0188_[1] net708 _08286_ VSS VSS VDD VDD _08287_ sky130_fd_sc_hd__o21ai_0
X_13953_ _08241_ _08285_ _08287_ net823 VSS VSS VDD VDD _08288_ sky130_fd_sc_hd__a22oi_1
X_13954_ u_core.u_top.u_core.acc[211] _08258_ _08288_ net673 VSS VSS VDD VDD u_core.u_top.u_core.acc_upd[211] sky130_fd_sc_hd__o22a_1
X_13955_ _0175_ _06493_ net708 VSS VSS VDD VDD _08289_ sky130_fd_sc_hd__mux2i_1
X_13956_ u_core.u_top.u_core.acc[202] u_core.u_top.u_core.acc[203] _02616_ VSS VSS VDD VDD _08290_ sky130_fd_sc_hd__and3_1
X_13957_ u_core.u_top.u_core.acc[205] u_core.u_top.u_core.acc[204] _08290_ VSS VSS VDD VDD _08291_ sky130_fd_sc_hd__and3_1
X_13958_ u_core.u_top.u_core.acc[207] u_core.u_top.u_core.acc[206] _08291_ VSS VSS VDD VDD _08292_ sky130_fd_sc_hd__nand3_1
X_13959_ u_core.u_top.u_core.acc[202] u_core.u_top.u_core.acc[203] VSS VSS VDD VDD _08293_ sky130_fd_sc_hd__nor2_1
X_13960_ _02615_ _08293_ VSS VSS VDD VDD _08294_ sky130_fd_sc_hd__nand2_1
X_13961_ u_core.u_top.u_core.acc[205] u_core.u_top.u_core.acc[204] _08294_ VSS VSS VDD VDD _08295_ sky130_fd_sc_hd__nor3_1
X_13962_ u_core.u_top.u_core.acc[207] u_core.u_top.u_core.acc[206] VSS VSS VDD VDD _08296_ sky130_fd_sc_hd__nor2_1
X_13963_ _08295_ _08296_ VSS VSS VDD VDD _08297_ sky130_fd_sc_hd__nand2_1
X_13964_ net695 _08292_ _08297_ net699 u_core.u_top.u_core.acc[208] VSS VSS VDD VDD _08298_ sky130_fd_sc_hd__o221a_2
X_13965_ _0175_ _06493_ net715 VSS VSS VDD VDD _08299_ sky130_fd_sc_hd__mux2_1
X_13966_ _06496_ _08292_ _08297_ _08299_ u_core.u_top.u_core.acc[208] VSS VSS VDD VDD _08300_ sky130_fd_sc_hd__a221oi_1
X_13967_ net673 _08298_ _08300_ net663 u_core.u_top.u_core.acc[208] VSS VSS VDD VDD u_core.u_top.u_core.acc_upd[208] sky130_fd_sc_hd__o32a_1
X_13968_ u_core.u_top.u_core.acc[204] u_core.u_top.u_core.acc[201] u_core.u_top.u_core.acc[200] VSS VSS VDD VDD _08301_ sky130_fd_sc_hd__nor3_1
X_13969_ u_core.u_top.u_core.acc[206] u_core.u_top.u_core.acc[205] VSS VSS VDD VDD _08302_ sky130_fd_sc_hd__nor2_1
X_13970_ _08293_ _08301_ _08302_ VSS VSS VDD VDD _08303_ sky130_fd_sc_hd__nand3_1
X_13971_ u_core.u_top.u_core.acc[202] u_core.u_top.u_core.acc[203] VSS VSS VDD VDD _08304_ sky130_fd_sc_hd__nand2_1
X_13972_ u_core.u_top.u_core.acc[204] u_core.u_top.u_core.acc[201] u_core.u_top.u_core.acc[200] VSS VSS VDD VDD _08305_ sky130_fd_sc_hd__nand3_1
X_13973_ _08304_ _08305_ VSS VSS VDD VDD _08306_ sky130_fd_sc_hd__or2_2
X_13974_ u_core.u_top.u_core.acc[206] u_core.u_top.u_core.acc[205] VSS VSS VDD VDD _08307_ sky130_fd_sc_hd__nand2_1
X_13975_ _08306_ _08307_ VSS VSS VDD VDD _08308_ sky130_fd_sc_hd__nor2_1
X_13976_ _06496_ _08308_ VSS VSS VDD VDD _08309_ sky130_fd_sc_hd__nand2_1
X_13977_ net699 _08303_ _08309_ u_core.u_top.u_core.acc[207] VSS VSS VDD VDD _08310_ sky130_fd_sc_hd__o211a_1
X_13978_ net695 _08308_ VSS VSS VDD VDD _08311_ sky130_fd_sc_hd__nor2_1
X_13979_ _08299_ _08303_ _08311_ u_core.u_top.u_core.acc[207] VSS VSS VDD VDD _08312_ sky130_fd_sc_hd__a211oi_1
X_13980_ net674 _08310_ _08312_ net663 u_core.u_top.u_core.acc[207] VSS VSS VDD VDD u_core.u_top.u_core.acc_upd[207] sky130_fd_sc_hd__o32a_1
X_13981_ u_core.u_top.u_core.acc[206] VSS VSS VDD VDD _08313_ sky130_fd_sc_hd__inv_1
X_13982_ _06496_ _08291_ _08295_ _08299_ _08313_ VSS VSS VDD VDD _08314_ sky130_fd_sc_hd__a221oi_1
X_13983_ net695 _08291_ _08295_ net699 VSS VSS VDD VDD _08315_ sky130_fd_sc_hd__o22ai_1
X_13984_ u_core.u_top.u_core.acc[206] _08315_ VSS VSS VDD VDD _08316_ sky130_fd_sc_hd__nor2_1
X_13985_ net673 _08314_ _08316_ net663 u_core.u_top.u_core.acc[206] VSS VSS VDD VDD u_core.u_top.u_core.acc_upd[206] sky130_fd_sc_hd__o32a_1
X_13986_ _08293_ _08301_ VSS VSS VDD VDD _08317_ sky130_fd_sc_hd__nand2_1
X_13987_ net699 _08317_ _08306_ net695 u_core.u_top.u_core.acc[205] VSS VSS VDD VDD _08318_ sky130_fd_sc_hd__o221a_2
X_13988_ _08299_ _08317_ _08306_ _06496_ u_core.u_top.u_core.acc[205] VSS VSS VDD VDD _08319_ sky130_fd_sc_hd__a221oi_1
X_13989_ net674 _08318_ _08319_ net663 u_core.u_top.u_core.acc[205] VSS VSS VDD VDD u_core.u_top.u_core.acc_upd[205] sky130_fd_sc_hd__o32a_1
X_13991_ net699 _08294_ VSS VSS VDD VDD _08321_ sky130_fd_sc_hd__nor2_1
X_13992_ _06496_ _08290_ _08321_ VSS VSS VDD VDD _08322_ sky130_fd_sc_hd__a21oi_1
X_13993_ net673 _08322_ VSS VSS VDD VDD _08323_ sky130_fd_sc_hd__nor2_1
X_13994_ u_core.u_top.u_core.acc[204] _08323_ VSS VSS VDD VDD u_core.u_top.u_core.acc_upd[204] sky130_fd_sc_hd__xor2_1
X_13995_ u_core.u_top.u_core.acc[202] u_core.u_top.u_core.acc[201] u_core.u_top.u_core.acc[200] _06496_ VSS VSS VDD VDD _08324_ sky130_fd_sc_hd__nand4_1
X_13996_ u_core.u_top.u_core.acc[202] u_core.u_top.u_core.acc[201] u_core.u_top.u_core.acc[200] net699 VSS VSS VDD VDD _08325_ sky130_fd_sc_hd__or4_1
X_13997_ _08324_ _08325_ net673 VSS VSS VDD VDD _08326_ sky130_fd_sc_hd__a21oi_1
X_13998_ u_core.u_top.u_core.acc[203] _08326_ VSS VSS VDD VDD u_core.u_top.u_core.acc_upd[203] sky130_fd_sc_hd__xor2_1
X_14000_ _02616_ net695 net699 _02615_ u_core.u_top.u_core.acc[202] VSS VSS VDD VDD _08328_ sky130_fd_sc_hd__o221ai_1
X_14001_ _02616_ _06496_ _08299_ _02615_ u_core.u_top.u_core.acc[202] VSS VSS VDD VDD _08329_ sky130_fd_sc_hd__a221o_1
X_14002_ net677 _08328_ _08329_ _06503_ u_core.u_top.u_core.acc[202] VSS VSS VDD VDD u_core.u_top.u_core.acc_upd[202] sky130_fd_sc_hd__a32o_1
X_14004_ u_core.u_top.u_core.acc[198] VSS VSS VDD VDD _08331_ sky130_fd_sc_hd__inv_1
X_14005_ _0163_ net824 VSS VSS VDD VDD _08332_ sky130_fd_sc_hd__nor2b_1
X_14006_ _0163_ _08332_ net706 VSS VSS VDD VDD _08333_ sky130_fd_sc_hd__mux2i_1
X_14007_ u_core.u_top.u_core.acc[193] u_core.u_top.u_core.acc[192] _02588_ VSS VSS VDD VDD _08334_ sky130_fd_sc_hd__and3_1
X_14008_ u_core.u_top.u_core.acc[195] u_core.u_top.u_core.acc[194] _08334_ VSS VSS VDD VDD _08335_ sky130_fd_sc_hd__nand3_1
X_14009_ u_core.u_top.u_core.acc[197] u_core.u_top.u_core.acc[196] VSS VSS VDD VDD _08336_ sky130_fd_sc_hd__nand2_1
X_14010_ _08335_ _08336_ VSS VSS VDD VDD _08337_ sky130_fd_sc_hd__or2_2
X_14011_ _0163_ _08332_ net713 VSS VSS VDD VDD _08338_ sky130_fd_sc_hd__mux2i_1
X_14012_ u_core.u_top.u_core.acc[193] u_core.u_top.u_core.acc[192] VSS VSS VDD VDD _08339_ sky130_fd_sc_hd__nor2_1
X_14013_ _02587_ _08339_ VSS VSS VDD VDD _08340_ sky130_fd_sc_hd__nand2_1
X_14014_ u_core.u_top.u_core.acc[195] u_core.u_top.u_core.acc[194] _08340_ VSS VSS VDD VDD _08341_ sky130_fd_sc_hd__or3_1
X_14015_ u_core.u_top.u_core.acc[197] u_core.u_top.u_core.acc[196] _08341_ VSS VSS VDD VDD _08342_ sky130_fd_sc_hd__or3_1
X_14016_ _08333_ _08337_ _08338_ _08342_ VSS VSS VDD VDD _08343_ sky130_fd_sc_hd__o22ai_1
X_14017_ _08331_ _08343_ VSS VSS VDD VDD _08344_ sky130_fd_sc_hd__nor2_1
X_14018_ _0163_ _08332_ net706 VSS VSS VDD VDD _08345_ sky130_fd_sc_hd__mux2_1
X_14019_ _0163_ _08332_ net713 VSS VSS VDD VDD _08346_ sky130_fd_sc_hd__mux2_1
X_14020_ _08345_ _08337_ _08346_ _08342_ u_core.u_top.u_core.acc[198] VSS VSS VDD VDD _08347_ sky130_fd_sc_hd__a221oi_1
X_14021_ _0163_ net824 VSS VSS VDD VDD _08348_ sky130_fd_sc_hd__nor2_1
X_14022_ net672 _08348_ VSS VSS VDD VDD _08349_ sky130_fd_sc_hd__nor2_1
X_14023_ net672 _08344_ _08347_ _08349_ u_core.u_top.u_core.acc[198] VSS VSS VDD VDD u_core.u_top.u_core.acc_upd[198] sky130_fd_sc_hd__o32a_1
X_14026_ u_core.u_top.u_core.acc[194] u_core.u_top.u_core.acc[191] u_core.u_top.u_core.acc[190] VSS VSS VDD VDD _08352_ sky130_fd_sc_hd__nor3_1
X_14027_ _08339_ _08352_ VSS VSS VDD VDD _08353_ sky130_fd_sc_hd__nand2_1
X_14028_ u_core.u_top.u_core.acc[196] u_core.u_top.u_core.acc[195] _08353_ VSS VSS VDD VDD _08354_ sky130_fd_sc_hd__nor3_1
X_14029_ u_core.u_top.u_core.acc[193] u_core.u_top.u_core.acc[192] VSS VSS VDD VDD _08355_ sky130_fd_sc_hd__nand2_1
X_14030_ u_core.u_top.u_core.acc[194] u_core.u_top.u_core.acc[191] u_core.u_top.u_core.acc[190] VSS VSS VDD VDD _08356_ sky130_fd_sc_hd__nand3_1
X_14031_ _08355_ _08356_ VSS VSS VDD VDD _08357_ sky130_fd_sc_hd__or2_2
X_14032_ u_core.u_top.u_core.acc[196] u_core.u_top.u_core.acc[195] VSS VSS VDD VDD _08358_ sky130_fd_sc_hd__nand2_1
X_14033_ _08357_ _08358_ VSS VSS VDD VDD _08359_ sky130_fd_sc_hd__nor2_1
X_14034_ _08346_ _08354_ _08359_ _08345_ VSS VSS VDD VDD _08360_ sky130_fd_sc_hd__a22oi_1
X_14035_ _08338_ _08354_ _08359_ _08333_ VSS VSS VDD VDD _08361_ sky130_fd_sc_hd__o22ai_1
X_14036_ u_core.u_top.u_core.acc[197] _08361_ VSS VSS VDD VDD _08362_ sky130_fd_sc_hd__nor2_1
X_14037_ u_core.u_top.u_core.acc[197] _08360_ _08362_ VSS VSS VDD VDD _08363_ sky130_fd_sc_hd__a21oi_1
X_14038_ u_core.u_top.u_core.acc[197] _08349_ VSS VSS VDD VDD _08364_ sky130_fd_sc_hd__nor2_1
X_14039_ net678 _08363_ _08364_ VSS VSS VDD VDD u_core.u_top.u_core.acc_upd[197] sky130_fd_sc_hd__a21oi_1
X_14040_ _08333_ _08335_ _08338_ _08341_ u_core.u_top.u_core.acc[196] VSS VSS VDD VDD _08365_ sky130_fd_sc_hd__o221a_2
X_14041_ _08345_ _08335_ _08346_ _08341_ u_core.u_top.u_core.acc[196] VSS VSS VDD VDD _08366_ sky130_fd_sc_hd__a221oi_1
X_14042_ net672 _08365_ _08366_ _08349_ u_core.u_top.u_core.acc[196] VSS VSS VDD VDD u_core.u_top.u_core.acc_upd[196] sky130_fd_sc_hd__o32a_1
X_14043_ _08338_ _08353_ _08357_ _08333_ u_core.u_top.u_core.acc[195] VSS VSS VDD VDD _08367_ sky130_fd_sc_hd__o221a_2
X_14044_ _08346_ _08353_ _08357_ _08345_ u_core.u_top.u_core.acc[195] VSS VSS VDD VDD _08368_ sky130_fd_sc_hd__a221oi_1
X_14045_ net672 _08367_ _08368_ _08349_ u_core.u_top.u_core.acc[195] VSS VSS VDD VDD u_core.u_top.u_core.acc_upd[195] sky130_fd_sc_hd__o32a_1
X_14046_ u_core.u_top.u_core.acc[194] _08340_ VSS VSS VDD VDD _08369_ sky130_fd_sc_hd__xnor2_1
X_14047_ u_core.u_top.u_core.acc[194] _08334_ VSS VSS VDD VDD _08370_ sky130_fd_sc_hd__xor2_1
X_14048_ _08338_ _08369_ _08370_ _08333_ VSS VSS VDD VDD _08371_ sky130_fd_sc_hd__o22ai_1
X_14049_ u_core.u_top.u_core.acc[194] _08349_ VSS VSS VDD VDD _08372_ sky130_fd_sc_hd__nor2_1
X_14050_ net678 _08371_ _08372_ VSS VSS VDD VDD u_core.u_top.u_core.acc_upd[194] sky130_fd_sc_hd__a21oi_1
X_14051_ u_core.u_top.u_core.acc[192] u_core.u_top.u_core.acc[191] u_core.u_top.u_core.acc[190] _08345_ VSS VSS VDD VDD _08373_ sky130_fd_sc_hd__nand4_1
X_14052_ u_core.u_top.u_core.acc[192] u_core.u_top.u_core.acc[191] u_core.u_top.u_core.acc[190] _08338_ VSS VSS VDD VDD _08374_ sky130_fd_sc_hd__or4_1
X_14053_ _08373_ _08374_ net672 VSS VSS VDD VDD _08375_ sky130_fd_sc_hd__a21oi_1
X_14054_ u_core.u_top.u_core.acc[193] _08375_ VSS VSS VDD VDD u_core.u_top.u_core.acc_upd[193] sky130_fd_sc_hd__xor2_1
X_14055_ _02588_ _08333_ _08338_ _02587_ u_core.u_top.u_core.acc[192] VSS VSS VDD VDD _08376_ sky130_fd_sc_hd__o221ai_1
X_14056_ _02588_ _08345_ _08346_ _02587_ u_core.u_top.u_core.acc[192] VSS VSS VDD VDD _08377_ sky130_fd_sc_hd__a221o_1
X_14057_ _08376_ _08377_ VSS VSS VDD VDD _08378_ sky130_fd_sc_hd__nand2_1
X_14058_ net672 _08348_ u_core.u_top.u_core.acc[192] VSS VSS VDD VDD _08379_ sky130_fd_sc_hd__o21ai_0
X_14059_ net672 _08378_ _08379_ VSS VSS VDD VDD u_core.u_top.u_core.acc_upd[192] sky130_fd_sc_hd__o21ai_0
X_14061_ _0164_[1] net715 VSS VSS VDD VDD _08381_ sky130_fd_sc_hd__nor2_1
X_14062_ _02567_ net713 _08381_ VSS VSS VDD VDD _08382_ sky130_fd_sc_hd__a21o_1
X_14063_ _02567_ net706 VSS VSS VDD VDD _08383_ sky130_fd_sc_hd__nand2_1
X_14064_ _0164_[1] net706 _08383_ VSS VSS VDD VDD _08384_ sky130_fd_sc_hd__o21ai_0
X_14065_ _08332_ _08382_ _08384_ _0163_ VSS VSS VDD VDD _08385_ sky130_fd_sc_hd__a22oi_1
X_14066_ u_core.u_top.u_core.acc[191] _08349_ _08385_ net672 VSS VSS VDD VDD u_core.u_top.u_core.acc_upd[191] sky130_fd_sc_hd__o22a_1
X_14067_ u_core.u_top.u_core.acc[188] VSS VSS VDD VDD _08386_ sky130_fd_sc_hd__inv_1
X_14068_ _0151_ net825 VSS VSS VDD VDD _08387_ sky130_fd_sc_hd__nor2b_1
X_14069_ _0151_ _08387_ net706 VSS VSS VDD VDD _08388_ sky130_fd_sc_hd__mux2i_1
X_14070_ u_core.u_top.u_core.acc[183] u_core.u_top.u_core.acc[182] _02543_ VSS VSS VDD VDD _08389_ sky130_fd_sc_hd__and3_1
X_14071_ u_core.u_top.u_core.acc[185] u_core.u_top.u_core.acc[184] _08389_ VSS VSS VDD VDD _08390_ sky130_fd_sc_hd__nand3_1
X_14072_ u_core.u_top.u_core.acc[187] u_core.u_top.u_core.acc[186] VSS VSS VDD VDD _08391_ sky130_fd_sc_hd__nand2_1
X_14073_ _08390_ _08391_ VSS VSS VDD VDD _08392_ sky130_fd_sc_hd__or2_2
X_14074_ _0151_ _08387_ net713 VSS VSS VDD VDD _08393_ sky130_fd_sc_hd__mux2i_1
X_14075_ u_core.u_top.u_core.acc[183] u_core.u_top.u_core.acc[182] VSS VSS VDD VDD _08394_ sky130_fd_sc_hd__nor2_1
X_14076_ _02542_ _08394_ VSS VSS VDD VDD _08395_ sky130_fd_sc_hd__nand2_1
X_14077_ u_core.u_top.u_core.acc[185] u_core.u_top.u_core.acc[184] _08395_ VSS VSS VDD VDD _08396_ sky130_fd_sc_hd__or3_1
X_14078_ u_core.u_top.u_core.acc[187] u_core.u_top.u_core.acc[186] _08396_ VSS VSS VDD VDD _08397_ sky130_fd_sc_hd__or3_1
X_14079_ _08388_ _08392_ _08393_ _08397_ VSS VSS VDD VDD _08398_ sky130_fd_sc_hd__o22ai_1
X_14080_ _08386_ _08398_ VSS VSS VDD VDD _08399_ sky130_fd_sc_hd__nor2_1
X_14081_ _0151_ _08387_ net706 VSS VSS VDD VDD _08400_ sky130_fd_sc_hd__mux2_1
X_14082_ _0151_ _08387_ net713 VSS VSS VDD VDD _08401_ sky130_fd_sc_hd__mux2_1
X_14083_ _08400_ _08392_ _08401_ _08397_ u_core.u_top.u_core.acc[188] VSS VSS VDD VDD _08402_ sky130_fd_sc_hd__a221oi_1
X_14084_ _0151_ net825 VSS VSS VDD VDD _08403_ sky130_fd_sc_hd__nor2_1
X_14085_ net672 _08403_ VSS VSS VDD VDD _08404_ sky130_fd_sc_hd__nor2_1
X_14086_ net672 _08399_ _08402_ _08404_ u_core.u_top.u_core.acc[188] VSS VSS VDD VDD u_core.u_top.u_core.acc_upd[188] sky130_fd_sc_hd__o32a_1
X_14087_ u_core.u_top.u_core.acc[183] u_core.u_top.u_core.acc[182] VSS VSS VDD VDD _08405_ sky130_fd_sc_hd__nand2_1
X_14088_ u_core.u_top.u_core.acc[184] u_core.u_top.u_core.acc[181] u_core.u_top.u_core.acc[180] VSS VSS VDD VDD _08406_ sky130_fd_sc_hd__nand3_1
X_14089_ _08405_ _08406_ VSS VSS VDD VDD _08407_ sky130_fd_sc_hd__or2_2
X_14090_ u_core.u_top.u_core.acc[186] u_core.u_top.u_core.acc[185] VSS VSS VDD VDD _08408_ sky130_fd_sc_hd__nand2_1
X_14091_ _08407_ _08408_ VSS VSS VDD VDD _08409_ sky130_fd_sc_hd__nor2_1
X_14092_ u_core.u_top.u_core.acc[184] u_core.u_top.u_core.acc[181] u_core.u_top.u_core.acc[180] VSS VSS VDD VDD _08410_ sky130_fd_sc_hd__nor3_1
X_14093_ _08394_ _08410_ VSS VSS VDD VDD _08411_ sky130_fd_sc_hd__nand2_1
X_14094_ u_core.u_top.u_core.acc[186] u_core.u_top.u_core.acc[185] _08411_ VSS VSS VDD VDD _08412_ sky130_fd_sc_hd__nor3_1
X_14095_ _08400_ _08409_ _08412_ _08401_ VSS VSS VDD VDD _08413_ sky130_fd_sc_hd__a22oi_1
X_14096_ _08388_ _08409_ _08412_ _08393_ VSS VSS VDD VDD _08414_ sky130_fd_sc_hd__o22ai_1
X_14097_ u_core.u_top.u_core.acc[187] _08414_ VSS VSS VDD VDD _08415_ sky130_fd_sc_hd__nor2_1
X_14098_ u_core.u_top.u_core.acc[187] _08413_ _08415_ VSS VSS VDD VDD _08416_ sky130_fd_sc_hd__a21oi_1
X_14099_ u_core.u_top.u_core.acc[187] _08404_ VSS VSS VDD VDD _08417_ sky130_fd_sc_hd__nor2_1
X_14100_ net678 _08416_ _08417_ VSS VSS VDD VDD u_core.u_top.u_core.acc_upd[187] sky130_fd_sc_hd__a21oi_1
X_14101_ _08388_ _08390_ _08393_ _08396_ u_core.u_top.u_core.acc[186] VSS VSS VDD VDD _08418_ sky130_fd_sc_hd__o221a_2
X_14102_ _08400_ _08390_ _08401_ _08396_ u_core.u_top.u_core.acc[186] VSS VSS VDD VDD _08419_ sky130_fd_sc_hd__a221oi_1
X_14103_ net672 _08418_ _08419_ _08404_ u_core.u_top.u_core.acc[186] VSS VSS VDD VDD u_core.u_top.u_core.acc_upd[186] sky130_fd_sc_hd__o32a_1
X_14104_ _08388_ _08407_ _08411_ _08393_ u_core.u_top.u_core.acc[185] VSS VSS VDD VDD _08420_ sky130_fd_sc_hd__o221a_2
X_14105_ _08400_ _08407_ _08411_ _08401_ u_core.u_top.u_core.acc[185] VSS VSS VDD VDD _08421_ sky130_fd_sc_hd__a221oi_1
X_14106_ net672 _08420_ _08421_ _08404_ u_core.u_top.u_core.acc[185] VSS VSS VDD VDD u_core.u_top.u_core.acc_upd[185] sky130_fd_sc_hd__o32a_1
X_14107_ u_core.u_top.u_core.acc[184] _08395_ VSS VSS VDD VDD _08422_ sky130_fd_sc_hd__xnor2_1
X_14108_ u_core.u_top.u_core.acc[184] _08389_ VSS VSS VDD VDD _08423_ sky130_fd_sc_hd__xor2_1
X_14109_ _08393_ _08422_ _08423_ _08388_ VSS VSS VDD VDD _08424_ sky130_fd_sc_hd__o22ai_1
X_14110_ u_core.u_top.u_core.acc[184] _08404_ VSS VSS VDD VDD _08425_ sky130_fd_sc_hd__nor2_1
X_14111_ net678 _08424_ _08425_ VSS VSS VDD VDD u_core.u_top.u_core.acc_upd[184] sky130_fd_sc_hd__a21oi_1
X_14112_ u_core.u_top.u_core.acc[182] u_core.u_top.u_core.acc[181] u_core.u_top.u_core.acc[180] _08400_ VSS VSS VDD VDD _08426_ sky130_fd_sc_hd__nand4_1
X_14113_ u_core.u_top.u_core.acc[182] u_core.u_top.u_core.acc[181] u_core.u_top.u_core.acc[180] _08393_ VSS VSS VDD VDD _08427_ sky130_fd_sc_hd__or4_1
X_14114_ _08426_ _08427_ net672 VSS VSS VDD VDD _08428_ sky130_fd_sc_hd__a21oi_1
X_14115_ u_core.u_top.u_core.acc[183] _08428_ VSS VSS VDD VDD u_core.u_top.u_core.acc_upd[183] sky130_fd_sc_hd__xor2_1
X_14116_ _02543_ _08388_ _08393_ _02542_ u_core.u_top.u_core.acc[182] VSS VSS VDD VDD _08429_ sky130_fd_sc_hd__o221ai_1
X_14117_ _02543_ _08400_ _08401_ _02542_ u_core.u_top.u_core.acc[182] VSS VSS VDD VDD _08430_ sky130_fd_sc_hd__a221o_1
X_14118_ _08429_ _08430_ VSS VSS VDD VDD _08431_ sky130_fd_sc_hd__nand2_1
X_14119_ net672 _08403_ u_core.u_top.u_core.acc[182] VSS VSS VDD VDD _08432_ sky130_fd_sc_hd__o21ai_0
X_14120_ net672 _08431_ _08432_ VSS VSS VDD VDD u_core.u_top.u_core.acc_upd[182] sky130_fd_sc_hd__o21ai_0
X_14122_ _02539_ net706 VSS VSS VDD VDD _08434_ sky130_fd_sc_hd__nor2_1
X_14123_ _0152_[1] net706 _08434_ VSS VSS VDD VDD _08435_ sky130_fd_sc_hd__a21oi_1
X_14124_ _02539_ net706 VSS VSS VDD VDD _08436_ sky130_fd_sc_hd__nand2_1
X_14125_ _0152_[1] net706 _08436_ VSS VSS VDD VDD _08437_ sky130_fd_sc_hd__o21ai_0
X_14126_ _08387_ _08435_ _08437_ _0151_ VSS VSS VDD VDD _08438_ sky130_fd_sc_hd__a22oi_1
X_14127_ u_core.u_top.u_core.acc[181] _08404_ _08438_ net672 VSS VSS VDD VDD u_core.u_top.u_core.acc_upd[181] sky130_fd_sc_hd__o22a_1
X_14130_ u_core.u_top.u_core.acc[173] u_core.u_top.u_core.acc[172] _03008_ VSS VSS VDD VDD _08441_ sky130_fd_sc_hd__and3_1
X_14132_ net963 u_core.u_top.u_core.acc[177] u_core.u_top.u_core.acc[176] VSS VSS VDD VDD _08443_ sky130_fd_sc_hd__and3_1
X_14133_ u_core.u_top.u_core.acc[174] _08441_ _08443_ VSS VSS VDD VDD _08444_ sky130_fd_sc_hd__nand3_1
X_14134_ net962 _08444_ VSS VSS VDD VDD _08445_ sky130_fd_sc_hd__xor2_1
X_14135_ u_core.u_top.u_core.acc[173] u_core.u_top.u_core.acc[172] VSS VSS VDD VDD _08446_ sky130_fd_sc_hd__nor2_1
X_14136_ _03006_ _08446_ VSS VSS VDD VDD _08447_ sky130_fd_sc_hd__nand2_1
X_14137_ u_core.u_top.u_core.acc[174] net963 _08447_ VSS VSS VDD VDD _08448_ sky130_fd_sc_hd__or3_1
X_14138_ u_core.u_top.u_core.acc[177] u_core.u_top.u_core.acc[176] _08448_ VSS VSS VDD VDD _08449_ sky130_fd_sc_hd__nor3_1
X_14139_ net962 _08449_ VSS VSS VDD VDD _08450_ sky130_fd_sc_hd__xnor2_1
X_14140_ _08445_ _08450_ net713 VSS VSS VDD VDD _08451_ sky130_fd_sc_hd__mux2_1
X_14141_ net962 net826 VSS VSS VDD VDD _08452_ sky130_fd_sc_hd__nor2_1
X_14142_ net826 net678 _08451_ _08452_ VSS VSS VDD VDD _08453_ sky130_fd_sc_hd__a31oi_1
X_14143_ _0140_ _08453_ VSS VSS VDD VDD _08454_ sky130_fd_sc_hd__nor2_1
X_14146_ _08445_ _08450_ net706 VSS VSS VDD VDD _08457_ sky130_fd_sc_hd__mux2i_1
X_14147_ _0140_ net678 VSS VSS VDD VDD _08458_ sky130_fd_sc_hd__nand2_1
X_14148_ net962 net678 _08457_ _08458_ VSS VSS VDD VDD _08459_ sky130_fd_sc_hd__o22ai_1
X_14149_ _08454_ _08459_ VSS VSS VDD VDD u_core.u_top.u_core.acc_upd[178] sky130_fd_sc_hd__nor2_1
X_14150_ _0140_ net826 VSS VSS VDD VDD _08460_ sky130_fd_sc_hd__nor2b_1
X_14151_ _0140_ _08460_ _06466_ VSS VSS VDD VDD _08461_ sky130_fd_sc_hd__mux2i_1
X_14152_ u_core.u_top.u_core.acc[170] u_core.u_top.u_core.acc[174] u_core.u_top.u_core.acc[171] VSS VSS VDD VDD _08462_ sky130_fd_sc_hd__nor3_1
X_14153_ _08446_ _08462_ VSS VSS VDD VDD _08463_ sky130_fd_sc_hd__nand2_1
X_14154_ net963 u_core.u_top.u_core.acc[176] _08463_ VSS VSS VDD VDD _08464_ sky130_fd_sc_hd__or3_1
X_14155_ _0140_ _08460_ net706 VSS VSS VDD VDD _08465_ sky130_fd_sc_hd__mux2_1
X_14156_ net963 u_core.u_top.u_core.acc[176] VSS VSS VDD VDD _08466_ sky130_fd_sc_hd__nand2_1
X_14157_ u_core.u_top.u_core.acc[173] u_core.u_top.u_core.acc[172] VSS VSS VDD VDD _08467_ sky130_fd_sc_hd__nand2_1
X_14158_ u_core.u_top.u_core.acc[170] u_core.u_top.u_core.acc[174] u_core.u_top.u_core.acc[171] VSS VSS VDD VDD _08468_ sky130_fd_sc_hd__nand3_1
X_14159_ _08467_ _08468_ VSS VSS VDD VDD _08469_ sky130_fd_sc_hd__or2_2
X_14160_ _08466_ _08469_ VSS VSS VDD VDD _08470_ sky130_fd_sc_hd__nor2_1
X_14161_ _08465_ _08470_ VSS VSS VDD VDD _08471_ sky130_fd_sc_hd__nand2_1
X_14162_ _08461_ _08464_ u_core.u_top.u_core.acc[177] _08471_ VSS VSS VDD VDD _08472_ sky130_fd_sc_hd__o211a_1
X_14163_ _0140_ _08460_ _06466_ VSS VSS VDD VDD _08473_ sky130_fd_sc_hd__mux2_1
X_14164_ _0140_ _08460_ net706 VSS VSS VDD VDD _08474_ sky130_fd_sc_hd__mux2i_1
X_14165_ _08474_ _08470_ VSS VSS VDD VDD _08475_ sky130_fd_sc_hd__nor2_1
X_14166_ _08473_ _08464_ _08475_ u_core.u_top.u_core.acc[177] VSS VSS VDD VDD _08476_ sky130_fd_sc_hd__a211oi_1
X_14167_ _0140_ net826 VSS VSS VDD VDD _08477_ sky130_fd_sc_hd__nor2_1
X_14168_ net672 _08477_ VSS VSS VDD VDD _08478_ sky130_fd_sc_hd__nor2_1
X_14169_ net672 _08472_ _08476_ _08478_ u_core.u_top.u_core.acc[177] VSS VSS VDD VDD u_core.u_top.u_core.acc_upd[177] sky130_fd_sc_hd__o32a_1
X_14170_ u_core.u_top.u_core.acc[176] VSS VSS VDD VDD _08479_ sky130_fd_sc_hd__inv_1
X_14171_ u_core.u_top.u_core.acc[174] net963 _08441_ VSS VSS VDD VDD _08480_ sky130_fd_sc_hd__nand3_1
X_14172_ u_core.u_top.u_core.acc[176] _08480_ VSS VSS VDD VDD _08481_ sky130_fd_sc_hd__xnor2_1
X_14173_ _08479_ _08448_ _08461_ _08481_ _08474_ VSS VSS VDD VDD _08482_ sky130_fd_sc_hd__o32ai_1
X_14174_ _08448_ _08473_ VSS VSS VDD VDD _08483_ sky130_fd_sc_hd__nand2_1
X_14175_ _08478_ _08483_ u_core.u_top.u_core.acc[176] VSS VSS VDD VDD _08484_ sky130_fd_sc_hd__a21oi_1
X_14176_ net678 _08482_ _08484_ VSS VSS VDD VDD u_core.u_top.u_core.acc_upd[176] sky130_fd_sc_hd__a21oi_1
X_14177_ _08474_ _08469_ _08461_ _08463_ net963 VSS VSS VDD VDD _08485_ sky130_fd_sc_hd__o221a_2
X_14178_ _08465_ _08469_ _08473_ _08463_ net963 VSS VSS VDD VDD _08486_ sky130_fd_sc_hd__a221oi_1
X_14179_ net672 _08485_ _08486_ _08478_ net963 VSS VSS VDD VDD u_core.u_top.u_core.acc_upd[175] sky130_fd_sc_hd__o32a_1
X_14180_ u_core.u_top.u_core.acc[174] _08447_ VSS VSS VDD VDD _08487_ sky130_fd_sc_hd__xnor2_1
X_14181_ u_core.u_top.u_core.acc[174] _08441_ VSS VSS VDD VDD _08488_ sky130_fd_sc_hd__xor2_1
X_14182_ _08461_ _08487_ _08488_ _08474_ VSS VSS VDD VDD _08489_ sky130_fd_sc_hd__o22ai_1
X_14183_ u_core.u_top.u_core.acc[174] _08478_ VSS VSS VDD VDD _08490_ sky130_fd_sc_hd__nor2_1
X_14184_ net678 _08489_ _08490_ VSS VSS VDD VDD u_core.u_top.u_core.acc_upd[174] sky130_fd_sc_hd__a21oi_1
X_14185_ u_core.u_top.u_core.acc[170] u_core.u_top.u_core.acc[172] u_core.u_top.u_core.acc[171] _08465_ VSS VSS VDD VDD _08491_ sky130_fd_sc_hd__nand4_1
X_14186_ u_core.u_top.u_core.acc[170] u_core.u_top.u_core.acc[172] u_core.u_top.u_core.acc[171] _08461_ VSS VSS VDD VDD _08492_ sky130_fd_sc_hd__or4_1
X_14187_ _08491_ _08492_ net672 VSS VSS VDD VDD _08493_ sky130_fd_sc_hd__a21oi_1
X_14188_ u_core.u_top.u_core.acc[173] _08493_ VSS VSS VDD VDD u_core.u_top.u_core.acc_upd[173] sky130_fd_sc_hd__xor2_1
X_14189_ _03008_ _08474_ _08461_ _03006_ u_core.u_top.u_core.acc[172] VSS VSS VDD VDD _08494_ sky130_fd_sc_hd__o221ai_1
X_14190_ _03008_ _08465_ _08473_ _03006_ u_core.u_top.u_core.acc[172] VSS VSS VDD VDD _08495_ sky130_fd_sc_hd__a221o_1
X_14191_ _08494_ _08495_ VSS VSS VDD VDD _08496_ sky130_fd_sc_hd__nand2_1
X_14192_ net672 _08477_ u_core.u_top.u_core.acc[172] VSS VSS VDD VDD _08497_ sky130_fd_sc_hd__o21ai_0
X_14193_ net672 _08496_ _08497_ VSS VSS VDD VDD u_core.u_top.u_core.acc_upd[172] sky130_fd_sc_hd__o21ai_0
X_14194_ _0141_[1] _06466_ VSS VSS VDD VDD _08498_ sky130_fd_sc_hd__xnor2_1
X_14195_ net826 _08498_ VSS VSS VDD VDD _08499_ sky130_fd_sc_hd__nand2_1
X_14196_ net826 u_core.u_top.u_core.acc[171] net672 _08499_ VSS VSS VDD VDD _08500_ sky130_fd_sc_hd__o22ai_1
X_14197_ _0140_ _08500_ VSS VSS VDD VDD _08501_ sky130_fd_sc_hd__nand2b_1
X_14198_ u_core.u_top.u_core.acc[171] net678 _08458_ _08498_ _08501_ VSS VSS VDD VDD _02446_ sky130_fd_sc_hd__o221ai_1
X_14199_ _02446_ VSS VSS VDD VDD u_core.u_top.u_core.acc_upd[171] sky130_fd_sc_hd__inv_1
X_14201_ _0129_ net827 VSS VSS VDD VDD _08503_ sky130_fd_sc_hd__nor2b_1
X_14202_ _0129_ _08503_ net706 VSS VSS VDD VDD _08504_ sky130_fd_sc_hd__mux2i_1
X_14203_ u_core.u_top.u_core.acc[163] u_core.u_top.u_core.acc[162] _03093_ VSS VSS VDD VDD _08505_ sky130_fd_sc_hd__nand3_1
X_14204_ u_core.u_top.u_core.acc[164] u_core.u_top.u_core.acc[165] VSS VSS VDD VDD _08506_ sky130_fd_sc_hd__nand2_1
X_14205_ _08505_ _08506_ VSS VSS VDD VDD _08507_ sky130_fd_sc_hd__nor2_1
X_14206_ u_core.u_top.u_core.acc[166] u_core.u_top.u_core.acc[167] _08507_ VSS VSS VDD VDD _08508_ sky130_fd_sc_hd__nand3_1
X_14207_ _0129_ _08503_ net713 VSS VSS VDD VDD _08509_ sky130_fd_sc_hd__mux2i_1
X_14208_ u_core.u_top.u_core.acc[163] u_core.u_top.u_core.acc[162] VSS VSS VDD VDD _08510_ sky130_fd_sc_hd__nor2_1
X_14209_ _03092_ _08510_ VSS VSS VDD VDD _08511_ sky130_fd_sc_hd__nand2_1
X_14210_ u_core.u_top.u_core.acc[164] u_core.u_top.u_core.acc[165] _08511_ VSS VSS VDD VDD _08512_ sky130_fd_sc_hd__nor3_1
X_14211_ u_core.u_top.u_core.acc[166] u_core.u_top.u_core.acc[167] VSS VSS VDD VDD _08513_ sky130_fd_sc_hd__nor2_1
X_14212_ _08512_ _08513_ VSS VSS VDD VDD _08514_ sky130_fd_sc_hd__nand2_1
X_14213_ net694 _08508_ net693 _08514_ u_core.u_top.u_core.acc[168] VSS VSS VDD VDD _08515_ sky130_fd_sc_hd__o221a_2
X_14214_ _0129_ _08503_ net706 VSS VSS VDD VDD _08516_ sky130_fd_sc_hd__mux2_1
X_14215_ _0129_ _08503_ net713 VSS VSS VDD VDD _08517_ sky130_fd_sc_hd__mux2_1
X_14216_ _08516_ _08508_ _08517_ _08514_ u_core.u_top.u_core.acc[168] VSS VSS VDD VDD _08518_ sky130_fd_sc_hd__a221oi_1
X_14217_ _0129_ net827 VSS VSS VDD VDD _08519_ sky130_fd_sc_hd__nor2_1
X_14218_ net672 _08519_ VSS VSS VDD VDD _08520_ sky130_fd_sc_hd__nor2_1
X_14219_ net672 _08515_ _08518_ _08520_ u_core.u_top.u_core.acc[168] VSS VSS VDD VDD u_core.u_top.u_core.acc_upd[168] sky130_fd_sc_hd__o32a_1
X_14220_ u_core.u_top.u_core.acc[164] VSS VSS VDD VDD _08521_ sky130_fd_sc_hd__inv_1
X_14221_ _0130_[0] _02890_ _08521_ _08510_ VSS VSS VDD VDD _08522_ sky130_fd_sc_hd__and4_1
X_14222_ u_core.u_top.u_core.acc[166] u_core.u_top.u_core.acc[165] VSS VSS VDD VDD _08523_ sky130_fd_sc_hd__nor2_1
X_14223_ _08522_ _08523_ VSS VSS VDD VDD _08524_ sky130_fd_sc_hd__nand2_1
X_14224_ u_core.u_top.u_core.acc[163] u_core.u_top.u_core.acc[162] VSS VSS VDD VDD _08525_ sky130_fd_sc_hd__nand2_1
X_14225_ _0130_[0] _02890_ _08521_ _08525_ VSS VSS VDD VDD _08526_ sky130_fd_sc_hd__nor4_1
X_14226_ u_core.u_top.u_core.acc[166] u_core.u_top.u_core.acc[165] _08526_ VSS VSS VDD VDD _08527_ sky130_fd_sc_hd__nand3_1
X_14227_ _08524_ _08527_ net713 VSS VSS VDD VDD _08528_ sky130_fd_sc_hd__mux2i_1
X_14229_ _08524_ _08527_ net706 VSS VSS VDD VDD _08530_ sky130_fd_sc_hd__mux2i_1
X_14230_ _0129_ _08528_ _08530_ _08503_ VSS VSS VDD VDD _08531_ sky130_fd_sc_hd__a22oi_1
X_14231_ net672 _08531_ VSS VSS VDD VDD _08532_ sky130_fd_sc_hd__nor2_1
X_14232_ u_core.u_top.u_core.acc[167] _08532_ VSS VSS VDD VDD u_core.u_top.u_core.acc_upd[167] sky130_fd_sc_hd__xor2_1
X_14234_ net694 _08507_ net693 _08512_ u_core.u_top.u_core.acc[166] VSS VSS VDD VDD _08534_ sky130_fd_sc_hd__o221ai_1
X_14235_ _08516_ _08507_ _08517_ _08512_ u_core.u_top.u_core.acc[166] VSS VSS VDD VDD _08535_ sky130_fd_sc_hd__a221o_1
X_14236_ _08534_ _08535_ VSS VSS VDD VDD _08536_ sky130_fd_sc_hd__nand2_1
X_14237_ net672 _08519_ u_core.u_top.u_core.acc[166] VSS VSS VDD VDD _08537_ sky130_fd_sc_hd__o21ai_0
X_14238_ net672 _08536_ _08537_ VSS VSS VDD VDD u_core.u_top.u_core.acc_upd[166] sky130_fd_sc_hd__o21ai_0
X_14239_ net693 _08522_ _08526_ net694 u_core.u_top.u_core.acc[165] VSS VSS VDD VDD _08538_ sky130_fd_sc_hd__o221ai_1
X_14240_ _08517_ _08522_ _08526_ _08516_ u_core.u_top.u_core.acc[165] VSS VSS VDD VDD _08539_ sky130_fd_sc_hd__a221o_1
X_14241_ _08538_ _08539_ VSS VSS VDD VDD _08540_ sky130_fd_sc_hd__nand2_1
X_14242_ net672 _08519_ u_core.u_top.u_core.acc[165] VSS VSS VDD VDD _08541_ sky130_fd_sc_hd__o21ai_0
X_14243_ net672 _08540_ _08541_ VSS VSS VDD VDD u_core.u_top.u_core.acc_upd[165] sky130_fd_sc_hd__o21ai_0
X_14244_ net694 _08505_ net693 _08511_ VSS VSS VDD VDD _08542_ sky130_fd_sc_hd__o22ai_1
X_14245_ _08521_ _08542_ VSS VSS VDD VDD _08543_ sky130_fd_sc_hd__nor2_1
X_14246_ _08516_ _08505_ _08517_ _08511_ u_core.u_top.u_core.acc[164] VSS VSS VDD VDD _08544_ sky130_fd_sc_hd__a221oi_1
X_14247_ net672 _08543_ _08544_ _08520_ u_core.u_top.u_core.acc[164] VSS VSS VDD VDD u_core.u_top.u_core.acc_upd[164] sky130_fd_sc_hd__o32a_1
X_14248_ u_core.u_top.u_core.acc[160] u_core.u_top.u_core.acc[161] u_core.u_top.u_core.acc[162] _08516_ VSS VSS VDD VDD _08545_ sky130_fd_sc_hd__nand4_1
X_14249_ u_core.u_top.u_core.acc[160] u_core.u_top.u_core.acc[161] u_core.u_top.u_core.acc[162] net693 VSS VSS VDD VDD _08546_ sky130_fd_sc_hd__or4_1
X_14250_ _08545_ _08546_ net672 VSS VSS VDD VDD _08547_ sky130_fd_sc_hd__a21oi_1
X_14251_ u_core.u_top.u_core.acc[163] _08547_ VSS VSS VDD VDD u_core.u_top.u_core.acc_upd[163] sky130_fd_sc_hd__xor2_1
X_14252_ _03093_ net694 net693 _03092_ u_core.u_top.u_core.acc[162] VSS VSS VDD VDD _08548_ sky130_fd_sc_hd__o221ai_1
X_14253_ _03093_ _08516_ _08517_ _03092_ u_core.u_top.u_core.acc[162] VSS VSS VDD VDD _08549_ sky130_fd_sc_hd__a221o_1
X_14254_ _08548_ _08549_ VSS VSS VDD VDD _08550_ sky130_fd_sc_hd__nand2_1
X_14255_ net672 _08519_ u_core.u_top.u_core.acc[162] VSS VSS VDD VDD _08551_ sky130_fd_sc_hd__o21ai_0
X_14256_ net672 _08550_ _08551_ VSS VSS VDD VDD u_core.u_top.u_core.acc_upd[162] sky130_fd_sc_hd__o21ai_0
X_14257_ _0130_[1] net713 VSS VSS VDD VDD _08552_ sky130_fd_sc_hd__nor2_1
X_14258_ _02892_ net713 _08552_ VSS VSS VDD VDD _08553_ sky130_fd_sc_hd__a21o_1
X_14259_ _02892_ net706 VSS VSS VDD VDD _08554_ sky130_fd_sc_hd__nand2_1
X_14260_ _0130_[1] net706 _08554_ VSS VSS VDD VDD _08555_ sky130_fd_sc_hd__o21ai_0
X_14261_ _08503_ _08553_ _08555_ _0129_ VSS VSS VDD VDD _08556_ sky130_fd_sc_hd__a22oi_1
X_14262_ u_core.u_top.u_core.acc[161] _08520_ _08556_ net672 VSS VSS VDD VDD u_core.u_top.u_core.acc_upd[161] sky130_fd_sc_hd__o22a_1
X_14264_ _0118_ net828 VSS VSS VDD VDD _08558_ sky130_fd_sc_hd__nor2b_1
X_14265_ _0118_ _08558_ net709 VSS VSS VDD VDD _08559_ sky130_fd_sc_hd__mux2i_1
X_14267_ u_core.u_top.u_core.acc[154] u_core.u_top.u_core.acc[153] u_core.u_top.u_core.acc[152] _02957_ VSS VSS VDD VDD _08561_ sky130_fd_sc_hd__nand4_1
X_14269_ u_core.u_top.u_core.acc[157] u_core.u_top.u_core.acc[155] u_core.u_top.u_core.acc[156] VSS VSS VDD VDD _08563_ sky130_fd_sc_hd__nand3_1
X_14270_ _08561_ _08563_ VSS VSS VDD VDD _08564_ sky130_fd_sc_hd__nor2_1
X_14271_ u_core.u_top.u_core.acc[158] _08564_ VSS VSS VDD VDD _08565_ sky130_fd_sc_hd__xor2_1
X_14272_ u_core.u_top.u_core.acc[153] u_core.u_top.u_core.acc[152] VSS VSS VDD VDD _08566_ sky130_fd_sc_hd__nor2_1
X_14273_ _02956_ _08566_ VSS VSS VDD VDD _08567_ sky130_fd_sc_hd__nand2_1
X_14274_ u_core.u_top.u_core.acc[157] u_core.u_top.u_core.acc[155] u_core.u_top.u_core.acc[156] VSS VSS VDD VDD _08568_ sky130_fd_sc_hd__or3_1
X_14275_ u_core.u_top.u_core.acc[154] _08567_ _08568_ VSS VSS VDD VDD _08569_ sky130_fd_sc_hd__nor3_1
X_14276_ u_core.u_top.u_core.acc[158] _08569_ VSS VSS VDD VDD _08570_ sky130_fd_sc_hd__xor2_1
X_14277_ _0118_ _08558_ net712 VSS VSS VDD VDD _08571_ sky130_fd_sc_hd__mux2i_1
X_14278_ _08559_ _08565_ _08570_ _08571_ VSS VSS VDD VDD _08572_ sky130_fd_sc_hd__o22ai_1
X_14279_ _0118_ net828 VSS VSS VDD VDD _08573_ sky130_fd_sc_hd__nor2_1
X_14280_ net670 _08573_ VSS VSS VDD VDD _08574_ sky130_fd_sc_hd__nor2_1
X_14281_ u_core.u_top.u_core.acc[158] _08574_ VSS VSS VDD VDD _08575_ sky130_fd_sc_hd__nor2_1
X_14282_ net678 _08572_ _08575_ VSS VSS VDD VDD u_core.u_top.u_core.acc_upd[158] sky130_fd_sc_hd__a21oi_1
X_14283_ u_core.u_top.u_core.acc[155] u_core.u_top.u_core.acc[156] VSS VSS VDD VDD _08576_ sky130_fd_sc_hd__nand2_1
X_14284_ u_core.u_top.u_core.acc[152] u_core.u_top.u_core.acc[151] u_core.u_top.u_core.acc[150] VSS VSS VDD VDD _08577_ sky130_fd_sc_hd__nand3_1
X_14285_ u_core.u_top.u_core.acc[154] u_core.u_top.u_core.acc[153] VSS VSS VDD VDD _08578_ sky130_fd_sc_hd__nand2_1
X_14286_ _08577_ _08578_ VSS VSS VDD VDD _08579_ sky130_fd_sc_hd__or2_2
X_14287_ _08576_ _08579_ VSS VSS VDD VDD _08580_ sky130_fd_sc_hd__nor2_1
X_14288_ u_core.u_top.u_core.acc[157] _08580_ VSS VSS VDD VDD _08581_ sky130_fd_sc_hd__xor2_1
X_14289_ u_core.u_top.u_core.acc[152] u_core.u_top.u_core.acc[151] u_core.u_top.u_core.acc[150] VSS VSS VDD VDD _08582_ sky130_fd_sc_hd__or3_1
X_14290_ u_core.u_top.u_core.acc[154] u_core.u_top.u_core.acc[153] _08582_ VSS VSS VDD VDD _08583_ sky130_fd_sc_hd__or3_1
X_14291_ u_core.u_top.u_core.acc[155] u_core.u_top.u_core.acc[156] _08583_ VSS VSS VDD VDD _08584_ sky130_fd_sc_hd__nor3_1
X_14292_ u_core.u_top.u_core.acc[157] _08584_ VSS VSS VDD VDD _08585_ sky130_fd_sc_hd__xor2_1
X_14293_ _08559_ _08581_ _08585_ _08571_ VSS VSS VDD VDD _08586_ sky130_fd_sc_hd__o22ai_1
X_14294_ u_core.u_top.u_core.acc[157] _08574_ VSS VSS VDD VDD _08587_ sky130_fd_sc_hd__nor2_1
X_14295_ net678 _08586_ _08587_ VSS VSS VDD VDD u_core.u_top.u_core.acc_upd[157] sky130_fd_sc_hd__a21oi_1
X_14296_ _08559_ _08561_ VSS VSS VDD VDD _08588_ sky130_fd_sc_hd__nor2_1
X_14297_ u_core.u_top.u_core.acc[154] u_core.u_top.u_core.acc[155] _08571_ _08567_ VSS VSS VDD VDD _08589_ sky130_fd_sc_hd__nor4_1
X_14298_ u_core.u_top.u_core.acc[155] _08588_ _08589_ VSS VSS VDD VDD _08590_ sky130_fd_sc_hd__a21oi_1
X_14299_ net670 _08590_ VSS VSS VDD VDD _08591_ sky130_fd_sc_hd__nor2_1
X_14300_ u_core.u_top.u_core.acc[156] _08591_ VSS VSS VDD VDD u_core.u_top.u_core.acc_upd[156] sky130_fd_sc_hd__xor2_1
X_14301_ _08571_ _08583_ _08579_ _08559_ u_core.u_top.u_core.acc[155] VSS VSS VDD VDD _08592_ sky130_fd_sc_hd__o221a_2
X_14302_ _08571_ VSS VSS VDD VDD _08593_ sky130_fd_sc_hd__inv_1
X_14303_ _0118_ _08558_ net709 VSS VSS VDD VDD _08594_ sky130_fd_sc_hd__mux2_1
X_14304_ _08593_ _08583_ _08579_ _08594_ u_core.u_top.u_core.acc[155] VSS VSS VDD VDD _08595_ sky130_fd_sc_hd__a221oi_1
X_14305_ net670 _08592_ _08595_ _08574_ u_core.u_top.u_core.acc[155] VSS VSS VDD VDD u_core.u_top.u_core.acc_upd[155] sky130_fd_sc_hd__o32a_1
X_14306_ u_core.u_top.u_core.acc[153] u_core.u_top.u_core.acc[152] _02957_ VSS VSS VDD VDD _08596_ sky130_fd_sc_hd__nand3_1
X_14307_ u_core.u_top.u_core.acc[154] _08596_ VSS VSS VDD VDD _08597_ sky130_fd_sc_hd__xnor2_1
X_14308_ u_core.u_top.u_core.acc[154] _08567_ VSS VSS VDD VDD _08598_ sky130_fd_sc_hd__xnor2_1
X_14309_ _08559_ _08597_ _08598_ _08571_ VSS VSS VDD VDD _08599_ sky130_fd_sc_hd__o22ai_1
X_14310_ u_core.u_top.u_core.acc[154] _08574_ VSS VSS VDD VDD _08600_ sky130_fd_sc_hd__nor2_1
X_14311_ net678 _08599_ _08600_ VSS VSS VDD VDD u_core.u_top.u_core.acc_upd[154] sky130_fd_sc_hd__a21oi_1
X_14313_ _08582_ _08577_ net709 VSS VSS VDD VDD _08602_ sky130_fd_sc_hd__mux2i_1
X_14314_ _08582_ _08577_ net712 VSS VSS VDD VDD _08603_ sky130_fd_sc_hd__mux2i_1
X_14315_ _08558_ _08602_ _08603_ _0118_ VSS VSS VDD VDD _08604_ sky130_fd_sc_hd__a22oi_1
X_14316_ net670 _08604_ VSS VSS VDD VDD _08605_ sky130_fd_sc_hd__nor2_1
X_14317_ u_core.u_top.u_core.acc[153] _08605_ VSS VSS VDD VDD u_core.u_top.u_core.acc_upd[153] sky130_fd_sc_hd__xor2_1
X_14318_ _02957_ _08559_ _08571_ _02956_ u_core.u_top.u_core.acc[152] VSS VSS VDD VDD _08606_ sky130_fd_sc_hd__o221ai_1
X_14319_ _02957_ _08594_ _08593_ _02956_ u_core.u_top.u_core.acc[152] VSS VSS VDD VDD _08607_ sky130_fd_sc_hd__a221o_1
X_14320_ _08606_ _08607_ VSS VSS VDD VDD _08608_ sky130_fd_sc_hd__nand2_1
X_14321_ net670 _08573_ u_core.u_top.u_core.acc[152] VSS VSS VDD VDD _08609_ sky130_fd_sc_hd__o21ai_0
X_14322_ net670 _08608_ _08609_ VSS VSS VDD VDD u_core.u_top.u_core.acc_upd[152] sky130_fd_sc_hd__o21ai_0
X_14324_ _02851_ net709 VSS VSS VDD VDD _08611_ sky130_fd_sc_hd__nor2_1
X_14325_ _0119_[1] net709 _08611_ VSS VSS VDD VDD _08612_ sky130_fd_sc_hd__a21oi_1
X_14326_ net828 u_core.u_top.u_core.acc[151] VSS VSS VDD VDD _08613_ sky130_fd_sc_hd__nor2_1
X_14327_ net828 net678 _08612_ _08613_ VSS VSS VDD VDD _08614_ sky130_fd_sc_hd__a31oi_1
X_14328_ _0119_[1] net712 VSS VSS VDD VDD _08615_ sky130_fd_sc_hd__nand2_1
X_14329_ _02851_ net712 _08615_ net678 _0118_ VSS VSS VDD VDD _08616_ sky130_fd_sc_hd__o2111ai_1
X_14330_ u_core.u_top.u_core.acc[151] net678 _08614_ _0118_ _08616_ VSS VSS VDD VDD _02376_ sky130_fd_sc_hd__o221ai_1
X_14331_ _02376_ VSS VSS VDD VDD u_core.u_top.u_core.acc_upd[151] sky130_fd_sc_hd__inv_1
X_14333_ net830 net678 VSS VSS VDD VDD _08618_ sky130_fd_sc_hd__nand2_1
X_14336_ u_core.u_top.u_core.acc[143] u_core.u_top.u_core.acc[142] VSS VSS VDD VDD _08621_ sky130_fd_sc_hd__nor2_1
X_14337_ _02914_ _08621_ VSS VSS VDD VDD _08622_ sky130_fd_sc_hd__nand2_1
X_14338_ u_core.u_top.u_core.acc[145] u_core.u_top.u_core.acc[144] _08622_ VSS VSS VDD VDD _08623_ sky130_fd_sc_hd__or3_1
X_14339_ u_core.u_top.u_core.acc[147] u_core.u_top.u_core.acc[146] _08623_ VSS VSS VDD VDD _08624_ sky130_fd_sc_hd__nor3_1
X_14340_ u_core.u_top.u_core.acc[148] _08624_ VSS VSS VDD VDD _08625_ sky130_fd_sc_hd__xnor2_1
X_14341_ u_core.u_top.u_core.acc[148] VSS VSS VDD VDD _08626_ sky130_fd_sc_hd__inv_1
X_14342_ u_core.u_top.u_core.acc[144] u_core.u_top.u_core.acc[143] u_core.u_top.u_core.acc[142] VSS VSS VDD VDD _08627_ sky130_fd_sc_hd__nand3_1
X_14343_ u_core.u_top.u_core.acc[147] u_core.u_top.u_core.acc[146] u_core.u_top.u_core.acc[145] VSS VSS VDD VDD _08628_ sky130_fd_sc_hd__nand3_1
X_14344_ _08627_ _08628_ VSS VSS VDD VDD _08629_ sky130_fd_sc_hd__nor2_1
X_14345_ _02916_ _08629_ VSS VSS VDD VDD _08630_ sky130_fd_sc_hd__nand2_1
X_14346_ _08626_ _08630_ VSS VSS VDD VDD _08631_ sky130_fd_sc_hd__xnor2_1
X_14347_ _08625_ _08631_ net712 VSS VSS VDD VDD _08632_ sky130_fd_sc_hd__mux2i_1
X_14348_ u_core.u_top.u_core.acc[148] net678 _08618_ _08632_ VSS VSS VDD VDD _08633_ sky130_fd_sc_hd__o22ai_1
X_14349_ _08625_ _08631_ net709 VSS VSS VDD VDD _08634_ sky130_fd_sc_hd__mux2i_1
X_14350_ net673 _08634_ net829 VSS VSS VDD VDD _08635_ sky130_fd_sc_hd__o21ai_0
X_14351_ _08626_ net829 _08635_ VSS VSS VDD VDD _08636_ sky130_fd_sc_hd__o21ai_0
X_14352_ net830 _08636_ VSS VSS VDD VDD _08637_ sky130_fd_sc_hd__nor2_1
X_14353_ _08633_ _08637_ VSS VSS VDD VDD u_core.u_top.u_core.acc_upd[148] sky130_fd_sc_hd__nor2_1
X_14354_ u_core.u_top.u_core.acc[143] u_core.u_top.u_core.acc[142] VSS VSS VDD VDD _08638_ sky130_fd_sc_hd__or2_2
X_14355_ u_core.u_top.u_core.acc[141] u_core.u_top.u_core.acc[144] u_core.u_top.u_core.acc[140] _08638_ VSS VSS VDD VDD _08639_ sky130_fd_sc_hd__nor4_1
X_14356_ u_core.u_top.u_core.acc[146] u_core.u_top.u_core.acc[145] _08639_ VSS VSS VDD VDD _08640_ sky130_fd_sc_hd__nor3b_1
X_14357_ u_core.u_top.u_core.acc[141] VSS VSS VDD VDD _02913_ sky130_fd_sc_hd__inv_1
X_14358_ _02913_ _0109_[0] _08627_ VSS VSS VDD VDD _08641_ sky130_fd_sc_hd__nor3_1
X_14359_ u_core.u_top.u_core.acc[146] u_core.u_top.u_core.acc[145] _08641_ VSS VSS VDD VDD _08642_ sky130_fd_sc_hd__and3_1
X_14360_ _08640_ _08642_ net712 VSS VSS VDD VDD _08643_ sky130_fd_sc_hd__mux2_1
X_14361_ _08640_ _08642_ net709 VSS VSS VDD VDD _08644_ sky130_fd_sc_hd__mux2_1
X_14362_ net830 _0113_ VSS VSS VDD VDD _08645_ sky130_fd_sc_hd__nor2b_1
X_14363_ net830 _08643_ _08644_ _08645_ VSS VSS VDD VDD _08646_ sky130_fd_sc_hd__a22oi_1
X_14364_ net673 _08646_ VSS VSS VDD VDD _08647_ sky130_fd_sc_hd__nor2_1
X_14365_ u_core.u_top.u_core.acc[147] _08647_ VSS VSS VDD VDD u_core.u_top.u_core.acc_upd[147] sky130_fd_sc_hd__xor2_1
X_14366_ _02916_ u_core.u_top.u_core.acc[143] u_core.u_top.u_core.acc[142] VSS VSS VDD VDD _08648_ sky130_fd_sc_hd__nand3_1
X_14367_ u_core.u_top.u_core.acc[145] u_core.u_top.u_core.acc[144] VSS VSS VDD VDD _08649_ sky130_fd_sc_hd__nand2_1
X_14368_ _08648_ _08649_ VSS VSS VDD VDD _08650_ sky130_fd_sc_hd__or2_2
X_14369_ _08623_ _08650_ net709 VSS VSS VDD VDD _08651_ sky130_fd_sc_hd__mux2i_1
X_14370_ _08623_ _08650_ net712 VSS VSS VDD VDD _08652_ sky130_fd_sc_hd__mux2i_1
X_14371_ _08645_ _08651_ _08652_ net830 VSS VSS VDD VDD _08653_ sky130_fd_sc_hd__a22oi_1
X_14372_ net673 _08653_ VSS VSS VDD VDD _08654_ sky130_fd_sc_hd__nor2_1
X_14373_ u_core.u_top.u_core.acc[146] _08654_ VSS VSS VDD VDD u_core.u_top.u_core.acc_upd[146] sky130_fd_sc_hd__xor2_1
X_14374_ net830 _08645_ net712 VSS VSS VDD VDD _08655_ sky130_fd_sc_hd__mux2i_1
X_14375_ u_core.u_top.u_core.acc[145] _08639_ VSS VSS VDD VDD _08656_ sky130_fd_sc_hd__xnor2_1
X_14376_ net830 _08645_ net709 VSS VSS VDD VDD _08657_ sky130_fd_sc_hd__mux2i_1
X_14377_ u_core.u_top.u_core.acc[145] _08641_ VSS VSS VDD VDD _08658_ sky130_fd_sc_hd__xnor2_1
X_14378_ _08655_ _08656_ _08657_ _08658_ VSS VSS VDD VDD _08659_ sky130_fd_sc_hd__o22ai_1
X_14379_ net830 net829 net678 VSS VSS VDD VDD _08660_ sky130_fd_sc_hd__o21ai_0
X_14380_ net678 _08659_ _08660_ u_core.u_top.u_core.acc[145] VSS VSS VDD VDD u_core.u_top.u_core.acc_upd[145] sky130_fd_sc_hd__a22o_1
X_14382_ _08622_ _08648_ net709 VSS VSS VDD VDD _08662_ sky130_fd_sc_hd__mux2i_1
X_14383_ _08622_ _08648_ net712 VSS VSS VDD VDD _08663_ sky130_fd_sc_hd__mux2i_1
X_14384_ _08645_ _08662_ _08663_ net830 VSS VSS VDD VDD _08664_ sky130_fd_sc_hd__a22oi_1
X_14385_ net673 _08664_ VSS VSS VDD VDD _08665_ sky130_fd_sc_hd__nor2_1
X_14386_ u_core.u_top.u_core.acc[144] _08665_ VSS VSS VDD VDD u_core.u_top.u_core.acc_upd[144] sky130_fd_sc_hd__xor2_1
X_14387_ _08657_ u_core.u_top.u_core.acc[140] u_core.u_top.u_core.acc[142] u_core.u_top.u_core.acc[141] VSS VSS VDD VDD _08666_ sky130_fd_sc_hd__nand4b_1
X_14388_ u_core.u_top.u_core.acc[141] u_core.u_top.u_core.acc[142] u_core.u_top.u_core.acc[140] _08655_ VSS VSS VDD VDD _08667_ sky130_fd_sc_hd__or4_1
X_14389_ _08666_ _08667_ net673 VSS VSS VDD VDD _08668_ sky130_fd_sc_hd__a21oi_1
X_14390_ u_core.u_top.u_core.acc[143] _08668_ VSS VSS VDD VDD u_core.u_top.u_core.acc_upd[143] sky130_fd_sc_hd__xor2_1
X_14391_ u_core.u_top.u_core.acc[142] _02914_ VSS VSS VDD VDD _08669_ sky130_fd_sc_hd__xnor2_1
X_14392_ _02916_ u_core.u_top.u_core.acc[142] VSS VSS VDD VDD _08670_ sky130_fd_sc_hd__xnor2_1
X_14393_ _08655_ _08669_ _08670_ _08657_ VSS VSS VDD VDD _08671_ sky130_fd_sc_hd__o22ai_1
X_14394_ u_core.u_top.u_core.acc[142] _08660_ _08671_ net678 VSS VSS VDD VDD u_core.u_top.u_core.acc_upd[142] sky130_fd_sc_hd__a22o_1
X_14395_ net830 net829 VSS VSS VDD VDD _08672_ sky130_fd_sc_hd__nor2_1
X_14396_ net673 _08672_ VSS VSS VDD VDD _08673_ sky130_fd_sc_hd__nor2_1
X_14398_ _0109_[1] net709 VSS VSS VDD VDD _08675_ sky130_fd_sc_hd__xnor2_1
X_14399_ net830 _08645_ _08675_ VSS VSS VDD VDD _08676_ sky130_fd_sc_hd__mux2i_1
X_14402_ _02913_ _08673_ _08676_ net673 VSS VSS VDD VDD u_core.u_top.u_core.acc_upd[141] sky130_fd_sc_hd__o22ai_1
X_14403_ u_core.u_top.u_core.acc[133] u_core.u_top.u_core.acc[132] _02821_ VSS VSS VDD VDD _08679_ sky130_fd_sc_hd__nand3_1
X_14404_ u_core.u_top.u_core.acc[135] u_core.u_top.u_core.acc[134] VSS VSS VDD VDD _08680_ sky130_fd_sc_hd__nand2_1
X_14405_ _08679_ _08680_ VSS VSS VDD VDD _08681_ sky130_fd_sc_hd__or2_2
X_14406_ _08681_ VSS VSS VDD VDD _08682_ sky130_fd_sc_hd__inv_1
X_14407_ u_core.u_top.u_core.acc[137] u_core.u_top.u_core.acc[136] _08682_ VSS VSS VDD VDD _08683_ sky130_fd_sc_hd__nand3_1
X_14408_ u_core.u_top.u_core.acc[133] u_core.u_top.u_core.acc[132] VSS VSS VDD VDD _08684_ sky130_fd_sc_hd__nor2_1
X_14409_ _02820_ _08684_ VSS VSS VDD VDD _08685_ sky130_fd_sc_hd__nand2_1
X_14410_ u_core.u_top.u_core.acc[135] u_core.u_top.u_core.acc[134] _08685_ VSS VSS VDD VDD _08686_ sky130_fd_sc_hd__or3_1
X_14411_ u_core.u_top.u_core.acc[137] u_core.u_top.u_core.acc[136] _08686_ VSS VSS VDD VDD _08687_ sky130_fd_sc_hd__or3_1
X_14412_ _08683_ _08687_ net712 VSS VSS VDD VDD _08688_ sky130_fd_sc_hd__mux2i_1
X_14413_ net832 net831 VSS VSS VDD VDD _08689_ sky130_fd_sc_hd__nor2b_1
X_14415_ _08683_ _08687_ net709 VSS VSS VDD VDD _08691_ sky130_fd_sc_hd__mux2i_1
X_14417_ _08688_ net795 _08691_ net832 VSS VSS VDD VDD _08693_ sky130_fd_sc_hd__a22oi_1
X_14418_ net670 _08693_ VSS VSS VDD VDD _08694_ sky130_fd_sc_hd__nor2_1
X_14419_ u_core.u_top.u_core.acc[138] _08694_ VSS VSS VDD VDD u_core.u_top.u_core.acc_upd[138] sky130_fd_sc_hd__xor2_1
X_14420_ u_core.u_top.u_core.acc[132] u_core.u_top.u_core.acc[131] u_core.u_top.u_core.acc[130] VSS VSS VDD VDD _08695_ sky130_fd_sc_hd__nand3_1
X_14421_ u_core.u_top.u_core.acc[134] u_core.u_top.u_core.acc[133] VSS VSS VDD VDD _08696_ sky130_fd_sc_hd__nand2_1
X_14422_ _08695_ _08696_ VSS VSS VDD VDD _08697_ sky130_fd_sc_hd__or2_2
X_14423_ _08697_ VSS VSS VDD VDD _08698_ sky130_fd_sc_hd__inv_1
X_14424_ u_core.u_top.u_core.acc[136] u_core.u_top.u_core.acc[135] _08698_ VSS VSS VDD VDD _08699_ sky130_fd_sc_hd__nand3_1
X_14425_ u_core.u_top.u_core.acc[132] u_core.u_top.u_core.acc[131] u_core.u_top.u_core.acc[130] VSS VSS VDD VDD _08700_ sky130_fd_sc_hd__or3_1
X_14426_ u_core.u_top.u_core.acc[134] u_core.u_top.u_core.acc[133] _08700_ VSS VSS VDD VDD _08701_ sky130_fd_sc_hd__or3_1
X_14427_ u_core.u_top.u_core.acc[136] u_core.u_top.u_core.acc[135] _08701_ VSS VSS VDD VDD _08702_ sky130_fd_sc_hd__or3_1
X_14428_ _08699_ _08702_ net712 VSS VSS VDD VDD _08703_ sky130_fd_sc_hd__mux2i_1
X_14429_ _08699_ _08702_ net709 VSS VSS VDD VDD _08704_ sky130_fd_sc_hd__mux2i_1
X_14430_ net795 _08703_ _08704_ net832 VSS VSS VDD VDD _08705_ sky130_fd_sc_hd__a22oi_1
X_14431_ net670 _08705_ VSS VSS VDD VDD _08706_ sky130_fd_sc_hd__nor2_1
X_14432_ u_core.u_top.u_core.acc[137] _08706_ VSS VSS VDD VDD u_core.u_top.u_core.acc_upd[137] sky130_fd_sc_hd__xor2_1
X_14434_ net709 _08682_ VSS VSS VDD VDD _08708_ sky130_fd_sc_hd__nand2_1
X_14435_ net709 _08686_ _08708_ VSS VSS VDD VDD _08709_ sky130_fd_sc_hd__o21ai_0
X_14436_ _08681_ _08686_ net709 VSS VSS VDD VDD _08710_ sky130_fd_sc_hd__mux2i_1
X_14437_ net795 _08709_ _08710_ net832 VSS VSS VDD VDD _08711_ sky130_fd_sc_hd__a22oi_1
X_14438_ net670 _08711_ VSS VSS VDD VDD _08712_ sky130_fd_sc_hd__nor2_1
X_14439_ u_core.u_top.u_core.acc[136] _08712_ VSS VSS VDD VDD u_core.u_top.u_core.acc_upd[136] sky130_fd_sc_hd__xor2_1
X_14440_ net709 _08698_ VSS VSS VDD VDD _08713_ sky130_fd_sc_hd__nand2_1
X_14441_ net709 _08701_ _08713_ VSS VSS VDD VDD _08714_ sky130_fd_sc_hd__o21ai_0
X_14442_ _08697_ _08701_ net709 VSS VSS VDD VDD _08715_ sky130_fd_sc_hd__mux2i_1
X_14443_ net795 _08714_ _08715_ net832 VSS VSS VDD VDD _08716_ sky130_fd_sc_hd__a22oi_1
X_14444_ net670 _08716_ VSS VSS VDD VDD _08717_ sky130_fd_sc_hd__nor2_1
X_14445_ u_core.u_top.u_core.acc[135] _08717_ VSS VSS VDD VDD u_core.u_top.u_core.acc_upd[135] sky130_fd_sc_hd__xor2_1
X_14446_ _08679_ _08685_ net712 VSS VSS VDD VDD _08718_ sky130_fd_sc_hd__mux2i_1
X_14448_ _02820_ net709 _08684_ VSS VSS VDD VDD _08720_ sky130_fd_sc_hd__nand3_1
X_14449_ net709 _08679_ _08720_ VSS VSS VDD VDD _08721_ sky130_fd_sc_hd__o21ai_0
X_14450_ net795 _08718_ _08721_ net832 VSS VSS VDD VDD _08722_ sky130_fd_sc_hd__a22oi_1
X_14451_ net670 _08722_ VSS VSS VDD VDD _08723_ sky130_fd_sc_hd__nor2_1
X_14452_ u_core.u_top.u_core.acc[134] _08723_ VSS VSS VDD VDD u_core.u_top.u_core.acc_upd[134] sky130_fd_sc_hd__xor2_1
X_14453_ _08695_ _08700_ net712 VSS VSS VDD VDD _08724_ sky130_fd_sc_hd__mux2i_1
X_14454_ _08695_ _08700_ net709 VSS VSS VDD VDD _08725_ sky130_fd_sc_hd__mux2i_1
X_14455_ net795 _08724_ _08725_ net832 VSS VSS VDD VDD _08726_ sky130_fd_sc_hd__a22oi_1
X_14456_ net670 _08726_ VSS VSS VDD VDD _08727_ sky130_fd_sc_hd__nor2_1
X_14457_ u_core.u_top.u_core.acc[133] _08727_ VSS VSS VDD VDD u_core.u_top.u_core.acc_upd[133] sky130_fd_sc_hd__xor2_1
X_14458_ net832 net795 net712 VSS VSS VDD VDD _08728_ sky130_fd_sc_hd__mux2i_1
X_14459_ u_core.u_top.u_core.acc[132] _02820_ VSS VSS VDD VDD _08729_ sky130_fd_sc_hd__xnor2_1
X_14460_ net832 net795 net709 VSS VSS VDD VDD _08730_ sky130_fd_sc_hd__mux2i_1
X_14461_ u_core.u_top.u_core.acc[132] _02821_ VSS VSS VDD VDD _08731_ sky130_fd_sc_hd__xnor2_1
X_14462_ _08728_ _08729_ _08730_ _08731_ VSS VSS VDD VDD _08732_ sky130_fd_sc_hd__o22ai_1
X_14463_ net832 net831 net679 VSS VSS VDD VDD _08733_ sky130_fd_sc_hd__o21ai_0
X_14464_ net678 _08732_ _08733_ u_core.u_top.u_core.acc[132] VSS VSS VDD VDD u_core.u_top.u_core.acc_upd[132] sky130_fd_sc_hd__a22o_1
X_14465_ _0098_[1] VSS VSS VDD VDD _08734_ sky130_fd_sc_hd__inv_1
X_14466_ _02803_ _08728_ _08730_ _08734_ VSS VSS VDD VDD _08735_ sky130_fd_sc_hd__o22ai_1
X_14467_ u_core.u_top.u_core.acc[131] _08733_ _08735_ net678 VSS VSS VDD VDD _02323_ sky130_fd_sc_hd__a22oi_1
X_14468_ _02323_ VSS VSS VDD VDD u_core.u_top.u_core.acc_upd[131] sky130_fd_sc_hd__inv_1
X_14470_ _0086_ net833 VSS VSS VDD VDD _08737_ sky130_fd_sc_hd__nor2b_1
X_14471_ _0086_ _08737_ net714 VSS VSS VDD VDD _08738_ sky130_fd_sc_hd__mux2i_1
X_14472_ u_core.u_top.u_core.acc[128] VSS VSS VDD VDD _08739_ sky130_fd_sc_hd__inv_1
X_14475_ u_core.u_top.u_core.acc[122] u_core.u_top.u_core.acc[123] VSS VSS VDD VDD _08742_ sky130_fd_sc_hd__nor2_1
X_14476_ _02994_ _08742_ VSS VSS VDD VDD _08743_ sky130_fd_sc_hd__nand2_1
X_14477_ u_core.u_top.u_core.acc[126] u_core.u_top.u_core.acc[125] VSS VSS VDD VDD _08744_ sky130_fd_sc_hd__nor2_1
X_14478_ u_core.u_top.u_core.acc[124] u_core.u_top.u_core.acc[127] _08743_ _08744_ VSS VSS VDD VDD _08745_ sky130_fd_sc_hd__nor4b_1
X_14479_ _08739_ _08745_ VSS VSS VDD VDD _08746_ sky130_fd_sc_hd__xnor2_1
X_14480_ u_core.u_top.u_core.acc[122] u_core.u_top.u_core.acc[123] _02995_ VSS VSS VDD VDD _08747_ sky130_fd_sc_hd__and3_1
X_14481_ u_core.u_top.u_core.acc[124] _08747_ VSS VSS VDD VDD _08748_ sky130_fd_sc_hd__nand2_1
X_14482_ u_core.u_top.u_core.acc[126] u_core.u_top.u_core.acc[127] u_core.u_top.u_core.acc[125] VSS VSS VDD VDD _08749_ sky130_fd_sc_hd__nand3_1
X_14483_ _08748_ _08749_ VSS VSS VDD VDD _08750_ sky130_fd_sc_hd__nor2_1
X_14484_ _08739_ _08750_ VSS VSS VDD VDD _08751_ sky130_fd_sc_hd__xnor2_1
X_14485_ _0086_ _08737_ net709 VSS VSS VDD VDD _08752_ sky130_fd_sc_hd__mux2i_1
X_14486_ _08738_ _08746_ _08751_ _08752_ VSS VSS VDD VDD _08753_ sky130_fd_sc_hd__o22ai_1
X_14487_ _0086_ net833 VSS VSS VDD VDD _08754_ sky130_fd_sc_hd__nor2_1
X_14488_ net673 _08754_ VSS VSS VDD VDD _08755_ sky130_fd_sc_hd__nor2_1
X_14489_ u_core.u_top.u_core.acc[128] _08755_ VSS VSS VDD VDD _08756_ sky130_fd_sc_hd__nor2_1
X_14490_ net678 _08753_ _08756_ VSS VSS VDD VDD u_core.u_top.u_core.acc_upd[128] sky130_fd_sc_hd__a21oi_1
X_14491_ u_core.u_top.u_core.acc[122] u_core.u_top.u_core.acc[123] VSS VSS VDD VDD _08757_ sky130_fd_sc_hd__nand2_1
X_14492_ u_core.u_top.u_core.acc[124] u_core.u_top.u_core.acc[120] u_core.u_top.u_core.acc[121] VSS VSS VDD VDD _08758_ sky130_fd_sc_hd__nand3_1
X_14493_ _08757_ _08758_ VSS VSS VDD VDD _08759_ sky130_fd_sc_hd__or2_2
X_14494_ _08759_ VSS VSS VDD VDD _08760_ sky130_fd_sc_hd__inv_1
X_14495_ u_core.u_top.u_core.acc[126] u_core.u_top.u_core.acc[125] _08760_ VSS VSS VDD VDD _08761_ sky130_fd_sc_hd__nand3_1
X_14496_ u_core.u_top.u_core.acc[124] u_core.u_top.u_core.acc[120] u_core.u_top.u_core.acc[121] VSS VSS VDD VDD _08762_ sky130_fd_sc_hd__nor3_1
X_14497_ _08742_ _08744_ _08762_ VSS VSS VDD VDD _08763_ sky130_fd_sc_hd__nand3_1
X_14498_ _08761_ _08763_ net714 VSS VSS VDD VDD _08764_ sky130_fd_sc_hd__mux2i_1
X_14499_ _08761_ _08763_ net709 VSS VSS VDD VDD _08765_ sky130_fd_sc_hd__mux2i_1
X_14500_ _08737_ _08764_ _08765_ _0086_ VSS VSS VDD VDD _08766_ sky130_fd_sc_hd__a22oi_1
X_14501_ net673 _08766_ VSS VSS VDD VDD _08767_ sky130_fd_sc_hd__nor2_1
X_14502_ u_core.u_top.u_core.acc[127] _08767_ VSS VSS VDD VDD u_core.u_top.u_core.acc_upd[127] sky130_fd_sc_hd__xor2_1
X_14504_ _08738_ VSS VSS VDD VDD _08769_ sky130_fd_sc_hd__inv_1
X_14505_ u_core.u_top.u_core.acc[124] u_core.u_top.u_core.acc[125] _08743_ VSS VSS VDD VDD _08770_ sky130_fd_sc_hd__or3_1
X_14506_ u_core.u_top.u_core.acc[124] u_core.u_top.u_core.acc[125] _08747_ VSS VSS VDD VDD _08771_ sky130_fd_sc_hd__nand3_1
X_14507_ _0086_ _08737_ net711 VSS VSS VDD VDD _08772_ sky130_fd_sc_hd__mux2_1
X_14508_ _08769_ _08770_ _08771_ _08772_ u_core.u_top.u_core.acc[126] VSS VSS VDD VDD _08773_ sky130_fd_sc_hd__a221oi_1
X_14509_ _08738_ _08770_ _08771_ _08752_ u_core.u_top.u_core.acc[126] VSS VSS VDD VDD _08774_ sky130_fd_sc_hd__o221a_2
X_14510_ net673 _08773_ _08774_ _08755_ u_core.u_top.u_core.acc[126] VSS VSS VDD VDD u_core.u_top.u_core.acc_upd[126] sky130_fd_sc_hd__o32a_1
X_14511_ _08742_ _08762_ VSS VSS VDD VDD _08775_ sky130_fd_sc_hd__nand2_1
X_14512_ net709 _08760_ VSS VSS VDD VDD _08776_ sky130_fd_sc_hd__nand2_1
X_14513_ net709 _08775_ _08776_ VSS VSS VDD VDD _08777_ sky130_fd_sc_hd__o21ai_0
X_14514_ _08759_ _08775_ net709 VSS VSS VDD VDD _08778_ sky130_fd_sc_hd__mux2i_1
X_14515_ _08737_ _08777_ _08778_ _0086_ VSS VSS VDD VDD _08779_ sky130_fd_sc_hd__a22oi_1
X_14516_ net673 _08779_ VSS VSS VDD VDD _08780_ sky130_fd_sc_hd__nor2_1
X_14517_ u_core.u_top.u_core.acc[125] _08780_ VSS VSS VDD VDD u_core.u_top.u_core.acc_upd[125] sky130_fd_sc_hd__xor2_1
X_14518_ u_core.u_top.u_core.acc[122] u_core.u_top.u_core.acc[123] _02995_ VSS VSS VDD VDD _08781_ sky130_fd_sc_hd__nand3_1
X_14519_ _08738_ _08743_ _08752_ _08781_ u_core.u_top.u_core.acc[124] VSS VSS VDD VDD _08782_ sky130_fd_sc_hd__o221ai_1
X_14520_ _08769_ _08743_ _08772_ _08781_ u_core.u_top.u_core.acc[124] VSS VSS VDD VDD _08783_ sky130_fd_sc_hd__a221o_1
X_14521_ u_core.u_top.u_core.acc[124] _08755_ VSS VSS VDD VDD _08784_ sky130_fd_sc_hd__nor2_1
X_14522_ net678 _08782_ _08783_ _08784_ VSS VSS VDD VDD u_core.u_top.u_core.acc_upd[124] sky130_fd_sc_hd__a31oi_1
X_14523_ u_core.u_top.u_core.acc[120] u_core.u_top.u_core.acc[122] u_core.u_top.u_core.acc[121] _08772_ VSS VSS VDD VDD _08785_ sky130_fd_sc_hd__nand4_1
X_14524_ u_core.u_top.u_core.acc[120] u_core.u_top.u_core.acc[122] u_core.u_top.u_core.acc[121] _08738_ VSS VSS VDD VDD _08786_ sky130_fd_sc_hd__or4_1
X_14525_ _08785_ _08786_ net673 VSS VSS VDD VDD _08787_ sky130_fd_sc_hd__a21oi_1
X_14526_ u_core.u_top.u_core.acc[123] _08787_ VSS VSS VDD VDD u_core.u_top.u_core.acc_upd[123] sky130_fd_sc_hd__xor2_1
X_14527_ _02994_ _08738_ _08752_ _02995_ u_core.u_top.u_core.acc[122] VSS VSS VDD VDD _08788_ sky130_fd_sc_hd__o221a_2
X_14528_ _02994_ _08769_ _08772_ _02995_ u_core.u_top.u_core.acc[122] VSS VSS VDD VDD _08789_ sky130_fd_sc_hd__a221oi_1
X_14530_ net673 _08754_ u_core.u_top.u_core.acc[122] VSS VSS VDD VDD _08791_ sky130_fd_sc_hd__o21ai_0
X_14531_ net673 _08788_ _08789_ _08791_ VSS VSS VDD VDD u_core.u_top.u_core.acc_upd[122] sky130_fd_sc_hd__o31ai_1
X_14532_ u_core.u_top.u_core.acc[121] VSS VSS VDD VDD _02606_ sky130_fd_sc_hd__inv_1
X_14533_ _0088_[1] _08772_ VSS VSS VDD VDD _08792_ sky130_fd_sc_hd__nand2_1
X_14534_ _02608_ _08738_ _08792_ VSS VSS VDD VDD _08793_ sky130_fd_sc_hd__o21ai_0
X_14535_ _02606_ _08755_ _08793_ net678 VSS VSS VDD VDD _02434_ sky130_fd_sc_hd__a2bb2oi_1
X_14536_ _02434_ VSS VSS VDD VDD u_core.u_top.u_core.acc_upd[121] sky130_fd_sc_hd__inv_1
X_14537_ _0076_ _0081_ VSS VSS VDD VDD _08794_ sky130_fd_sc_hd__nor2b_1
X_14538_ _0076_ _08794_ net712 VSS VSS VDD VDD _08795_ sky130_fd_sc_hd__mux2i_1
X_14539_ u_core.u_top.u_core.acc[113] u_core.u_top.u_core.acc[112] VSS VSS VDD VDD _08796_ sky130_fd_sc_hd__nor2_1
X_14540_ _02973_ _08796_ VSS VSS VDD VDD _08797_ sky130_fd_sc_hd__nand2_1
X_14541_ u_core.u_top.u_core.acc[115] u_core.u_top.u_core.acc[114] _08797_ VSS VSS VDD VDD _08798_ sky130_fd_sc_hd__or3_1
X_14542_ u_core.u_top.u_core.acc[116] u_core.u_top.u_core.acc[117] _08798_ VSS VSS VDD VDD _08799_ sky130_fd_sc_hd__nor3_1
X_14543_ u_core.u_top.u_core.acc[118] _08799_ VSS VSS VDD VDD _08800_ sky130_fd_sc_hd__xor2_1
X_14544_ _02974_ u_core.u_top.u_core.acc[113] u_core.u_top.u_core.acc[112] VSS VSS VDD VDD _08801_ sky130_fd_sc_hd__nand3_1
X_14545_ u_core.u_top.u_core.acc[115] u_core.u_top.u_core.acc[114] VSS VSS VDD VDD _08802_ sky130_fd_sc_hd__nand2_1
X_14546_ _08801_ _08802_ VSS VSS VDD VDD _08803_ sky130_fd_sc_hd__nor2_1
X_14547_ u_core.u_top.u_core.acc[116] u_core.u_top.u_core.acc[117] _08803_ VSS VSS VDD VDD _08804_ sky130_fd_sc_hd__nand3_1
X_14548_ u_core.u_top.u_core.acc[118] _08804_ VSS VSS VDD VDD _08805_ sky130_fd_sc_hd__xnor2_1
X_14549_ _0076_ _08794_ net710 VSS VSS VDD VDD _08806_ sky130_fd_sc_hd__mux2i_1
X_14550_ _08795_ _08800_ _08805_ _08806_ VSS VSS VDD VDD _08807_ sky130_fd_sc_hd__o22ai_1
X_14551_ u_core.u_top.u_core.acc[118] _06553_ VSS VSS VDD VDD _08808_ sky130_fd_sc_hd__nor2_1
X_14552_ net679 _08807_ _08808_ VSS VSS VDD VDD u_core.u_top.u_core.acc_upd[118] sky130_fd_sc_hd__a21oi_1
X_14553_ u_core.u_top.u_core.acc[111] u_core.u_top.u_core.acc[110] u_core.u_top.u_core.acc[114] VSS VSS VDD VDD _08809_ sky130_fd_sc_hd__nor3_1
X_14554_ _08796_ _08809_ VSS VSS VDD VDD _08810_ sky130_fd_sc_hd__nand2_1
X_14555_ u_core.u_top.u_core.acc[116] u_core.u_top.u_core.acc[115] _08810_ VSS VSS VDD VDD _08811_ sky130_fd_sc_hd__or3_1
X_14556_ u_core.u_top.u_core.acc[113] u_core.u_top.u_core.acc[112] VSS VSS VDD VDD _08812_ sky130_fd_sc_hd__nand2_1
X_14557_ u_core.u_top.u_core.acc[111] u_core.u_top.u_core.acc[110] u_core.u_top.u_core.acc[114] VSS VSS VDD VDD _08813_ sky130_fd_sc_hd__nand3_1
X_14558_ _08812_ _08813_ VSS VSS VDD VDD _08814_ sky130_fd_sc_hd__or2_2
X_14559_ u_core.u_top.u_core.acc[116] u_core.u_top.u_core.acc[115] VSS VSS VDD VDD _08815_ sky130_fd_sc_hd__nand2_1
X_14560_ _08814_ _08815_ VSS VSS VDD VDD _08816_ sky130_fd_sc_hd__nor2_1
X_14561_ _08816_ VSS VSS VDD VDD _08817_ sky130_fd_sc_hd__inv_1
X_14562_ _08795_ _08811_ _08817_ _08806_ u_core.u_top.u_core.acc[117] VSS VSS VDD VDD _08818_ sky130_fd_sc_hd__o221a_2
X_14563_ _08795_ VSS VSS VDD VDD _08819_ sky130_fd_sc_hd__inv_1
X_14564_ _0076_ _08794_ net710 VSS VSS VDD VDD _08820_ sky130_fd_sc_hd__mux2_1
X_14565_ _08819_ _08811_ _08817_ _08820_ u_core.u_top.u_core.acc[117] VSS VSS VDD VDD _08821_ sky130_fd_sc_hd__a221oi_1
X_14566_ net669 _08818_ _08821_ _06553_ u_core.u_top.u_core.acc[117] VSS VSS VDD VDD u_core.u_top.u_core.acc_upd[117] sky130_fd_sc_hd__o32a_1
X_14567_ _08801_ _08802_ VSS VSS VDD VDD _08822_ sky130_fd_sc_hd__or2_2
X_14568_ _08795_ _08798_ _08806_ _08822_ u_core.u_top.u_core.acc[116] VSS VSS VDD VDD _08823_ sky130_fd_sc_hd__o221a_2
X_14569_ _08819_ _08798_ _08820_ _08822_ u_core.u_top.u_core.acc[116] VSS VSS VDD VDD _08824_ sky130_fd_sc_hd__a221oi_1
X_14570_ net669 _08823_ _08824_ _06553_ u_core.u_top.u_core.acc[116] VSS VSS VDD VDD u_core.u_top.u_core.acc_upd[116] sky130_fd_sc_hd__o32a_1
X_14571_ _08795_ _08810_ _08814_ _08806_ u_core.u_top.u_core.acc[115] VSS VSS VDD VDD _08825_ sky130_fd_sc_hd__o221ai_1
X_14572_ _08819_ _08810_ _08814_ _08820_ u_core.u_top.u_core.acc[115] VSS VSS VDD VDD _08826_ sky130_fd_sc_hd__a221o_1
X_14573_ u_core.u_top.u_core.acc[115] _06553_ VSS VSS VDD VDD _08827_ sky130_fd_sc_hd__nor2_1
X_14574_ net676 _08825_ _08826_ _08827_ VSS VSS VDD VDD u_core.u_top.u_core.acc_upd[115] sky130_fd_sc_hd__a31oi_1
X_14575_ _08797_ _08801_ net710 VSS VSS VDD VDD _08828_ sky130_fd_sc_hd__mux2i_1
X_14576_ _02973_ net710 _08796_ VSS VSS VDD VDD _08829_ sky130_fd_sc_hd__nand3_1
X_14577_ net710 _08801_ _08829_ VSS VSS VDD VDD _08830_ sky130_fd_sc_hd__o21ai_0
X_14578_ _08794_ _08828_ _08830_ _0076_ VSS VSS VDD VDD _08831_ sky130_fd_sc_hd__a22oi_1
X_14579_ net669 _08831_ VSS VSS VDD VDD _08832_ sky130_fd_sc_hd__nor2_1
X_14580_ u_core.u_top.u_core.acc[114] _08832_ VSS VSS VDD VDD u_core.u_top.u_core.acc_upd[114] sky130_fd_sc_hd__xor2_1
X_14581_ u_core.u_top.u_core.acc[111] u_core.u_top.u_core.acc[110] u_core.u_top.u_core.acc[112] _08820_ VSS VSS VDD VDD _08833_ sky130_fd_sc_hd__nand4_1
X_14582_ u_core.u_top.u_core.acc[111] u_core.u_top.u_core.acc[110] u_core.u_top.u_core.acc[112] _08795_ VSS VSS VDD VDD _08834_ sky130_fd_sc_hd__or4_1
X_14583_ _08833_ _08834_ net669 VSS VSS VDD VDD _08835_ sky130_fd_sc_hd__a21oi_1
X_14584_ u_core.u_top.u_core.acc[113] _08835_ VSS VSS VDD VDD u_core.u_top.u_core.acc_upd[113] sky130_fd_sc_hd__xor2_1
X_14585_ _02973_ _08795_ _08806_ _02974_ u_core.u_top.u_core.acc[112] VSS VSS VDD VDD _08836_ sky130_fd_sc_hd__o221ai_1
X_14586_ _02973_ _08819_ _08820_ _02974_ u_core.u_top.u_core.acc[112] VSS VSS VDD VDD _08837_ sky130_fd_sc_hd__a221o_1
X_14587_ _08836_ _08837_ VSS VSS VDD VDD _08838_ sky130_fd_sc_hd__nand2_1
X_14589_ net669 _06552_ u_core.u_top.u_core.acc[112] VSS VSS VDD VDD _08840_ sky130_fd_sc_hd__o21ai_0
X_14590_ net669 _08838_ _08840_ VSS VSS VDD VDD u_core.u_top.u_core.acc_upd[112] sky130_fd_sc_hd__o21ai_0
X_14591_ _0077_[1] net712 VSS VSS VDD VDD _08841_ sky130_fd_sc_hd__nor2_1
X_14592_ _02925_ net712 _08841_ VSS VSS VDD VDD _08842_ sky130_fd_sc_hd__a21o_1
X_14593_ _02925_ net710 VSS VSS VDD VDD _08843_ sky130_fd_sc_hd__nand2_1
X_14594_ _0077_[1] net710 _08843_ VSS VSS VDD VDD _08844_ sky130_fd_sc_hd__o21ai_0
X_14595_ _08794_ _08842_ _08844_ _0076_ VSS VSS VDD VDD _08845_ sky130_fd_sc_hd__a22oi_1
X_14596_ u_core.u_top.u_core.acc[111] _06553_ _08845_ net669 VSS VSS VDD VDD u_core.u_top.u_core.acc_upd[111] sky130_fd_sc_hd__o22a_1
X_14597_ _0065_ _06342_ net711 VSS VSS VDD VDD _08846_ sky130_fd_sc_hd__mux2i_1
X_14598_ u_core.u_top.u_core.acc[104] VSS VSS VDD VDD _08847_ sky130_fd_sc_hd__inv_1
X_14599_ u_core.u_top.u_core.acc[102] _02844_ u_core.u_top.u_core.acc[103] VSS VSS VDD VDD _08848_ sky130_fd_sc_hd__nand3_1
X_14600_ _08847_ _08848_ VSS VSS VDD VDD _08849_ sky130_fd_sc_hd__nor2_1
X_14601_ u_core.u_top.u_core.acc[105] u_core.u_top.u_core.acc[107] u_core.u_top.u_core.acc[106] _08849_ VSS VSS VDD VDD _08850_ sky130_fd_sc_hd__nand4_1
X_14602_ u_core.u_top.u_core.acc[102] u_core.u_top.u_core.acc[103] VSS VSS VDD VDD _08851_ sky130_fd_sc_hd__nor2_1
X_14603_ _02843_ _08851_ VSS VSS VDD VDD _08852_ sky130_fd_sc_hd__nand2_1
X_14604_ u_core.u_top.u_core.acc[104] _08852_ VSS VSS VDD VDD _08853_ sky130_fd_sc_hd__nor2_1
X_14605_ u_core.u_top.u_core.acc[105] u_core.u_top.u_core.acc[107] u_core.u_top.u_core.acc[106] VSS VSS VDD VDD _08854_ sky130_fd_sc_hd__nor3_1
X_14606_ _08853_ _08854_ VSS VSS VDD VDD _08855_ sky130_fd_sc_hd__nand2_1
X_14607_ _08846_ _08850_ _08855_ _06469_ u_core.u_top.u_core.acc[108] VSS VSS VDD VDD _08856_ sky130_fd_sc_hd__o221a_2
X_14608_ _0065_ _06342_ net712 VSS VSS VDD VDD _08857_ sky130_fd_sc_hd__mux2_1
X_14609_ _06473_ _08850_ _08855_ _08857_ u_core.u_top.u_core.acc[108] VSS VSS VDD VDD _08858_ sky130_fd_sc_hd__a221oi_1
X_14610_ _0065_ net834 VSS VSS VDD VDD _08859_ sky130_fd_sc_hd__nor2_1
X_14611_ net669 _08859_ VSS VSS VDD VDD _08860_ sky130_fd_sc_hd__nor2_1
X_14612_ net669 _08856_ _08858_ _08860_ u_core.u_top.u_core.acc[108] VSS VSS VDD VDD u_core.u_top.u_core.acc_upd[108] sky130_fd_sc_hd__o32a_1
X_14614_ u_core.u_top.u_core.acc[101] VSS VSS VDD VDD _02813_ sky130_fd_sc_hd__inv_1
X_14615_ u_core.u_top.u_core.acc[102] u_core.u_top.u_core.acc[103] VSS VSS VDD VDD _08862_ sky130_fd_sc_hd__nand2_1
X_14616_ _0066_[0] _08847_ _02813_ _08862_ VSS VSS VDD VDD _08863_ sky130_fd_sc_hd__nor4_1
X_14617_ u_core.u_top.u_core.acc[105] u_core.u_top.u_core.acc[106] _08863_ VSS VSS VDD VDD _08864_ sky130_fd_sc_hd__nand3_1
X_14618_ u_core.u_top.u_core.acc[105] u_core.u_top.u_core.acc[106] VSS VSS VDD VDD _08865_ sky130_fd_sc_hd__nor2_1
X_14619_ u_core.u_top.u_core.acc[102] u_core.u_top.u_core.acc[103] VSS VSS VDD VDD _08866_ sky130_fd_sc_hd__or2_2
X_14620_ u_core.u_top.u_core.acc[100] u_core.u_top.u_core.acc[104] u_core.u_top.u_core.acc[101] _08866_ VSS VSS VDD VDD _08867_ sky130_fd_sc_hd__nor4_1
X_14621_ _08865_ net1040 VSS VSS VDD VDD _08868_ sky130_fd_sc_hd__nand2_1
X_14622_ _08864_ _08868_ net712 VSS VSS VDD VDD _08869_ sky130_fd_sc_hd__mux2i_1
X_14623_ _08864_ _08868_ net711 VSS VSS VDD VDD _08870_ sky130_fd_sc_hd__mux2i_1
X_14624_ _06342_ _08869_ _08870_ _0065_ VSS VSS VDD VDD _08871_ sky130_fd_sc_hd__a22oi_1
X_14625_ net669 _08871_ VSS VSS VDD VDD _08872_ sky130_fd_sc_hd__nor2_1
X_14626_ u_core.u_top.u_core.acc[107] _08872_ VSS VSS VDD VDD u_core.u_top.u_core.acc_upd[107] sky130_fd_sc_hd__xor2_1
X_14627_ u_core.u_top.u_core.acc[105] VSS VSS VDD VDD _08873_ sky130_fd_sc_hd__inv_1
X_14628_ _08873_ _08857_ _08853_ VSS VSS VDD VDD _08874_ sky130_fd_sc_hd__and3_1
X_14629_ u_core.u_top.u_core.acc[105] _06473_ _08849_ _08874_ VSS VSS VDD VDD _08875_ sky130_fd_sc_hd__a31oi_1
X_14630_ net669 _08875_ VSS VSS VDD VDD _08876_ sky130_fd_sc_hd__nor2_1
X_14631_ u_core.u_top.u_core.acc[106] _08876_ VSS VSS VDD VDD u_core.u_top.u_core.acc_upd[106] sky130_fd_sc_hd__xor2_1
X_14632_ _06473_ _08863_ net1040 _08857_ _08873_ VSS VSS VDD VDD _08877_ sky130_fd_sc_hd__a221o_1
X_14633_ _08846_ _08863_ net1040 _06469_ _08873_ VSS VSS VDD VDD _08878_ sky130_fd_sc_hd__o221ai_1
X_14634_ net679 _08877_ _08878_ _06477_ _08873_ VSS VSS VDD VDD u_core.u_top.u_core.acc_upd[105] sky130_fd_sc_hd__a32oi_1
X_14635_ _08848_ _08852_ net712 VSS VSS VDD VDD _08879_ sky130_fd_sc_hd__mux2i_1
X_14636_ _02843_ net711 _08851_ VSS VSS VDD VDD _08880_ sky130_fd_sc_hd__nand3_1
X_14637_ net711 _08848_ _08880_ VSS VSS VDD VDD _08881_ sky130_fd_sc_hd__o21ai_0
X_14638_ _06342_ _08879_ _08881_ _0065_ VSS VSS VDD VDD _08882_ sky130_fd_sc_hd__a22oi_1
X_14639_ net669 _08882_ VSS VSS VDD VDD _08883_ sky130_fd_sc_hd__nor2_1
X_14640_ _08847_ _08883_ VSS VSS VDD VDD u_core.u_top.u_core.acc_upd[104] sky130_fd_sc_hd__xnor2_1
X_14641_ u_core.u_top.u_core.acc[102] u_core.u_top.u_core.acc[101] VSS VSS VDD VDD _08884_ sky130_fd_sc_hd__nor2_1
X_14642_ u_core.u_top.u_core.acc[102] u_core.u_top.u_core.acc[101] VSS VSS VDD VDD _08885_ sky130_fd_sc_hd__nand2_1
X_14643_ _06473_ _08885_ VSS VSS VDD VDD _08886_ sky130_fd_sc_hd__nand2_1
X_14644_ _06469_ _08884_ _08886_ VSS VSS VDD VDD _08887_ sky130_fd_sc_hd__o21ai_0
X_14645_ u_core.u_top.u_core.acc[103] _08846_ _08885_ VSS VSS VDD VDD _08888_ sky130_fd_sc_hd__nor3_1
X_14646_ u_core.u_top.u_core.acc[103] _08857_ _08888_ VSS VSS VDD VDD _08889_ sky130_fd_sc_hd__a21oi_1
X_14647_ u_core.u_top.u_core.acc[101] _08866_ VSS VSS VDD VDD _08890_ sky130_fd_sc_hd__nor2_1
X_14648_ u_core.u_top.u_core.acc[103] _06473_ _08857_ _08890_ u_core.u_top.u_core.acc[100] VSS VSS VDD VDD _08891_ sky130_fd_sc_hd__a221oi_1
X_14649_ u_core.u_top.u_core.acc[100] _08889_ _08891_ VSS VSS VDD VDD _08892_ sky130_fd_sc_hd__a21oi_1
X_14650_ u_core.u_top.u_core.acc[103] _08887_ _08892_ VSS VSS VDD VDD _08893_ sky130_fd_sc_hd__a21oi_1
X_14651_ u_core.u_top.u_core.acc[103] _06477_ VSS VSS VDD VDD _08894_ sky130_fd_sc_hd__nand2_1
X_14652_ net670 _08893_ _08894_ VSS VSS VDD VDD u_core.u_top.u_core.acc_upd[103] sky130_fd_sc_hd__o21ai_0
X_14653_ _02844_ _08846_ _06469_ _02843_ u_core.u_top.u_core.acc[102] VSS VSS VDD VDD _08895_ sky130_fd_sc_hd__o221ai_1
X_14654_ _02844_ _06473_ _08857_ _02843_ u_core.u_top.u_core.acc[102] VSS VSS VDD VDD _08896_ sky130_fd_sc_hd__a221o_1
X_14655_ net679 _08895_ _08896_ _06477_ u_core.u_top.u_core.acc[102] VSS VSS VDD VDD u_core.u_top.u_core.acc_upd[102] sky130_fd_sc_hd__a32o_1
X_14656_ u_core.u_top.u_core.acc[98] VSS VSS VDD VDD _08897_ sky130_fd_sc_hd__inv_1
X_14657_ _0054_ net835 VSS VSS VDD VDD _08898_ sky130_fd_sc_hd__nor2b_1
X_14658_ _0054_ _08898_ net712 VSS VSS VDD VDD _08899_ sky130_fd_sc_hd__mux2i_1
X_14660_ u_core.u_top.u_core.acc[94] u_core.u_top.u_core.acc[93] u_core.u_top.u_core.acc[92] VSS VSS VDD VDD _08901_ sky130_fd_sc_hd__nor3_1
X_14661_ _02701_ _08901_ VSS VSS VDD VDD _08902_ sky130_fd_sc_hd__nand2_1
X_14662_ u_core.u_top.u_core.acc[96] u_core.u_top.u_core.acc[97] u_core.u_top.u_core.acc[95] _08902_ VSS VSS VDD VDD _08903_ sky130_fd_sc_hd__or4_1
X_14663_ _0054_ _08898_ net711 VSS VSS VDD VDD _08904_ sky130_fd_sc_hd__mux2i_1
X_14664_ u_core.u_top.u_core.acc[94] VSS VSS VDD VDD _08905_ sky130_fd_sc_hd__inv_1
X_14665_ u_core.u_top.u_core.acc[93] u_core.u_top.u_core.acc[92] _02702_ VSS VSS VDD VDD _08906_ sky130_fd_sc_hd__nand3_1
X_14666_ _08905_ _08906_ VSS VSS VDD VDD _08907_ sky130_fd_sc_hd__nor2_1
X_14667_ u_core.u_top.u_core.acc[96] u_core.u_top.u_core.acc[97] u_core.u_top.u_core.acc[95] _08907_ VSS VSS VDD VDD _08908_ sky130_fd_sc_hd__nand4_1
X_14668_ _08899_ _08903_ _08904_ _08908_ VSS VSS VDD VDD _08909_ sky130_fd_sc_hd__o22ai_1
X_14669_ _08897_ _08909_ VSS VSS VDD VDD _08910_ sky130_fd_sc_hd__nor2_1
X_14670_ _0054_ _08898_ net712 VSS VSS VDD VDD _08911_ sky130_fd_sc_hd__mux2_1
X_14671_ _0054_ _08898_ net711 VSS VSS VDD VDD _08912_ sky130_fd_sc_hd__mux2_2
X_14672_ _08911_ _08903_ _08912_ _08908_ u_core.u_top.u_core.acc[98] VSS VSS VDD VDD _08913_ sky130_fd_sc_hd__a221oi_1
X_14673_ _0054_ net835 VSS VSS VDD VDD _08914_ sky130_fd_sc_hd__nor2_1
X_14674_ net670 _08914_ VSS VSS VDD VDD _08915_ sky130_fd_sc_hd__nor2_1
X_14675_ net670 _08910_ _08913_ _08915_ u_core.u_top.u_core.acc[98] VSS VSS VDD VDD u_core.u_top.u_core.acc_upd[98] sky130_fd_sc_hd__o32a_1
X_14676_ _02595_ _0055_[0] _08901_ VSS VSS VDD VDD _08916_ sky130_fd_sc_hd__nand3_1
X_14677_ u_core.u_top.u_core.acc[96] u_core.u_top.u_core.acc[95] _08916_ VSS VSS VDD VDD _08917_ sky130_fd_sc_hd__or3_1
X_14678_ u_core.u_top.u_core.acc[96] u_core.u_top.u_core.acc[95] VSS VSS VDD VDD _08918_ sky130_fd_sc_hd__nand2_1
X_14679_ _08905_ _02595_ _0055_[0] VSS VSS VDD VDD _08919_ sky130_fd_sc_hd__nor3_1
X_14680_ u_core.u_top.u_core.acc[93] u_core.u_top.u_core.acc[92] _08919_ VSS VSS VDD VDD _08920_ sky130_fd_sc_hd__nand3_1
X_14681_ _08918_ _08920_ VSS VSS VDD VDD _08921_ sky130_fd_sc_hd__nor2_1
X_14682_ _08912_ _08921_ VSS VSS VDD VDD _08922_ sky130_fd_sc_hd__nand2_1
X_14683_ _08899_ _08917_ _08922_ u_core.u_top.u_core.acc[97] VSS VSS VDD VDD _08923_ sky130_fd_sc_hd__o211ai_1
X_14684_ _08904_ _08921_ VSS VSS VDD VDD _08924_ sky130_fd_sc_hd__nor2_1
X_14685_ _08911_ _08917_ _08924_ u_core.u_top.u_core.acc[97] VSS VSS VDD VDD _08925_ sky130_fd_sc_hd__a211o_1
X_14686_ u_core.u_top.u_core.acc[97] _08915_ VSS VSS VDD VDD _08926_ sky130_fd_sc_hd__nor2_1
X_14687_ net679 _08923_ _08925_ _08926_ VSS VSS VDD VDD u_core.u_top.u_core.acc_upd[97] sky130_fd_sc_hd__a31oi_1
X_14688_ u_core.u_top.u_core.acc[95] _08907_ VSS VSS VDD VDD _08927_ sky130_fd_sc_hd__nand2_1
X_14689_ u_core.u_top.u_core.acc[95] _08902_ VSS VSS VDD VDD _08928_ sky130_fd_sc_hd__or2_2
X_14690_ _08904_ _08927_ _08928_ _08899_ u_core.u_top.u_core.acc[96] VSS VSS VDD VDD _08929_ sky130_fd_sc_hd__o221ai_1
X_14691_ _08912_ _08927_ _08928_ _08911_ u_core.u_top.u_core.acc[96] VSS VSS VDD VDD _08930_ sky130_fd_sc_hd__a221oi_1
X_14692_ net670 _08930_ VSS VSS VDD VDD _08931_ sky130_fd_sc_hd__nor2_1
X_14693_ u_core.u_top.u_core.acc[96] _08915_ VSS VSS VDD VDD _08932_ sky130_fd_sc_hd__nor2_1
X_14694_ _08929_ _08931_ _08932_ VSS VSS VDD VDD u_core.u_top.u_core.acc_upd[96] sky130_fd_sc_hd__a21oi_1
X_14695_ _08904_ _08920_ _08916_ _08899_ VSS VSS VDD VDD _08933_ sky130_fd_sc_hd__o22a_1
X_14696_ net670 _08933_ VSS VSS VDD VDD _08934_ sky130_fd_sc_hd__nor2_1
X_14697_ u_core.u_top.u_core.acc[95] _08934_ VSS VSS VDD VDD u_core.u_top.u_core.acc_upd[95] sky130_fd_sc_hd__xor2_1
X_14698_ u_core.u_top.u_core.acc[93] u_core.u_top.u_core.acc[92] VSS VSS VDD VDD _08935_ sky130_fd_sc_hd__nor2_1
X_14699_ _02701_ _08935_ VSS VSS VDD VDD _08936_ sky130_fd_sc_hd__nand2_1
X_14700_ u_core.u_top.u_core.acc[94] _08936_ VSS VSS VDD VDD _08937_ sky130_fd_sc_hd__nand2_1
X_14701_ _08911_ _08902_ _08937_ _08907_ _08912_ VSS VSS VDD VDD _08938_ sky130_fd_sc_hd__a32o_1
X_14702_ _08912_ _08906_ VSS VSS VDD VDD _08939_ sky130_fd_sc_hd__nand2_1
X_14703_ _08915_ _08939_ u_core.u_top.u_core.acc[94] VSS VSS VDD VDD _08940_ sky130_fd_sc_hd__a21oi_1
X_14704_ net679 _08938_ _08940_ VSS VSS VDD VDD u_core.u_top.u_core.acc_upd[94] sky130_fd_sc_hd__a21oi_1
X_14705_ u_core.u_top.u_core.acc[91] u_core.u_top.u_core.acc[92] u_core.u_top.u_core.acc[90] _08912_ VSS VSS VDD VDD _08941_ sky130_fd_sc_hd__nand4_1
X_14706_ u_core.u_top.u_core.acc[91] u_core.u_top.u_core.acc[92] u_core.u_top.u_core.acc[90] _08899_ VSS VSS VDD VDD _08942_ sky130_fd_sc_hd__or4_1
X_14707_ _08941_ _08942_ net670 VSS VSS VDD VDD _08943_ sky130_fd_sc_hd__a21oi_1
X_14708_ u_core.u_top.u_core.acc[93] _08943_ VSS VSS VDD VDD u_core.u_top.u_core.acc_upd[93] sky130_fd_sc_hd__xor2_1
X_14709_ _02701_ _08899_ _08904_ _02702_ u_core.u_top.u_core.acc[92] VSS VSS VDD VDD _08944_ sky130_fd_sc_hd__o221ai_1
X_14710_ _02701_ _08911_ _08912_ _02702_ u_core.u_top.u_core.acc[92] VSS VSS VDD VDD _08945_ sky130_fd_sc_hd__a221o_1
X_14711_ _08944_ _08945_ VSS VSS VDD VDD _08946_ sky130_fd_sc_hd__nand2_1
X_14712_ net670 _08914_ u_core.u_top.u_core.acc[92] VSS VSS VDD VDD _08947_ sky130_fd_sc_hd__o21ai_0
X_14713_ net670 _08946_ _08947_ VSS VSS VDD VDD u_core.u_top.u_core.acc_upd[92] sky130_fd_sc_hd__o21ai_0
X_14714_ _02597_ net711 VSS VSS VDD VDD _08948_ sky130_fd_sc_hd__nor2_1
X_14715_ _0055_[1] net711 _08948_ VSS VSS VDD VDD _08949_ sky130_fd_sc_hd__a21oi_1
X_14716_ _02597_ net711 VSS VSS VDD VDD _08950_ sky130_fd_sc_hd__nand2_1
X_14717_ _0055_[1] net711 _08950_ VSS VSS VDD VDD _08951_ sky130_fd_sc_hd__o21ai_0
X_14718_ _08898_ _08949_ _08951_ _0054_ VSS VSS VDD VDD _08952_ sky130_fd_sc_hd__a22oi_1
X_14719_ u_core.u_top.u_core.acc[91] _08915_ _08952_ net670 VSS VSS VDD VDD u_core.u_top.u_core.acc_upd[91] sky130_fd_sc_hd__o22a_1
X_14721_ _0043_ net836 VSS VSS VDD VDD _08954_ sky130_fd_sc_hd__nor2b_1
X_14722_ _0043_ _08954_ net710 VSS VSS VDD VDD _08955_ sky130_fd_sc_hd__mux2i_1
X_14723_ u_core.u_top.u_core.acc[82] u_core.u_top.u_core.acc[83] _03129_ VSS VSS VDD VDD _08956_ sky130_fd_sc_hd__nand3_1
X_14724_ u_core.u_top.u_core.acc[84] u_core.u_top.u_core.acc[85] VSS VSS VDD VDD _08957_ sky130_fd_sc_hd__nand2_1
X_14725_ _08956_ _08957_ VSS VSS VDD VDD _08958_ sky130_fd_sc_hd__nor2_1
X_14726_ u_core.u_top.u_core.acc[87] u_core.u_top.u_core.acc[86] _08958_ VSS VSS VDD VDD _08959_ sky130_fd_sc_hd__nand3_1
X_14727_ u_core.u_top.u_core.acc[88] _08959_ VSS VSS VDD VDD _08960_ sky130_fd_sc_hd__xnor2_1
X_14728_ u_core.u_top.u_core.acc[82] u_core.u_top.u_core.acc[83] VSS VSS VDD VDD _08961_ sky130_fd_sc_hd__nor2_1
X_14729_ _03127_ _08961_ VSS VSS VDD VDD _08962_ sky130_fd_sc_hd__nand2_1
X_14730_ u_core.u_top.u_core.acc[84] u_core.u_top.u_core.acc[85] _08962_ VSS VSS VDD VDD _08963_ sky130_fd_sc_hd__nor3_1
X_14731_ u_core.u_top.u_core.acc[87] u_core.u_top.u_core.acc[86] VSS VSS VDD VDD _08964_ sky130_fd_sc_hd__nor2_1
X_14732_ _08963_ _08964_ VSS VSS VDD VDD _08965_ sky130_fd_sc_hd__nand2_1
X_14733_ u_core.u_top.u_core.acc[88] _08965_ VSS VSS VDD VDD _08966_ sky130_fd_sc_hd__xnor2_1
X_14734_ _0043_ _08954_ net712 VSS VSS VDD VDD _08967_ sky130_fd_sc_hd__mux2i_1
X_14735_ _08955_ _08960_ _08966_ net692 VSS VSS VDD VDD _08968_ sky130_fd_sc_hd__o22ai_1
X_14736_ _0043_ net836 VSS VSS VDD VDD _08969_ sky130_fd_sc_hd__nor2_1
X_14737_ net675 _08969_ VSS VSS VDD VDD _08970_ sky130_fd_sc_hd__nor2_1
X_14738_ u_core.u_top.u_core.acc[88] _08970_ VSS VSS VDD VDD _08971_ sky130_fd_sc_hd__nor2_1
X_14739_ net676 _08968_ _08971_ VSS VSS VDD VDD u_core.u_top.u_core.acc_upd[88] sky130_fd_sc_hd__a21oi_1
X_14740_ u_core.u_top.u_core.acc[82] u_core.u_top.u_core.acc[83] VSS VSS VDD VDD _08972_ sky130_fd_sc_hd__nand2_1
X_14741_ u_core.u_top.u_core.acc[80] u_core.u_top.u_core.acc[84] u_core.u_top.u_core.acc[81] VSS VSS VDD VDD _08973_ sky130_fd_sc_hd__nand3_1
X_14742_ _08972_ _08973_ VSS VSS VDD VDD _08974_ sky130_fd_sc_hd__nor2_1
X_14743_ u_core.u_top.u_core.acc[86] u_core.u_top.u_core.acc[85] _08974_ VSS VSS VDD VDD _08975_ sky130_fd_sc_hd__nand3_1
X_14744_ net710 _08975_ net836 VSS VSS VDD VDD _08976_ sky130_fd_sc_hd__a21boi_0
X_14745_ _0043_ _08975_ VSS VSS VDD VDD _08977_ sky130_fd_sc_hd__nand2_1
X_14746_ _0043_ _08954_ net712 VSS VSS VDD VDD _08978_ sky130_fd_sc_hd__mux2_1
X_14747_ u_core.u_top.u_core.acc[80] u_core.u_top.u_core.acc[84] u_core.u_top.u_core.acc[81] _08961_ VSS VSS VDD VDD _08979_ sky130_fd_sc_hd__nor4b_1
X_14748_ u_core.u_top.u_core.acc[86] u_core.u_top.u_core.acc[85] VSS VSS VDD VDD _08980_ sky130_fd_sc_hd__nor2_1
X_14749_ _08979_ _08980_ VSS VSS VDD VDD _08981_ sky130_fd_sc_hd__nand2_1
X_14750_ _08978_ _08981_ net675 VSS VSS VDD VDD _08982_ sky130_fd_sc_hd__a21oi_1
X_14751_ _0043_ _08976_ _08977_ net710 _08982_ VSS VSS VDD VDD _08983_ sky130_fd_sc_hd__o221ai_1
X_14752_ _0043_ _08954_ net710 VSS VSS VDD VDD _08984_ sky130_fd_sc_hd__mux2_1
X_14753_ _08975_ VSS VSS VDD VDD _08985_ sky130_fd_sc_hd__inv_1
X_14754_ net692 _08981_ VSS VSS VDD VDD _08986_ sky130_fd_sc_hd__nor2_1
X_14755_ _08984_ _08985_ _08986_ VSS VSS VDD VDD _08987_ sky130_fd_sc_hd__a21oi_1
X_14756_ net675 _08987_ u_core.u_top.u_core.acc[87] VSS VSS VDD VDD _08988_ sky130_fd_sc_hd__o21ai_0
X_14757_ u_core.u_top.u_core.acc[87] _08983_ _08988_ VSS VSS VDD VDD u_core.u_top.u_core.acc_upd[87] sky130_fd_sc_hd__o21ai_0
X_14758_ _08955_ _08958_ net692 _08963_ u_core.u_top.u_core.acc[86] VSS VSS VDD VDD _08989_ sky130_fd_sc_hd__o221ai_1
X_14759_ _08984_ _08958_ _08978_ _08963_ u_core.u_top.u_core.acc[86] VSS VSS VDD VDD _08990_ sky130_fd_sc_hd__a221o_1
X_14760_ _08989_ _08990_ VSS VSS VDD VDD _08991_ sky130_fd_sc_hd__nand2_1
X_14761_ net675 _08969_ u_core.u_top.u_core.acc[86] VSS VSS VDD VDD _08992_ sky130_fd_sc_hd__o21ai_0
X_14762_ net675 _08991_ _08992_ VSS VSS VDD VDD u_core.u_top.u_core.acc_upd[86] sky130_fd_sc_hd__o21ai_0
X_14763_ net692 _08979_ _08974_ _08955_ u_core.u_top.u_core.acc[85] VSS VSS VDD VDD _08993_ sky130_fd_sc_hd__o221ai_1
X_14764_ _08978_ _08979_ _08974_ _08984_ u_core.u_top.u_core.acc[85] VSS VSS VDD VDD _08994_ sky130_fd_sc_hd__a221o_1
X_14765_ _08993_ _08994_ VSS VSS VDD VDD _08995_ sky130_fd_sc_hd__nand2_1
X_14766_ net675 _08969_ u_core.u_top.u_core.acc[85] VSS VSS VDD VDD _08996_ sky130_fd_sc_hd__o21ai_0
X_14767_ net675 _08995_ _08996_ VSS VSS VDD VDD u_core.u_top.u_core.acc_upd[85] sky130_fd_sc_hd__o21ai_0
X_14768_ _08955_ _08956_ net692 _08962_ u_core.u_top.u_core.acc[84] VSS VSS VDD VDD _08997_ sky130_fd_sc_hd__o221a_2
X_14769_ _08984_ _08956_ _08978_ _08962_ u_core.u_top.u_core.acc[84] VSS VSS VDD VDD _08998_ sky130_fd_sc_hd__a221oi_1
X_14770_ net675 _08997_ _08998_ _08970_ u_core.u_top.u_core.acc[84] VSS VSS VDD VDD u_core.u_top.u_core.acc_upd[84] sky130_fd_sc_hd__o32a_1
X_14771_ u_core.u_top.u_core.acc[82] u_core.u_top.u_core.acc[80] u_core.u_top.u_core.acc[81] _08984_ VSS VSS VDD VDD _08999_ sky130_fd_sc_hd__nand4_1
X_14772_ u_core.u_top.u_core.acc[82] u_core.u_top.u_core.acc[80] u_core.u_top.u_core.acc[81] net692 VSS VSS VDD VDD _09000_ sky130_fd_sc_hd__or4_1
X_14773_ _08999_ _09000_ net675 VSS VSS VDD VDD _09001_ sky130_fd_sc_hd__a21oi_1
X_14774_ u_core.u_top.u_core.acc[83] _09001_ VSS VSS VDD VDD u_core.u_top.u_core.acc_upd[83] sky130_fd_sc_hd__xor2_1
X_14775_ _03129_ _08955_ net692 _03127_ u_core.u_top.u_core.acc[82] VSS VSS VDD VDD _09002_ sky130_fd_sc_hd__o221ai_1
X_14776_ _03129_ _08984_ _08978_ _03127_ u_core.u_top.u_core.acc[82] VSS VSS VDD VDD _09003_ sky130_fd_sc_hd__a221o_1
X_14777_ _09002_ _09003_ VSS VSS VDD VDD _09004_ sky130_fd_sc_hd__nand2_1
X_14778_ net675 _08969_ u_core.u_top.u_core.acc[82] VSS VSS VDD VDD _09005_ sky130_fd_sc_hd__o21ai_0
X_14779_ net675 _09004_ _09005_ VSS VSS VDD VDD u_core.u_top.u_core.acc_upd[82] sky130_fd_sc_hd__o21ai_0
X_14780_ _0044_[1] net712 VSS VSS VDD VDD _09006_ sky130_fd_sc_hd__xnor2_1
X_14781_ _09006_ net669 _08954_ VSS VSS VDD VDD _09007_ sky130_fd_sc_hd__nor3b_1
X_14782_ _0043_ net676 _09006_ _09007_ VSS VSS VDD VDD _09008_ sky130_fd_sc_hd__a31oi_1
X_14783_ net675 _08969_ u_core.u_top.u_core.acc[81] VSS VSS VDD VDD _09009_ sky130_fd_sc_hd__o21ai_0
X_14784_ _09008_ _09009_ VSS VSS VDD VDD u_core.u_top.u_core.acc_upd[81] sky130_fd_sc_hd__nand2_1
X_14786_ u_core.u_top.u_core.acc[78] VSS VSS VDD VDD _09011_ sky130_fd_sc_hd__inv_1
X_14787_ _02899_ u_core.u_top.u_core.acc[74] u_core.u_top.u_core.acc[73] u_core.u_top.u_core.acc[72] VSS VSS VDD VDD _09012_ sky130_fd_sc_hd__nand4_1
X_14788_ u_core.u_top.u_core.acc[75] u_core.u_top.u_core.acc[77] u_core.u_top.u_core.acc[76] VSS VSS VDD VDD _09013_ sky130_fd_sc_hd__nand3_1
X_14789_ _09012_ _09013_ VSS VSS VDD VDD _09014_ sky130_fd_sc_hd__nor2_1
X_14790_ u_core.u_top.u_core.acc[78] _09014_ VSS VSS VDD VDD _09015_ sky130_fd_sc_hd__xnor2_1
X_14791_ u_core.u_top.u_core.acc[74] VSS VSS VDD VDD _09016_ sky130_fd_sc_hd__inv_1
X_14792_ u_core.u_top.u_core.acc[75] VSS VSS VDD VDD _09017_ sky130_fd_sc_hd__inv_1
X_14793_ u_core.u_top.u_core.acc[73] u_core.u_top.u_core.acc[72] VSS VSS VDD VDD _09018_ sky130_fd_sc_hd__nor2_1
X_14794_ _09016_ _09017_ _02898_ _09018_ VSS VSS VDD VDD _09019_ sky130_fd_sc_hd__nand4_1
X_14795_ u_core.u_top.u_core.acc[77] u_core.u_top.u_core.acc[76] _09019_ VSS VSS VDD VDD _09020_ sky130_fd_sc_hd__nor3_1
X_14796_ u_core.u_top.u_core.acc[78] _09020_ VSS VSS VDD VDD _09021_ sky130_fd_sc_hd__xnor2_1
X_14797_ _09015_ _09021_ net714 VSS VSS VDD VDD _09022_ sky130_fd_sc_hd__mux2i_1
X_14798_ net837 _09022_ VSS VSS VDD VDD _09023_ sky130_fd_sc_hd__nand2_1
X_14799_ _09011_ net837 net674 _09023_ VSS VSS VDD VDD _09024_ sky130_fd_sc_hd__o22a_1
X_14800_ _09015_ _09021_ net707 VSS VSS VDD VDD _09025_ sky130_fd_sc_hd__mux2i_1
X_14801_ _09011_ net677 VSS VSS VDD VDD _09026_ sky130_fd_sc_hd__nor2_1
X_14802_ _0031_ net677 _09025_ _09026_ VSS VSS VDD VDD _09027_ sky130_fd_sc_hd__a31oi_1
X_14803_ _0031_ _09024_ _09027_ VSS VSS VDD VDD u_core.u_top.u_core.acc_upd[78] sky130_fd_sc_hd__o21ai_0
X_14804_ _0032_[0] _09016_ _02878_ _09018_ VSS VSS VDD VDD _09028_ sky130_fd_sc_hd__nand4_1
X_14805_ u_core.u_top.u_core.acc[75] u_core.u_top.u_core.acc[76] _09028_ VSS VSS VDD VDD _09029_ sky130_fd_sc_hd__or3_1
X_14806_ u_core.u_top.u_core.acc[75] u_core.u_top.u_core.acc[76] VSS VSS VDD VDD _09030_ sky130_fd_sc_hd__nand2_1
X_14807_ u_core.u_top.u_core.acc[73] u_core.u_top.u_core.acc[72] VSS VSS VDD VDD _09031_ sky130_fd_sc_hd__nand2_1
X_14808_ u_core.u_top.u_core.acc[70] u_core.u_top.u_core.acc[71] VSS VSS VDD VDD _09032_ sky130_fd_sc_hd__nand2_1
X_14809_ _09016_ _09031_ _09032_ VSS VSS VDD VDD _09033_ sky130_fd_sc_hd__or3_1
X_14810_ _09030_ _09033_ VSS VSS VDD VDD _09034_ sky130_fd_sc_hd__or2_2
X_14811_ _09029_ _09034_ net714 VSS VSS VDD VDD _09035_ sky130_fd_sc_hd__mux2i_1
X_14812_ _09029_ _09034_ net707 VSS VSS VDD VDD _09036_ sky130_fd_sc_hd__mux2i_1
X_14813_ _0031_ net837 VSS VSS VDD VDD _09037_ sky130_fd_sc_hd__nor2b_1
X_14814_ _0031_ _09035_ _09036_ _09037_ VSS VSS VDD VDD _09038_ sky130_fd_sc_hd__a22oi_1
X_14815_ net674 _09038_ VSS VSS VDD VDD _09039_ sky130_fd_sc_hd__nor2_1
X_14816_ u_core.u_top.u_core.acc[77] _09039_ VSS VSS VDD VDD u_core.u_top.u_core.acc_upd[77] sky130_fd_sc_hd__xor2_1
X_14817_ _0031_ _09037_ net708 VSS VSS VDD VDD _09040_ sky130_fd_sc_hd__mux2i_1
X_14818_ _0031_ _09037_ net714 VSS VSS VDD VDD _09041_ sky130_fd_sc_hd__mux2i_1
X_14819_ _09017_ _09012_ _09040_ _09041_ _09019_ VSS VSS VDD VDD _09042_ sky130_fd_sc_hd__o32ai_1
X_14820_ net677 _09042_ VSS VSS VDD VDD _09043_ sky130_fd_sc_hd__and2_1
X_14821_ u_core.u_top.u_core.acc[76] _09043_ VSS VSS VDD VDD u_core.u_top.u_core.acc_upd[76] sky130_fd_sc_hd__xor2_1
X_14822_ _09028_ _09041_ _09040_ _09033_ u_core.u_top.u_core.acc[75] VSS VSS VDD VDD _09044_ sky130_fd_sc_hd__o221ai_1
X_14823_ _09041_ VSS VSS VDD VDD _09045_ sky130_fd_sc_hd__inv_1
X_14824_ _0031_ _09037_ net708 VSS VSS VDD VDD _09046_ sky130_fd_sc_hd__mux2_1
X_14825_ _09028_ _09045_ _09046_ _09033_ u_core.u_top.u_core.acc[75] VSS VSS VDD VDD _09047_ sky130_fd_sc_hd__a221o_1
X_14826_ _0031_ net837 VSS VSS VDD VDD _09048_ sky130_fd_sc_hd__nor2_1
X_14827_ net674 _09048_ VSS VSS VDD VDD _09049_ sky130_fd_sc_hd__nor2_1
X_14828_ u_core.u_top.u_core.acc[75] _09049_ VSS VSS VDD VDD _09050_ sky130_fd_sc_hd__nor2_1
X_14829_ net677 _09044_ _09047_ _09050_ VSS VSS VDD VDD u_core.u_top.u_core.acc_upd[75] sky130_fd_sc_hd__a31oi_1
X_14830_ _02898_ _09018_ VSS VSS VDD VDD _09051_ sky130_fd_sc_hd__nand2_1
X_14831_ u_core.u_top.u_core.acc[74] _09051_ VSS VSS VDD VDD _09052_ sky130_fd_sc_hd__xnor2_1
X_14832_ _02899_ u_core.u_top.u_core.acc[73] u_core.u_top.u_core.acc[72] VSS VSS VDD VDD _09053_ sky130_fd_sc_hd__nand3_1
X_14833_ u_core.u_top.u_core.acc[74] _09053_ VSS VSS VDD VDD _09054_ sky130_fd_sc_hd__xnor2_1
X_14834_ _09041_ _09052_ _09054_ _09040_ VSS VSS VDD VDD _09055_ sky130_fd_sc_hd__o22ai_1
X_14835_ u_core.u_top.u_core.acc[74] _09049_ VSS VSS VDD VDD _09056_ sky130_fd_sc_hd__nor2_1
X_14836_ net677 _09055_ _09056_ VSS VSS VDD VDD u_core.u_top.u_core.acc_upd[74] sky130_fd_sc_hd__a21oi_1
X_14837_ _09032_ _09040_ VSS VSS VDD VDD _09057_ sky130_fd_sc_hd__nor2_1
X_14838_ u_core.u_top.u_core.acc[70] u_core.u_top.u_core.acc[71] u_core.u_top.u_core.acc[72] _09041_ VSS VSS VDD VDD _09058_ sky130_fd_sc_hd__nor4_1
X_14839_ u_core.u_top.u_core.acc[72] _09057_ _09058_ VSS VSS VDD VDD _09059_ sky130_fd_sc_hd__a21oi_1
X_14840_ net674 _09059_ VSS VSS VDD VDD _09060_ sky130_fd_sc_hd__nor2_1
X_14841_ u_core.u_top.u_core.acc[73] _09060_ VSS VSS VDD VDD u_core.u_top.u_core.acc_upd[73] sky130_fd_sc_hd__xor2_1
X_14842_ _02898_ _09041_ _09040_ _02899_ u_core.u_top.u_core.acc[72] VSS VSS VDD VDD _09061_ sky130_fd_sc_hd__o221ai_1
X_14843_ _02898_ _09045_ _09046_ _02899_ u_core.u_top.u_core.acc[72] VSS VSS VDD VDD _09062_ sky130_fd_sc_hd__a221o_1
X_14844_ _09061_ _09062_ VSS VSS VDD VDD _09063_ sky130_fd_sc_hd__nand2_1
X_14845_ net674 _09048_ u_core.u_top.u_core.acc[72] VSS VSS VDD VDD _09064_ sky130_fd_sc_hd__o21ai_0
X_14846_ net674 _09063_ _09064_ VSS VSS VDD VDD u_core.u_top.u_core.acc_upd[72] sky130_fd_sc_hd__o21ai_0
X_14847_ _02880_ net708 VSS VSS VDD VDD _09065_ sky130_fd_sc_hd__nor2_1
X_14848_ _0032_[1] net708 _09065_ VSS VSS VDD VDD _09066_ sky130_fd_sc_hd__a21oi_1
X_14849_ _02880_ net708 VSS VSS VDD VDD _09067_ sky130_fd_sc_hd__nand2_1
X_14850_ _0032_[1] net708 _09067_ VSS VSS VDD VDD _09068_ sky130_fd_sc_hd__o21ai_0
X_14851_ _09037_ _09066_ _09068_ _0031_ VSS VSS VDD VDD _09069_ sky130_fd_sc_hd__a22oi_1
X_14852_ u_core.u_top.u_core.acc[71] _09049_ _09069_ net674 VSS VSS VDD VDD u_core.u_top.u_core.acc_upd[71] sky130_fd_sc_hd__o22a_1
X_14853_ _0020_ net838 VSS VSS VDD VDD _09070_ sky130_fd_sc_hd__nor2b_1
X_14854_ _0020_ _09070_ net715 VSS VSS VDD VDD _09071_ sky130_fd_sc_hd__mux2i_1
X_14856_ u_core.u_top.u_core.acc[62] net961 VSS VSS VDD VDD _09073_ sky130_fd_sc_hd__nor2_1
X_14857_ _03153_ _09073_ VSS VSS VDD VDD _09074_ sky130_fd_sc_hd__nand2_1
X_14858_ net960 u_core.u_top.u_core.acc[65] _09074_ VSS VSS VDD VDD _09075_ sky130_fd_sc_hd__or3_1
X_14859_ net959 u_core.u_top.u_core.acc[66] _09075_ VSS VSS VDD VDD _09076_ sky130_fd_sc_hd__or3_1
X_14860_ _0020_ _09070_ net708 VSS VSS VDD VDD _09077_ sky130_fd_sc_hd__mux2i_1
X_14861_ u_core.u_top.u_core.acc[62] net961 _03154_ VSS VSS VDD VDD _09078_ sky130_fd_sc_hd__nand3_1
X_14862_ net960 u_core.u_top.u_core.acc[65] VSS VSS VDD VDD _09079_ sky130_fd_sc_hd__nand2_1
X_14863_ _09078_ _09079_ VSS VSS VDD VDD _09080_ sky130_fd_sc_hd__nor2_1
X_14864_ net959 u_core.u_top.u_core.acc[66] _09080_ VSS VSS VDD VDD _09081_ sky130_fd_sc_hd__nand3_1
X_14865_ net691 _09076_ net690 _09081_ u_core.u_top.u_core.acc[68] VSS VSS VDD VDD _09082_ sky130_fd_sc_hd__o221a_2
X_14866_ _0020_ _09070_ net715 VSS VSS VDD VDD _09083_ sky130_fd_sc_hd__mux2_1
X_14867_ _0020_ _09070_ net708 VSS VSS VDD VDD _09084_ sky130_fd_sc_hd__mux2_1
X_14868_ _09083_ _09076_ _09084_ _09081_ u_core.u_top.u_core.acc[68] VSS VSS VDD VDD _09085_ sky130_fd_sc_hd__a221oi_1
X_14869_ _0020_ net838 VSS VSS VDD VDD _09086_ sky130_fd_sc_hd__nor2_1
X_14870_ net673 _09086_ VSS VSS VDD VDD _09087_ sky130_fd_sc_hd__nor2_1
X_14871_ net673 _09082_ _09085_ _09087_ u_core.u_top.u_core.acc[68] VSS VSS VDD VDD u_core.u_top.u_core.acc_upd[68] sky130_fd_sc_hd__o32a_1
X_14872_ u_core.u_top.u_core.acc[61] u_core.u_top.u_core.acc[60] VSS VSS VDD VDD _09088_ sky130_fd_sc_hd__nor2_1
X_14873_ net960 _09073_ _09088_ VSS VSS VDD VDD _09089_ sky130_fd_sc_hd__and3b_1
X_14874_ u_core.u_top.u_core.acc[66] u_core.u_top.u_core.acc[65] VSS VSS VDD VDD _09090_ sky130_fd_sc_hd__nor2_1
X_14875_ _09089_ _09090_ VSS VSS VDD VDD _09091_ sky130_fd_sc_hd__nand2_1
X_14876_ u_core.u_top.u_core.acc[62] net961 VSS VSS VDD VDD _09092_ sky130_fd_sc_hd__nand2_1
X_14877_ u_core.u_top.u_core.acc[61] net960 u_core.u_top.u_core.acc[60] VSS VSS VDD VDD _09093_ sky130_fd_sc_hd__nand3_1
X_14878_ _09092_ _09093_ VSS VSS VDD VDD _09094_ sky130_fd_sc_hd__nor2_1
X_14879_ u_core.u_top.u_core.acc[66] u_core.u_top.u_core.acc[65] _09094_ VSS VSS VDD VDD _09095_ sky130_fd_sc_hd__nand3_1
X_14880_ net691 _09091_ _09095_ net690 net959 VSS VSS VDD VDD _09096_ sky130_fd_sc_hd__o221ai_1
X_14881_ _09083_ _09091_ _09095_ _09084_ net959 VSS VSS VDD VDD _09097_ sky130_fd_sc_hd__a221o_1
X_14882_ net959 _09087_ VSS VSS VDD VDD _09098_ sky130_fd_sc_hd__nor2_1
X_14883_ net677 _09096_ _09097_ _09098_ VSS VSS VDD VDD u_core.u_top.u_core.acc_upd[67] sky130_fd_sc_hd__a31oi_1
X_14884_ _09078_ _09079_ VSS VSS VDD VDD _09099_ sky130_fd_sc_hd__or2_2
X_14885_ net691 _09075_ net690 _09099_ u_core.u_top.u_core.acc[66] VSS VSS VDD VDD _09100_ sky130_fd_sc_hd__o221a_2
X_14886_ _09083_ _09075_ _09084_ _09099_ u_core.u_top.u_core.acc[66] VSS VSS VDD VDD _09101_ sky130_fd_sc_hd__a221oi_1
X_14887_ net673 _09100_ _09101_ _09087_ u_core.u_top.u_core.acc[66] VSS VSS VDD VDD u_core.u_top.u_core.acc_upd[66] sky130_fd_sc_hd__o32a_1
X_14888_ net691 _09089_ _09094_ net690 _09087_ VSS VSS VDD VDD _09102_ sky130_fd_sc_hd__o221ai_1
X_14889_ u_core.u_top.u_core.acc[65] _09102_ VSS VSS VDD VDD u_core.u_top.u_core.acc_upd[65] sky130_fd_sc_hd__xnor2_1
X_14890_ net691 _09074_ net690 _09078_ net960 VSS VSS VDD VDD _09103_ sky130_fd_sc_hd__o221a_2
X_14891_ _09083_ _09074_ _09084_ _09078_ net960 VSS VSS VDD VDD _09104_ sky130_fd_sc_hd__a221oi_1
X_14892_ net673 _09103_ _09104_ _09087_ net960 VSS VSS VDD VDD u_core.u_top.u_core.acc_upd[64] sky130_fd_sc_hd__o32a_1
X_14893_ _02707_ _0021_[0] _09084_ VSS VSS VDD VDD _09105_ sky130_fd_sc_hd__o21ai_0
X_14894_ net691 _09088_ _09105_ VSS VSS VDD VDD _09106_ sky130_fd_sc_hd__o21ai_0
X_14895_ _02707_ net961 _0021_[0] net690 VSS VSS VDD VDD _09107_ sky130_fd_sc_hd__nor4_1
X_14896_ net961 _09083_ _09107_ VSS VSS VDD VDD _09108_ sky130_fd_sc_hd__a21oi_1
X_14897_ u_core.u_top.u_core.acc[61] net961 u_core.u_top.u_core.acc[60] VSS VSS VDD VDD _09109_ sky130_fd_sc_hd__nor3_1
X_14898_ net961 _09084_ _09109_ _09083_ u_core.u_top.u_core.acc[62] VSS VSS VDD VDD _09110_ sky130_fd_sc_hd__a221oi_1
X_14899_ u_core.u_top.u_core.acc[62] _09108_ _09110_ VSS VSS VDD VDD _09111_ sky130_fd_sc_hd__a21oi_1
X_14900_ net961 _09106_ _09111_ VSS VSS VDD VDD _09112_ sky130_fd_sc_hd__a21oi_1
X_14901_ net673 _09086_ net961 VSS VSS VDD VDD _09113_ sky130_fd_sc_hd__o21ai_0
X_14902_ net673 _09112_ _09113_ VSS VSS VDD VDD u_core.u_top.u_core.acc_upd[63] sky130_fd_sc_hd__o21ai_0
X_14903_ _03153_ net691 net690 _03154_ u_core.u_top.u_core.acc[62] VSS VSS VDD VDD _09114_ sky130_fd_sc_hd__o221ai_1
X_14904_ _03153_ _09083_ _09084_ _03154_ u_core.u_top.u_core.acc[62] VSS VSS VDD VDD _09115_ sky130_fd_sc_hd__a221o_1
X_14905_ _09114_ _09115_ VSS VSS VDD VDD _09116_ sky130_fd_sc_hd__nand2_1
X_14906_ net673 _09086_ u_core.u_top.u_core.acc[62] VSS VSS VDD VDD _09117_ sky130_fd_sc_hd__o21ai_0
X_14907_ net673 _09116_ _09117_ VSS VSS VDD VDD u_core.u_top.u_core.acc_upd[62] sky130_fd_sc_hd__o21ai_0
X_14908_ _0021_[1] net715 VSS VSS VDD VDD _09118_ sky130_fd_sc_hd__nor2_1
X_14909_ _02709_ net715 _09118_ VSS VSS VDD VDD _09119_ sky130_fd_sc_hd__a21o_1
X_14910_ _02709_ net708 VSS VSS VDD VDD _09120_ sky130_fd_sc_hd__nand2_1
X_14911_ _0021_[1] net708 _09120_ VSS VSS VDD VDD _09121_ sky130_fd_sc_hd__o21ai_0
X_14912_ _09070_ _09119_ _09121_ _0020_ VSS VSS VDD VDD _09122_ sky130_fd_sc_hd__a22oi_1
X_14913_ u_core.u_top.u_core.acc[61] _09087_ _09122_ net673 VSS VSS VDD VDD u_core.u_top.u_core.acc_upd[61] sky130_fd_sc_hd__o22a_1
X_14914_ u_core.u_top.u_core.acc[53] u_core.u_top.u_core.acc[52] VSS VSS VDD VDD _09123_ sky130_fd_sc_hd__nor2_1
X_14915_ _02846_ _09123_ VSS VSS VDD VDD _09124_ sky130_fd_sc_hd__nand2_1
X_14916_ u_core.u_top.u_core.acc[54] _09124_ VSS VSS VDD VDD _09125_ sky130_fd_sc_hd__nor2_1
X_14918_ u_core.u_top.u_core.acc[57] u_core.u_top.u_core.acc[56] u_core.u_top.u_core.acc[55] VSS VSS VDD VDD _09127_ sky130_fd_sc_hd__nor3_1
X_14919_ _09125_ _09127_ VSS VSS VDD VDD _09128_ sky130_fd_sc_hd__nand2_1
X_14920_ u_core.u_top.u_core.acc[53] u_core.u_top.u_core.acc[52] VSS VSS VDD VDD _09129_ sky130_fd_sc_hd__and2_0
X_14922_ u_core.u_top.u_core.acc[54] _02848_ _09129_ VSS VSS VDD VDD _09131_ sky130_fd_sc_hd__and3_1
X_14923_ u_core.u_top.u_core.acc[57] u_core.u_top.u_core.acc[56] u_core.u_top.u_core.acc[55] _09131_ VSS VSS VDD VDD _09132_ sky130_fd_sc_hd__nand4_1
X_14924_ _09128_ _09132_ net714 VSS VSS VDD VDD _09133_ sky130_fd_sc_hd__mux2i_1
X_14925_ _09128_ _09132_ net707 VSS VSS VDD VDD _09134_ sky130_fd_sc_hd__mux2i_1
X_14926_ _0434_ _0012_ VSS VSS VDD VDD _09135_ sky130_fd_sc_hd__nor2b_1
X_14928_ _0434_ _09133_ _09134_ _09135_ VSS VSS VDD VDD _09137_ sky130_fd_sc_hd__a22oi_1
X_14929_ net674 _09137_ VSS VSS VDD VDD _09138_ sky130_fd_sc_hd__nor2_1
X_14930_ u_core.u_top.u_core.acc[58] _09138_ VSS VSS VDD VDD u_core.u_top.u_core.acc_upd[58] sky130_fd_sc_hd__xor2_1
X_14931_ _0434_ _09135_ net707 VSS VSS VDD VDD _09139_ sky130_fd_sc_hd__mux2i_1
X_14932_ u_core.u_top.u_core.acc[56] u_core.u_top.u_core.acc[55] VSS VSS VDD VDD _09140_ sky130_fd_sc_hd__nand2_1
X_14933_ u_core.u_top.u_core.acc[51] u_core.u_top.u_core.acc[54] u_core.u_top.u_core.acc[50] _09129_ VSS VSS VDD VDD _09141_ sky130_fd_sc_hd__nand4_1
X_14934_ _09140_ _09141_ VSS VSS VDD VDD _09142_ sky130_fd_sc_hd__nor2_1
X_14935_ u_core.u_top.u_core.acc[57] _09142_ VSS VSS VDD VDD _09143_ sky130_fd_sc_hd__xor2_1
X_14936_ _0434_ _09135_ net714 VSS VSS VDD VDD _09144_ sky130_fd_sc_hd__mux2i_1
X_14937_ u_core.u_top.u_core.acc[51] u_core.u_top.u_core.acc[54] u_core.u_top.u_core.acc[50] VSS VSS VDD VDD _09145_ sky130_fd_sc_hd__nor3_1
X_14938_ _09123_ _09145_ VSS VSS VDD VDD _09146_ sky130_fd_sc_hd__nand2_1
X_14939_ u_core.u_top.u_core.acc[56] u_core.u_top.u_core.acc[55] _09146_ VSS VSS VDD VDD _09147_ sky130_fd_sc_hd__nor3_1
X_14940_ u_core.u_top.u_core.acc[57] _09147_ VSS VSS VDD VDD _09148_ sky130_fd_sc_hd__xor2_1
X_14941_ _09139_ _09143_ _09144_ _09148_ VSS VSS VDD VDD _09149_ sky130_fd_sc_hd__o22ai_1
X_14942_ u_core.u_top.u_core.acc[57] _06507_ VSS VSS VDD VDD _09150_ sky130_fd_sc_hd__nor2_1
X_14943_ net677 _09149_ _09150_ VSS VSS VDD VDD u_core.u_top.u_core.acc_upd[57] sky130_fd_sc_hd__a21oi_1
X_14944_ u_core.u_top.u_core.acc[54] u_core.u_top.u_core.acc[55] _09124_ VSS VSS VDD VDD _09151_ sky130_fd_sc_hd__or3_1
X_14946_ u_core.u_top.u_core.acc[55] net707 _09131_ VSS VSS VDD VDD _09153_ sky130_fd_sc_hd__nand3_1
X_14947_ net707 _09151_ _09153_ VSS VSS VDD VDD _09154_ sky130_fd_sc_hd__o21ai_0
X_14948_ u_core.u_top.u_core.acc[55] _09131_ VSS VSS VDD VDD _09155_ sky130_fd_sc_hd__nand2_1
X_14949_ _09155_ _09151_ net707 VSS VSS VDD VDD _09156_ sky130_fd_sc_hd__mux2i_1
X_14950_ _09135_ _09154_ _09156_ _0434_ VSS VSS VDD VDD _09157_ sky130_fd_sc_hd__a22oi_1
X_14951_ net674 _09157_ VSS VSS VDD VDD _09158_ sky130_fd_sc_hd__nor2_1
X_14952_ u_core.u_top.u_core.acc[56] _09158_ VSS VSS VDD VDD u_core.u_top.u_core.acc_upd[56] sky130_fd_sc_hd__xor2_1
X_14953_ _09141_ _09146_ net714 VSS VSS VDD VDD _09159_ sky130_fd_sc_hd__mux2i_1
X_14954_ _09141_ _09146_ net707 VSS VSS VDD VDD _09160_ sky130_fd_sc_hd__mux2i_1
X_14955_ _09135_ _09159_ _09160_ _0434_ VSS VSS VDD VDD _09161_ sky130_fd_sc_hd__a22oi_1
X_14956_ net674 _09161_ VSS VSS VDD VDD _09162_ sky130_fd_sc_hd__nor2_1
X_14957_ u_core.u_top.u_core.acc[55] _09162_ VSS VSS VDD VDD u_core.u_top.u_core.acc_upd[55] sky130_fd_sc_hd__xor2_1
X_14958_ _02848_ net707 _09129_ VSS VSS VDD VDD _09163_ sky130_fd_sc_hd__nand3_1
X_14959_ net707 _09124_ _09163_ VSS VSS VDD VDD _09164_ sky130_fd_sc_hd__o21ai_0
X_14960_ _02848_ _09129_ VSS VSS VDD VDD _09165_ sky130_fd_sc_hd__nand2_1
X_14961_ _02846_ net707 _09123_ VSS VSS VDD VDD _09166_ sky130_fd_sc_hd__nand3_1
X_14962_ net707 _09165_ _09166_ VSS VSS VDD VDD _09167_ sky130_fd_sc_hd__o21ai_0
X_14963_ _09135_ _09164_ _09167_ _0434_ VSS VSS VDD VDD _09168_ sky130_fd_sc_hd__a22oi_1
X_14964_ net674 _09168_ VSS VSS VDD VDD _09169_ sky130_fd_sc_hd__nor2_1
X_14965_ u_core.u_top.u_core.acc[54] _09169_ VSS VSS VDD VDD u_core.u_top.u_core.acc_upd[54] sky130_fd_sc_hd__xor2_1
X_14966_ _09139_ u_core.u_top.u_core.acc[50] u_core.u_top.u_core.acc[52] u_core.u_top.u_core.acc[51] VSS VSS VDD VDD _09170_ sky130_fd_sc_hd__nand4b_1
X_14967_ u_core.u_top.u_core.acc[51] u_core.u_top.u_core.acc[52] u_core.u_top.u_core.acc[50] _09144_ VSS VSS VDD VDD _09171_ sky130_fd_sc_hd__or4_1
X_14968_ _09170_ _09171_ net674 VSS VSS VDD VDD _09172_ sky130_fd_sc_hd__a21oi_1
X_14969_ u_core.u_top.u_core.acc[53] _09172_ VSS VSS VDD VDD u_core.u_top.u_core.acc_upd[53] sky130_fd_sc_hd__xor2_1
X_14970_ u_core.u_top.u_core.acc[52] _02846_ VSS VSS VDD VDD _09173_ sky130_fd_sc_hd__xnor2_1
X_14971_ u_core.u_top.u_core.acc[52] _02848_ VSS VSS VDD VDD _09174_ sky130_fd_sc_hd__xnor2_1
X_14972_ _09144_ _09173_ _09174_ _09139_ VSS VSS VDD VDD _09175_ sky130_fd_sc_hd__o22a_1
X_14973_ net674 _06506_ u_core.u_top.u_core.acc[52] VSS VSS VDD VDD _09176_ sky130_fd_sc_hd__o21ai_0
X_14974_ net674 _09175_ _09176_ VSS VSS VDD VDD u_core.u_top.u_core.acc_upd[52] sky130_fd_sc_hd__o21ai_0
X_14975_ _0014_[1] net707 VSS VSS VDD VDD _09177_ sky130_fd_sc_hd__xnor2_1
X_14976_ _0434_ _09135_ _09177_ VSS VSS VDD VDD _09178_ sky130_fd_sc_hd__mux2i_1
X_14977_ _02845_ _06507_ _09178_ net674 VSS VSS VDD VDD u_core.u_top.u_core.acc_upd[51] sky130_fd_sc_hd__o22ai_1
X_14979_ u_core.u_top.u_core.acc[44] VSS VSS VDD VDD _09180_ sky130_fd_sc_hd__inv_1
X_14980_ u_core.u_top.u_core.acc[43] _03442_ u_core.u_top.u_core.acc[42] VSS VSS VDD VDD _09181_ sky130_fd_sc_hd__nand3_1
X_14981_ _09180_ _09181_ VSS VSS VDD VDD _09182_ sky130_fd_sc_hd__nor2_1
X_14982_ u_core.u_top.u_core.acc[46] u_core.u_top.u_core.acc[47] u_core.u_top.u_core.acc[45] _09182_ VSS VSS VDD VDD _09183_ sky130_fd_sc_hd__nand4_1
X_14983_ u_core.u_top.u_core.acc[48] _09183_ VSS VSS VDD VDD _09184_ sky130_fd_sc_hd__xor2_1
X_14984_ u_core.u_top.u_core.acc[43] u_core.u_top.u_core.acc[42] VSS VSS VDD VDD _09185_ sky130_fd_sc_hd__nor2_1
X_14985_ _03440_ _09185_ VSS VSS VDD VDD _09186_ sky130_fd_sc_hd__nand2_1
X_14986_ u_core.u_top.u_core.acc[46] u_core.u_top.u_core.acc[45] VSS VSS VDD VDD _09187_ sky130_fd_sc_hd__nor2_1
X_14987_ u_core.u_top.u_core.acc[47] u_core.u_top.u_core.acc[44] _09186_ _09187_ VSS VSS VDD VDD _09188_ sky130_fd_sc_hd__nor4b_1
X_14988_ u_core.u_top.u_core.acc[48] _09188_ VSS VSS VDD VDD _09189_ sky130_fd_sc_hd__xnor2_1
X_14989_ _09184_ _09189_ net715 VSS VSS VDD VDD _09190_ sky130_fd_sc_hd__mux2i_1
X_14990_ net840 u_core.u_top.u_core.acc[48] VSS VSS VDD VDD _09191_ sky130_fd_sc_hd__nor2b_1
X_14991_ net840 net677 _09190_ _09191_ VSS VSS VDD VDD _09192_ sky130_fd_sc_hd__a31oi_1
X_14993_ _09184_ _09189_ net708 VSS VSS VDD VDD _09194_ sky130_fd_sc_hd__mux2i_1
X_14994_ net841 net677 _09194_ VSS VSS VDD VDD _09195_ sky130_fd_sc_hd__and3_1
X_14995_ u_core.u_top.u_core.acc[48] net673 _09195_ VSS VSS VDD VDD _09196_ sky130_fd_sc_hd__a21oi_1
X_14996_ net841 _09192_ _09196_ VSS VSS VDD VDD u_core.u_top.u_core.acc_upd[48] sky130_fd_sc_hd__o21ai_0
X_14997_ u_core.u_top.u_core.acc[46] u_core.u_top.u_core.acc[45] VSS VSS VDD VDD _09197_ sky130_fd_sc_hd__nand2_1
X_14998_ u_core.u_top.u_core.acc[41] VSS VSS VDD VDD _03439_ sky130_fd_sc_hd__inv_1
X_14999_ _0938_[0] _03439_ _09180_ VSS VSS VDD VDD _09198_ sky130_fd_sc_hd__nor3_1
X_15000_ u_core.u_top.u_core.acc[43] u_core.u_top.u_core.acc[42] _09198_ VSS VSS VDD VDD _09199_ sky130_fd_sc_hd__nand3_1
X_15001_ _09197_ _09199_ VSS VSS VDD VDD _09200_ sky130_fd_sc_hd__nor2_1
X_15002_ _0938_[0] _03439_ _09180_ _09185_ VSS VSS VDD VDD _09201_ sky130_fd_sc_hd__nand4_1
X_15003_ u_core.u_top.u_core.acc[46] u_core.u_top.u_core.acc[45] _09201_ VSS VSS VDD VDD _09202_ sky130_fd_sc_hd__or3_1
X_15004_ net715 _09202_ VSS VSS VDD VDD _09203_ sky130_fd_sc_hd__nor2_1
X_15005_ net715 _09200_ _09203_ VSS VSS VDD VDD _09204_ sky130_fd_sc_hd__a21o_1
X_15006_ net708 _09200_ VSS VSS VDD VDD _09205_ sky130_fd_sc_hd__nand2_1
X_15007_ net708 _09202_ _09205_ VSS VSS VDD VDD _09206_ sky130_fd_sc_hd__o21ai_0
X_15008_ net841 _0430_ VSS VSS VDD VDD _09207_ sky130_fd_sc_hd__nor2b_1
X_15010_ net841 _09204_ _09206_ _09207_ VSS VSS VDD VDD _09209_ sky130_fd_sc_hd__a22oi_1
X_15011_ net673 _09209_ VSS VSS VDD VDD _09210_ sky130_fd_sc_hd__nor2_1
X_15012_ u_core.u_top.u_core.acc[47] _09210_ VSS VSS VDD VDD u_core.u_top.u_core.acc_upd[47] sky130_fd_sc_hd__xor2_1
X_15013_ u_core.u_top.u_core.acc[45] _09182_ VSS VSS VDD VDD _09211_ sky130_fd_sc_hd__nand2_1
X_15014_ u_core.u_top.u_core.acc[46] _09211_ VSS VSS VDD VDD _09212_ sky130_fd_sc_hd__xnor2_1
X_15015_ net841 _09207_ net708 VSS VSS VDD VDD _09213_ sky130_fd_sc_hd__mux2i_1
X_15016_ u_core.u_top.u_core.acc[45] u_core.u_top.u_core.acc[44] _09186_ VSS VSS VDD VDD _09214_ sky130_fd_sc_hd__nor3_1
X_15017_ u_core.u_top.u_core.acc[46] _09214_ VSS VSS VDD VDD _09215_ sky130_fd_sc_hd__xor2_1
X_15018_ _09207_ net841 net708 VSS VSS VDD VDD _09216_ sky130_fd_sc_hd__mux2i_1
X_15019_ _09212_ _09213_ _09215_ _09216_ VSS VSS VDD VDD _09217_ sky130_fd_sc_hd__o22ai_1
X_15020_ net841 net840 VSS VSS VDD VDD _09218_ sky130_fd_sc_hd__nor2_1
X_15021_ net673 _09218_ VSS VSS VDD VDD _09219_ sky130_fd_sc_hd__nor2_1
X_15022_ u_core.u_top.u_core.acc[46] _09219_ VSS VSS VDD VDD _09220_ sky130_fd_sc_hd__nor2_1
X_15023_ net677 _09217_ _09220_ VSS VSS VDD VDD u_core.u_top.u_core.acc_upd[46] sky130_fd_sc_hd__a21oi_1
X_15024_ _09199_ _09201_ net708 VSS VSS VDD VDD _09221_ sky130_fd_sc_hd__mux2i_1
X_15025_ _09201_ _09199_ net708 VSS VSS VDD VDD _09222_ sky130_fd_sc_hd__mux2i_1
X_15026_ net841 _09221_ _09222_ _09207_ VSS VSS VDD VDD _09223_ sky130_fd_sc_hd__a22oi_1
X_15027_ net673 _09223_ VSS VSS VDD VDD _09224_ sky130_fd_sc_hd__nor2_1
X_15028_ u_core.u_top.u_core.acc[45] _09224_ VSS VSS VDD VDD u_core.u_top.u_core.acc_upd[45] sky130_fd_sc_hd__xor2_1
X_15029_ _09186_ _09181_ net708 VSS VSS VDD VDD _09225_ sky130_fd_sc_hd__mux2i_1
X_15030_ _03440_ net708 _09185_ VSS VSS VDD VDD _09226_ sky130_fd_sc_hd__nand3_1
X_15031_ net708 _09181_ _09226_ VSS VSS VDD VDD _09227_ sky130_fd_sc_hd__o21ai_0
X_15032_ _09207_ _09225_ _09227_ net841 VSS VSS VDD VDD _09228_ sky130_fd_sc_hd__a22oi_1
X_15033_ net673 _09228_ VSS VSS VDD VDD _09229_ sky130_fd_sc_hd__nor2_1
X_15034_ _09180_ _09229_ VSS VSS VDD VDD u_core.u_top.u_core.acc_upd[44] sky130_fd_sc_hd__xnor2_1
X_15035_ _0938_[0] _03439_ VSS VSS VDD VDD _09230_ sky130_fd_sc_hd__nand2_1
X_15036_ u_core.u_top.u_core.acc[42] u_core.u_top.u_core.acc[40] u_core.u_top.u_core.acc[41] VSS VSS VDD VDD _09231_ sky130_fd_sc_hd__nand3_1
X_15037_ u_core.u_top.u_core.acc[42] _09230_ _09216_ _09231_ _09213_ VSS VSS VDD VDD _09232_ sky130_fd_sc_hd__o32a_1
X_15038_ net673 _09232_ VSS VSS VDD VDD _09233_ sky130_fd_sc_hd__nor2_1
X_15039_ u_core.u_top.u_core.acc[43] _09233_ VSS VSS VDD VDD u_core.u_top.u_core.acc_upd[43] sky130_fd_sc_hd__xor2_1
X_15040_ u_core.u_top.u_core.acc[42] _03440_ VSS VSS VDD VDD _09234_ sky130_fd_sc_hd__xnor2_1
X_15041_ _03442_ u_core.u_top.u_core.acc[42] VSS VSS VDD VDD _09235_ sky130_fd_sc_hd__xnor2_1
X_15042_ _09216_ _09234_ _09235_ _09213_ VSS VSS VDD VDD _09236_ sky130_fd_sc_hd__o22a_1
X_15043_ net673 _09218_ u_core.u_top.u_core.acc[42] VSS VSS VDD VDD _09237_ sky130_fd_sc_hd__o21ai_0
X_15044_ net673 _09236_ _09237_ VSS VSS VDD VDD u_core.u_top.u_core.acc_upd[42] sky130_fd_sc_hd__o21ai_0
X_15045_ _0938_[1] net708 VSS VSS VDD VDD _09238_ sky130_fd_sc_hd__xnor2_1
X_15046_ net841 _09207_ _09238_ VSS VSS VDD VDD _09239_ sky130_fd_sc_hd__mux2i_1
X_15047_ _03439_ _09219_ _09239_ net673 VSS VSS VDD VDD u_core.u_top.u_core.acc_upd[41] sky130_fd_sc_hd__o22ai_1
X_15049_ _0422_ net842 VSS VSS VDD VDD _09241_ sky130_fd_sc_hd__nor2b_1
X_15050_ _0422_ _09241_ net710 VSS VSS VDD VDD _09242_ sky130_fd_sc_hd__mux2i_1
X_15052_ u_core.u_top.u_core.acc[34] VSS VSS VDD VDD _09244_ sky130_fd_sc_hd__inv_1
X_15053_ u_core.u_top.u_core.acc[33] u_core.u_top.u_core.acc[32] _03345_ VSS VSS VDD VDD _09245_ sky130_fd_sc_hd__nand3_1
X_15054_ _09244_ _09245_ VSS VSS VDD VDD _09246_ sky130_fd_sc_hd__nor2_1
X_15055_ u_core.u_top.u_core.acc[35] u_core.u_top.u_core.acc[37] u_core.u_top.u_core.acc[36] _09246_ VSS VSS VDD VDD _09247_ sky130_fd_sc_hd__nand4_1
X_15056_ _09241_ _0422_ net710 VSS VSS VDD VDD _09248_ sky130_fd_sc_hd__mux2i_1
X_15057_ u_core.u_top.u_core.acc[33] u_core.u_top.u_core.acc[32] VSS VSS VDD VDD _09249_ sky130_fd_sc_hd__nor2_1
X_15058_ _03344_ _09249_ VSS VSS VDD VDD _09250_ sky130_fd_sc_hd__nand2_1
X_15059_ u_core.u_top.u_core.acc[34] _09250_ VSS VSS VDD VDD _09251_ sky130_fd_sc_hd__nor2_1
X_15060_ u_core.u_top.u_core.acc[35] u_core.u_top.u_core.acc[36] VSS VSS VDD VDD _09252_ sky130_fd_sc_hd__nor2_1
X_15061_ u_core.u_top.u_core.acc[37] _09251_ _09252_ VSS VSS VDD VDD _09253_ sky130_fd_sc_hd__nand3b_1
X_15062_ net689 _09247_ _09248_ _09253_ u_core.u_top.u_core.acc[38] VSS VSS VDD VDD _09254_ sky130_fd_sc_hd__o221a_2
X_15063_ _0422_ _09241_ net710 VSS VSS VDD VDD _09255_ sky130_fd_sc_hd__mux2_1
X_15064_ _09241_ _0422_ net710 VSS VSS VDD VDD _09256_ sky130_fd_sc_hd__mux2_1
X_15065_ _09255_ _09247_ _09256_ _09253_ u_core.u_top.u_core.acc[38] VSS VSS VDD VDD _09257_ sky130_fd_sc_hd__a221oi_1
X_15066_ _0422_ net842 VSS VSS VDD VDD _09258_ sky130_fd_sc_hd__nor2_1
X_15067_ net670 _09258_ VSS VSS VDD VDD _09259_ sky130_fd_sc_hd__nor2_1
X_15068_ net670 _09254_ _09257_ _09259_ u_core.u_top.u_core.acc[38] VSS VSS VDD VDD u_core.u_top.u_core.acc_upd[38] sky130_fd_sc_hd__o32a_1
X_15069_ u_core.u_top.u_core.acc[31] VSS VSS VDD VDD _02969_ sky130_fd_sc_hd__inv_1
X_15070_ _0932_[0] _09244_ _02969_ _09249_ VSS VSS VDD VDD _09260_ sky130_fd_sc_hd__nand4_1
X_15071_ u_core.u_top.u_core.acc[35] u_core.u_top.u_core.acc[36] _09260_ VSS VSS VDD VDD _09261_ sky130_fd_sc_hd__or3_1
X_15072_ _09261_ VSS VSS VDD VDD _09262_ sky130_fd_sc_hd__inv_1
X_15073_ u_core.u_top.u_core.acc[35] u_core.u_top.u_core.acc[36] VSS VSS VDD VDD _09263_ sky130_fd_sc_hd__nand2_1
X_15074_ _0932_[0] _02969_ VSS VSS VDD VDD _09264_ sky130_fd_sc_hd__nor2_1
X_15075_ u_core.u_top.u_core.acc[33] u_core.u_top.u_core.acc[34] u_core.u_top.u_core.acc[32] _09264_ VSS VSS VDD VDD _09265_ sky130_fd_sc_hd__nand4_1
X_15076_ _09263_ _09265_ VSS VSS VDD VDD _09266_ sky130_fd_sc_hd__nor2_1
X_15077_ _09248_ _09262_ _09266_ net689 VSS VSS VDD VDD _09267_ sky130_fd_sc_hd__o22ai_1
X_15078_ _09256_ _09262_ _09266_ _09255_ VSS VSS VDD VDD _09268_ sky130_fd_sc_hd__a22oi_1
X_15079_ u_core.u_top.u_core.acc[37] _09268_ VSS VSS VDD VDD _09269_ sky130_fd_sc_hd__nand2_1
X_15080_ u_core.u_top.u_core.acc[37] _09267_ _09269_ VSS VSS VDD VDD _09270_ sky130_fd_sc_hd__o21ai_0
X_15081_ u_core.u_top.u_core.acc[37] _09259_ _09270_ net670 VSS VSS VDD VDD u_core.u_top.u_core.acc_upd[37] sky130_fd_sc_hd__o22a_1
X_15082_ u_core.u_top.u_core.acc[36] _09255_ _09246_ VSS VSS VDD VDD _09271_ sky130_fd_sc_hd__nand3_1
X_15083_ u_core.u_top.u_core.acc[36] _09248_ _09271_ VSS VSS VDD VDD _09272_ sky130_fd_sc_hd__o21ai_0
X_15084_ net689 _09246_ _09248_ _09251_ VSS VSS VDD VDD _09273_ sky130_fd_sc_hd__o22a_1
X_15085_ u_core.u_top.u_core.acc[36] net689 VSS VSS VDD VDD _09274_ sky130_fd_sc_hd__nor2_1
X_15086_ u_core.u_top.u_core.acc[36] _09256_ _09251_ _09274_ VSS VSS VDD VDD _09275_ sky130_fd_sc_hd__a31oi_1
X_15087_ u_core.u_top.u_core.acc[36] _09273_ _09275_ u_core.u_top.u_core.acc[35] VSS VSS VDD VDD _09276_ sky130_fd_sc_hd__o22ai_1
X_15088_ u_core.u_top.u_core.acc[35] _09272_ _09276_ VSS VSS VDD VDD _09277_ sky130_fd_sc_hd__a21oi_1
X_15089_ u_core.u_top.u_core.acc[36] _09259_ _09277_ net670 VSS VSS VDD VDD u_core.u_top.u_core.acc_upd[36] sky130_fd_sc_hd__o22a_1
X_15090_ _09248_ _09260_ _09265_ net689 u_core.u_top.u_core.acc[35] VSS VSS VDD VDD _09278_ sky130_fd_sc_hd__o221a_2
X_15091_ _09256_ _09260_ _09265_ _09255_ u_core.u_top.u_core.acc[35] VSS VSS VDD VDD _09279_ sky130_fd_sc_hd__a221oi_1
X_15092_ net670 _09278_ _09279_ _09259_ u_core.u_top.u_core.acc[35] VSS VSS VDD VDD u_core.u_top.u_core.acc_upd[35] sky130_fd_sc_hd__o32a_1
X_15093_ _09250_ _09245_ net710 VSS VSS VDD VDD _09280_ sky130_fd_sc_hd__mux2i_1
X_15094_ _03344_ net710 _09249_ VSS VSS VDD VDD _09281_ sky130_fd_sc_hd__nand3_1
X_15095_ net710 _09245_ _09281_ VSS VSS VDD VDD _09282_ sky130_fd_sc_hd__o21ai_0
X_15096_ _09241_ _09280_ _09282_ _0422_ VSS VSS VDD VDD _09283_ sky130_fd_sc_hd__a22oi_1
X_15097_ net675 _09283_ VSS VSS VDD VDD _09284_ sky130_fd_sc_hd__nor2_1
X_15098_ _09244_ _09284_ VSS VSS VDD VDD u_core.u_top.u_core.acc_upd[34] sky130_fd_sc_hd__xnor2_1
X_15099_ _0932_[0] _02969_ VSS VSS VDD VDD _09285_ sky130_fd_sc_hd__nand2_1
X_15100_ u_core.u_top.u_core.acc[32] _09248_ _09285_ VSS VSS VDD VDD _09286_ sky130_fd_sc_hd__nor3_1
X_15101_ u_core.u_top.u_core.acc[32] _09255_ _09264_ _09286_ VSS VSS VDD VDD _09287_ sky130_fd_sc_hd__a31oi_1
X_15102_ net670 _09287_ VSS VSS VDD VDD _09288_ sky130_fd_sc_hd__nor2_1
X_15103_ u_core.u_top.u_core.acc[33] _09288_ VSS VSS VDD VDD u_core.u_top.u_core.acc_upd[33] sky130_fd_sc_hd__xor2_1
X_15104_ _03345_ net689 _09248_ _03344_ u_core.u_top.u_core.acc[32] VSS VSS VDD VDD _09289_ sky130_fd_sc_hd__o221ai_1
X_15105_ _03345_ _09255_ _09256_ _03344_ u_core.u_top.u_core.acc[32] VSS VSS VDD VDD _09290_ sky130_fd_sc_hd__a221o_1
X_15106_ _09289_ _09290_ VSS VSS VDD VDD _09291_ sky130_fd_sc_hd__nand2_1
X_15107_ net670 _09258_ u_core.u_top.u_core.acc[32] VSS VSS VDD VDD _09292_ sky130_fd_sc_hd__o21ai_0
X_15108_ net670 _09291_ _09292_ VSS VSS VDD VDD u_core.u_top.u_core.acc_upd[32] sky130_fd_sc_hd__o21ai_0
X_15109_ _0932_[1] VSS VSS VDD VDD _09293_ sky130_fd_sc_hd__inv_1
X_15110_ _02971_ _09293_ net710 VSS VSS VDD VDD _09294_ sky130_fd_sc_hd__mux2i_1
X_15111_ net670 _09294_ net842 VSS VSS VDD VDD _09295_ sky130_fd_sc_hd__o21ai_0
X_15112_ net842 _02969_ _09295_ VSS VSS VDD VDD _09296_ sky130_fd_sc_hd__o21ai_0
X_15113_ _02971_ net710 VSS VSS VDD VDD _09297_ sky130_fd_sc_hd__nand2_1
X_15114_ _0932_[1] net710 _09297_ VSS VSS VDD VDD _09298_ sky130_fd_sc_hd__o21ai_0
X_15115_ _0422_ net676 _09298_ VSS VSS VDD VDD _09299_ sky130_fd_sc_hd__nand3_1
X_15116_ u_core.u_top.u_core.acc[31] net676 _09296_ _0422_ _09299_ VSS VSS VDD VDD _02481_ sky130_fd_sc_hd__o221ai_1
X_15117_ _02481_ VSS VSS VDD VDD u_core.u_top.u_core.acc_upd[31] sky130_fd_sc_hd__inv_1
X_15119_ u_core.u_top.u_core.acc[28] VSS VSS VDD VDD _09301_ sky130_fd_sc_hd__inv_1
X_15121_ u_core.u_top.u_core.acc[22] u_core.u_top.u_core.acc[23] VSS VSS VDD VDD _09303_ sky130_fd_sc_hd__nor2_1
X_15122_ _03042_ _09303_ VSS VSS VDD VDD _09304_ sky130_fd_sc_hd__nand2_1
X_15124_ u_core.u_top.u_core.acc[26] u_core.u_top.u_core.acc[25] u_core.u_top.u_core.acc[27] VSS VSS VDD VDD _09306_ sky130_fd_sc_hd__or3_1
X_15125_ u_core.u_top.u_core.acc[24] _09304_ _09306_ VSS VSS VDD VDD _09307_ sky130_fd_sc_hd__nor3_1
X_15126_ u_core.u_top.u_core.acc[28] _09307_ VSS VSS VDD VDD _09308_ sky130_fd_sc_hd__xnor2_1
X_15127_ u_core.u_top.u_core.acc[22] _03044_ u_core.u_top.u_core.acc[23] VSS VSS VDD VDD _09309_ sky130_fd_sc_hd__nand3_1
X_15129_ u_core.u_top.u_core.acc[25] u_core.u_top.u_core.acc[24] VSS VSS VDD VDD _09311_ sky130_fd_sc_hd__nand2_1
X_15130_ _09309_ _09311_ VSS VSS VDD VDD _09312_ sky130_fd_sc_hd__nor2_1
X_15131_ u_core.u_top.u_core.acc[26] u_core.u_top.u_core.acc[27] _09312_ VSS VSS VDD VDD _09313_ sky130_fd_sc_hd__nand3_1
X_15132_ _09301_ _09313_ VSS VSS VDD VDD _09314_ sky130_fd_sc_hd__xnor2_1
X_15133_ _09308_ _09314_ net710 VSS VSS VDD VDD _09315_ sky130_fd_sc_hd__mux2i_1
X_15134_ net843 _09315_ VSS VSS VDD VDD _09316_ sky130_fd_sc_hd__nand2_1
X_15135_ _09301_ net843 net675 _09316_ VSS VSS VDD VDD _09317_ sky130_fd_sc_hd__o22a_1
X_15136_ _09314_ _09308_ net710 VSS VSS VDD VDD _09318_ sky130_fd_sc_hd__mux2i_1
X_15137_ _09301_ net676 VSS VSS VDD VDD _09319_ sky130_fd_sc_hd__nor2_1
X_15138_ net844 net676 _09318_ _09319_ VSS VSS VDD VDD _09320_ sky130_fd_sc_hd__a31oi_1
X_15139_ net844 _09317_ _09320_ VSS VSS VDD VDD u_core.u_top.u_core.acc_upd[28] sky130_fd_sc_hd__o21ai_0
X_15140_ u_core.u_top.u_core.acc[22] u_core.u_top.u_core.acc[23] VSS VSS VDD VDD _09321_ sky130_fd_sc_hd__nand2_1
X_15141_ u_core.u_top.u_core.acc[20] u_core.u_top.u_core.acc[24] u_core.u_top.u_core.acc[21] VSS VSS VDD VDD _09322_ sky130_fd_sc_hd__nand3_1
X_15142_ _09321_ _09322_ VSS VSS VDD VDD _09323_ sky130_fd_sc_hd__nor2_1
X_15143_ u_core.u_top.u_core.acc[26] u_core.u_top.u_core.acc[25] _09323_ VSS VSS VDD VDD _09324_ sky130_fd_sc_hd__nand3_1
X_15144_ net844 net710 VSS VSS VDD VDD _09325_ sky130_fd_sc_hd__xor2_1
X_15145_ net844 net843 net676 VSS VSS VDD VDD _09326_ sky130_fd_sc_hd__o21ai_0
X_15146_ _09324_ _09325_ _09326_ VSS VSS VDD VDD _09327_ sky130_fd_sc_hd__a21oi_1
X_15147_ u_core.u_top.u_core.acc[26] u_core.u_top.u_core.acc[25] VSS VSS VDD VDD _09328_ sky130_fd_sc_hd__nor2_1
X_15148_ _0926_[0] _03041_ VSS VSS VDD VDD _09329_ sky130_fd_sc_hd__nand2_1
X_15149_ u_core.u_top.u_core.acc[22] u_core.u_top.u_core.acc[23] u_core.u_top.u_core.acc[24] _09329_ VSS VSS VDD VDD _09330_ sky130_fd_sc_hd__nor4_1
X_15150_ _09328_ _09330_ VSS VSS VDD VDD _09331_ sky130_fd_sc_hd__nand2_1
X_15151_ u_core.u_top.u_core.acc[27] _09331_ VSS VSS VDD VDD _09332_ sky130_fd_sc_hd__xnor2_1
X_15152_ u_core.u_top.u_core.acc[26] u_core.u_top.u_core.acc[25] u_core.u_top.u_core.acc[27] _09323_ VSS VSS VDD VDD _09333_ sky130_fd_sc_hd__nand4_1
X_15153_ _09332_ _09333_ net710 VSS VSS VDD VDD _09334_ sky130_fd_sc_hd__mux2i_1
X_15154_ net844 net843 VSS VSS VDD VDD _09335_ sky130_fd_sc_hd__nor2b_1
X_15155_ _09333_ _09332_ net710 VSS VSS VDD VDD _09336_ sky130_fd_sc_hd__mux2i_1
X_15156_ _09334_ _09335_ _09336_ net844 VSS VSS VDD VDD _09337_ sky130_fd_sc_hd__a22oi_1
X_15157_ u_core.u_top.u_core.acc[27] _09327_ _09337_ net675 VSS VSS VDD VDD u_core.u_top.u_core.acc_upd[27] sky130_fd_sc_hd__o22a_1
X_15158_ net844 _09335_ net710 VSS VSS VDD VDD _09338_ sky130_fd_sc_hd__mux2i_1
X_15159_ _09335_ net844 net710 VSS VSS VDD VDD _09339_ sky130_fd_sc_hd__mux2i_1
X_15160_ u_core.u_top.u_core.acc[25] u_core.u_top.u_core.acc[24] _09304_ VSS VSS VDD VDD _09340_ sky130_fd_sc_hd__nor3_1
X_15161_ _09312_ _09338_ _09339_ _09340_ VSS VSS VDD VDD _09341_ sky130_fd_sc_hd__o22ai_1
X_15162_ net844 _09335_ net710 VSS VSS VDD VDD _09342_ sky130_fd_sc_hd__mux2_1
X_15163_ _09335_ net844 net710 VSS VSS VDD VDD _09343_ sky130_fd_sc_hd__mux2_1
X_15164_ _09312_ _09342_ _09343_ _09340_ VSS VSS VDD VDD _09344_ sky130_fd_sc_hd__a22oi_1
X_15165_ u_core.u_top.u_core.acc[26] net675 _09344_ VSS VSS VDD VDD _09345_ sky130_fd_sc_hd__nor3_1
X_15166_ u_core.u_top.u_core.acc[26] net679 _09341_ _09345_ VSS VSS VDD VDD _09346_ sky130_fd_sc_hd__a31oi_1
X_15167_ u_core.u_top.u_core.acc[26] _09326_ VSS VSS VDD VDD _09347_ sky130_fd_sc_hd__nand2_1
X_15168_ _09346_ _09347_ VSS VSS VDD VDD u_core.u_top.u_core.acc_upd[26] sky130_fd_sc_hd__nand2_1
X_15169_ _09323_ _09338_ _09339_ _09330_ u_core.u_top.u_core.acc[25] VSS VSS VDD VDD _09348_ sky130_fd_sc_hd__o221ai_1
X_15170_ _09323_ _09342_ _09343_ _09330_ u_core.u_top.u_core.acc[25] VSS VSS VDD VDD _09349_ sky130_fd_sc_hd__a221o_1
X_15171_ net679 _09348_ _09349_ _09326_ u_core.u_top.u_core.acc[25] VSS VSS VDD VDD u_core.u_top.u_core.acc_upd[25] sky130_fd_sc_hd__a32o_1
X_15172_ _09309_ _09338_ _09339_ _09304_ u_core.u_top.u_core.acc[24] VSS VSS VDD VDD _09350_ sky130_fd_sc_hd__o221ai_1
X_15173_ _09309_ _09342_ _09343_ _09304_ u_core.u_top.u_core.acc[24] VSS VSS VDD VDD _09351_ sky130_fd_sc_hd__a221o_1
X_15174_ net844 net843 VSS VSS VDD VDD _09352_ sky130_fd_sc_hd__nor2_1
X_15175_ net675 _09352_ VSS VSS VDD VDD _09353_ sky130_fd_sc_hd__nor2_1
X_15176_ u_core.u_top.u_core.acc[24] _09353_ VSS VSS VDD VDD _09354_ sky130_fd_sc_hd__nor2_1
X_15177_ net679 _09350_ _09351_ _09354_ VSS VSS VDD VDD u_core.u_top.u_core.acc_upd[24] sky130_fd_sc_hd__a31oi_1
X_15178_ u_core.u_top.u_core.acc[22] u_core.u_top.u_core.acc[20] u_core.u_top.u_core.acc[21] _09342_ VSS VSS VDD VDD _09355_ sky130_fd_sc_hd__nand4_1
X_15179_ u_core.u_top.u_core.acc[22] _09329_ _09339_ VSS VSS VDD VDD _09356_ sky130_fd_sc_hd__or3_1
X_15180_ _09355_ _09356_ net675 VSS VSS VDD VDD _09357_ sky130_fd_sc_hd__a21oi_1
X_15181_ u_core.u_top.u_core.acc[23] _09357_ VSS VSS VDD VDD u_core.u_top.u_core.acc_upd[23] sky130_fd_sc_hd__xor2_1
X_15182_ _03044_ _09338_ _09339_ _03042_ u_core.u_top.u_core.acc[22] VSS VSS VDD VDD _09358_ sky130_fd_sc_hd__o221ai_1
X_15183_ _03044_ _09342_ _09343_ _03042_ u_core.u_top.u_core.acc[22] VSS VSS VDD VDD _09359_ sky130_fd_sc_hd__a221o_1
X_15184_ net679 _09358_ _09359_ _09326_ u_core.u_top.u_core.acc[22] VSS VSS VDD VDD u_core.u_top.u_core.acc_upd[22] sky130_fd_sc_hd__a32o_1
X_15185_ _0926_[1] net710 VSS VSS VDD VDD _09360_ sky130_fd_sc_hd__xnor2_1
X_15186_ net844 _09335_ _09360_ VSS VSS VDD VDD _09361_ sky130_fd_sc_hd__mux2i_1
X_15187_ _03041_ _09353_ _09361_ net675 VSS VSS VDD VDD u_core.u_top.u_core.acc_upd[21] sky130_fd_sc_hd__o22ai_1
X_15188_ net846 net845 VSS VSS VDD VDD _09362_ sky130_fd_sc_hd__nor2b_1
X_15190_ _09362_ net846 net708 VSS VSS VDD VDD _09364_ sky130_fd_sc_hd__mux2_1
X_15191_ u_core.u_top.u_core.acc[13] u_core.u_top.u_core.acc[12] VSS VSS VDD VDD _09365_ sky130_fd_sc_hd__nor2_1
X_15192_ _03475_ _09365_ VSS VSS VDD VDD _09366_ sky130_fd_sc_hd__nand2_1
X_15193_ u_core.u_top.u_core.acc[15] u_core.u_top.u_core.acc[14] _09366_ VSS VSS VDD VDD _09367_ sky130_fd_sc_hd__or3_1
X_15194_ u_core.u_top.u_core.acc[17] u_core.u_top.u_core.acc[16] _09367_ VSS VSS VDD VDD _09368_ sky130_fd_sc_hd__nor3_1
X_15195_ u_core.u_top.u_core.acc[18] _09368_ VSS VSS VDD VDD _09369_ sky130_fd_sc_hd__xnor2_1
X_15196_ u_core.u_top.u_core.acc[13] u_core.u_top.u_core.acc[12] _03476_ VSS VSS VDD VDD _09370_ sky130_fd_sc_hd__nand3_1
X_15197_ u_core.u_top.u_core.acc[15] u_core.u_top.u_core.acc[14] VSS VSS VDD VDD _09371_ sky130_fd_sc_hd__nand2_1
X_15198_ _09370_ _09371_ VSS VSS VDD VDD _09372_ sky130_fd_sc_hd__or2_2
X_15199_ u_core.u_top.u_core.acc[17] u_core.u_top.u_core.acc[16] VSS VSS VDD VDD _09373_ sky130_fd_sc_hd__nand2_1
X_15200_ _09372_ _09373_ VSS VSS VDD VDD _09374_ sky130_fd_sc_hd__nor2_1
X_15201_ u_core.u_top.u_core.acc[18] _09374_ VSS VSS VDD VDD _09375_ sky130_fd_sc_hd__xnor2_1
X_15202_ net846 _09362_ net708 VSS VSS VDD VDD _09376_ sky130_fd_sc_hd__mux2_1
X_15203_ _09364_ _09369_ _09375_ _09376_ VSS VSS VDD VDD _09377_ sky130_fd_sc_hd__a22oi_1
X_15204_ net846 net845 VSS VSS VDD VDD _09378_ sky130_fd_sc_hd__nor2_1
X_15205_ net674 _09378_ VSS VSS VDD VDD _09379_ sky130_fd_sc_hd__nor2_1
X_15206_ net674 _09377_ _09379_ u_core.u_top.u_core.acc[18] VSS VSS VDD VDD u_core.u_top.u_core.acc_upd[18] sky130_fd_sc_hd__o22a_1
X_15207_ u_core.u_top.u_core.acc[14] u_core.u_top.u_core.acc[11] u_core.u_top.u_core.acc[10] VSS VSS VDD VDD _09380_ sky130_fd_sc_hd__nor3_1
X_15208_ _09365_ _09380_ VSS VSS VDD VDD _09381_ sky130_fd_sc_hd__nand2_1
X_15209_ u_core.u_top.u_core.acc[15] u_core.u_top.u_core.acc[16] _09381_ VSS VSS VDD VDD _09382_ sky130_fd_sc_hd__or3_1
X_15210_ u_core.u_top.u_core.acc[13] u_core.u_top.u_core.acc[12] VSS VSS VDD VDD _09383_ sky130_fd_sc_hd__nand2_1
X_15211_ u_core.u_top.u_core.acc[14] u_core.u_top.u_core.acc[11] u_core.u_top.u_core.acc[10] VSS VSS VDD VDD _09384_ sky130_fd_sc_hd__nand3_1
X_15212_ _09383_ _09384_ VSS VSS VDD VDD _09385_ sky130_fd_sc_hd__or2_2
X_15213_ _09385_ VSS VSS VDD VDD _09386_ sky130_fd_sc_hd__inv_1
X_15214_ u_core.u_top.u_core.acc[15] u_core.u_top.u_core.acc[16] _09386_ VSS VSS VDD VDD _09387_ sky130_fd_sc_hd__nand3_1
X_15215_ _09382_ _09387_ net711 VSS VSS VDD VDD _09388_ sky130_fd_sc_hd__mux2i_1
X_15216_ _09387_ _09382_ net711 VSS VSS VDD VDD _09389_ sky130_fd_sc_hd__mux2i_1
X_15217_ _09362_ _09388_ _09389_ net846 VSS VSS VDD VDD _09390_ sky130_fd_sc_hd__a22oi_1
X_15218_ net674 _09390_ VSS VSS VDD VDD _09391_ sky130_fd_sc_hd__nor2_1
X_15219_ u_core.u_top.u_core.acc[17] _09391_ VSS VSS VDD VDD u_core.u_top.u_core.acc_upd[17] sky130_fd_sc_hd__xor2_1
X_15220_ _09367_ _09372_ net707 VSS VSS VDD VDD _09392_ sky130_fd_sc_hd__mux2i_1
X_15221_ _09372_ _09367_ net707 VSS VSS VDD VDD _09393_ sky130_fd_sc_hd__mux2i_1
X_15222_ _09362_ _09392_ _09393_ net846 VSS VSS VDD VDD _09394_ sky130_fd_sc_hd__a22oi_1
X_15223_ net674 _09394_ VSS VSS VDD VDD _09395_ sky130_fd_sc_hd__nor2_1
X_15224_ u_core.u_top.u_core.acc[16] _09395_ VSS VSS VDD VDD u_core.u_top.u_core.acc_upd[16] sky130_fd_sc_hd__xor2_1
X_15225_ net846 _09362_ net708 VSS VSS VDD VDD _09396_ sky130_fd_sc_hd__mux2i_1
X_15226_ _09362_ net846 net708 VSS VSS VDD VDD _09397_ sky130_fd_sc_hd__mux2i_1
X_15227_ _09396_ _09385_ _09381_ _09397_ u_core.u_top.u_core.acc[15] VSS VSS VDD VDD _09398_ sky130_fd_sc_hd__o221a_2
X_15228_ _09376_ _09385_ _09381_ _09364_ u_core.u_top.u_core.acc[15] VSS VSS VDD VDD _09399_ sky130_fd_sc_hd__a221oi_1
X_15229_ net674 _09398_ _09399_ _09379_ u_core.u_top.u_core.acc[15] VSS VSS VDD VDD u_core.u_top.u_core.acc_upd[15] sky130_fd_sc_hd__o32a_1
X_15230_ _09366_ _09370_ net707 VSS VSS VDD VDD _09400_ sky130_fd_sc_hd__mux2i_1
X_15231_ _03475_ net707 _09365_ VSS VSS VDD VDD _09401_ sky130_fd_sc_hd__nand3_1
X_15232_ net707 _09370_ _09401_ VSS VSS VDD VDD _09402_ sky130_fd_sc_hd__o21ai_0
X_15233_ _09362_ _09400_ _09402_ net846 VSS VSS VDD VDD _09403_ sky130_fd_sc_hd__a22oi_1
X_15234_ net674 _09403_ VSS VSS VDD VDD _09404_ sky130_fd_sc_hd__nor2_1
X_15235_ u_core.u_top.u_core.acc[14] _09404_ VSS VSS VDD VDD u_core.u_top.u_core.acc_upd[14] sky130_fd_sc_hd__xor2_1
X_15236_ u_core.u_top.u_core.acc[12] u_core.u_top.u_core.acc[11] u_core.u_top.u_core.acc[10] _09376_ VSS VSS VDD VDD _09405_ sky130_fd_sc_hd__nand4_1
X_15237_ u_core.u_top.u_core.acc[12] u_core.u_top.u_core.acc[11] u_core.u_top.u_core.acc[10] _09397_ VSS VSS VDD VDD _09406_ sky130_fd_sc_hd__or4_1
X_15238_ _09405_ _09406_ net674 VSS VSS VDD VDD _09407_ sky130_fd_sc_hd__a21oi_1
X_15239_ u_core.u_top.u_core.acc[13] _09407_ VSS VSS VDD VDD u_core.u_top.u_core.acc_upd[13] sky130_fd_sc_hd__xor2_1
X_15240_ _03475_ _09397_ _09396_ _03476_ u_core.u_top.u_core.acc[12] VSS VSS VDD VDD _09408_ sky130_fd_sc_hd__o221ai_1
X_15241_ _03475_ _09364_ _09376_ _03476_ u_core.u_top.u_core.acc[12] VSS VSS VDD VDD _09409_ sky130_fd_sc_hd__a221o_1
X_15242_ _09408_ _09409_ VSS VSS VDD VDD _09410_ sky130_fd_sc_hd__nand2_1
X_15243_ net674 _09378_ u_core.u_top.u_core.acc[12] VSS VSS VDD VDD _09411_ sky130_fd_sc_hd__o21ai_0
X_15244_ net674 _09410_ _09411_ VSS VSS VDD VDD u_core.u_top.u_core.acc_upd[12] sky130_fd_sc_hd__o21ai_0
X_15245_ u_core.u_top.u_core.acc[11] VSS VSS VDD VDD _03459_ sky130_fd_sc_hd__inv_1
X_15246_ _0919_[1] VSS VSS VDD VDD _09412_ sky130_fd_sc_hd__inv_1
X_15247_ _03461_ _09412_ net711 VSS VSS VDD VDD _09413_ sky130_fd_sc_hd__mux2i_1
X_15248_ net674 _09413_ net845 VSS VSS VDD VDD _09414_ sky130_fd_sc_hd__o21ai_0
X_15249_ net845 _03459_ _09414_ VSS VSS VDD VDD _09415_ sky130_fd_sc_hd__o21ai_0
X_15250_ _03461_ net708 VSS VSS VDD VDD _09416_ sky130_fd_sc_hd__nand2_1
X_15251_ _0919_[1] net711 _09416_ VSS VSS VDD VDD _09417_ sky130_fd_sc_hd__o21ai_0
X_15252_ net846 net677 _09417_ VSS VSS VDD VDD _09418_ sky130_fd_sc_hd__nand3_1
X_15253_ u_core.u_top.u_core.acc[11] net677 _09415_ net846 _09418_ VSS VSS VDD VDD _02319_ sky130_fd_sc_hd__o221ai_1
X_15254_ _02319_ VSS VSS VDD VDD u_core.u_top.u_core.acc_upd[11] sky130_fd_sc_hd__inv_1
X_15255_ _0404_ net847 VSS VSS VDD VDD _09419_ sky130_fd_sc_hd__nor2b_1
X_15256_ _0404_ _09419_ net710 VSS VSS VDD VDD _09420_ sky130_fd_sc_hd__mux2i_1
X_15258_ u_core.u_top.u_core.acc[2] u_core.u_top.u_core.acc[3] _02861_ VSS VSS VDD VDD _09422_ sky130_fd_sc_hd__nand3_1
X_15259_ u_core.u_top.u_core.acc[5] u_core.u_top.u_core.acc[4] VSS VSS VDD VDD _09423_ sky130_fd_sc_hd__nand2_1
X_15260_ _09422_ _09423_ VSS VSS VDD VDD _09424_ sky130_fd_sc_hd__nor2_1
X_15261_ u_core.u_top.u_core.acc[6] u_core.u_top.u_core.acc[7] _09424_ VSS VSS VDD VDD _09425_ sky130_fd_sc_hd__and3_1
X_15262_ _09419_ _0404_ net711 VSS VSS VDD VDD _09426_ sky130_fd_sc_hd__mux2i_1
X_15263_ u_core.u_top.u_core.acc[2] u_core.u_top.u_core.acc[3] VSS VSS VDD VDD _09427_ sky130_fd_sc_hd__nor2_1
X_15264_ _02860_ _09427_ VSS VSS VDD VDD _09428_ sky130_fd_sc_hd__nand2_1
X_15265_ u_core.u_top.u_core.acc[5] u_core.u_top.u_core.acc[4] _09428_ VSS VSS VDD VDD _09429_ sky130_fd_sc_hd__or3_1
X_15266_ u_core.u_top.u_core.acc[6] u_core.u_top.u_core.acc[7] _09429_ VSS VSS VDD VDD _09430_ sky130_fd_sc_hd__nor3_1
X_15267_ net688 _09425_ _09426_ _09430_ u_core.u_top.u_core.acc[8] VSS VSS VDD VDD _09431_ sky130_fd_sc_hd__o221ai_1
X_15268_ _0404_ _09419_ net711 VSS VSS VDD VDD _09432_ sky130_fd_sc_hd__mux2_1
X_15269_ _09419_ _0404_ net711 VSS VSS VDD VDD _09433_ sky130_fd_sc_hd__mux2_1
X_15270_ _09432_ _09425_ _09433_ _09430_ u_core.u_top.u_core.acc[8] VSS VSS VDD VDD _09434_ sky130_fd_sc_hd__a221o_1
X_15271_ _0404_ net847 _06338_ VSS VSS VDD VDD _09435_ sky130_fd_sc_hd__o21ai_1
X_15272_ net678 _09431_ _09434_ net661 u_core.u_top.u_core.acc[8] VSS VSS VDD VDD u_core.u_top.u_core.acc_upd[8] sky130_fd_sc_hd__a32o_1
X_15273_ u_core.u_top.u_core.acc[4] u_core.u_top.u_core.acc[1] u_core.u_top.u_core.acc[0] _09427_ VSS VSS VDD VDD _09436_ sky130_fd_sc_hd__nor4b_1
X_15274_ u_core.u_top.u_core.acc[5] u_core.u_top.u_core.acc[6] VSS VSS VDD VDD _09437_ sky130_fd_sc_hd__nor2_1
X_15275_ _09436_ _09437_ VSS VSS VDD VDD _09438_ sky130_fd_sc_hd__and2_1
X_15276_ u_core.u_top.u_core.acc[2] u_core.u_top.u_core.acc[3] VSS VSS VDD VDD _09439_ sky130_fd_sc_hd__nand2_1
X_15277_ u_core.u_top.u_core.acc[4] u_core.u_top.u_core.acc[1] u_core.u_top.u_core.acc[0] VSS VSS VDD VDD _09440_ sky130_fd_sc_hd__nand3_1
X_15278_ _09439_ _09440_ VSS VSS VDD VDD _09441_ sky130_fd_sc_hd__nor2_1
X_15279_ u_core.u_top.u_core.acc[5] u_core.u_top.u_core.acc[6] _09441_ VSS VSS VDD VDD _09442_ sky130_fd_sc_hd__and3_1
X_15280_ _09426_ _09438_ _09442_ net688 u_core.u_top.u_core.acc[7] VSS VSS VDD VDD _09443_ sky130_fd_sc_hd__o221ai_1
X_15281_ _09433_ _09438_ _09442_ _09432_ u_core.u_top.u_core.acc[7] VSS VSS VDD VDD _09444_ sky130_fd_sc_hd__a221o_1
X_15282_ net678 _09443_ _09444_ net661 u_core.u_top.u_core.acc[7] VSS VSS VDD VDD u_core.u_top.u_core.acc_upd[7] sky130_fd_sc_hd__a32o_1
X_15283_ net688 _09424_ VSS VSS VDD VDD _09445_ sky130_fd_sc_hd__nor2_1
X_15284_ _09433_ _09429_ _09445_ VSS VSS VDD VDD _09446_ sky130_fd_sc_hd__a21oi_1
X_15285_ net674 _09446_ VSS VSS VDD VDD _09447_ sky130_fd_sc_hd__nor2_1
X_15286_ net661 _09447_ VSS VSS VDD VDD _09448_ sky130_fd_sc_hd__nor2_1
X_15287_ u_core.u_top.u_core.acc[6] _09448_ VSS VSS VDD VDD u_core.u_top.u_core.acc_upd[6] sky130_fd_sc_hd__xor2_1
X_15288_ _09426_ _09436_ _09441_ net688 u_core.u_top.u_core.acc[5] VSS VSS VDD VDD _09449_ sky130_fd_sc_hd__o221ai_1
X_15289_ _09433_ _09436_ _09441_ _09432_ u_core.u_top.u_core.acc[5] VSS VSS VDD VDD _09450_ sky130_fd_sc_hd__a221o_1
X_15290_ net678 _09449_ _09450_ net661 u_core.u_top.u_core.acc[5] VSS VSS VDD VDD u_core.u_top.u_core.acc_upd[5] sky130_fd_sc_hd__a32o_1
X_15291_ _02860_ _09427_ _09426_ VSS VSS VDD VDD _09451_ sky130_fd_sc_hd__a21oi_1
X_15292_ _09426_ _09428_ u_core.u_top.u_core.acc[4] VSS VSS VDD VDD _09452_ sky130_fd_sc_hd__o21ai_0
X_15293_ net688 _09422_ VSS VSS VDD VDD _09453_ sky130_fd_sc_hd__nor2_1
X_15294_ u_core.u_top.u_core.acc[4] net661 _09451_ _09452_ _09453_ VSS VSS VDD VDD _09454_ sky130_fd_sc_hd__o32ai_1
X_15295_ _09432_ _09422_ _09452_ VSS VSS VDD VDD _09455_ sky130_fd_sc_hd__nand3_1
X_15296_ u_core.u_top.u_core.acc[4] net674 _09454_ _09455_ VSS VSS VDD VDD u_core.u_top.u_core.acc_upd[4] sky130_fd_sc_hd__a22o_1
X_15297_ u_core.u_top.u_core.acc[3] _09433_ VSS VSS VDD VDD _09456_ sky130_fd_sc_hd__nand2_1
X_15298_ _02689_ u_core.u_top.u_core.acc[3] _0912_[0] net688 _09456_ VSS VSS VDD VDD _09457_ sky130_fd_sc_hd__o41ai_1
X_15299_ u_core.u_top.u_core.acc[1] u_core.u_top.u_core.acc[3] u_core.u_top.u_core.acc[0] _09426_ VSS VSS VDD VDD _09458_ sky130_fd_sc_hd__nor4_1
X_15300_ u_core.u_top.u_core.acc[3] _09432_ _09458_ VSS VSS VDD VDD _09459_ sky130_fd_sc_hd__a21oi_1
X_15301_ u_core.u_top.u_core.acc[1] u_core.u_top.u_core.acc[0] net688 VSS VSS VDD VDD _09460_ sky130_fd_sc_hd__a21oi_1
X_15302_ _02689_ _0912_[0] _09426_ VSS VSS VDD VDD _09461_ sky130_fd_sc_hd__a21oi_1
X_15303_ _09460_ _09461_ u_core.u_top.u_core.acc[3] VSS VSS VDD VDD _09462_ sky130_fd_sc_hd__o21ai_0
X_15304_ u_core.u_top.u_core.acc[2] _09459_ _09462_ VSS VSS VDD VDD _09463_ sky130_fd_sc_hd__o21ai_0
X_15305_ u_core.u_top.u_core.acc[2] _09457_ _09463_ VSS VSS VDD VDD _09464_ sky130_fd_sc_hd__a21oi_1
X_15306_ u_core.u_top.u_core.acc[3] net661 VSS VSS VDD VDD _09465_ sky130_fd_sc_hd__nand2_1
X_15307_ net672 _09464_ _09465_ VSS VSS VDD VDD u_core.u_top.u_core.acc_upd[3] sky130_fd_sc_hd__o21ai_0
X_15308_ _02861_ net688 _09426_ _02860_ u_core.u_top.u_core.acc[2] VSS VSS VDD VDD _09466_ sky130_fd_sc_hd__o221ai_1
X_15309_ _02861_ _09432_ _09433_ _02860_ u_core.u_top.u_core.acc[2] VSS VSS VDD VDD _09467_ sky130_fd_sc_hd__a221o_1
X_15310_ net678 _09466_ _09467_ net661 u_core.u_top.u_core.acc[2] VSS VSS VDD VDD u_core.u_top.u_core.acc_upd[2] sky130_fd_sc_hd__a32o_1
X_15311_ _0912_[1] net706 VSS VSS VDD VDD _09468_ sky130_fd_sc_hd__nand2_1
X_15312_ _02691_ net706 _09468_ VSS VSS VDD VDD _09469_ sky130_fd_sc_hd__o21ai_0
X_15313_ _0912_[1] net706 VSS VSS VDD VDD _09470_ sky130_fd_sc_hd__nor2_1
X_15314_ _02691_ net706 _09470_ VSS VSS VDD VDD _09471_ sky130_fd_sc_hd__a21oi_1
X_15315_ _09419_ _09469_ _09471_ _0404_ VSS VSS VDD VDD _09472_ sky130_fd_sc_hd__a22oi_1
X_15316_ net675 _09472_ VSS VSS VDD VDD _09473_ sky130_fd_sc_hd__nor2_1
X_15317_ u_core.u_top.u_core.acc[1] net661 _09473_ VSS VSS VDD VDD _02460_ sky130_fd_sc_hd__a21oi_1
X_15318_ _02460_ VSS VSS VDD VDD u_core.u_top.u_core.acc_upd[1] sky130_fd_sc_hd__inv_1
X_15320_ net999 u_core.u_actl.st[9] VSS VSS VDD VDD _09475_ sky130_fd_sc_hd__nor2_2
X_15321_ u_core.u_actl.st[2] u_core.u_actl.st[9] VSS VSS VDD VDD _09476_ sky130_fd_sc_hd__or2_2
X_15324_ u_core.u_actl.op[0] u_core.u_actl.op[1] u_core.u_actl.op[2] VSS VSS VDD VDD _09479_ sky130_fd_sc_hd__a21oi_2
X_15325_ net39 _09479_ VSS VSS VDD VDD _09480_ sky130_fd_sc_hd__nand2_1
X_15326_ u_core.u_actl.op[0] u_core.u_actl.op[1] VSS VSS VDD VDD _09481_ sky130_fd_sc_hd__nand2_1
X_15327_ u_core.u_actl.op[2] _09481_ VSS VSS VDD VDD _09482_ sky130_fd_sc_hd__nand2b_1
X_15328_ net36 _09482_ VSS VSS VDD VDD _09483_ sky130_fd_sc_hd__nand2_1
X_15329_ _09476_ _09480_ _09483_ VSS VSS VDD VDD _09484_ sky130_fd_sc_hd__and3_1
X_15330_ net41 _09475_ _09484_ VSS VSS VDD VDD _09485_ sky130_fd_sc_hd__a21oi_2
X_15331_ net40 _09479_ VSS VSS VDD VDD _09486_ sky130_fd_sc_hd__nand2_1
X_15332_ net37 _09482_ VSS VSS VDD VDD _09487_ sky130_fd_sc_hd__nand2_1
X_15333_ _09476_ _09486_ _09487_ VSS VSS VDD VDD _09488_ sky130_fd_sc_hd__and3_1
X_15334_ _0684_[1] _09475_ _09488_ VSS VSS VDD VDD _09489_ sky130_fd_sc_hd__a21oi_2
X_15335_ net41 net43 net42 VSS VSS VDD VDD _09490_ sky130_fd_sc_hd__nand3_1
X_15336_ _09476_ _09490_ VSS VSS VDD VDD _09491_ sky130_fd_sc_hd__nor2_1
X_15337_ _0694_[3] _09476_ _09482_ _09491_ VSS VSS VDD VDD _09492_ sky130_fd_sc_hd__a31oi_1
X_15338_ net43 _03054_ VSS VSS VDD VDD _09493_ sky130_fd_sc_hd__xor2_1
X_15339_ _0694_[2] _09482_ VSS VSS VDD VDD _09494_ sky130_fd_sc_hd__nand2_1
X_15340_ _09476_ _09486_ _09494_ VSS VSS VDD VDD _09495_ sky130_fd_sc_hd__nand3_1
X_15341_ _09476_ _09493_ _09495_ VSS VSS VDD VDD _09496_ sky130_fd_sc_hd__o21ai_1
X_15342_ net794 net736 VSS VSS VDD VDD _09497_ sky130_fd_sc_hd__and2_1
X_15343_ _09485_ _09489_ _09497_ VSS VSS VDD VDD _0687_[0] sky130_fd_sc_hd__nand3b_1
X_15344_ u_core.u_actl.cnt[0] VSS VSS VDD VDD _0699_[0] sky130_fd_sc_hd__inv_1
X_15345_ u_core.u_top.u_core.d_acc[160] VSS VSS VDD VDD _0311_[0] sky130_fd_sc_hd__inv_1
X_15346_ _02520_ _06224_ _03325_ VSS VSS VDD VDD _09498_ sky130_fd_sc_hd__o21ai_0
X_15347_ _03324_ _09498_ VSS VSS VDD VDD _09499_ sky130_fd_sc_hd__nand2b_1
X_15348_ _03416_ _09499_ _03415_ VSS VSS VDD VDD _09500_ sky130_fd_sc_hd__a21oi_1
X_15349_ _02508_ _09500_ VSS VSS VDD VDD _0226_[8] sky130_fd_sc_hd__xnor2_1
X_15350_ _02725_ _06222_ VSS VSS VDD VDD _0226_[4] sky130_fd_sc_hd__xor2_1
X_15351_ u_core.arr_sa_p[20] VSS VSS VDD VDD _0617_ sky130_fd_sc_hd__inv_1
X_15353_ net994 u_core.u_top.u_core.d_acc[19] VSS VSS VDD VDD _09502_ sky130_fd_sc_hd__xnor2_1
X_15354_ _03159_ VSS VSS VDD VDD _09503_ sky130_fd_sc_hd__inv_1
X_15355_ u_core.u_top.u_core.d_acc[10] _02746_ _02804_ VSS VSS VDD VDD _09504_ sky130_fd_sc_hd__a21o_1
X_15356_ _02650_ _09504_ _02649_ VSS VSS VDD VDD _09505_ sky130_fd_sc_hd__a21oi_1
X_15357_ _06534_ _09505_ _06537_ VSS VSS VDD VDD _09506_ sky130_fd_sc_hd__o21ai_0
X_15358_ _02825_ _09506_ _02824_ VSS VSS VDD VDD _09507_ sky130_fd_sc_hd__a21oi_1
X_15359_ _06533_ _09507_ _02511_ VSS VSS VDD VDD _09508_ sky130_fd_sc_hd__o21bai_1
X_15360_ _02863_ _09508_ _02862_ VSS VSS VDD VDD _09509_ sky130_fd_sc_hd__a21oi_1
X_15361_ _09503_ _09509_ _03158_ VSS VSS VDD VDD _09510_ sky130_fd_sc_hd__o21bai_1
X_15362_ _03020_ _09510_ _03019_ VSS VSS VDD VDD _09511_ sky130_fd_sc_hd__a21oi_1
X_15363_ _09502_ _09511_ VSS VSS VDD VDD _0232_[9] sky130_fd_sc_hd__xnor2_1
X_15364_ _02512_ _09507_ VSS VSS VDD VDD _0232_[5] sky130_fd_sc_hd__xnor2_1
X_15365_ u_core.u_top.u_core.d_acc[20] VSS VSS VDD VDD _0238_[0] sky130_fd_sc_hd__inv_1
X_15366_ u_core.arr_sa_p[6] VSS VSS VDD VDD _0524_ sky130_fd_sc_hd__inv_1
X_15367_ _03026_ VSS VSS VDD VDD u_core.u_top.u_core.m72_t[4] sky130_fd_sc_hd__inv_1
X_15369_ _03368_ _08104_ VSS VSS VDD VDD _0264_[4] sky130_fd_sc_hd__xor2_1
X_15370_ _02303_ VSS VSS VDD VDD _09512_ sky130_fd_sc_hd__inv_1
X_15371_ _09512_ _03436_ _03435_ VSS VSS VDD VDD _09513_ sky130_fd_sc_hd__a21oi_1
X_15372_ _08092_ _09513_ _03297_ VSS VSS VDD VDD _09514_ sky130_fd_sc_hd__o21bai_1
X_15373_ _02806_ _09514_ _02805_ VSS VSS VDD VDD _09515_ sky130_fd_sc_hd__a21oi_1
X_15374_ _08091_ _09515_ VSS VSS VDD VDD _09516_ sky130_fd_sc_hd__nor2_1
X_15375_ _02818_ _09516_ VSS VSS VDD VDD _09517_ sky130_fd_sc_hd__nor2_1
X_15376_ _03241_ _09517_ VSS VSS VDD VDD _0238_[6] sky130_fd_sc_hd__xnor2_1
X_15377_ _02303_ _03436_ VSS VSS VDD VDD _0238_[2] sky130_fd_sc_hd__xnor2_1
X_15378_ u_core.u_actl.st[4] u_core.u_actl.st[10] VSS VSS VDD VDD _1006_ sky130_fd_sc_hd__or2_2
X_15379_ net987 VSS VSS VDD VDD _0731_[0] sky130_fd_sc_hd__inv_1
X_15380_ u_core.u_top.u_core.d_acc[150] _03004_ _03136_ VSS VSS VDD VDD _09518_ sky130_fd_sc_hd__a21o_1
X_15381_ _03138_ _09518_ _03137_ VSS VSS VDD VDD _09519_ sky130_fd_sc_hd__a21oi_1
X_15382_ _03146_ _09519_ VSS VSS VDD VDD _0306_[3] sky130_fd_sc_hd__xnor2_1
X_15383_ _02390_ VSS VSS VDD VDD _0306_[1] sky130_fd_sc_hd__inv_1
X_15384_ _02549_ _02409_ VSS VSS VDD VDD _0249_[2] sky130_fd_sc_hd__xnor2_1
X_15385_ net986 VSS VSS VDD VDD _02795_ sky130_fd_sc_hd__inv_1
X_15386_ _03163_ VSS VSS VDD VDD _09520_ sky130_fd_sc_hd__inv_1
X_15387_ _02895_ u_core.u_top.u_core.d_acc[180] _03434_ VSS VSS VDD VDD _09521_ sky130_fd_sc_hd__a21o_1
X_15388_ _03095_ _09521_ _03094_ VSS VSS VDD VDD _09522_ sky130_fd_sc_hd__a21oi_1
X_15389_ _09520_ _09522_ _03162_ VSS VSS VDD VDD _09523_ sky130_fd_sc_hd__o21bai_1
X_15390_ _03014_ _09523_ _03013_ VSS VSS VDD VDD _09524_ sky130_fd_sc_hd__a21oi_1
X_15391_ _02599_ _09524_ VSS VSS VDD VDD _0322_[5] sky130_fd_sc_hd__xnor2_1
X_15392_ _02750_ VSS VSS VDD VDD _09525_ sky130_fd_sc_hd__inv_1
X_15393_ _09525_ _06230_ _02749_ VSS VSS VDD VDD _09526_ sky130_fd_sc_hd__o21bai_1
X_15394_ _03102_ _09526_ _03101_ VSS VSS VDD VDD _09527_ sky130_fd_sc_hd__a21oi_1
X_15395_ _02831_ _09527_ VSS VSS VDD VDD _0294_[7] sky130_fd_sc_hd__xnor2_1
X_15396_ _03412_ _02393_ VSS VSS VDD VDD _0294_[2] sky130_fd_sc_hd__xnor2_1
X_15397_ _02474_ VSS VSS VDD VDD _0349_[1] sky130_fd_sc_hd__inv_1
X_15398_ u_core.u_top.bus_we _06599_ net866 VSS VSS VDD VDD _0296_ sky130_fd_sc_hd__and3_1
X_15399_ _03159_ _09509_ VSS VSS VDD VDD _0232_[7] sky130_fd_sc_hd__xnor2_1
X_15400_ u_core.u_top.u_core.acc_upd[61] VSS VSS VDD VDD _02477_ sky130_fd_sc_hd__inv_1
X_15401_ _02506_ _09505_ VSS VSS VDD VDD _0232_[3] sky130_fd_sc_hd__xnor2_1
X_15402_ u_core.arr_sa_n[20] VSS VSS VDD VDD _0615_ sky130_fd_sc_hd__inv_1
X_15403_ _02771_ _02397_ VSS VSS VDD VDD _0254_[2] sky130_fd_sc_hd__xnor2_1
X_15404_ u_core.u_top.u_core.acc[80] _08970_ VSS VSS VDD VDD _02535_ sky130_fd_sc_hd__xnor2_1
X_15405_ _03095_ _02358_ VSS VSS VDD VDD _0322_[2] sky130_fd_sc_hd__xnor2_1
X_15406_ u_core.u_top.u_core.acc[190] _08349_ VSS VSS VDD VDD _02493_ sky130_fd_sc_hd__xnor2_1
X_15407_ _02927_ VSS VSS VDD VDD _09528_ sky130_fd_sc_hd__inv_1
X_15408_ u_core.u_actl.cnt[4] u_core.u_actl.cnt[5] u_core.u_actl.cnt[2] u_core.u_actl.cnt[3] VSS VSS VDD VDD _09529_ sky130_fd_sc_hd__or4_1
X_15409_ u_core.u_actl.cnt[7] _09528_ u_core.u_actl.cnt[6] _09529_ VSS VSS VDD VDD _09530_ sky130_fd_sc_hd__nor4_1
X_15410_ u_core.u_actl.cnt[8] _09530_ VSS VSS VDD VDD _09531_ sky130_fd_sc_hd__nor2b_1
X_15411_ _09475_ _09531_ VSS VSS VDD VDD _09532_ sky130_fd_sc_hd__nor2_1
X_15412_ net999 _09532_ VSS VSS VDD VDD _09533_ sky130_fd_sc_hd__nor2_1
X_15414_ u_core.u_actl.cnt[6] _09529_ VSS VSS VDD VDD _09535_ sky130_fd_sc_hd__nor2_1
X_15415_ u_core.u_actl.cnt[1] u_core.u_actl.cnt[0] VSS VSS VDD VDD _09536_ sky130_fd_sc_hd__nor2_1
X_15416_ _09535_ _09536_ VSS VSS VDD VDD _09537_ sky130_fd_sc_hd__nand2_1
X_15417_ u_core.u_actl.cnt[7] _09537_ VSS VSS VDD VDD _09538_ sky130_fd_sc_hd__xnor2_1
X_15418_ net705 _09538_ VSS VSS VDD VDD _09539_ sky130_fd_sc_hd__nor2_1
X_15419_ net794 net705 _09539_ VSS VSS VDD VDD _1114_[7] sky130_fd_sc_hd__a21oi_1
X_15420_ _09528_ _09529_ VSS VSS VDD VDD _09540_ sky130_fd_sc_hd__nor2_1
X_15421_ u_core.u_actl.cnt[6] _09540_ VSS VSS VDD VDD _09541_ sky130_fd_sc_hd__xnor2_1
X_15422_ _09489_ net736 VSS VSS VDD VDD _09542_ sky130_fd_sc_hd__nor2_1
X_15423_ _09542_ VSS VSS VDD VDD _09543_ sky130_fd_sc_hd__inv_1
X_15425_ _09485_ net794 VSS VSS VDD VDD _09545_ sky130_fd_sc_hd__nand2b_1
X_15426_ _03211_ _09545_ VSS VSS VDD VDD _09546_ sky130_fd_sc_hd__nor2_1
X_15427_ _03211_ _09485_ _09546_ VSS VSS VDD VDD _09547_ sky130_fd_sc_hd__a21oi_1
X_15428_ _09489_ net736 VSS VSS VDD VDD _09548_ sky130_fd_sc_hd__nand2_1
X_15429_ net794 _09548_ VSS VSS VDD VDD _09549_ sky130_fd_sc_hd__nand2_1
X_15430_ _03211_ _09549_ VSS VSS VDD VDD _09550_ sky130_fd_sc_hd__nand2_1
X_15431_ _09543_ _09547_ _09550_ VSS VSS VDD VDD _09551_ sky130_fd_sc_hd__o21ai_0
X_15432_ net705 _09551_ VSS VSS VDD VDD _09552_ sky130_fd_sc_hd__nand2_1
X_15433_ net705 _09541_ _09552_ VSS VSS VDD VDD _1114_[6] sky130_fd_sc_hd__o21ai_0
X_15434_ u_core.u_actl.cnt[2] u_core.u_actl.cnt[3] VSS VSS VDD VDD _09553_ sky130_fd_sc_hd__nor2_1
X_15435_ u_core.u_actl.cnt[4] _09553_ _09536_ VSS VSS VDD VDD _09554_ sky130_fd_sc_hd__nand3b_1
X_15436_ u_core.u_actl.cnt[5] _09554_ VSS VSS VDD VDD _09555_ sky130_fd_sc_hd__xnor2_1
X_15437_ net705 _09555_ VSS VSS VDD VDD _09556_ sky130_fd_sc_hd__nor2_1
X_15438_ net794 net705 _09543_ _09556_ VSS VSS VDD VDD _1114_[5] sky130_fd_sc_hd__a31oi_1
X_15439_ _02927_ _09553_ VSS VSS VDD VDD _09557_ sky130_fd_sc_hd__nand2_1
X_15440_ u_core.u_actl.cnt[4] _09557_ VSS VSS VDD VDD _09558_ sky130_fd_sc_hd__xor2_1
X_15441_ _09489_ VSS VSS VDD VDD _09559_ sky130_fd_sc_hd__inv_1
X_15442_ _03211_ _09559_ _09545_ VSS VSS VDD VDD _09560_ sky130_fd_sc_hd__nor3_1
X_15443_ _03211_ _09559_ _09560_ VSS VSS VDD VDD _09561_ sky130_fd_sc_hd__a21oi_1
X_15444_ _09485_ net736 _09489_ VSS VSS VDD VDD _09562_ sky130_fd_sc_hd__o21ai_0
X_15445_ net794 _09562_ VSS VSS VDD VDD _09563_ sky130_fd_sc_hd__nand2_1
X_15446_ _03211_ _09563_ VSS VSS VDD VDD _09564_ sky130_fd_sc_hd__nand2_1
X_15447_ net736 _09561_ _09564_ VSS VSS VDD VDD _09565_ sky130_fd_sc_hd__o21ai_0
X_15448_ net705 _09565_ VSS VSS VDD VDD _09566_ sky130_fd_sc_hd__nand2_1
X_15449_ net705 _09558_ _09566_ VSS VSS VDD VDD _1114_[4] sky130_fd_sc_hd__o21ai_0
X_15450_ u_core.u_actl.cnt[1] u_core.u_actl.cnt[2] u_core.u_actl.cnt[0] VSS VSS VDD VDD _09567_ sky130_fd_sc_hd__nor3_1
X_15451_ u_core.u_actl.cnt[3] _09567_ VSS VSS VDD VDD _09568_ sky130_fd_sc_hd__xor2_1
X_15452_ net705 _09568_ VSS VSS VDD VDD _09569_ sky130_fd_sc_hd__nor2_1
X_15453_ _09497_ net705 _09569_ VSS VSS VDD VDD _1114_[3] sky130_fd_sc_hd__a21oi_1
X_15454_ _09485_ _09489_ VSS VSS VDD VDD _09570_ sky130_fd_sc_hd__nor2_1
X_15455_ _09497_ _09570_ VSS VSS VDD VDD _09571_ sky130_fd_sc_hd__nand2_1
X_15456_ _03211_ _09571_ VSS VSS VDD VDD _09572_ sky130_fd_sc_hd__xor2_1
X_15457_ _02927_ u_core.u_actl.cnt[2] VSS VSS VDD VDD _09573_ sky130_fd_sc_hd__xor2_1
X_15458_ net705 _09573_ VSS VSS VDD VDD _09574_ sky130_fd_sc_hd__nor2_1
X_15459_ net705 _09572_ _09574_ VSS VSS VDD VDD _1114_[2] sky130_fd_sc_hd__a21oi_1
X_15460_ _02928_ _03212_ net705 VSS VSS VDD VDD _1114_[1] sky130_fd_sc_hd__mux2i_1
X_15461_ _0699_[0] _0687_[0] net705 VSS VSS VDD VDD _1114_[0] sky130_fd_sc_hd__mux2_1
X_15463_ u_core.u_actl.st[5] u_core.u_actl.op[0] u_core.u_actl.op[2] u_core.u_actl.op[1] VSS VSS VDD VDD _1109_[1] sky130_fd_sc_hd__nor4_1
X_15464_ u_core.u_actl.st[5] u_core.u_actl.op[0] u_core.u_actl.op[2] u_core.u_actl.op[1] VSS VSS VDD VDD _1109_[0] sky130_fd_sc_hd__nor4b_1
X_15466_ u_core.u_actl.op[2] _09481_ VSS VSS VDD VDD _09577_ sky130_fd_sc_hd__nor2_4
X_15469_ u_core.u_actl.op[0] u_core.u_actl.op[1] VSS VSS VDD VDD _09580_ sky130_fd_sc_hd__nor2_1
X_15470_ u_core.u_actl.op[2] _09580_ VSS VSS VDD VDD _09581_ sky130_fd_sc_hd__nand2_2
X_15473_ u_core.u_actl.mn[22] net1038 VSS VSS VDD VDD _09584_ sky130_fd_sc_hd__nor2_1
X_15474_ u_core.u_actl.mn[22] net864 _09584_ VSS VSS VDD VDD _09585_ sky130_fd_sc_hd__a21oi_1
X_15475_ net997 _09585_ VSS VSS VDD VDD _1099_[22] sky130_fd_sc_hd__nor2_1
X_15476_ u_core.u_actl.mn[21] net1038 VSS VSS VDD VDD _09586_ sky130_fd_sc_hd__nor2_1
X_15477_ u_core.u_actl.mn[21] net864 _09586_ VSS VSS VDD VDD _09587_ sky130_fd_sc_hd__a21oi_1
X_15478_ net997 _09587_ VSS VSS VDD VDD _1099_[21] sky130_fd_sc_hd__nor2_1
X_15479_ u_core.u_actl.mn[20] net1038 VSS VSS VDD VDD _09588_ sky130_fd_sc_hd__nor2_1
X_15480_ u_core.u_actl.mn[20] net864 _09588_ VSS VSS VDD VDD _09589_ sky130_fd_sc_hd__a21oi_1
X_15481_ net997 _09589_ VSS VSS VDD VDD _1099_[20] sky130_fd_sc_hd__nor2_1
X_15482_ u_core.u_actl.mn[19] net1038 VSS VSS VDD VDD _09590_ sky130_fd_sc_hd__nor2_1
X_15483_ u_core.u_actl.mn[19] net864 _09590_ VSS VSS VDD VDD _09591_ sky130_fd_sc_hd__a21oi_1
X_15484_ net997 _09591_ VSS VSS VDD VDD _1099_[19] sky130_fd_sc_hd__nor2_1
X_15485_ u_core.u_actl.mn[18] net1038 VSS VSS VDD VDD _09592_ sky130_fd_sc_hd__nor2_1
X_15486_ u_core.u_actl.mn[18] net864 _09592_ VSS VSS VDD VDD _09593_ sky130_fd_sc_hd__a21oi_1
X_15487_ net997 _09593_ VSS VSS VDD VDD _1099_[18] sky130_fd_sc_hd__nor2_1
X_15488_ u_core.u_actl.mn[17] net1038 VSS VSS VDD VDD _09594_ sky130_fd_sc_hd__nor2_1
X_15489_ u_core.u_actl.mn[17] net864 _09594_ VSS VSS VDD VDD _09595_ sky130_fd_sc_hd__a21oi_1
X_15490_ net997 _09595_ VSS VSS VDD VDD _1099_[17] sky130_fd_sc_hd__nor2_1
X_15491_ u_core.u_actl.mn[16] net1038 VSS VSS VDD VDD _09596_ sky130_fd_sc_hd__nor2_1
X_15492_ u_core.u_actl.mn[16] net864 _09596_ VSS VSS VDD VDD _09597_ sky130_fd_sc_hd__a21oi_1
X_15493_ net997 _09597_ VSS VSS VDD VDD _1099_[16] sky130_fd_sc_hd__nor2_1
X_15494_ u_core.u_actl.mn[15] net1038 VSS VSS VDD VDD _09598_ sky130_fd_sc_hd__nor2_1
X_15495_ u_core.u_actl.mn[15] net864 _09598_ VSS VSS VDD VDD _09599_ sky130_fd_sc_hd__a21oi_1
X_15496_ net997 _09599_ VSS VSS VDD VDD _1099_[15] sky130_fd_sc_hd__nor2_1
X_15497_ u_core.u_actl.mn[14] net1038 VSS VSS VDD VDD _09600_ sky130_fd_sc_hd__nor2_1
X_15498_ u_core.u_actl.mn[14] net864 _09600_ VSS VSS VDD VDD _09601_ sky130_fd_sc_hd__a21oi_1
X_15499_ net997 _09601_ VSS VSS VDD VDD _1099_[14] sky130_fd_sc_hd__nor2_1
X_15501_ u_core.u_actl.mn[13] net1038 VSS VSS VDD VDD _09603_ sky130_fd_sc_hd__nor2_1
X_15502_ u_core.u_actl.mn[13] net864 _09603_ VSS VSS VDD VDD _09604_ sky130_fd_sc_hd__a21oi_1
X_15503_ net997 _09604_ VSS VSS VDD VDD _1099_[13] sky130_fd_sc_hd__nor2_1
X_15506_ u_core.u_actl.mn[12] net1038 VSS VSS VDD VDD _09607_ sky130_fd_sc_hd__nor2_1
X_15507_ u_core.u_actl.mn[12] net864 _09607_ VSS VSS VDD VDD _09608_ sky130_fd_sc_hd__a21oi_1
X_15508_ net997 _09608_ VSS VSS VDD VDD _1099_[12] sky130_fd_sc_hd__nor2_1
X_15509_ u_core.u_actl.mn[11] net1038 VSS VSS VDD VDD _09609_ sky130_fd_sc_hd__nor2_1
X_15510_ u_core.u_actl.mn[11] net864 _09609_ VSS VSS VDD VDD _09610_ sky130_fd_sc_hd__a21oi_1
X_15511_ net997 _09610_ VSS VSS VDD VDD _1099_[11] sky130_fd_sc_hd__nor2_1
X_15512_ u_core.u_actl.mn[10] net1038 VSS VSS VDD VDD _09611_ sky130_fd_sc_hd__nor2_1
X_15513_ u_core.u_actl.mn[10] net864 _09611_ VSS VSS VDD VDD _09612_ sky130_fd_sc_hd__a21oi_1
X_15514_ net997 _09612_ VSS VSS VDD VDD _1099_[10] sky130_fd_sc_hd__nor2_1
X_15515_ u_core.u_actl.mn[9] net1038 VSS VSS VDD VDD _09613_ sky130_fd_sc_hd__nor2_1
X_15516_ u_core.u_actl.mn[9] net864 _09613_ VSS VSS VDD VDD _09614_ sky130_fd_sc_hd__a21oi_1
X_15517_ net997 _09614_ VSS VSS VDD VDD _1099_[9] sky130_fd_sc_hd__nor2_1
X_15518_ u_core.u_actl.mn[8] net1038 VSS VSS VDD VDD _09615_ sky130_fd_sc_hd__nor2_1
X_15519_ u_core.u_actl.mn[8] net864 _09615_ VSS VSS VDD VDD _09616_ sky130_fd_sc_hd__a21oi_1
X_15520_ net997 _09616_ VSS VSS VDD VDD _1099_[8] sky130_fd_sc_hd__nor2_1
X_15521_ u_core.u_actl.mn[7] net1038 VSS VSS VDD VDD _09617_ sky130_fd_sc_hd__nor2_1
X_15522_ u_core.u_actl.mn[7] net864 _09617_ VSS VSS VDD VDD _09618_ sky130_fd_sc_hd__a21oi_1
X_15523_ net997 _09618_ VSS VSS VDD VDD _1099_[7] sky130_fd_sc_hd__nor2_1
X_15524_ u_core.u_actl.mn[6] net1038 VSS VSS VDD VDD _09619_ sky130_fd_sc_hd__nor2_1
X_15525_ u_core.u_actl.mn[6] net864 _09619_ VSS VSS VDD VDD _09620_ sky130_fd_sc_hd__a21oi_1
X_15526_ net997 _09620_ VSS VSS VDD VDD _1099_[6] sky130_fd_sc_hd__nor2_1
X_15527_ u_core.u_actl.mn[5] net1038 VSS VSS VDD VDD _09621_ sky130_fd_sc_hd__nor2_1
X_15528_ u_core.u_actl.mn[5] net864 _09621_ VSS VSS VDD VDD _09622_ sky130_fd_sc_hd__a21oi_1
X_15529_ net997 _09622_ VSS VSS VDD VDD _1099_[5] sky130_fd_sc_hd__nor2_1
X_15530_ u_core.u_actl.mn[4] net1038 VSS VSS VDD VDD _09623_ sky130_fd_sc_hd__nor2_1
X_15531_ u_core.u_actl.mn[4] net864 _09623_ VSS VSS VDD VDD _09624_ sky130_fd_sc_hd__a21oi_1
X_15532_ net997 _09624_ VSS VSS VDD VDD _1099_[4] sky130_fd_sc_hd__nor2_1
X_15534_ u_core.u_actl.mn[3] net1038 VSS VSS VDD VDD _09626_ sky130_fd_sc_hd__nor2_1
X_15535_ u_core.u_actl.mn[3] net864 _09626_ VSS VSS VDD VDD _09627_ sky130_fd_sc_hd__a21oi_1
X_15536_ net997 _09627_ VSS VSS VDD VDD _1099_[3] sky130_fd_sc_hd__nor2_1
X_15539_ u_core.u_actl.mn[2] net1038 VSS VSS VDD VDD _09630_ sky130_fd_sc_hd__nor2_1
X_15540_ u_core.u_actl.mn[2] net864 _09630_ VSS VSS VDD VDD _09631_ sky130_fd_sc_hd__a21oi_1
X_15541_ net997 _09631_ VSS VSS VDD VDD _1099_[2] sky130_fd_sc_hd__nor2_1
X_15542_ u_core.u_actl.mn[1] net1038 VSS VSS VDD VDD _09632_ sky130_fd_sc_hd__nor2_1
X_15543_ u_core.u_actl.mn[1] net864 _09632_ VSS VSS VDD VDD _09633_ sky130_fd_sc_hd__a21oi_1
X_15544_ net997 _09633_ VSS VSS VDD VDD _1099_[1] sky130_fd_sc_hd__nor2_1
X_15545_ u_core.u_actl.mn[0] net1038 VSS VSS VDD VDD _09634_ sky130_fd_sc_hd__nor2_1
X_15546_ u_core.u_actl.mn[0] net864 _09634_ VSS VSS VDD VDD _09635_ sky130_fd_sc_hd__a21oi_1
X_15547_ net997 _09635_ VSS VSS VDD VDD _1099_[0] sky130_fd_sc_hd__nor2_1
X_15548_ u_core.u_actl.mp[22] net1038 VSS VSS VDD VDD _09636_ sky130_fd_sc_hd__nor2_1
X_15549_ u_core.u_actl.mp[22] net864 _09636_ VSS VSS VDD VDD _09637_ sky130_fd_sc_hd__a21oi_1
X_15550_ net997 _09637_ VSS VSS VDD VDD _1097_[22] sky130_fd_sc_hd__nor2_1
X_15551_ u_core.u_actl.mp[21] net1038 VSS VSS VDD VDD _09638_ sky130_fd_sc_hd__nor2_1
X_15552_ u_core.u_actl.mp[21] net864 _09638_ VSS VSS VDD VDD _09639_ sky130_fd_sc_hd__a21oi_1
X_15553_ net997 _09639_ VSS VSS VDD VDD _1097_[21] sky130_fd_sc_hd__nor2_1
X_15554_ u_core.u_actl.mp[20] net1038 VSS VSS VDD VDD _09640_ sky130_fd_sc_hd__nor2_1
X_15555_ u_core.u_actl.mp[20] net864 _09640_ VSS VSS VDD VDD _09641_ sky130_fd_sc_hd__a21oi_1
X_15556_ net997 _09641_ VSS VSS VDD VDD _1097_[20] sky130_fd_sc_hd__nor2_1
X_15557_ u_core.u_actl.mp[19] net1038 VSS VSS VDD VDD _09642_ sky130_fd_sc_hd__nor2_1
X_15558_ u_core.u_actl.mp[19] net864 _09642_ VSS VSS VDD VDD _09643_ sky130_fd_sc_hd__a21oi_1
X_15559_ net997 _09643_ VSS VSS VDD VDD _1097_[19] sky130_fd_sc_hd__nor2_1
X_15560_ u_core.u_actl.mp[18] net1038 VSS VSS VDD VDD _09644_ sky130_fd_sc_hd__nor2_1
X_15561_ u_core.u_actl.mp[18] net864 _09644_ VSS VSS VDD VDD _09645_ sky130_fd_sc_hd__a21oi_1
X_15562_ net997 _09645_ VSS VSS VDD VDD _1097_[18] sky130_fd_sc_hd__nor2_1
X_15563_ u_core.u_actl.mp[17] net1038 VSS VSS VDD VDD _09646_ sky130_fd_sc_hd__nor2_1
X_15564_ u_core.u_actl.mp[17] net864 _09646_ VSS VSS VDD VDD _09647_ sky130_fd_sc_hd__a21oi_1
X_15565_ net997 _09647_ VSS VSS VDD VDD _1097_[17] sky130_fd_sc_hd__nor2_1
X_15567_ u_core.u_actl.mp[16] net1038 VSS VSS VDD VDD _09649_ sky130_fd_sc_hd__nor2_1
X_15568_ u_core.u_actl.mp[16] net864 _09649_ VSS VSS VDD VDD _09650_ sky130_fd_sc_hd__a21oi_1
X_15569_ net997 _09650_ VSS VSS VDD VDD _1097_[16] sky130_fd_sc_hd__nor2_1
X_15572_ u_core.u_actl.mp[15] net1038 VSS VSS VDD VDD _09653_ sky130_fd_sc_hd__nor2_1
X_15573_ u_core.u_actl.mp[15] net864 _09653_ VSS VSS VDD VDD _09654_ sky130_fd_sc_hd__a21oi_1
X_15574_ net997 _09654_ VSS VSS VDD VDD _1097_[15] sky130_fd_sc_hd__nor2_1
X_15575_ u_core.u_actl.mp[14] net1038 VSS VSS VDD VDD _09655_ sky130_fd_sc_hd__nor2_1
X_15576_ u_core.u_actl.mp[14] net864 _09655_ VSS VSS VDD VDD _09656_ sky130_fd_sc_hd__a21oi_1
X_15577_ net997 _09656_ VSS VSS VDD VDD _1097_[14] sky130_fd_sc_hd__nor2_1
X_15578_ u_core.u_actl.mp[13] net1038 VSS VSS VDD VDD _09657_ sky130_fd_sc_hd__nor2_1
X_15579_ u_core.u_actl.mp[13] net864 _09657_ VSS VSS VDD VDD _09658_ sky130_fd_sc_hd__a21oi_1
X_15580_ net997 _09658_ VSS VSS VDD VDD _1097_[13] sky130_fd_sc_hd__nor2_1
X_15581_ u_core.u_actl.mp[12] net1038 VSS VSS VDD VDD _09659_ sky130_fd_sc_hd__nor2_1
X_15582_ u_core.u_actl.mp[12] net864 _09659_ VSS VSS VDD VDD _09660_ sky130_fd_sc_hd__a21oi_1
X_15583_ net997 _09660_ VSS VSS VDD VDD _1097_[12] sky130_fd_sc_hd__nor2_1
X_15584_ u_core.u_actl.mp[11] net1038 VSS VSS VDD VDD _09661_ sky130_fd_sc_hd__nor2_1
X_15585_ u_core.u_actl.mp[11] net864 _09661_ VSS VSS VDD VDD _09662_ sky130_fd_sc_hd__a21oi_1
X_15586_ net997 _09662_ VSS VSS VDD VDD _1097_[11] sky130_fd_sc_hd__nor2_1
X_15587_ u_core.u_actl.mp[10] net863 VSS VSS VDD VDD _09663_ sky130_fd_sc_hd__nor2_1
X_15588_ u_core.u_actl.mp[10] net864 _09663_ VSS VSS VDD VDD _09664_ sky130_fd_sc_hd__a21oi_1
X_15589_ net997 _09664_ VSS VSS VDD VDD _1097_[10] sky130_fd_sc_hd__nor2_1
X_15590_ u_core.u_actl.mp[9] net863 VSS VSS VDD VDD _09665_ sky130_fd_sc_hd__nor2_1
X_15591_ u_core.u_actl.mp[9] net864 _09665_ VSS VSS VDD VDD _09666_ sky130_fd_sc_hd__a21oi_1
X_15592_ net997 _09666_ VSS VSS VDD VDD _1097_[9] sky130_fd_sc_hd__nor2_1
X_15593_ u_core.u_actl.mp[8] net1038 VSS VSS VDD VDD _09667_ sky130_fd_sc_hd__nor2_1
X_15594_ u_core.u_actl.mp[8] net864 _09667_ VSS VSS VDD VDD _09668_ sky130_fd_sc_hd__a21oi_1
X_15595_ net997 _09668_ VSS VSS VDD VDD _1097_[8] sky130_fd_sc_hd__nor2_1
X_15596_ u_core.u_actl.mp[7] net1038 VSS VSS VDD VDD _09669_ sky130_fd_sc_hd__nor2_1
X_15597_ u_core.u_actl.mp[7] net864 _09669_ VSS VSS VDD VDD _09670_ sky130_fd_sc_hd__a21oi_1
X_15598_ net997 _09670_ VSS VSS VDD VDD _1097_[7] sky130_fd_sc_hd__nor2_1
X_15599_ u_core.u_actl.mp[6] net863 VSS VSS VDD VDD _09671_ sky130_fd_sc_hd__nor2_1
X_15600_ u_core.u_actl.mp[6] net864 _09671_ VSS VSS VDD VDD _09672_ sky130_fd_sc_hd__a21oi_1
X_15601_ net997 _09672_ VSS VSS VDD VDD _1097_[6] sky130_fd_sc_hd__nor2_1
X_15603_ u_core.u_actl.mp[5] net863 VSS VSS VDD VDD _09674_ sky130_fd_sc_hd__nor2_1
X_15604_ u_core.u_actl.mp[5] net864 _09674_ VSS VSS VDD VDD _09675_ sky130_fd_sc_hd__a21oi_1
X_15605_ net997 _09675_ VSS VSS VDD VDD _1097_[5] sky130_fd_sc_hd__nor2_1
X_15606_ u_core.u_actl.mp[4] net863 VSS VSS VDD VDD _09676_ sky130_fd_sc_hd__nor2_1
X_15607_ u_core.u_actl.mp[4] net864 _09676_ VSS VSS VDD VDD _09677_ sky130_fd_sc_hd__a21oi_1
X_15608_ net997 _09677_ VSS VSS VDD VDD _1097_[4] sky130_fd_sc_hd__nor2_1
X_15609_ u_core.u_actl.mp[3] net863 VSS VSS VDD VDD _09678_ sky130_fd_sc_hd__nor2_1
X_15610_ u_core.u_actl.mp[3] net864 _09678_ VSS VSS VDD VDD _09679_ sky130_fd_sc_hd__a21oi_1
X_15611_ net997 _09679_ VSS VSS VDD VDD _1097_[3] sky130_fd_sc_hd__nor2_1
X_15612_ u_core.u_actl.mp[2] _09581_ VSS VSS VDD VDD _09680_ sky130_fd_sc_hd__nor2_1
X_15613_ u_core.u_actl.mp[2] net864 _09680_ VSS VSS VDD VDD _09681_ sky130_fd_sc_hd__a21oi_1
X_15614_ net997 _09681_ VSS VSS VDD VDD _1097_[2] sky130_fd_sc_hd__nor2_1
X_15615_ u_core.u_actl.mp[1] net863 VSS VSS VDD VDD _09682_ sky130_fd_sc_hd__nor2_1
X_15616_ u_core.u_actl.mp[1] net864 _09682_ VSS VSS VDD VDD _09683_ sky130_fd_sc_hd__a21oi_1
X_15617_ net997 _09683_ VSS VSS VDD VDD _1097_[1] sky130_fd_sc_hd__nor2_1
X_15618_ u_core.u_actl.mp[0] _09581_ VSS VSS VDD VDD _09684_ sky130_fd_sc_hd__nor2_1
X_15619_ u_core.u_actl.mp[0] _09577_ _09684_ VSS VSS VDD VDD _09685_ sky130_fd_sc_hd__a21oi_1
X_15620_ u_core.u_actl.st[5] _09685_ VSS VSS VDD VDD _1097_[0] sky130_fd_sc_hd__nor2_1
X_15623_ u_core.u_actl.row[3] u_core.u_actl.row[2] VSS VSS VDD VDD _09688_ sky130_fd_sc_hd__nand2b_1
X_15624_ u_core.u_actl.row[0] u_core.u_actl.row[1] VSS VSS VDD VDD _09689_ sky130_fd_sc_hd__nand2b_1
X_15625_ _09688_ _09689_ VSS VSS VDD VDD _09690_ sky130_fd_sc_hd__nor2_1
X_15626_ u_core.u_actl.row[4] u_core.u_actl.row[5] u_core.u_actl.row[6] VSS VSS VDD VDD _09691_ sky130_fd_sc_hd__nor3b_2
X_15627_ _09690_ _09691_ net226 VSS VSS VDD VDD _09692_ sky130_fd_sc_hd__a21oi_1
X_15628_ net999 _09692_ VSS VSS VDD VDD _1093_[70] sky130_fd_sc_hd__nor2_1
X_15629_ u_core.u_actl.row[1] u_core.u_actl.row[0] VSS VSS VDD VDD _09693_ sky130_fd_sc_hd__nand2b_1
X_15630_ _09688_ _09693_ VSS VSS VDD VDD _09694_ sky130_fd_sc_hd__nor2_1
X_15631_ _09691_ _09694_ net224 VSS VSS VDD VDD _09695_ sky130_fd_sc_hd__a21oi_1
X_15632_ net999 _09695_ VSS VSS VDD VDD _1093_[69] sky130_fd_sc_hd__nor2_1
X_15633_ u_core.u_actl.row[1] u_core.u_actl.row[0] _09688_ VSS VSS VDD VDD _09696_ sky130_fd_sc_hd__nor3_1
X_15634_ _09691_ _09696_ net223 VSS VSS VDD VDD _09697_ sky130_fd_sc_hd__a21oi_1
X_15635_ net999 _09697_ VSS VSS VDD VDD _1093_[68] sky130_fd_sc_hd__nor2_1
X_15636_ u_core.u_actl.row[1] u_core.u_actl.row[0] VSS VSS VDD VDD _09698_ sky130_fd_sc_hd__nand2_1
X_15637_ u_core.u_actl.row[3] u_core.u_actl.row[2] _09698_ VSS VSS VDD VDD _09699_ sky130_fd_sc_hd__nor3_1
X_15638_ _09691_ _09699_ net222 VSS VSS VDD VDD _09700_ sky130_fd_sc_hd__a21oi_1
X_15639_ net999 _09700_ VSS VSS VDD VDD _1093_[67] sky130_fd_sc_hd__nor2_1
X_15640_ u_core.u_actl.row[3] u_core.u_actl.row[2] _09689_ VSS VSS VDD VDD _09701_ sky130_fd_sc_hd__nor3_1
X_15641_ _09691_ _09701_ net221 VSS VSS VDD VDD _09702_ sky130_fd_sc_hd__a21oi_1
X_15642_ net999 _09702_ VSS VSS VDD VDD _1093_[66] sky130_fd_sc_hd__nor2_1
X_15643_ u_core.u_actl.row[3] u_core.u_actl.row[2] _09693_ VSS VSS VDD VDD _09703_ sky130_fd_sc_hd__nor3_1
X_15644_ _09691_ _09703_ net220 VSS VSS VDD VDD _09704_ sky130_fd_sc_hd__a21oi_1
X_15645_ net999 _09704_ VSS VSS VDD VDD _1093_[65] sky130_fd_sc_hd__nor2_1
X_15646_ u_core.u_actl.row[3] u_core.u_actl.row[2] u_core.u_actl.row[1] u_core.u_actl.row[0] VSS VSS VDD VDD _09705_ sky130_fd_sc_hd__nor4_1
X_15647_ _09691_ net887 net219 VSS VSS VDD VDD _09706_ sky130_fd_sc_hd__a21oi_1
X_15648_ net998 _09706_ VSS VSS VDD VDD _1093_[64] sky130_fd_sc_hd__nor2_1
X_15649_ u_core.u_actl.row[3] u_core.u_actl.row[2] VSS VSS VDD VDD _09707_ sky130_fd_sc_hd__nand2_1
X_15650_ _09698_ _09707_ VSS VSS VDD VDD _09708_ sky130_fd_sc_hd__nor2_1
X_15651_ u_core.u_actl.row[6] u_core.u_actl.row[5] u_core.u_actl.row[4] VSS VSS VDD VDD _09709_ sky130_fd_sc_hd__and3b_1
X_15654_ _09708_ _09709_ net218 VSS VSS VDD VDD _09712_ sky130_fd_sc_hd__a21oi_1
X_15655_ net998 _09712_ VSS VSS VDD VDD _1093_[63] sky130_fd_sc_hd__nor2_1
X_15656_ _09689_ _09707_ VSS VSS VDD VDD _09713_ sky130_fd_sc_hd__nor2_1
X_15657_ _09709_ _09713_ net217 VSS VSS VDD VDD _09714_ sky130_fd_sc_hd__a21oi_1
X_15658_ net998 _09714_ VSS VSS VDD VDD _1093_[62] sky130_fd_sc_hd__nor2_1
X_15659_ _09693_ _09707_ VSS VSS VDD VDD _09715_ sky130_fd_sc_hd__nor2_1
X_15660_ _09709_ _09715_ net216 VSS VSS VDD VDD _09716_ sky130_fd_sc_hd__a21oi_1
X_15661_ net998 _09716_ VSS VSS VDD VDD _1093_[61] sky130_fd_sc_hd__nor2_1
X_15663_ u_core.u_actl.row[1] u_core.u_actl.row[0] _09707_ VSS VSS VDD VDD _09718_ sky130_fd_sc_hd__nor3_1
X_15664_ _09709_ _09718_ net215 VSS VSS VDD VDD _09719_ sky130_fd_sc_hd__a21oi_1
X_15665_ net998 _09719_ VSS VSS VDD VDD _1093_[60] sky130_fd_sc_hd__nor2_1
X_15666_ u_core.u_actl.row[2] u_core.u_actl.row[3] VSS VSS VDD VDD _09720_ sky130_fd_sc_hd__nand2b_1
X_15667_ _09698_ _09720_ VSS VSS VDD VDD _09721_ sky130_fd_sc_hd__nor2_1
X_15668_ _09709_ _09721_ net213 VSS VSS VDD VDD _09722_ sky130_fd_sc_hd__a21oi_1
X_15669_ net998 _09722_ VSS VSS VDD VDD _1093_[59] sky130_fd_sc_hd__nor2_1
X_15670_ _09689_ _09720_ VSS VSS VDD VDD _09723_ sky130_fd_sc_hd__nor2_1
X_15671_ _09709_ _09723_ net212 VSS VSS VDD VDD _09724_ sky130_fd_sc_hd__a21oi_1
X_15672_ net999 _09724_ VSS VSS VDD VDD _1093_[58] sky130_fd_sc_hd__nor2_1
X_15673_ _09693_ _09720_ VSS VSS VDD VDD _09725_ sky130_fd_sc_hd__nor2_1
X_15674_ _09709_ _09725_ net211 VSS VSS VDD VDD _09726_ sky130_fd_sc_hd__a21oi_1
X_15675_ net999 _09726_ VSS VSS VDD VDD _1093_[57] sky130_fd_sc_hd__nor2_1
X_15676_ u_core.u_actl.row[1] u_core.u_actl.row[0] _09720_ VSS VSS VDD VDD _09727_ sky130_fd_sc_hd__nor3_1
X_15677_ _09709_ _09727_ net210 VSS VSS VDD VDD _09728_ sky130_fd_sc_hd__a21oi_1
X_15678_ net999 _09728_ VSS VSS VDD VDD _1093_[56] sky130_fd_sc_hd__nor2_1
X_15679_ _09688_ _09698_ VSS VSS VDD VDD _09729_ sky130_fd_sc_hd__nor2_1
X_15680_ _09709_ _09729_ net209 VSS VSS VDD VDD _09730_ sky130_fd_sc_hd__a21oi_1
X_15681_ net999 _09730_ VSS VSS VDD VDD _1093_[55] sky130_fd_sc_hd__nor2_1
X_15682_ _09690_ _09709_ net208 VSS VSS VDD VDD _09731_ sky130_fd_sc_hd__a21oi_1
X_15683_ net999 _09731_ VSS VSS VDD VDD _1093_[54] sky130_fd_sc_hd__nor2_1
X_15684_ _09694_ _09709_ net207 VSS VSS VDD VDD _09732_ sky130_fd_sc_hd__a21oi_1
X_15685_ net999 _09732_ VSS VSS VDD VDD _1093_[53] sky130_fd_sc_hd__nor2_1
X_15686_ _09696_ _09709_ net206 VSS VSS VDD VDD _09733_ sky130_fd_sc_hd__a21oi_1
X_15687_ net999 _09733_ VSS VSS VDD VDD _1093_[52] sky130_fd_sc_hd__nor2_1
X_15688_ _09699_ _09709_ net205 VSS VSS VDD VDD _09734_ sky130_fd_sc_hd__a21oi_1
X_15689_ net999 _09734_ VSS VSS VDD VDD _1093_[51] sky130_fd_sc_hd__nor2_1
X_15691_ _09701_ _09709_ net204 VSS VSS VDD VDD _09736_ sky130_fd_sc_hd__a21oi_1
X_15692_ net998 _09736_ VSS VSS VDD VDD _1093_[50] sky130_fd_sc_hd__nor2_1
X_15693_ _09703_ _09709_ net202 VSS VSS VDD VDD _09737_ sky130_fd_sc_hd__a21oi_1
X_15694_ net998 _09737_ VSS VSS VDD VDD _1093_[49] sky130_fd_sc_hd__nor2_1
X_15695_ net887 _09709_ net201 VSS VSS VDD VDD _09738_ sky130_fd_sc_hd__a21oi_1
X_15696_ net998 _09738_ VSS VSS VDD VDD _1093_[48] sky130_fd_sc_hd__nor2_1
X_15697_ u_core.u_actl.row[4] u_core.u_actl.row[6] u_core.u_actl.row[5] VSS VSS VDD VDD _09739_ sky130_fd_sc_hd__nor3b_4
X_15699_ _09708_ _09739_ net200 VSS VSS VDD VDD _09741_ sky130_fd_sc_hd__a21oi_1
X_15700_ net998 _09741_ VSS VSS VDD VDD _1093_[47] sky130_fd_sc_hd__nor2_1
X_15701_ _09713_ _09739_ net199 VSS VSS VDD VDD _09742_ sky130_fd_sc_hd__a21oi_1
X_15702_ net998 _09742_ VSS VSS VDD VDD _1093_[46] sky130_fd_sc_hd__nor2_1
X_15703_ _09715_ _09739_ net198 VSS VSS VDD VDD _09743_ sky130_fd_sc_hd__a21oi_1
X_15704_ net998 _09743_ VSS VSS VDD VDD _1093_[45] sky130_fd_sc_hd__nor2_1
X_15705_ _09718_ _09739_ net197 VSS VSS VDD VDD _09744_ sky130_fd_sc_hd__a21oi_1
X_15706_ net998 _09744_ VSS VSS VDD VDD _1093_[44] sky130_fd_sc_hd__nor2_1
X_15707_ _09721_ _09739_ net196 VSS VSS VDD VDD _09745_ sky130_fd_sc_hd__a21oi_1
X_15708_ net998 _09745_ VSS VSS VDD VDD _1093_[43] sky130_fd_sc_hd__nor2_1
X_15709_ _09723_ _09739_ net195 VSS VSS VDD VDD _09746_ sky130_fd_sc_hd__a21oi_1
X_15710_ net998 _09746_ VSS VSS VDD VDD _1093_[42] sky130_fd_sc_hd__nor2_1
X_15711_ _09725_ _09739_ net194 VSS VSS VDD VDD _09747_ sky130_fd_sc_hd__a21oi_1
X_15712_ net998 _09747_ VSS VSS VDD VDD _1093_[41] sky130_fd_sc_hd__nor2_1
X_15714_ _09727_ _09739_ net193 VSS VSS VDD VDD _09749_ sky130_fd_sc_hd__a21oi_1
X_15715_ net998 _09749_ VSS VSS VDD VDD _1093_[40] sky130_fd_sc_hd__nor2_1
X_15716_ _09729_ _09739_ net191 VSS VSS VDD VDD _09750_ sky130_fd_sc_hd__a21oi_1
X_15717_ net998 _09750_ VSS VSS VDD VDD _1093_[39] sky130_fd_sc_hd__nor2_1
X_15718_ _09690_ _09739_ net190 VSS VSS VDD VDD _09751_ sky130_fd_sc_hd__a21oi_1
X_15719_ net999 _09751_ VSS VSS VDD VDD _1093_[38] sky130_fd_sc_hd__nor2_1
X_15720_ _09694_ _09739_ net189 VSS VSS VDD VDD _09752_ sky130_fd_sc_hd__a21oi_1
X_15721_ net999 _09752_ VSS VSS VDD VDD _1093_[37] sky130_fd_sc_hd__nor2_1
X_15722_ _09696_ _09739_ net188 VSS VSS VDD VDD _09753_ sky130_fd_sc_hd__a21oi_1
X_15723_ net998 _09753_ VSS VSS VDD VDD _1093_[36] sky130_fd_sc_hd__nor2_1
X_15724_ _09699_ _09739_ net187 VSS VSS VDD VDD _09754_ sky130_fd_sc_hd__a21oi_1
X_15725_ net998 _09754_ VSS VSS VDD VDD _1093_[35] sky130_fd_sc_hd__nor2_1
X_15726_ _09701_ _09739_ net186 VSS VSS VDD VDD _09755_ sky130_fd_sc_hd__a21oi_1
X_15727_ net998 _09755_ VSS VSS VDD VDD _1093_[34] sky130_fd_sc_hd__nor2_1
X_15728_ _09703_ _09739_ net185 VSS VSS VDD VDD _09756_ sky130_fd_sc_hd__a21oi_1
X_15729_ net998 _09756_ VSS VSS VDD VDD _1093_[33] sky130_fd_sc_hd__nor2_1
X_15730_ net887 _09739_ net184 VSS VSS VDD VDD _09757_ sky130_fd_sc_hd__a21oi_1
X_15731_ net998 _09757_ VSS VSS VDD VDD _1093_[32] sky130_fd_sc_hd__nor2_1
X_15732_ u_core.u_actl.row[5] u_core.u_actl.row[6] u_core.u_actl.row[4] VSS VSS VDD VDD _09758_ sky130_fd_sc_hd__nor3b_4
X_15734_ _09708_ _09758_ net183 VSS VSS VDD VDD _09760_ sky130_fd_sc_hd__a21oi_1
X_15735_ net998 _09760_ VSS VSS VDD VDD _1093_[31] sky130_fd_sc_hd__nor2_1
X_15737_ _09713_ _09758_ net182 VSS VSS VDD VDD _09762_ sky130_fd_sc_hd__a21oi_1
X_15738_ net998 _09762_ VSS VSS VDD VDD _1093_[30] sky130_fd_sc_hd__nor2_1
X_15739_ _09715_ _09758_ net180 VSS VSS VDD VDD _09763_ sky130_fd_sc_hd__a21oi_1
X_15740_ net998 _09763_ VSS VSS VDD VDD _1093_[29] sky130_fd_sc_hd__nor2_1
X_15741_ _09718_ _09758_ net179 VSS VSS VDD VDD _09764_ sky130_fd_sc_hd__a21oi_1
X_15742_ net998 _09764_ VSS VSS VDD VDD _1093_[28] sky130_fd_sc_hd__nor2_1
X_15743_ _09721_ _09758_ net178 VSS VSS VDD VDD _09765_ sky130_fd_sc_hd__a21oi_1
X_15744_ net998 _09765_ VSS VSS VDD VDD _1093_[27] sky130_fd_sc_hd__nor2_1
X_15745_ _09723_ _09758_ net177 VSS VSS VDD VDD _09766_ sky130_fd_sc_hd__a21oi_1
X_15746_ net999 _09766_ VSS VSS VDD VDD _1093_[26] sky130_fd_sc_hd__nor2_1
X_15747_ _09725_ _09758_ net176 VSS VSS VDD VDD _09767_ sky130_fd_sc_hd__a21oi_1
X_15748_ net999 _09767_ VSS VSS VDD VDD _1093_[25] sky130_fd_sc_hd__nor2_1
X_15749_ _09727_ _09758_ net175 VSS VSS VDD VDD _09768_ sky130_fd_sc_hd__a21oi_1
X_15750_ net998 _09768_ VSS VSS VDD VDD _1093_[24] sky130_fd_sc_hd__nor2_1
X_15751_ _09729_ _09758_ net174 VSS VSS VDD VDD _09769_ sky130_fd_sc_hd__a21oi_1
X_15752_ net999 _09769_ VSS VSS VDD VDD _1093_[23] sky130_fd_sc_hd__nor2_1
X_15753_ _09690_ _09758_ net173 VSS VSS VDD VDD _09770_ sky130_fd_sc_hd__a21oi_1
X_15754_ net999 _09770_ VSS VSS VDD VDD _1093_[22] sky130_fd_sc_hd__nor2_1
X_15755_ _09694_ _09758_ net172 VSS VSS VDD VDD _09771_ sky130_fd_sc_hd__a21oi_1
X_15756_ net999 _09771_ VSS VSS VDD VDD _1093_[21] sky130_fd_sc_hd__nor2_1
X_15758_ _09696_ _09758_ net171 VSS VSS VDD VDD _09773_ sky130_fd_sc_hd__a21oi_1
X_15759_ net998 _09773_ VSS VSS VDD VDD _1093_[20] sky130_fd_sc_hd__nor2_1
X_15760_ _09699_ _09758_ net169 VSS VSS VDD VDD _09774_ sky130_fd_sc_hd__a21oi_1
X_15761_ net998 _09774_ VSS VSS VDD VDD _1093_[19] sky130_fd_sc_hd__nor2_1
X_15762_ _09701_ _09758_ net168 VSS VSS VDD VDD _09775_ sky130_fd_sc_hd__a21oi_1
X_15763_ net998 _09775_ VSS VSS VDD VDD _1093_[18] sky130_fd_sc_hd__nor2_1
X_15764_ _09703_ _09758_ net167 VSS VSS VDD VDD _09776_ sky130_fd_sc_hd__a21oi_1
X_15765_ net998 _09776_ VSS VSS VDD VDD _1093_[17] sky130_fd_sc_hd__nor2_1
X_15766_ net887 _09758_ net166 VSS VSS VDD VDD _09777_ sky130_fd_sc_hd__a21oi_1
X_15767_ net998 _09777_ VSS VSS VDD VDD _1093_[16] sky130_fd_sc_hd__nor2_1
X_15768_ u_core.u_actl.row[4] u_core.u_actl.row[5] u_core.u_actl.row[6] VSS VSS VDD VDD _09778_ sky130_fd_sc_hd__nor3_4
X_15770_ _09708_ _09778_ net165 VSS VSS VDD VDD _09780_ sky130_fd_sc_hd__a21oi_1
X_15771_ net998 _09780_ VSS VSS VDD VDD _1093_[15] sky130_fd_sc_hd__nor2_1
X_15772_ _09713_ _09778_ net164 VSS VSS VDD VDD _09781_ sky130_fd_sc_hd__a21oi_1
X_15773_ net998 _09781_ VSS VSS VDD VDD _1093_[14] sky130_fd_sc_hd__nor2_1
X_15774_ _09715_ _09778_ net163 VSS VSS VDD VDD _09782_ sky130_fd_sc_hd__a21oi_1
X_15775_ net998 _09782_ VSS VSS VDD VDD _1093_[13] sky130_fd_sc_hd__nor2_1
X_15776_ _09718_ _09778_ net162 VSS VSS VDD VDD _09783_ sky130_fd_sc_hd__a21oi_1
X_15777_ net998 _09783_ VSS VSS VDD VDD _1093_[12] sky130_fd_sc_hd__nor2_1
X_15778_ _09721_ _09778_ net161 VSS VSS VDD VDD _09784_ sky130_fd_sc_hd__a21oi_1
X_15779_ net998 _09784_ VSS VSS VDD VDD _1093_[11] sky130_fd_sc_hd__nor2_1
X_15781_ _09723_ _09778_ net160 VSS VSS VDD VDD _09786_ sky130_fd_sc_hd__a21oi_1
X_15782_ net999 _09786_ VSS VSS VDD VDD _1093_[10] sky130_fd_sc_hd__nor2_1
X_15783_ _09725_ _09778_ net230 VSS VSS VDD VDD _09787_ sky130_fd_sc_hd__a21oi_1
X_15784_ net999 _09787_ VSS VSS VDD VDD _1093_[9] sky130_fd_sc_hd__nor2_1
X_15785_ _09727_ _09778_ net229 VSS VSS VDD VDD _09788_ sky130_fd_sc_hd__a21oi_1
X_15786_ net999 _09788_ VSS VSS VDD VDD _1093_[8] sky130_fd_sc_hd__nor2_1
X_15787_ _09729_ _09778_ net228 VSS VSS VDD VDD _09789_ sky130_fd_sc_hd__a21oi_1
X_15788_ net999 _09789_ VSS VSS VDD VDD _1093_[7] sky130_fd_sc_hd__nor2_1
X_15789_ _09690_ _09778_ net225 VSS VSS VDD VDD _09790_ sky130_fd_sc_hd__a21oi_1
X_15790_ net999 _09790_ VSS VSS VDD VDD _1093_[6] sky130_fd_sc_hd__nor2_1
X_15791_ _09694_ _09778_ net214 VSS VSS VDD VDD _09791_ sky130_fd_sc_hd__a21oi_1
X_15792_ net999 _09791_ VSS VSS VDD VDD _1093_[5] sky130_fd_sc_hd__nor2_1
X_15793_ _09696_ _09778_ net203 VSS VSS VDD VDD _09792_ sky130_fd_sc_hd__a21oi_1
X_15794_ net999 _09792_ VSS VSS VDD VDD _1093_[4] sky130_fd_sc_hd__nor2_1
X_15795_ _09699_ _09778_ net192 VSS VSS VDD VDD _09793_ sky130_fd_sc_hd__a21oi_1
X_15796_ net999 _09793_ VSS VSS VDD VDD _1093_[3] sky130_fd_sc_hd__nor2_1
X_15797_ _09701_ _09778_ net181 VSS VSS VDD VDD _09794_ sky130_fd_sc_hd__a21oi_1
X_15798_ net999 _09794_ VSS VSS VDD VDD _1093_[2] sky130_fd_sc_hd__nor2_1
X_15799_ _09703_ _09778_ net170 VSS VSS VDD VDD _09795_ sky130_fd_sc_hd__a21oi_1
X_15800_ net999 _09795_ VSS VSS VDD VDD _1093_[1] sky130_fd_sc_hd__nor2_1
X_15801_ net887 _09778_ net159 VSS VSS VDD VDD _09796_ sky130_fd_sc_hd__a21oi_1
X_15802_ net998 _09796_ VSS VSS VDD VDD _1093_[0] sky130_fd_sc_hd__nor2_1
X_15803_ u_core.u_actl.st[4] _09482_ VSS VSS VDD VDD _09797_ sky130_fd_sc_hd__nor2_4
X_15806_ u_core.u_actl.q1_n[22] net793 VSS VSS VDD VDD _1091_[22] sky130_fd_sc_hd__and2_1
X_15807_ u_core.u_actl.q1_n[21] net793 VSS VSS VDD VDD _1091_[21] sky130_fd_sc_hd__and2_1
X_15808_ u_core.u_actl.q1_n[20] net793 VSS VSS VDD VDD _1091_[20] sky130_fd_sc_hd__and2_1
X_15809_ u_core.u_actl.q1_n[19] net793 VSS VSS VDD VDD _1091_[19] sky130_fd_sc_hd__and2_1
X_15810_ u_core.u_actl.q1_n[18] net793 VSS VSS VDD VDD _1091_[18] sky130_fd_sc_hd__and2_1
X_15811_ u_core.u_actl.q1_n[17] net793 VSS VSS VDD VDD _1091_[17] sky130_fd_sc_hd__and2_1
X_15812_ u_core.u_actl.q1_n[16] net793 VSS VSS VDD VDD _1091_[16] sky130_fd_sc_hd__and2_1
X_15813_ u_core.u_actl.q1_n[15] net793 VSS VSS VDD VDD _1091_[15] sky130_fd_sc_hd__and2_1
X_15814_ u_core.u_actl.q1_n[14] net793 VSS VSS VDD VDD _1091_[14] sky130_fd_sc_hd__and2_1
X_15815_ u_core.u_actl.q1_n[13] net793 VSS VSS VDD VDD _1091_[13] sky130_fd_sc_hd__and2_1
X_15817_ u_core.u_actl.q1_n[12] net793 VSS VSS VDD VDD _1091_[12] sky130_fd_sc_hd__and2_1
X_15818_ u_core.u_actl.q1_n[11] net793 VSS VSS VDD VDD _1091_[11] sky130_fd_sc_hd__and2_1
X_15819_ u_core.u_actl.q1_n[10] net793 VSS VSS VDD VDD _1091_[10] sky130_fd_sc_hd__and2_1
X_15820_ u_core.u_actl.q1_n[9] net793 VSS VSS VDD VDD _1091_[9] sky130_fd_sc_hd__and2_1
X_15821_ u_core.u_actl.q1_n[8] net793 VSS VSS VDD VDD _1091_[8] sky130_fd_sc_hd__and2_1
X_15822_ u_core.u_actl.q1_n[7] net793 VSS VSS VDD VDD _1091_[7] sky130_fd_sc_hd__and2_1
X_15823_ u_core.u_actl.q1_n[6] net793 VSS VSS VDD VDD _1091_[6] sky130_fd_sc_hd__and2_1
X_15824_ u_core.u_actl.q1_n[5] net793 VSS VSS VDD VDD _1091_[5] sky130_fd_sc_hd__and2_1
X_15825_ u_core.u_actl.q1_n[4] net793 VSS VSS VDD VDD _1091_[4] sky130_fd_sc_hd__and2_1
X_15826_ u_core.u_actl.q1_n[3] net793 VSS VSS VDD VDD _1091_[3] sky130_fd_sc_hd__and2_1
X_15828_ u_core.u_actl.q1_n[2] net793 VSS VSS VDD VDD _1091_[2] sky130_fd_sc_hd__and2_1
X_15829_ u_core.u_actl.q1_n[1] net793 VSS VSS VDD VDD _1091_[1] sky130_fd_sc_hd__and2_1
X_15830_ u_core.u_actl.q1_n[0] net793 VSS VSS VDD VDD _1091_[0] sky130_fd_sc_hd__and2_1
X_15831_ u_core.u_actl.q1_p[22] net793 VSS VSS VDD VDD _1089_[22] sky130_fd_sc_hd__and2_1
X_15832_ u_core.u_actl.q1_p[21] net793 VSS VSS VDD VDD _1089_[21] sky130_fd_sc_hd__and2_1
X_15833_ u_core.u_actl.q1_p[20] net793 VSS VSS VDD VDD _1089_[20] sky130_fd_sc_hd__and2_1
X_15834_ u_core.u_actl.q1_p[19] net793 VSS VSS VDD VDD _1089_[19] sky130_fd_sc_hd__and2_1
X_15835_ u_core.u_actl.q1_p[18] net793 VSS VSS VDD VDD _1089_[18] sky130_fd_sc_hd__and2_1
X_15836_ u_core.u_actl.q1_p[17] net793 VSS VSS VDD VDD _1089_[17] sky130_fd_sc_hd__and2_1
X_15837_ u_core.u_actl.q1_p[16] net793 VSS VSS VDD VDD _1089_[16] sky130_fd_sc_hd__and2_1
X_15839_ u_core.u_actl.q1_p[15] net793 VSS VSS VDD VDD _1089_[15] sky130_fd_sc_hd__and2_1
X_15840_ u_core.u_actl.q1_p[14] net793 VSS VSS VDD VDD _1089_[14] sky130_fd_sc_hd__and2_1
X_15841_ u_core.u_actl.q1_p[13] net793 VSS VSS VDD VDD _1089_[13] sky130_fd_sc_hd__and2_1
X_15842_ u_core.u_actl.q1_p[12] net793 VSS VSS VDD VDD _1089_[12] sky130_fd_sc_hd__and2_1
X_15843_ u_core.u_actl.q1_p[11] net793 VSS VSS VDD VDD _1089_[11] sky130_fd_sc_hd__and2_1
X_15844_ u_core.u_actl.q1_p[10] net793 VSS VSS VDD VDD _1089_[10] sky130_fd_sc_hd__and2_1
X_15845_ u_core.u_actl.q1_p[9] net793 VSS VSS VDD VDD _1089_[9] sky130_fd_sc_hd__and2_1
X_15846_ u_core.u_actl.q1_p[8] net793 VSS VSS VDD VDD _1089_[8] sky130_fd_sc_hd__and2_1
X_15847_ u_core.u_actl.q1_p[7] net793 VSS VSS VDD VDD _1089_[7] sky130_fd_sc_hd__and2_1
X_15848_ u_core.u_actl.q1_p[6] net793 VSS VSS VDD VDD _1089_[6] sky130_fd_sc_hd__and2_1
X_15849_ u_core.u_actl.q1_p[5] net793 VSS VSS VDD VDD _1089_[5] sky130_fd_sc_hd__and2_1
X_15850_ u_core.u_actl.q1_p[4] net793 VSS VSS VDD VDD _1089_[4] sky130_fd_sc_hd__and2_1
X_15851_ u_core.u_actl.q1_p[3] net793 VSS VSS VDD VDD _1089_[3] sky130_fd_sc_hd__and2_1
X_15852_ u_core.u_actl.q1_p[2] net793 VSS VSS VDD VDD _1089_[2] sky130_fd_sc_hd__and2_1
X_15853_ u_core.u_actl.q1_p[1] net793 VSS VSS VDD VDD _1089_[1] sky130_fd_sc_hd__and2_1
X_15854_ u_core.u_actl.q1_p[0] net793 VSS VSS VDD VDD _1089_[0] sky130_fd_sc_hd__and2_1
X_15858_ net896 net895 VSS VSS VDD VDD _09806_ sky130_fd_sc_hd__nor2b_1
X_15860_ net898 net897 net886 VSS VSS VDD VDD _09808_ sky130_fd_sc_hd__nand3_2
X_15864_ u_core.u_top.u_core.amp[3] _02698_ u_core.u_top.u_core.amp[2] u_core.u_top.u_core.amp[4] VSS VSS VDD VDD _09812_ sky130_fd_sc_hd__and4b_1
X_15866_ u_core.arr_sa_p[5] u_core.u_top.u_core.pend_p[5] VSS VSS VDD VDD _09814_ sky130_fd_sc_hd__nor2b_1
X_15867_ u_core.arr_sa_n[5] u_core.u_top.u_core.pend_n[5] VSS VSS VDD VDD _09815_ sky130_fd_sc_hd__nor2b_1
X_15868_ _09814_ _09815_ VSS VSS VDD VDD _09816_ sky130_fd_sc_hd__nor2_1
X_15869_ net978 u_core.u_top.u_core.pend_p[3] VSS VSS VDD VDD _09817_ sky130_fd_sc_hd__nor2b_1
X_15870_ net979 u_core.u_top.u_core.pend_n[3] VSS VSS VDD VDD _09818_ sky130_fd_sc_hd__nor2b_1
X_15871_ _09817_ _09818_ VSS VSS VDD VDD _09819_ sky130_fd_sc_hd__nor2_1
X_15872_ u_core.arr_sa_n[4] u_core.u_top.u_core.pend_n[4] VSS VSS VDD VDD _09820_ sky130_fd_sc_hd__nor2b_1
X_15873_ _0511_ u_core.u_top.u_core.pend_p[4] _09820_ VSS VSS VDD VDD _09821_ sky130_fd_sc_hd__a21oi_1
X_15874_ u_core.arr_sa_p[17] u_core.u_top.u_core.pend_p[17] VSS VSS VDD VDD _09822_ sky130_fd_sc_hd__nor2b_1
X_15875_ u_core.arr_sa_n[17] u_core.u_top.u_core.pend_n[17] VSS VSS VDD VDD _09823_ sky130_fd_sc_hd__nor2b_1
X_15876_ _09822_ _09823_ VSS VSS VDD VDD _09824_ sky130_fd_sc_hd__nor2_1
X_15877_ _09816_ _09819_ _09821_ _09824_ VSS VSS VDD VDD _09825_ sky130_fd_sc_hd__nand4_1
X_15878_ u_core.arr_sa_p[19] u_core.u_top.u_core.pend_p[19] VSS VSS VDD VDD _09826_ sky130_fd_sc_hd__nor2b_1
X_15879_ u_core.arr_sa_n[19] u_core.u_top.u_core.pend_n[19] VSS VSS VDD VDD _09827_ sky130_fd_sc_hd__nor2b_1
X_15880_ _09826_ _09827_ VSS VSS VDD VDD _09828_ sky130_fd_sc_hd__nor2_1
X_15881_ u_core.arr_sa_p[10] u_core.u_top.u_core.pend_p[10] VSS VSS VDD VDD _09829_ sky130_fd_sc_hd__nor2b_1
X_15882_ u_core.arr_sa_n[10] u_core.u_top.u_core.pend_n[10] VSS VSS VDD VDD _09830_ sky130_fd_sc_hd__nor2b_1
X_15883_ _09829_ _09830_ VSS VSS VDD VDD _09831_ sky130_fd_sc_hd__nor2_1
X_15884_ u_core.arr_sa_p[7] u_core.u_top.u_core.pend_p[7] VSS VSS VDD VDD _09832_ sky130_fd_sc_hd__nor2b_1
X_15885_ u_core.arr_sa_n[7] u_core.u_top.u_core.pend_n[7] VSS VSS VDD VDD _09833_ sky130_fd_sc_hd__nor2b_1
X_15886_ _09832_ _09833_ VSS VSS VDD VDD _09834_ sky130_fd_sc_hd__nor2_1
X_15887_ u_core.arr_sa_p[16] u_core.u_top.u_core.pend_p[16] VSS VSS VDD VDD _09835_ sky130_fd_sc_hd__nor2b_1
X_15888_ u_core.arr_sa_n[16] u_core.u_top.u_core.pend_n[16] VSS VSS VDD VDD _09836_ sky130_fd_sc_hd__nor2b_1
X_15889_ _09835_ _09836_ VSS VSS VDD VDD _09837_ sky130_fd_sc_hd__nor2_1
X_15890_ _09828_ _09831_ _09834_ _09837_ VSS VSS VDD VDD _09838_ sky130_fd_sc_hd__nand4_1
X_15891_ net958 u_core.u_top.u_core.r_varprog VSS VSS VDD VDD _09839_ sky130_fd_sc_hd__nor2b_1
X_15892_ net792 _09839_ VSS VSS VDD VDD _09840_ sky130_fd_sc_hd__nor2_1
X_15893_ u_core.arr_sa_n[9] VSS VSS VDD VDD _0542_ sky130_fd_sc_hd__inv_1
X_15894_ u_core.arr_sa_p[9] u_core.u_top.u_core.pend_p[9] VSS VSS VDD VDD _09841_ sky130_fd_sc_hd__nor2b_1
X_15895_ _0542_ u_core.u_top.u_core.pend_n[9] _09841_ VSS VSS VDD VDD _09842_ sky130_fd_sc_hd__a21oi_1
X_15896_ u_core.arr_sa_p[21] u_core.u_top.u_core.pend_p[21] VSS VSS VDD VDD _09843_ sky130_fd_sc_hd__nor2b_1
X_15897_ u_core.arr_sa_n[21] u_core.u_top.u_core.pend_n[21] VSS VSS VDD VDD _09844_ sky130_fd_sc_hd__nor2b_1
X_15898_ _09843_ _09844_ VSS VSS VDD VDD _09845_ sky130_fd_sc_hd__nor2_1
X_15899_ u_core.arr_sa_p[8] u_core.u_top.u_core.pend_p[8] VSS VSS VDD VDD _09846_ sky130_fd_sc_hd__nor2b_1
X_15900_ u_core.arr_sa_n[8] u_core.u_top.u_core.pend_n[8] VSS VSS VDD VDD _09847_ sky130_fd_sc_hd__nor2b_1
X_15901_ _09846_ _09847_ VSS VSS VDD VDD _09848_ sky130_fd_sc_hd__nor2_1
X_15902_ u_core.arr_sa_p[18] u_core.u_top.u_core.pend_p[18] VSS VSS VDD VDD _09849_ sky130_fd_sc_hd__nor2b_1
X_15903_ u_core.arr_sa_n[18] u_core.u_top.u_core.pend_n[18] VSS VSS VDD VDD _09850_ sky130_fd_sc_hd__nor2b_1
X_15904_ _09849_ _09850_ VSS VSS VDD VDD _09851_ sky130_fd_sc_hd__nor2_1
X_15905_ _09842_ _09845_ _09848_ _09851_ VSS VSS VDD VDD _09852_ sky130_fd_sc_hd__nand4_1
X_15906_ _09825_ _09838_ _09840_ _09852_ VSS VSS VDD VDD _09853_ sky130_fd_sc_hd__or4_1
X_15907_ u_core.arr_sa_p[23] VSS VSS VDD VDD _0637_ sky130_fd_sc_hd__inv_1
X_15908_ u_core.arr_sa_n[23] VSS VSS VDD VDD _0634_ sky130_fd_sc_hd__inv_1
X_15909_ _0637_ u_core.u_top.u_core.pend_p[23] u_core.u_top.u_core.pend_n[23] _0634_ VSS VSS VDD VDD _09854_ sky130_fd_sc_hd__a22oi_1
X_15910_ u_core.arr_sa_p[13] u_core.u_top.u_core.pend_p[13] VSS VSS VDD VDD _09855_ sky130_fd_sc_hd__nor2b_1
X_15911_ u_core.arr_sa_n[13] u_core.u_top.u_core.pend_n[13] VSS VSS VDD VDD _09856_ sky130_fd_sc_hd__nor2b_1
X_15912_ _09855_ _09856_ VSS VSS VDD VDD _09857_ sky130_fd_sc_hd__nor2_1
X_15913_ u_core.arr_sa_p[14] u_core.u_top.u_core.pend_p[14] VSS VSS VDD VDD _09858_ sky130_fd_sc_hd__nor2b_1
X_15914_ u_core.arr_sa_n[14] u_core.u_top.u_core.pend_n[14] VSS VSS VDD VDD _09859_ sky130_fd_sc_hd__nor2b_1
X_15915_ _09858_ _09859_ VSS VSS VDD VDD _09860_ sky130_fd_sc_hd__nor2_1
X_15916_ net980 VSS VSS VDD VDD _0628_ sky130_fd_sc_hd__inv_1
X_15917_ u_core.arr_sa_p[22] u_core.u_top.u_core.pend_p[22] VSS VSS VDD VDD _09861_ sky130_fd_sc_hd__nor2b_1
X_15918_ _0628_ u_core.u_top.u_core.pend_n[22] _09861_ VSS VSS VDD VDD _09862_ sky130_fd_sc_hd__a21oi_1
X_15919_ _09854_ _09857_ _09860_ _09862_ VSS VSS VDD VDD _09863_ sky130_fd_sc_hd__nand4_1
X_15920_ u_core.arr_sa_p[2] u_core.u_top.u_core.pend_p[2] VSS VSS VDD VDD _09864_ sky130_fd_sc_hd__nor2b_1
X_15921_ u_core.arr_sa_n[2] u_core.u_top.u_core.pend_n[2] VSS VSS VDD VDD _09865_ sky130_fd_sc_hd__nor2b_1
X_15922_ _09864_ _09865_ VSS VSS VDD VDD _09866_ sky130_fd_sc_hd__nor2_1
X_15923_ u_core.arr_sa_p[15] u_core.u_top.u_core.pend_p[15] VSS VSS VDD VDD _09867_ sky130_fd_sc_hd__nor2b_1
X_15924_ u_core.arr_sa_n[15] u_core.u_top.u_core.pend_n[15] VSS VSS VDD VDD _09868_ sky130_fd_sc_hd__nor2b_1
X_15925_ _09867_ _09868_ VSS VSS VDD VDD _09869_ sky130_fd_sc_hd__nor2_1
X_15926_ u_core.arr_sa_n[12] VSS VSS VDD VDD _0562_ sky130_fd_sc_hd__inv_1
X_15927_ u_core.arr_sa_p[12] u_core.u_top.u_core.pend_p[12] VSS VSS VDD VDD _09870_ sky130_fd_sc_hd__nor2b_1
X_15928_ _0562_ u_core.u_top.u_core.pend_n[12] _09870_ VSS VSS VDD VDD _09871_ sky130_fd_sc_hd__a21oi_1
X_15929_ u_core.arr_sa_p[20] u_core.u_top.u_core.pend_p[20] VSS VSS VDD VDD _09872_ sky130_fd_sc_hd__nor2b_1
X_15930_ u_core.arr_sa_n[20] u_core.u_top.u_core.pend_n[20] VSS VSS VDD VDD _09873_ sky130_fd_sc_hd__nor2b_1
X_15931_ _09872_ _09873_ VSS VSS VDD VDD _09874_ sky130_fd_sc_hd__nor2_1
X_15932_ _09866_ _09869_ _09871_ _09874_ VSS VSS VDD VDD _09875_ sky130_fd_sc_hd__nand4_1
X_15933_ u_core.arr_sa_p[11] u_core.u_top.u_core.pend_p[11] VSS VSS VDD VDD _09876_ sky130_fd_sc_hd__nor2b_1
X_15934_ u_core.arr_sa_n[11] u_core.u_top.u_core.pend_n[11] VSS VSS VDD VDD _09877_ sky130_fd_sc_hd__nor2b_1
X_15935_ _09876_ _09877_ VSS VSS VDD VDD _09878_ sky130_fd_sc_hd__nor2_1
X_15936_ u_core.arr_sa_p[6] u_core.u_top.u_core.pend_p[6] VSS VSS VDD VDD _09879_ sky130_fd_sc_hd__nor2b_1
X_15937_ u_core.arr_sa_n[6] u_core.u_top.u_core.pend_n[6] VSS VSS VDD VDD _09880_ sky130_fd_sc_hd__nor2b_1
X_15938_ _09879_ _09880_ VSS VSS VDD VDD _09881_ sky130_fd_sc_hd__nor2_1
X_15939_ u_core.arr_sa_p[0] u_core.u_top.u_core.pend_p[0] VSS VSS VDD VDD _09882_ sky130_fd_sc_hd__nor2b_1
X_15940_ u_core.arr_sa_n[0] u_core.u_top.u_core.pend_n[0] VSS VSS VDD VDD _09883_ sky130_fd_sc_hd__nor2b_1
X_15941_ _09882_ _09883_ VSS VSS VDD VDD _09884_ sky130_fd_sc_hd__nor2_1
X_15942_ u_core.arr_sa_p[1] u_core.u_top.u_core.pend_p[1] VSS VSS VDD VDD _09885_ sky130_fd_sc_hd__nor2b_1
X_15943_ u_core.arr_sa_n[1] u_core.u_top.u_core.pend_n[1] VSS VSS VDD VDD _09886_ sky130_fd_sc_hd__nor2b_1
X_15944_ _09885_ _09886_ VSS VSS VDD VDD _09887_ sky130_fd_sc_hd__nor2_1
X_15945_ _09878_ _09881_ _09884_ _09887_ VSS VSS VDD VDD _09888_ sky130_fd_sc_hd__nand4_1
X_15946_ _09853_ _09863_ _09875_ _09888_ VSS VSS VDD VDD _09889_ sky130_fd_sc_hd__nor4_1
X_15947_ net792 net722 net897 VSS VSS VDD VDD _09890_ sky130_fd_sc_hd__o21ai_0
X_15948_ _09839_ net792 VSS VSS VDD VDD _09891_ sky130_fd_sc_hd__nand2b_1
X_15949_ u_core.arr_sa_p[21] u_core.u_top.u_core.pend_p[21] VSS VSS VDD VDD _09892_ sky130_fd_sc_hd__nand2_1
X_15950_ u_core.arr_sa_p[14] u_core.u_top.u_core.pend_p[14] VSS VSS VDD VDD _09893_ sky130_fd_sc_hd__nand2_1
X_15951_ u_core.arr_sa_p[13] u_core.u_top.u_core.pend_p[13] VSS VSS VDD VDD _09894_ sky130_fd_sc_hd__nand2_1
X_15952_ u_core.arr_sa_p[15] u_core.u_top.u_core.pend_p[15] VSS VSS VDD VDD _09895_ sky130_fd_sc_hd__nand2_1
X_15953_ _09892_ _09893_ _09894_ _09895_ VSS VSS VDD VDD _09896_ sky130_fd_sc_hd__nand4_1
X_15954_ u_core.arr_sa_n[5] u_core.u_top.u_core.pend_n[5] VSS VSS VDD VDD _09897_ sky130_fd_sc_hd__nand2_1
X_15955_ u_core.arr_sa_p[9] u_core.u_top.u_core.pend_p[9] VSS VSS VDD VDD _09898_ sky130_fd_sc_hd__nand2_1
X_15956_ u_core.arr_sa_p[7] u_core.u_top.u_core.pend_p[7] VSS VSS VDD VDD _09899_ sky130_fd_sc_hd__nand2_1
X_15957_ u_core.arr_sa_n[2] u_core.u_top.u_core.pend_n[2] VSS VSS VDD VDD _09900_ sky130_fd_sc_hd__nand2_1
X_15958_ _09897_ _09898_ _09899_ _09900_ VSS VSS VDD VDD _09901_ sky130_fd_sc_hd__nand4_1
X_15959_ u_core.arr_sa_n[0] u_core.u_top.u_core.pend_n[0] VSS VSS VDD VDD _09902_ sky130_fd_sc_hd__nand2_1
X_15960_ u_core.arr_sa_n[18] u_core.u_top.u_core.pend_n[18] VSS VSS VDD VDD _09903_ sky130_fd_sc_hd__nand2_1
X_15961_ u_core.arr_sa_p[0] u_core.u_top.u_core.pend_p[0] VSS VSS VDD VDD _09904_ sky130_fd_sc_hd__nand2_1
X_15962_ net980 u_core.u_top.u_core.pend_n[22] VSS VSS VDD VDD _09905_ sky130_fd_sc_hd__nand2_1
X_15963_ _09902_ _09903_ _09904_ _09905_ VSS VSS VDD VDD _09906_ sky130_fd_sc_hd__nand4_1
X_15964_ u_core.arr_sa_p[10] u_core.u_top.u_core.pend_p[10] VSS VSS VDD VDD _09907_ sky130_fd_sc_hd__nand2_1
X_15965_ u_core.arr_sa_n[9] u_core.u_top.u_core.pend_n[9] VSS VSS VDD VDD _09908_ sky130_fd_sc_hd__nand2_1
X_15966_ u_core.arr_sa_n[23] u_core.u_top.u_core.pend_n[23] VSS VSS VDD VDD _09909_ sky130_fd_sc_hd__nand2_1
X_15967_ u_core.arr_sa_p[23] u_core.u_top.u_core.pend_p[23] VSS VSS VDD VDD _09910_ sky130_fd_sc_hd__nand2_1
X_15968_ _09907_ _09908_ _09909_ _09910_ VSS VSS VDD VDD _09911_ sky130_fd_sc_hd__nand4_1
X_15969_ _09896_ _09901_ _09906_ _09911_ VSS VSS VDD VDD _09912_ sky130_fd_sc_hd__nor4_1
X_15970_ net978 u_core.u_top.u_core.pend_p[3] VSS VSS VDD VDD _09913_ sky130_fd_sc_hd__nand2_1
X_15971_ u_core.arr_sa_n[17] u_core.u_top.u_core.pend_n[17] VSS VSS VDD VDD _09914_ sky130_fd_sc_hd__nand2_1
X_15972_ u_core.arr_sa_n[15] u_core.u_top.u_core.pend_n[15] VSS VSS VDD VDD _09915_ sky130_fd_sc_hd__nand2_1
X_15973_ u_core.arr_sa_p[20] u_core.u_top.u_core.pend_p[20] VSS VSS VDD VDD _09916_ sky130_fd_sc_hd__nand2_1
X_15974_ _09913_ _09914_ _09915_ _09916_ VSS VSS VDD VDD _09917_ sky130_fd_sc_hd__nand4_1
X_15975_ u_core.arr_sa_p[22] u_core.u_top.u_core.pend_p[22] VSS VSS VDD VDD _09918_ sky130_fd_sc_hd__nand2_1
X_15976_ u_core.arr_sa_n[14] u_core.u_top.u_core.pend_n[14] VSS VSS VDD VDD _09919_ sky130_fd_sc_hd__nand2_1
X_15977_ u_core.arr_sa_n[13] u_core.u_top.u_core.pend_n[13] VSS VSS VDD VDD _09920_ sky130_fd_sc_hd__nand2_1
X_15978_ u_core.arr_sa_p[16] u_core.u_top.u_core.pend_p[16] VSS VSS VDD VDD _09921_ sky130_fd_sc_hd__nand2_1
X_15979_ _09918_ _09919_ _09920_ _09921_ VSS VSS VDD VDD _09922_ sky130_fd_sc_hd__nand4_1
X_15980_ _09917_ _09922_ VSS VSS VDD VDD _09923_ sky130_fd_sc_hd__nor2_1
X_15981_ u_core.arr_sa_p[12] u_core.u_top.u_core.pend_p[12] VSS VSS VDD VDD _09924_ sky130_fd_sc_hd__nand2_1
X_15982_ u_core.arr_sa_n[21] u_core.u_top.u_core.pend_n[21] VSS VSS VDD VDD _09925_ sky130_fd_sc_hd__nand2_1
X_15983_ net979 u_core.u_top.u_core.pend_n[3] VSS VSS VDD VDD _09926_ sky130_fd_sc_hd__nand2_1
X_15984_ u_core.arr_sa_p[18] u_core.u_top.u_core.pend_p[18] VSS VSS VDD VDD _09927_ sky130_fd_sc_hd__nand2_1
X_15985_ _09924_ _09925_ _09926_ _09927_ VSS VSS VDD VDD _09928_ sky130_fd_sc_hd__nand4_1
X_15986_ u_core.arr_sa_n[8] u_core.u_top.u_core.pend_n[8] VSS VSS VDD VDD _09929_ sky130_fd_sc_hd__nand2_1
X_15987_ u_core.arr_sa_p[11] u_core.u_top.u_core.pend_p[11] VSS VSS VDD VDD _09930_ sky130_fd_sc_hd__nand2_1
X_15988_ u_core.arr_sa_p[1] u_core.u_top.u_core.pend_p[1] VSS VSS VDD VDD _09931_ sky130_fd_sc_hd__nand2_1
X_15989_ u_core.arr_sa_n[16] u_core.u_top.u_core.pend_n[16] VSS VSS VDD VDD _09932_ sky130_fd_sc_hd__nand2_1
X_15990_ _09929_ _09930_ _09931_ _09932_ VSS VSS VDD VDD _09933_ sky130_fd_sc_hd__nand4_1
X_15991_ _09840_ _09928_ _09933_ VSS VSS VDD VDD _09934_ sky130_fd_sc_hd__nor3_1
X_15992_ u_core.arr_sa_n[1] u_core.u_top.u_core.pend_n[1] VSS VSS VDD VDD _09935_ sky130_fd_sc_hd__nand2_1
X_15993_ u_core.arr_sa_p[19] u_core.u_top.u_core.pend_p[19] VSS VSS VDD VDD _09936_ sky130_fd_sc_hd__nand2_1
X_15994_ u_core.arr_sa_p[5] u_core.u_top.u_core.pend_p[5] VSS VSS VDD VDD _09937_ sky130_fd_sc_hd__nand2_1
X_15995_ u_core.arr_sa_n[10] u_core.u_top.u_core.pend_n[10] VSS VSS VDD VDD _09938_ sky130_fd_sc_hd__nand2_1
X_15996_ _09935_ _09936_ _09937_ _09938_ VSS VSS VDD VDD _09939_ sky130_fd_sc_hd__nand4_1
X_15997_ u_core.arr_sa_p[6] u_core.u_top.u_core.pend_p[6] VSS VSS VDD VDD _09940_ sky130_fd_sc_hd__nand2_1
X_15998_ u_core.arr_sa_n[6] u_core.u_top.u_core.pend_n[6] VSS VSS VDD VDD _09941_ sky130_fd_sc_hd__nand2_1
X_15999_ u_core.arr_sa_n[20] u_core.u_top.u_core.pend_n[20] VSS VSS VDD VDD _09942_ sky130_fd_sc_hd__nand2_1
X_16000_ u_core.arr_sa_n[4] u_core.u_top.u_core.pend_n[4] VSS VSS VDD VDD _09943_ sky130_fd_sc_hd__nand2_1
X_16001_ _09940_ _09941_ _09942_ _09943_ VSS VSS VDD VDD _09944_ sky130_fd_sc_hd__nand4_1
X_16002_ u_core.arr_sa_n[12] u_core.u_top.u_core.pend_n[12] VSS VSS VDD VDD _09945_ sky130_fd_sc_hd__nand2_1
X_16003_ u_core.arr_sa_n[19] u_core.u_top.u_core.pend_n[19] VSS VSS VDD VDD _09946_ sky130_fd_sc_hd__nand2_1
X_16004_ u_core.arr_sa_p[4] u_core.u_top.u_core.pend_p[4] VSS VSS VDD VDD _09947_ sky130_fd_sc_hd__nand2_1
X_16005_ u_core.arr_sa_n[11] u_core.u_top.u_core.pend_n[11] VSS VSS VDD VDD _09948_ sky130_fd_sc_hd__nand2_1
X_16006_ _09945_ _09946_ _09947_ _09948_ VSS VSS VDD VDD _09949_ sky130_fd_sc_hd__nand4_1
X_16007_ u_core.arr_sa_p[2] u_core.u_top.u_core.pend_p[2] VSS VSS VDD VDD _09950_ sky130_fd_sc_hd__nand2_1
X_16008_ u_core.arr_sa_p[8] u_core.u_top.u_core.pend_p[8] VSS VSS VDD VDD _09951_ sky130_fd_sc_hd__nand2_1
X_16009_ u_core.arr_sa_p[17] u_core.u_top.u_core.pend_p[17] VSS VSS VDD VDD _09952_ sky130_fd_sc_hd__nand2_1
X_16010_ u_core.arr_sa_n[7] u_core.u_top.u_core.pend_n[7] VSS VSS VDD VDD _09953_ sky130_fd_sc_hd__nand2_1
X_16011_ _09950_ _09951_ _09952_ _09953_ VSS VSS VDD VDD _09954_ sky130_fd_sc_hd__nand4_1
X_16012_ _09939_ _09944_ _09949_ _09954_ VSS VSS VDD VDD _09955_ sky130_fd_sc_hd__nor4_1
X_16013_ _09912_ _09923_ _09934_ _09955_ VSS VSS VDD VDD _09956_ sky130_fd_sc_hd__nand4_1
X_16014_ _09891_ net721 VSS VSS VDD VDD _09957_ sky130_fd_sc_hd__and2_1
X_16015_ net792 _09957_ VSS VSS VDD VDD _09958_ sky130_fd_sc_hd__nand2_1
X_16016_ _09890_ _09958_ net898 VSS VSS VDD VDD _09959_ sky130_fd_sc_hd__a21oi_1
X_16017_ net895 _09959_ VSS VSS VDD VDD _09960_ sky130_fd_sc_hd__nor2_1
X_16019_ net898 net897 VSS VSS VDD VDD _09962_ sky130_fd_sc_hd__nor2_1
X_16020_ net895 net885 VSS VSS VDD VDD _09963_ sky130_fd_sc_hd__nand2_1
X_16021_ net1000 _09963_ VSS VSS VDD VDD _09964_ sky130_fd_sc_hd__nor2_1
X_16023_ _09960_ _09964_ net896 VSS VSS VDD VDD _09966_ sky130_fd_sc_hd__o21ai_0
X_16024_ net952 _0888_[4] VSS VSS VDD VDD _09967_ sky130_fd_sc_hd__nor2_1
X_16025_ net952 _02631_ _09967_ VSS VSS VDD VDD _09968_ sky130_fd_sc_hd__a21oi_1
X_16026_ u_core.u_top.u_core.r_prow[2] u_core.u_top.u_core.r_prow[1] net955 VSS VSS VDD VDD _09969_ sky130_fd_sc_hd__and3b_1
X_16028_ u_core.u_top.u_core.r_prow[2] _09968_ _09969_ VSS VSS VDD VDD _09971_ sky130_fd_sc_hd__a21oi_1
X_16029_ net952 u_core.u_top.u_core.r_prow[2] VSS VSS VDD VDD _09972_ sky130_fd_sc_hd__and2_1
X_16030_ _09969_ _09972_ VSS VSS VDD VDD _09973_ sky130_fd_sc_hd__nor2_1
X_16031_ net951 _09973_ VSS VSS VDD VDD _09974_ sky130_fd_sc_hd__nand2_1
X_16032_ net952 u_core.u_top.u_core.r_prow[2] _0888_[4] VSS VSS VDD VDD _09975_ sky130_fd_sc_hd__nand3b_1
X_16033_ net951 _09975_ VSS VSS VDD VDD _09976_ sky130_fd_sc_hd__nand2_1
X_16034_ net950 _09976_ VSS VSS VDD VDD _09977_ sky130_fd_sc_hd__nor2_1
X_16035_ _09971_ _09974_ _09977_ VSS VSS VDD VDD _09978_ sky130_fd_sc_hd__a21oi_1
X_16036_ _02751_ _02752_ net952 VSS VSS VDD VDD _09979_ sky130_fd_sc_hd__mux2i_1
X_16037_ net950 net953 _03073_ VSS VSS VDD VDD _09980_ sky130_fd_sc_hd__nand3_1
X_16038_ _09979_ _09980_ VSS VSS VDD VDD _09981_ sky130_fd_sc_hd__nor2_1
X_16039_ net952 VSS VSS VDD VDD _09982_ sky130_fd_sc_hd__inv_1
X_16040_ _02751_ _03074_ VSS VSS VDD VDD _09983_ sky130_fd_sc_hd__nand2b_1
X_16041_ _09982_ u_core.u_top.u_core.r_prow[2] _09983_ _06483_ net950 VSS VSS VDD VDD _09984_ sky130_fd_sc_hd__a311oi_1
X_16042_ net950 VSS VSS VDD VDD _09985_ sky130_fd_sc_hd__inv_1
X_16043_ _09985_ _09969_ _09972_ VSS VSS VDD VDD _09986_ sky130_fd_sc_hd__nor3_1
X_16044_ _09981_ _09984_ _09986_ net951 VSS VSS VDD VDD _09987_ sky130_fd_sc_hd__o31ai_1
X_16045_ _09971_ _09987_ VSS VSS VDD VDD _09988_ sky130_fd_sc_hd__xor2_1
X_16047_ net950 net953 u_core.u_top.u_core.r_prow[1] net955 VSS VSS VDD VDD _09990_ sky130_fd_sc_hd__nor4bb_1
X_16048_ net950 _06480_ _0888_[0] _09990_ _06209_ VSS VSS VDD VDD _09991_ sky130_fd_sc_hd__a311oi_1
X_16049_ net950 net955 VSS VSS VDD VDD _09992_ sky130_fd_sc_hd__nor2_1
X_16050_ u_core.u_top.u_core.r_prow[2] _06482_ _09979_ _09992_ VSS VSS VDD VDD _09993_ sky130_fd_sc_hd__nand4_1
X_16051_ u_core.u_top.u_core.r_prow[2] net955 VSS VSS VDD VDD _09994_ sky130_fd_sc_hd__nand2_1
X_16052_ _09985_ _06482_ _09979_ _09994_ VSS VSS VDD VDD _09995_ sky130_fd_sc_hd__or4_4
X_16053_ _09969_ _09972_ VSS VSS VDD VDD _09996_ sky130_fd_sc_hd__or2_2
X_16054_ _09991_ _09993_ _09995_ _09996_ VSS VSS VDD VDD _09997_ sky130_fd_sc_hd__a31oi_4
X_16055_ _09996_ _09991_ _09993_ _09995_ VSS VSS VDD VDD _09998_ sky130_fd_sc_hd__and4_4
X_16056_ _09997_ _09998_ VSS VSS VDD VDD _09999_ sky130_fd_sc_hd__nor2_2
X_16057_ net953 _09979_ _09969_ VSS VSS VDD VDD _10000_ sky130_fd_sc_hd__a21oi_2
X_16058_ _03074_ _03073_ net950 VSS VSS VDD VDD _10001_ sky130_fd_sc_hd__mux2i_1
X_16059_ _06209_ _10001_ VSS VSS VDD VDD _10002_ sky130_fd_sc_hd__nor2_1
X_16060_ _10000_ net687 VSS VSS VDD VDD _10003_ sky130_fd_sc_hd__xor2_1
X_16061_ _03281_ _10003_ VSS VSS VDD VDD _10004_ sky130_fd_sc_hd__nor2_1
X_16062_ net660 _09999_ _10004_ VSS VSS VDD VDD _10005_ sky130_fd_sc_hd__nor3_1
X_16063_ _02751_ _0888_[1] VSS VSS VDD VDD _10006_ sky130_fd_sc_hd__nand2b_1
X_16064_ net952 u_core.u_top.u_core.r_prow[2] _02631_ VSS VSS VDD VDD _10007_ sky130_fd_sc_hd__nand3_1
X_16065_ _06209_ net955 _09975_ _10006_ _10007_ VSS VSS VDD VDD _10008_ sky130_fd_sc_hd__o41a_1
X_16066_ _0890_[1] net955 VSS VSS VDD VDD _10009_ sky130_fd_sc_hd__nand2b_1
X_16067_ u_core.u_top.u_core.r_prow[2] _09979_ _10009_ _09969_ _10007_ VSS VSS VDD VDD _10010_ sky130_fd_sc_hd__a2111oi_0
X_16068_ net950 net951 _09975_ VSS VSS VDD VDD _10011_ sky130_fd_sc_hd__nand3_1
X_16069_ _09969_ _09972_ _06209_ VSS VSS VDD VDD _10012_ sky130_fd_sc_hd__o21ai_0
X_16070_ net950 _10008_ _10010_ _10011_ _10012_ VSS VSS VDD VDD _10013_ sky130_fd_sc_hd__o221ai_1
X_16071_ net948 _06479_ VSS VSS VDD VDD _10014_ sky130_fd_sc_hd__nor2_1
X_16072_ net667 _10014_ VSS VSS VDD VDD _10015_ sky130_fd_sc_hd__nand2_1
X_16073_ _06209_ _03282_ _10001_ VSS VSS VDD VDD _10016_ sky130_fd_sc_hd__nor3_1
X_16074_ _03074_ _03073_ net950 VSS VSS VDD VDD _10017_ sky130_fd_sc_hd__mux2_1
X_16075_ net951 _10017_ _03282_ VSS VSS VDD VDD _10018_ sky130_fd_sc_hd__a21oi_1
X_16076_ _10016_ _10018_ _10000_ VSS VSS VDD VDD _10019_ sky130_fd_sc_hd__mux2i_1
X_16077_ net948 net949 VSS VSS VDD VDD _10020_ sky130_fd_sc_hd__nand2_1
X_16078_ net660 _09999_ _10019_ _10020_ net667 VSS VSS VDD VDD _10021_ sky130_fd_sc_hd__a311o_1
X_16079_ _10005_ _10015_ _10021_ VSS VSS VDD VDD _10022_ sky130_fd_sc_hd__o21ai_1
X_16080_ net668 _10022_ VSS VSS VDD VDD _10023_ sky130_fd_sc_hd__xnor2_1
X_16081_ _09997_ _09998_ _10003_ _03281_ _10014_ VSS VSS VDD VDD _10024_ sky130_fd_sc_hd__o221ai_1
X_16082_ _09997_ _09998_ _10020_ _10019_ VSS VSS VDD VDD _10025_ sky130_fd_sc_hd__or4b_4
X_16083_ net660 _10024_ _10025_ VSS VSS VDD VDD _10026_ sky130_fd_sc_hd__and3_4
X_16084_ _10024_ _10025_ net660 VSS VSS VDD VDD _10027_ sky130_fd_sc_hd__a21oi_4
X_16085_ net953 _09979_ VSS VSS VDD VDD _10028_ sky130_fd_sc_hd__and2_0
X_16086_ _09969_ _10028_ net687 VSS VSS VDD VDD _10029_ sky130_fd_sc_hd__nor3_1
X_16087_ net955 net953 VSS VSS VDD VDD _10030_ sky130_fd_sc_hd__nor2b_1
X_16088_ net951 _10030_ _06487_ _10028_ net687 VSS VSS VDD VDD _10031_ sky130_fd_sc_hd__a32o_1
X_16089_ _06482_ _09994_ VSS VSS VDD VDD _10032_ sky130_fd_sc_hd__nor2_1
X_16090_ net953 net955 VSS VSS VDD VDD _10033_ sky130_fd_sc_hd__nor2_1
X_16091_ _10032_ _10033_ _06209_ VSS VSS VDD VDD _10034_ sky130_fd_sc_hd__o21a_1
X_16092_ u_core.u_top.u_core.r_prow[1] _10017_ _06487_ VSS VSS VDD VDD _10035_ sky130_fd_sc_hd__a21oi_1
X_16093_ _06209_ net953 _0888_[0] _10035_ VSS VSS VDD VDD _10036_ sky130_fd_sc_hd__nor4_1
X_16094_ _10029_ _10031_ _10034_ _10036_ _10014_ VSS VSS VDD VDD _10037_ sky130_fd_sc_hd__o41ai_1
X_16095_ _10030_ _06482_ VSS VSS VDD VDD _10038_ sky130_fd_sc_hd__nand2_1
X_16096_ net953 _09979_ _09969_ _06209_ VSS VSS VDD VDD _10039_ sky130_fd_sc_hd__a211oi_1
X_16097_ _10000_ _10038_ _10039_ net687 VSS VSS VDD VDD _10040_ sky130_fd_sc_hd__a211o_1
X_16098_ _0003_[0] _06487_ VSS VSS VDD VDD _10041_ sky130_fd_sc_hd__nor2_1
X_16099_ net953 _09979_ _10001_ _09969_ VSS VSS VDD VDD _10042_ sky130_fd_sc_hd__a211oi_1
X_16100_ _10041_ _10042_ net951 VSS VSS VDD VDD _10043_ sky130_fd_sc_hd__o21ai_0
X_16101_ _10040_ _10043_ _10020_ VSS VSS VDD VDD _10044_ sky130_fd_sc_hd__a21o_1
X_16102_ _09999_ _10037_ _10044_ VSS VSS VDD VDD _10045_ sky130_fd_sc_hd__nand3_1
X_16103_ _10029_ _10031_ _10034_ _10036_ _10014_ VSS VSS VDD VDD _10046_ sky130_fd_sc_hd__o41a_1
X_16104_ _10040_ _10043_ _10020_ VSS VSS VDD VDD _10047_ sky130_fd_sc_hd__a21oi_1
X_16105_ _09997_ _09998_ VSS VSS VDD VDD _10048_ sky130_fd_sc_hd__or2_2
X_16106_ _10046_ _10047_ _10048_ VSS VSS VDD VDD _10049_ sky130_fd_sc_hd__o21ai_2
X_16107_ u_core.u_top.u_core.r_prow[7] _03281_ VSS VSS VDD VDD _10050_ sky130_fd_sc_hd__nor2b_1
X_16108_ u_core.u_top.u_core.r_prow[7] _03282_ _10050_ _06479_ VSS VSS VDD VDD _10051_ sky130_fd_sc_hd__a211oi_1
X_16109_ _10000_ net687 _10051_ VSS VSS VDD VDD _10052_ sky130_fd_sc_hd__xnor3_1
X_16110_ _02654_ _10052_ VSS VSS VDD VDD _10053_ sky130_fd_sc_hd__nand2_1
X_16111_ _10045_ _10049_ _10053_ VSS VSS VDD VDD _10054_ sky130_fd_sc_hd__a21oi_1
X_16112_ _10029_ _10031_ _10034_ _10036_ VSS VSS VDD VDD _10055_ sky130_fd_sc_hd__nor4_1
X_16113_ net660 _09999_ _10055_ VSS VSS VDD VDD _10056_ sky130_fd_sc_hd__nor3_1
X_16114_ net948 net667 VSS VSS VDD VDD _10057_ sky130_fd_sc_hd__nor2_1
X_16115_ _10040_ _10043_ _09997_ _09998_ VSS VSS VDD VDD _10058_ sky130_fd_sc_hd__a211oi_1
X_16116_ net949 net667 VSS VSS VDD VDD _10059_ sky130_fd_sc_hd__nand2_1
X_16117_ net948 net660 _10058_ _10059_ VSS VSS VDD VDD _10060_ sky130_fd_sc_hd__a31oi_1
X_16118_ net948 net660 _09999_ _10055_ VSS VSS VDD VDD _10061_ sky130_fd_sc_hd__or4_4
X_16119_ _10040_ _10043_ net667 VSS VSS VDD VDD _10062_ sky130_fd_sc_hd__a21oi_1
X_16120_ net949 net667 VSS VSS VDD VDD _10063_ sky130_fd_sc_hd__nor2_1
X_16121_ net948 net660 _09999_ _10062_ _10063_ VSS VSS VDD VDD _10064_ sky130_fd_sc_hd__a41o_1
X_16122_ _10056_ _10057_ _10060_ _10061_ _10064_ VSS VSS VDD VDD _10065_ sky130_fd_sc_hd__a221oi_4
X_16123_ _10026_ _10027_ _10054_ _10065_ VSS VSS VDD VDD _10066_ sky130_fd_sc_hd__o31ai_2
X_16124_ net946 _06508_ VSS VSS VDD VDD _10067_ sky130_fd_sc_hd__nor2_1
X_16125_ u_core.u_top.u_core.r_prow[9] VSS VSS VDD VDD _10068_ sky130_fd_sc_hd__inv_1
X_16126_ _10068_ _06508_ VSS VSS VDD VDD _10069_ sky130_fd_sc_hd__nor2_1
X_16127_ _10026_ _10027_ VSS VSS VDD VDD _10070_ sky130_fd_sc_hd__nor2_4
X_16128_ net687 _10051_ VSS VSS VDD VDD _10071_ sky130_fd_sc_hd__xnor2_1
X_16129_ _10000_ _10071_ VSS VSS VDD VDD _10072_ sky130_fd_sc_hd__xnor2_1
X_16130_ _02653_ _10045_ _10049_ _10072_ VSS VSS VDD VDD _10073_ sky130_fd_sc_hd__and4_1
X_16131_ _10070_ _10073_ _10065_ VSS VSS VDD VDD _10074_ sky130_fd_sc_hd__o21bai_1
X_16132_ _10066_ _10067_ _10069_ _10074_ VSS VSS VDD VDD _10075_ sky130_fd_sc_hd__a22oi_2
X_16133_ _10023_ _10075_ VSS VSS VDD VDD _10076_ sky130_fd_sc_hd__xnor2_2
X_16134_ _10065_ VSS VSS VDD VDD _10077_ sky130_fd_sc_hd__inv_1
X_16135_ _10068_ net947 VSS VSS VDD VDD _10078_ sky130_fd_sc_hd__nand2_1
X_16136_ _10046_ _10047_ _09999_ VSS VSS VDD VDD _10079_ sky130_fd_sc_hd__o21ai_0
X_16137_ _10048_ _10037_ _10044_ VSS VSS VDD VDD _10080_ sky130_fd_sc_hd__nand3_1
X_16138_ _0007_[1] VSS VSS VDD VDD _02652_ sky130_fd_sc_hd__inv_1
X_16139_ _02652_ _0900_[0] _10072_ VSS VSS VDD VDD _10081_ sky130_fd_sc_hd__nor3_1
X_16140_ _10079_ _10080_ _10081_ _10027_ _10026_ VSS VSS VDD VDD _10082_ sky130_fd_sc_hd__a311oi_4
X_16141_ _0007_[1] _0900_[0] VSS VSS VDD VDD _10083_ sky130_fd_sc_hd__nand2b_1
X_16142_ _10052_ _10083_ VSS VSS VDD VDD _10084_ sky130_fd_sc_hd__nor2_1
X_16143_ _10045_ _10049_ _10069_ _10084_ VSS VSS VDD VDD _10085_ sky130_fd_sc_hd__nand4_1
X_16144_ _10068_ _06508_ net660 VSS VSS VDD VDD _10086_ sky130_fd_sc_hd__nor3_1
X_16145_ net660 _10069_ VSS VSS VDD VDD _10087_ sky130_fd_sc_hd__and2_1
X_16146_ _10024_ _10025_ VSS VSS VDD VDD _10088_ sky130_fd_sc_hd__nand2_1
X_16147_ _10086_ _10087_ _10088_ VSS VSS VDD VDD _10089_ sky130_fd_sc_hd__mux2i_1
X_16148_ _10078_ _10082_ _10085_ _10089_ VSS VSS VDD VDD _10090_ sky130_fd_sc_hd__o211ai_2
X_16149_ _10077_ _10090_ VSS VSS VDD VDD _10091_ sky130_fd_sc_hd__xnor2_2
X_16150_ _10045_ _10049_ _10053_ net946 VSS VSS VDD VDD _10092_ sky130_fd_sc_hd__a211oi_1
X_16151_ net946 _10073_ _10092_ _06508_ VSS VSS VDD VDD _10093_ sky130_fd_sc_hd__a211oi_2
X_16152_ _10070_ _10093_ VSS VSS VDD VDD _10094_ sky130_fd_sc_hd__xnor2_2
X_16153_ u_core.u_top.u_core.r_prow[11] VSS VSS VDD VDD _10095_ sky130_fd_sc_hd__inv_1
X_16154_ net954 _10095_ VSS VSS VDD VDD _10096_ sky130_fd_sc_hd__nand2_1
X_16155_ _10046_ _10047_ VSS VSS VDD VDD _10097_ sky130_fd_sc_hd__nor2_1
X_16156_ _10068_ _0007_[1] _0007_[0] _10052_ VSS VSS VDD VDD _10098_ sky130_fd_sc_hd__or4_4
X_16157_ _10068_ _0007_[1] _0007_[0] _10052_ VSS VSS VDD VDD _10099_ sky130_fd_sc_hd__nand4_1
X_16158_ _10098_ _10099_ _06508_ VSS VSS VDD VDD _10100_ sky130_fd_sc_hd__a21oi_1
X_16159_ _10048_ _10097_ _10100_ VSS VSS VDD VDD _10101_ sky130_fd_sc_hd__xnor3_1
X_16160_ _02654_ _02653_ net946 VSS VSS VDD VDD _10102_ sky130_fd_sc_hd__mux2i_1
X_16161_ _06508_ _10102_ VSS VSS VDD VDD _10103_ sky130_fd_sc_hd__nor2_1
X_16162_ _10052_ _10103_ VSS VSS VDD VDD _10104_ sky130_fd_sc_hd__xnor2_1
X_16163_ _03283_ _10101_ _10104_ VSS VSS VDD VDD _10105_ sky130_fd_sc_hd__nor3_1
X_16164_ _10094_ _10096_ _10105_ VSS VSS VDD VDD _10106_ sky130_fd_sc_hd__or3_1
X_16165_ _03284_ _10101_ _10104_ VSS VSS VDD VDD _10107_ sky130_fd_sc_hd__nand3b_1
X_16166_ net954 u_core.u_top.u_core.r_prow[11] _10107_ VSS VSS VDD VDD _10108_ sky130_fd_sc_hd__and3_1
X_16167_ _10108_ _10091_ _10094_ VSS VSS VDD VDD _10109_ sky130_fd_sc_hd__nand3_1
X_16168_ _10091_ _10106_ _10109_ VSS VSS VDD VDD _10110_ sky130_fd_sc_hd__o21ai_0
X_16169_ _10076_ _10110_ VSS VSS VDD VDD _10111_ sky130_fd_sc_hd__xnor2_1
X_16170_ _06492_ _0900_[0] _10083_ net947 VSS VSS VDD VDD _10112_ sky130_fd_sc_hd__o22ai_1
X_16171_ _10101_ _10104_ _10112_ _10095_ net954 VSS VSS VDD VDD _10113_ sky130_fd_sc_hd__o311ai_1
X_16172_ _06508_ _06491_ _0007_[0] VSS VSS VDD VDD _10114_ sky130_fd_sc_hd__or3_1
X_16173_ net947 _02652_ _0900_[0] _10104_ _10114_ VSS VSS VDD VDD _10115_ sky130_fd_sc_hd__o311a_1
X_16174_ _10101_ _10115_ VSS VSS VDD VDD _10116_ sky130_fd_sc_hd__nand2_1
X_16175_ net954 u_core.u_top.u_core.r_prow[11] _10116_ VSS VSS VDD VDD _10117_ sky130_fd_sc_hd__nand3_1
X_16176_ _10113_ _10117_ _10094_ VSS VSS VDD VDD _10118_ sky130_fd_sc_hd__mux2i_1
X_16177_ _10091_ _10118_ VSS VSS VDD VDD _10119_ sky130_fd_sc_hd__xor2_1
X_16178_ net954 VSS VSS VDD VDD _10120_ sky130_fd_sc_hd__inv_1
X_16179_ u_core.u_top.u_core.r_prow[11] _10104_ _10112_ VSS VSS VDD VDD _10121_ sky130_fd_sc_hd__nor3_1
X_16180_ u_core.u_top.u_core.r_prow[11] _10115_ _10121_ VSS VSS VDD VDD _10122_ sky130_fd_sc_hd__a21oi_1
X_16181_ _10120_ _10122_ VSS VSS VDD VDD _10123_ sky130_fd_sc_hd__nor2_1
X_16182_ _10101_ _10123_ VSS VSS VDD VDD _10124_ sky130_fd_sc_hd__xnor2_1
X_16183_ _10096_ _10105_ _10108_ VSS VSS VDD VDD _10125_ sky130_fd_sc_hd__o21bai_1
X_16184_ _10094_ _10125_ VSS VSS VDD VDD _10126_ sky130_fd_sc_hd__xor2_1
X_16185_ _10119_ _10124_ _10126_ VSS VSS VDD VDD _10127_ sky130_fd_sc_hd__or3_1
X_16186_ _10091_ _10094_ VSS VSS VDD VDD _10128_ sky130_fd_sc_hd__nor2_1
X_16187_ _10113_ _10076_ _10128_ VSS VSS VDD VDD _10129_ sky130_fd_sc_hd__and3b_4
X_16188_ _10091_ _10094_ VSS VSS VDD VDD _10130_ sky130_fd_sc_hd__nand2_1
X_16189_ _10076_ _10130_ _10117_ VSS VSS VDD VDD _10131_ sky130_fd_sc_hd__nor3_1
X_16190_ _09971_ net951 VSS VSS VDD VDD _10132_ sky130_fd_sc_hd__nand2b_1
X_16191_ net950 net951 _09996_ _10132_ VSS VSS VDD VDD _10133_ sky130_fd_sc_hd__a22o_1
X_16192_ _09975_ _10133_ VSS VSS VDD VDD _10134_ sky130_fd_sc_hd__nand2_1
X_16193_ net660 _10058_ VSS VSS VDD VDD _10135_ sky130_fd_sc_hd__nand2_1
X_16194_ net668 net667 _10020_ VSS VSS VDD VDD _10136_ sky130_fd_sc_hd__nor3_1
X_16195_ net668 net667 _10014_ VSS VSS VDD VDD _10137_ sky130_fd_sc_hd__nand3_1
X_16196_ _10135_ _10136_ _10137_ _10056_ VSS VSS VDD VDD _10138_ sky130_fd_sc_hd__o2bb2ai_1
X_16197_ _10134_ _10138_ VSS VSS VDD VDD _10139_ sky130_fd_sc_hd__xor2_1
X_16198_ _10078_ _10082_ VSS VSS VDD VDD _10140_ sky130_fd_sc_hd__nor2_1
X_16199_ _10068_ net668 _10022_ VSS VSS VDD VDD _10141_ sky130_fd_sc_hd__xnor3_1
X_16200_ _10085_ _10089_ _10065_ VSS VSS VDD VDD _10142_ sky130_fd_sc_hd__a21oi_1
X_16201_ _10065_ _10140_ _10141_ net947 _10142_ VSS VSS VDD VDD _10143_ sky130_fd_sc_hd__a221oi_1
X_16202_ _10139_ _10143_ VSS VSS VDD VDD _10144_ sky130_fd_sc_hd__xnor2_1
X_16203_ _10129_ _10131_ _10144_ VSS VSS VDD VDD _10145_ sky130_fd_sc_hd__o21a_1
X_16204_ _10144_ _10129_ _10131_ VSS VSS VDD VDD _10146_ sky130_fd_sc_hd__nor3_1
X_16205_ _10111_ _10127_ _10145_ _10146_ VSS VSS VDD VDD _10147_ sky130_fd_sc_hd__a211oi_1
X_16206_ u_core.u_top.u_core.r_prow[2] _02633_ VSS VSS VDD VDD _10148_ sky130_fd_sc_hd__and2_1
X_16207_ _09973_ _10148_ _09975_ VSS VSS VDD VDD _10149_ sky130_fd_sc_hd__o21ai_0
X_16208_ net950 _09975_ _09973_ VSS VSS VDD VDD _10150_ sky130_fd_sc_hd__and3_1
X_16209_ net950 _09971_ _09973_ VSS VSS VDD VDD _10151_ sky130_fd_sc_hd__nor3_1
X_16210_ _10150_ _10151_ net951 VSS VSS VDD VDD _10152_ sky130_fd_sc_hd__o21ai_0
X_16211_ _10149_ _10152_ VSS VSS VDD VDD _10153_ sky130_fd_sc_hd__xor2_1
X_16212_ net660 _09999_ _10019_ net667 VSS VSS VDD VDD _10154_ sky130_fd_sc_hd__a31oi_1
X_16213_ net668 _10154_ VSS VSS VDD VDD _10155_ sky130_fd_sc_hd__nor2_1
X_16214_ net948 net949 _09975_ VSS VSS VDD VDD _10156_ sky130_fd_sc_hd__nand3_1
X_16215_ _10005_ _10134_ _10137_ VSS VSS VDD VDD _10157_ sky130_fd_sc_hd__or3_1
X_16216_ _10133_ _10155_ _10156_ _10157_ VSS VSS VDD VDD _10158_ sky130_fd_sc_hd__o31a_1
X_16217_ _10153_ _10158_ VSS VSS VDD VDD _10159_ sky130_fd_sc_hd__xor2_1
X_16218_ _10023_ _10066_ _10139_ net946 VSS VSS VDD VDD _10160_ sky130_fd_sc_hd__a211oi_1
X_16219_ net668 _10022_ VSS VSS VDD VDD _10161_ sky130_fd_sc_hd__xor2_1
X_16220_ _10134_ _10138_ VSS VSS VDD VDD _10162_ sky130_fd_sc_hd__xnor2_1
X_16221_ _10161_ _10074_ _10162_ _10068_ VSS VSS VDD VDD _10163_ sky130_fd_sc_hd__a211oi_1
X_16222_ _10160_ _10163_ net947 VSS VSS VDD VDD _10164_ sky130_fd_sc_hd__o21ai_1
X_16223_ _10159_ _10164_ VSS VSS VDD VDD _10165_ sky130_fd_sc_hd__xnor2_1
X_16224_ u_core.u_top.u_core.r_prow[11] _10107_ _10091_ _10094_ VSS VSS VDD VDD _10166_ sky130_fd_sc_hd__nand4_1
X_16225_ u_core.u_top.u_core.r_prow[11] _10105_ VSS VSS VDD VDD _10167_ sky130_fd_sc_hd__nor2_1
X_16226_ _10076_ _10128_ _10144_ _10167_ _10120_ VSS VSS VDD VDD _10168_ sky130_fd_sc_hd__a41oi_1
X_16227_ _10076_ _10144_ _10166_ _10168_ VSS VSS VDD VDD _10169_ sky130_fd_sc_hd__o31ai_1
X_16228_ _10165_ _10169_ VSS VSS VDD VDD _10170_ sky130_fd_sc_hd__xor2_1
X_16229_ u_core.u_top.u_core.r_prow[11] _10091_ _10094_ _10116_ VSS VSS VDD VDD _10171_ sky130_fd_sc_hd__nand4_1
X_16230_ _10076_ _10144_ _10171_ VSS VSS VDD VDD _10172_ sky130_fd_sc_hd__nor3_2
X_16231_ u_core.u_top.u_core.r_prow[11] _10159_ _10164_ VSS VSS VDD VDD _10173_ sky130_fd_sc_hd__xor3_1
X_16232_ _10144_ _10129_ _10172_ _10173_ _10120_ VSS VSS VDD VDD _10174_ sky130_fd_sc_hd__a2111oi_4
X_16233_ _10077_ _10082_ _10023_ VSS VSS VDD VDD _10175_ sky130_fd_sc_hd__o21ai_0
X_16234_ _10132_ _10149_ VSS VSS VDD VDD _10176_ sky130_fd_sc_hd__nand2b_1
X_16235_ _09996_ _10176_ net950 VSS VSS VDD VDD _10177_ sky130_fd_sc_hd__a21oi_1
X_16236_ _09976_ _09973_ _10177_ VSS VSS VDD VDD _10178_ sky130_fd_sc_hd__a21oi_1
X_16237_ _10056_ _10134_ _10137_ VSS VSS VDD VDD _10179_ sky130_fd_sc_hd__or3_1
X_16238_ _10178_ _10179_ _10153_ VSS VSS VDD VDD _10180_ sky130_fd_sc_hd__a21oi_1
X_16239_ _10135_ _10134_ _10136_ _10178_ VSS VSS VDD VDD _10181_ sky130_fd_sc_hd__a31oi_1
X_16240_ _10067_ _10162_ _10175_ _10180_ _10181_ VSS VSS VDD VDD _10182_ sky130_fd_sc_hd__a311o_1
X_16241_ _10045_ _10049_ _10084_ _10070_ VSS VSS VDD VDD _10183_ sky130_fd_sc_hd__a31oi_1
X_16242_ _10065_ _10183_ _10161_ VSS VSS VDD VDD _10184_ sky130_fd_sc_hd__o21ai_0
X_16243_ _10181_ _10180_ VSS VSS VDD VDD _10185_ sky130_fd_sc_hd__nor2_1
X_16244_ _10069_ _10139_ _10184_ _10185_ VSS VSS VDD VDD _10186_ sky130_fd_sc_hd__a31oi_1
X_16245_ _10159_ _10182_ _10186_ VSS VSS VDD VDD _10187_ sky130_fd_sc_hd__a21oi_1
X_16246_ _10174_ _10187_ VSS VSS VDD VDD _10188_ sky130_fd_sc_hd__xnor2_1
X_16247_ _10147_ _10170_ _10188_ VSS VSS VDD VDD _10189_ sky130_fd_sc_hd__and3_1
X_16249_ net971 u_core.u_top.bus_wdata[0] VSS VSS VDD VDD _10191_ sky130_fd_sc_hd__nor2b_1
X_16251_ u_core.u_top.bus_addr[0] u_core.u_top.bus_addr[1] _07278_ VSS VSS VDD VDD _10192_ sky130_fd_sc_hd__a21oi_1
X_16252_ net866 net812 _10192_ VSS VSS VDD VDD _10193_ sky130_fd_sc_hd__nor3_1
X_16253_ _06606_ _06596_ net798 net797 VSS VSS VDD VDD _10194_ sky130_fd_sc_hd__nor4_1
X_16254_ _10193_ _10194_ VSS VSS VDD VDD _10195_ sky130_fd_sc_hd__nand2_1
X_16255_ u_core.u_top.bus_we _06599_ _10195_ VSS VSS VDD VDD _10196_ sky130_fd_sc_hd__nand3_1
X_16256_ u_core.u_top.u_core.r_en net865 VSS VSS VDD VDD _10197_ sky130_fd_sc_hd__nand2_1
X_16257_ _07278_ _10196_ _10197_ VSS VSS VDD VDD _10198_ sky130_fd_sc_hd__nor3_1
X_16258_ net884 net704 VSS VSS VDD VDD _10199_ sky130_fd_sc_hd__and2_1
X_16261_ _10189_ net686 VSS VSS VDD VDD _10202_ sky130_fd_sc_hd__nand2_1
X_16262_ net862 _09966_ _10202_ VSS VSS VDD VDD _1085_[2] sky130_fd_sc_hd__nand3_1
X_16263_ net896 net895 VSS VSS VDD VDD _10203_ sky130_fd_sc_hd__nor2_1
X_16264_ net883 net885 VSS VSS VDD VDD _10204_ sky130_fd_sc_hd__nand2_1
X_16266_ net964 u_core.u_top.bus_wdata[6] VSS VSS VDD VDD _10206_ sky130_fd_sc_hd__nor2b_1
X_16267_ u_core.u_top.bus_we net865 _10195_ VSS VSS VDD VDD _10207_ sky130_fd_sc_hd__nand3_1
X_16268_ _06581_ _10207_ VSS VSS VDD VDD _1314_ sky130_fd_sc_hd__nor2_1
X_16269_ net884 _10206_ _1314_ VSS VSS VDD VDD _10208_ sky130_fd_sc_hd__and3_1
X_16271_ net972 net704 net685 VSS VSS VDD VDD _10210_ sky130_fd_sc_hd__a21oi_1
X_16272_ _2033_[1] net685 VSS VSS VDD VDD _10211_ sky130_fd_sc_hd__nand2_1
X_16273_ _10189_ _10210_ _10211_ VSS VSS VDD VDD _10212_ sky130_fd_sc_hd__a21boi_0
X_16274_ net896 VSS VSS VDD VDD _10213_ sky130_fd_sc_hd__inv_1
X_16275_ _10213_ net895 VSS VSS VDD VDD _10214_ sky130_fd_sc_hd__nand2_1
X_16276_ net898 VSS VSS VDD VDD _10215_ sky130_fd_sc_hd__clkinv_1
X_16277_ _10215_ net897 VSS VSS VDD VDD _10216_ sky130_fd_sc_hd__nand2_1
X_16278_ _10214_ _10216_ VSS VSS VDD VDD _10217_ sky130_fd_sc_hd__nor2_4
X_16282_ _10213_ net898 _09890_ VSS VSS VDD VDD _10221_ sky130_fd_sc_hd__nor3_1
X_16283_ _09891_ net721 VSS VSS VDD VDD _10222_ sky130_fd_sc_hd__nand2_1
X_16284_ _10215_ _10222_ net897 VSS VSS VDD VDD _10223_ sky130_fd_sc_hd__a21oi_1
X_16285_ net898 net1000 VSS VSS VDD VDD _10224_ sky130_fd_sc_hd__nand2_1
X_16286_ net897 _10224_ net896 VSS VSS VDD VDD _10225_ sky130_fd_sc_hd__a21oi_1
X_16287_ net895 _10221_ _10223_ _10225_ VSS VSS VDD VDD _10226_ sky130_fd_sc_hd__nor4_1
X_16288_ _10217_ _10226_ VSS VSS VDD VDD _10227_ sky130_fd_sc_hd__nor2_1
X_16289_ _10204_ _10212_ _10227_ VSS VSS VDD VDD _1085_[1] sky130_fd_sc_hd__o21ai_1
X_16291_ net972 net971 net958 net704 VSS VSS VDD VDD _10229_ sky130_fd_sc_hd__nand4_1
X_16292_ _10189_ _10229_ net685 VSS VSS VDD VDD _10230_ sky130_fd_sc_hd__a21o_2
X_16293_ net884 _10206_ _1314_ VSS VSS VDD VDD _10231_ sky130_fd_sc_hd__nand3_1
X_16295_ _2033_[1] net684 net885 VSS VSS VDD VDD _10233_ sky130_fd_sc_hd__o21ai_0
X_16296_ net1000 VSS VSS VDD VDD _10234_ sky130_fd_sc_hd__inv_1
X_16297_ net897 net989 VSS VSS VDD VDD _10235_ sky130_fd_sc_hd__nor2_1
X_16298_ u_core.u_top.u_core.state[1] VSS VSS VDD VDD _10236_ sky130_fd_sc_hd__clkinv_1
X_16299_ net896 _10236_ VSS VSS VDD VDD _10237_ sky130_fd_sc_hd__nor2_1
X_16300_ _10235_ _10237_ net895 VSS VSS VDD VDD _10238_ sky130_fd_sc_hd__o21ai_0
X_16301_ _10236_ _10222_ VSS VSS VDD VDD _10239_ sky130_fd_sc_hd__nand2_1
X_16302_ _10213_ net895 VSS VSS VDD VDD _10240_ sky130_fd_sc_hd__nor2_1
X_16303_ _10239_ net861 VSS VSS VDD VDD _10241_ sky130_fd_sc_hd__nand2_1
X_16304_ _10238_ _10241_ net898 VSS VSS VDD VDD _10242_ sky130_fd_sc_hd__a21oi_1
X_16305_ net883 _10233_ _10242_ VSS VSS VDD VDD _10243_ sky130_fd_sc_hd__a21oi_1
X_16306_ _08079_ _10230_ _10243_ VSS VSS VDD VDD _1085_[0] sky130_fd_sc_hd__o21ai_1
X_16307_ net898 net861 VSS VSS VDD VDD _10244_ sky130_fd_sc_hd__nand2_1
X_16309_ u_core.u_top.u_core.amp[2] u_core.u_top.u_core.amp[1] u_core.u_top.u_core.amp[0] VSS VSS VDD VDD _10246_ sky130_fd_sc_hd__nand3_1
X_16310_ u_core.u_top.u_core.amp[3] _10246_ VSS VSS VDD VDD _10247_ sky130_fd_sc_hd__xor2_1
X_16311_ net790 _10247_ VSS VSS VDD VDD _1064_[3] sky130_fd_sc_hd__nor2_1
X_16312_ u_core.u_top.u_core.amp[2] _02700_ VSS VSS VDD VDD _10248_ sky130_fd_sc_hd__xnor2_1
X_16313_ net790 _10248_ VSS VSS VDD VDD _1064_[2] sky130_fd_sc_hd__nor2_1
X_16314_ _02699_ net790 VSS VSS VDD VDD _1064_[1] sky130_fd_sc_hd__nor2_1
X_16315_ u_core.u_top.u_core.amp[0] net790 VSS VSS VDD VDD _1064_[0] sky130_fd_sc_hd__nor2_1
X_16316_ net895 net896 VSS VSS VDD VDD _10249_ sky130_fd_sc_hd__nand2b_1
X_16317_ _10214_ _10249_ _10216_ VSS VSS VDD VDD _10250_ sky130_fd_sc_hd__a21oi_4
X_16319_ u_core.u_top.u_core.r_pdata[45] u_core.u_top.u_core.r_pdata[44] VSS VSS VDD VDD _10252_ sky130_fd_sc_hd__nand2_1
X_16320_ net885 _10240_ VSS VSS VDD VDD _10253_ sky130_fd_sc_hd__nand2_1
X_16322_ net721 _10252_ _10253_ VSS VSS VDD VDD _10255_ sky130_fd_sc_hd__nor3_1
X_16323_ _09905_ net702 _10253_ VSS VSS VDD VDD _10256_ sky130_fd_sc_hd__nor3_1
X_16324_ _10252_ _10253_ _10255_ _10256_ VSS VSS VDD VDD _10257_ sky130_fd_sc_hd__a211oi_1
X_16325_ _10216_ _10249_ VSS VSS VDD VDD _10258_ sky130_fd_sc_hd__nor2_4
X_16327_ u_core.u_top.u_core.pend_n[22] net788 VSS VSS VDD VDD _10260_ sky130_fd_sc_hd__nand2_1
X_16328_ net980 net791 VSS VSS VDD VDD _10261_ sky130_fd_sc_hd__nand2_1
X_16329_ net789 _10257_ _10260_ net980 _10261_ VSS VSS VDD VDD _1060_[22] sky130_fd_sc_hd__o221ai_1
X_16331_ net898 net897 _10249_ VSS VSS VDD VDD _10263_ sky130_fd_sc_hd__nor3_1
X_16333_ u_core.u_top.u_core.r_pdata[43] u_core.u_top.u_core.r_pdata[42] VSS VSS VDD VDD _10265_ sky130_fd_sc_hd__nand2_1
X_16337_ _09925_ net703 _10265_ net720 net859 VSS VSS VDD VDD _10269_ sky130_fd_sc_hd__o221ai_1
X_16338_ net859 _10265_ _10269_ VSS VSS VDD VDD _10270_ sky130_fd_sc_hd__o21ai_0
X_16340_ u_core.arr_sa_n[21] net791 net788 _09844_ VSS VSS VDD VDD _10272_ sky130_fd_sc_hd__a22oi_1
X_16341_ net789 _10270_ _10272_ VSS VSS VDD VDD _1060_[21] sky130_fd_sc_hd__o21ai_0
X_16342_ u_core.u_top.u_core.r_pdata[41] u_core.u_top.u_core.r_pdata[40] VSS VSS VDD VDD _10273_ sky130_fd_sc_hd__nand2_1
X_16343_ _09942_ net703 _10273_ net720 net859 VSS VSS VDD VDD _10274_ sky130_fd_sc_hd__o221ai_1
X_16344_ net859 _10273_ _10274_ VSS VSS VDD VDD _10275_ sky130_fd_sc_hd__o21ai_0
X_16345_ u_core.arr_sa_n[20] net791 net788 _09873_ VSS VSS VDD VDD _10276_ sky130_fd_sc_hd__a22oi_1
X_16346_ net789 _10275_ _10276_ VSS VSS VDD VDD _1060_[20] sky130_fd_sc_hd__o21ai_0
X_16347_ u_core.u_top.u_core.r_pdata[39] u_core.u_top.u_core.r_pdata[38] VSS VSS VDD VDD _10277_ sky130_fd_sc_hd__nand2_1
X_16348_ _09946_ net703 _10277_ net720 net859 VSS VSS VDD VDD _10278_ sky130_fd_sc_hd__o221ai_1
X_16349_ net859 _10277_ _10278_ VSS VSS VDD VDD _10279_ sky130_fd_sc_hd__o21ai_0
X_16350_ u_core.arr_sa_n[19] net791 net788 _09827_ VSS VSS VDD VDD _10280_ sky130_fd_sc_hd__a22oi_1
X_16351_ net789 _10279_ _10280_ VSS VSS VDD VDD _1060_[19] sky130_fd_sc_hd__o21ai_0
X_16352_ u_core.u_top.u_core.r_pdata[37] u_core.u_top.u_core.r_pdata[36] VSS VSS VDD VDD _10281_ sky130_fd_sc_hd__nand2_1
X_16353_ _09903_ net703 _10281_ net720 net859 VSS VSS VDD VDD _10282_ sky130_fd_sc_hd__o221ai_1
X_16354_ net859 _10281_ _10282_ VSS VSS VDD VDD _10283_ sky130_fd_sc_hd__o21ai_0
X_16355_ u_core.arr_sa_n[18] net791 net788 _09850_ VSS VSS VDD VDD _10284_ sky130_fd_sc_hd__a22oi_1
X_16356_ net789 _10283_ _10284_ VSS VSS VDD VDD _1060_[18] sky130_fd_sc_hd__o21ai_0
X_16357_ u_core.u_top.u_core.r_pdata[35] u_core.u_top.u_core.r_pdata[34] VSS VSS VDD VDD _10285_ sky130_fd_sc_hd__nand2_1
X_16358_ _09914_ net703 _10285_ net720 net859 VSS VSS VDD VDD _10286_ sky130_fd_sc_hd__o221ai_1
X_16359_ net859 _10285_ _10286_ VSS VSS VDD VDD _10287_ sky130_fd_sc_hd__o21ai_0
X_16360_ u_core.arr_sa_n[17] net791 net788 _09823_ VSS VSS VDD VDD _10288_ sky130_fd_sc_hd__a22oi_1
X_16361_ net789 _10287_ _10288_ VSS VSS VDD VDD _1060_[17] sky130_fd_sc_hd__o21ai_0
X_16362_ u_core.u_top.u_core.r_pdata[33] u_core.u_top.u_core.r_pdata[32] VSS VSS VDD VDD _10289_ sky130_fd_sc_hd__nand2_1
X_16364_ _09932_ net703 _10289_ net720 net859 VSS VSS VDD VDD _10291_ sky130_fd_sc_hd__o221ai_1
X_16365_ net859 _10289_ _10291_ VSS VSS VDD VDD _10292_ sky130_fd_sc_hd__o21ai_0
X_16367_ u_core.arr_sa_n[16] net791 net788 _09836_ VSS VSS VDD VDD _10294_ sky130_fd_sc_hd__a22oi_1
X_16368_ net789 _10292_ _10294_ VSS VSS VDD VDD _1060_[16] sky130_fd_sc_hd__o21ai_0
X_16369_ u_core.u_top.u_core.r_pdata[31] u_core.u_top.u_core.r_pdata[30] VSS VSS VDD VDD _10295_ sky130_fd_sc_hd__nand2_1
X_16370_ _09915_ net703 _10295_ net720 net859 VSS VSS VDD VDD _10296_ sky130_fd_sc_hd__o221ai_1
X_16371_ net859 _10295_ _10296_ VSS VSS VDD VDD _10297_ sky130_fd_sc_hd__o21ai_0
X_16372_ u_core.arr_sa_n[15] net791 net788 _09868_ VSS VSS VDD VDD _10298_ sky130_fd_sc_hd__a22oi_1
X_16373_ net789 _10297_ _10298_ VSS VSS VDD VDD _1060_[15] sky130_fd_sc_hd__o21ai_0
X_16376_ u_core.u_top.u_core.r_pdata[29] u_core.u_top.u_core.r_pdata[28] VSS VSS VDD VDD _10301_ sky130_fd_sc_hd__nand2_1
X_16377_ _09919_ net703 _10301_ net720 net859 VSS VSS VDD VDD _10302_ sky130_fd_sc_hd__o221ai_1
X_16378_ net859 _10301_ _10302_ VSS VSS VDD VDD _10303_ sky130_fd_sc_hd__o21ai_0
X_16379_ u_core.arr_sa_n[14] net791 net788 _09859_ VSS VSS VDD VDD _10304_ sky130_fd_sc_hd__a22oi_1
X_16380_ net789 _10303_ _10304_ VSS VSS VDD VDD _1060_[14] sky130_fd_sc_hd__o21ai_0
X_16381_ u_core.u_top.u_core.r_pdata[27] u_core.u_top.u_core.r_pdata[26] VSS VSS VDD VDD _10305_ sky130_fd_sc_hd__nand2_1
X_16382_ _09920_ net703 _10305_ net720 net860 VSS VSS VDD VDD _10306_ sky130_fd_sc_hd__o221ai_1
X_16383_ net860 _10305_ _10306_ VSS VSS VDD VDD _10307_ sky130_fd_sc_hd__o21ai_0
X_16384_ u_core.arr_sa_n[13] net791 net788 _09856_ VSS VSS VDD VDD _10308_ sky130_fd_sc_hd__a22oi_1
X_16385_ _10250_ _10307_ _10308_ VSS VSS VDD VDD _1060_[13] sky130_fd_sc_hd__o21ai_0
X_16386_ u_core.u_top.u_core.r_pdata[25] u_core.u_top.u_core.r_pdata[24] VSS VSS VDD VDD _10309_ sky130_fd_sc_hd__nand2_1
X_16388_ _09945_ net703 _10309_ net720 net859 VSS VSS VDD VDD _10311_ sky130_fd_sc_hd__o221ai_1
X_16389_ net859 _10309_ _10311_ VSS VSS VDD VDD _10312_ sky130_fd_sc_hd__o21ai_0
X_16390_ _0562_ _10214_ _10216_ VSS VSS VDD VDD _10313_ sky130_fd_sc_hd__nor3_1
X_16391_ _0562_ u_core.u_top.u_core.pend_n[12] net788 _10313_ VSS VSS VDD VDD _10314_ sky130_fd_sc_hd__a31oi_1
X_16392_ net789 _10312_ _10314_ VSS VSS VDD VDD _1060_[12] sky130_fd_sc_hd__o21ai_0
X_16394_ u_core.u_top.u_core.r_pdata[23] u_core.u_top.u_core.r_pdata[22] VSS VSS VDD VDD _10316_ sky130_fd_sc_hd__nand2_1
X_16396_ _09948_ net703 _10316_ net720 net860 VSS VSS VDD VDD _10318_ sky130_fd_sc_hd__o221ai_1
X_16397_ net860 _10316_ _10318_ VSS VSS VDD VDD _10319_ sky130_fd_sc_hd__o21ai_0
X_16398_ u_core.arr_sa_n[11] net791 net788 _09877_ VSS VSS VDD VDD _10320_ sky130_fd_sc_hd__a22oi_1
X_16399_ _10250_ _10319_ _10320_ VSS VSS VDD VDD _1060_[11] sky130_fd_sc_hd__o21ai_0
X_16400_ u_core.u_top.u_core.r_pdata[21] u_core.u_top.u_core.r_pdata[20] VSS VSS VDD VDD _10321_ sky130_fd_sc_hd__nand2_1
X_16401_ _09938_ net702 _10321_ net720 net858 VSS VSS VDD VDD _10322_ sky130_fd_sc_hd__o221ai_1
X_16402_ net858 _10321_ _10322_ VSS VSS VDD VDD _10323_ sky130_fd_sc_hd__o21ai_0
X_16404_ u_core.arr_sa_n[10] net791 net788 _09830_ VSS VSS VDD VDD _10325_ sky130_fd_sc_hd__a22oi_1
X_16405_ _10250_ _10323_ _10325_ VSS VSS VDD VDD _1060_[10] sky130_fd_sc_hd__o21ai_0
X_16406_ u_core.u_top.u_core.r_pdata[19] u_core.u_top.u_core.r_pdata[18] VSS VSS VDD VDD _10326_ sky130_fd_sc_hd__nand2_1
X_16407_ _09908_ net702 _10326_ net721 net860 VSS VSS VDD VDD _10327_ sky130_fd_sc_hd__o221ai_1
X_16408_ net860 _10326_ _10327_ VSS VSS VDD VDD _10328_ sky130_fd_sc_hd__o21ai_0
X_16409_ _0542_ _10214_ _10216_ VSS VSS VDD VDD _10329_ sky130_fd_sc_hd__nor3_1
X_16410_ _0542_ u_core.u_top.u_core.pend_n[9] _10258_ _10329_ VSS VSS VDD VDD _10330_ sky130_fd_sc_hd__a31oi_1
X_16411_ net789 _10328_ _10330_ VSS VSS VDD VDD _1060_[9] sky130_fd_sc_hd__o21ai_0
X_16412_ u_core.u_top.u_core.r_pdata[17] u_core.u_top.u_core.r_pdata[16] VSS VSS VDD VDD _10331_ sky130_fd_sc_hd__nand2_1
X_16413_ _09929_ net702 _10331_ net721 net858 VSS VSS VDD VDD _10332_ sky130_fd_sc_hd__o221ai_1
X_16414_ net858 _10331_ _10332_ VSS VSS VDD VDD _10333_ sky130_fd_sc_hd__o21ai_0
X_16415_ u_core.arr_sa_n[8] _10217_ _10258_ _09847_ VSS VSS VDD VDD _10334_ sky130_fd_sc_hd__a22oi_1
X_16416_ _10250_ _10333_ _10334_ VSS VSS VDD VDD _1060_[8] sky130_fd_sc_hd__o21ai_0
X_16417_ u_core.u_top.u_core.r_pdata[15] u_core.u_top.u_core.r_pdata[14] VSS VSS VDD VDD _10335_ sky130_fd_sc_hd__nand2_1
X_16418_ _09953_ net702 _10335_ net721 net858 VSS VSS VDD VDD _10336_ sky130_fd_sc_hd__o221ai_1
X_16419_ net858 _10335_ _10336_ VSS VSS VDD VDD _10337_ sky130_fd_sc_hd__o21ai_0
X_16420_ u_core.arr_sa_n[7] net791 _10258_ _09833_ VSS VSS VDD VDD _10338_ sky130_fd_sc_hd__a22oi_1
X_16421_ _10250_ _10337_ _10338_ VSS VSS VDD VDD _1060_[7] sky130_fd_sc_hd__o21ai_0
X_16422_ u_core.u_top.u_core.r_pdata[13] u_core.u_top.u_core.r_pdata[12] VSS VSS VDD VDD _10339_ sky130_fd_sc_hd__nand2_1
X_16424_ _09941_ net702 _10339_ net721 net860 VSS VSS VDD VDD _10341_ sky130_fd_sc_hd__o221ai_1
X_16425_ net860 _10339_ _10341_ VSS VSS VDD VDD _10342_ sky130_fd_sc_hd__o21ai_0
X_16426_ u_core.arr_sa_n[6] _10217_ _10258_ _09880_ VSS VSS VDD VDD _10343_ sky130_fd_sc_hd__a22oi_1
X_16427_ net789 _10342_ _10343_ VSS VSS VDD VDD _1060_[6] sky130_fd_sc_hd__o21ai_0
X_16428_ u_core.u_top.u_core.r_pdata[11] u_core.u_top.u_core.r_pdata[10] VSS VSS VDD VDD _10344_ sky130_fd_sc_hd__nand2_1
X_16429_ _09897_ net702 _10344_ net721 net858 VSS VSS VDD VDD _10345_ sky130_fd_sc_hd__o221ai_1
X_16430_ net858 _10344_ _10345_ VSS VSS VDD VDD _10346_ sky130_fd_sc_hd__o21ai_0
X_16431_ u_core.arr_sa_n[5] _10217_ _10258_ _09815_ VSS VSS VDD VDD _10347_ sky130_fd_sc_hd__a22oi_1
X_16432_ _10250_ _10346_ _10347_ VSS VSS VDD VDD _1060_[5] sky130_fd_sc_hd__o21ai_0
X_16434_ u_core.u_top.u_core.r_pdata[9] u_core.u_top.u_core.r_pdata[8] VSS VSS VDD VDD _10349_ sky130_fd_sc_hd__nand2_1
X_16435_ _09943_ net703 _10349_ net720 net860 VSS VSS VDD VDD _10350_ sky130_fd_sc_hd__o221ai_1
X_16436_ net859 _10349_ _10350_ VSS VSS VDD VDD _10351_ sky130_fd_sc_hd__o21ai_0
X_16438_ u_core.arr_sa_n[4] net791 net788 _09820_ VSS VSS VDD VDD _10353_ sky130_fd_sc_hd__a22oi_1
X_16439_ net789 _10351_ _10353_ VSS VSS VDD VDD _1060_[4] sky130_fd_sc_hd__o21ai_0
X_16440_ u_core.u_top.u_core.r_pdata[7] u_core.u_top.u_core.r_pdata[6] VSS VSS VDD VDD _10354_ sky130_fd_sc_hd__nand2_1
X_16441_ _09926_ net703 _10354_ net720 net860 VSS VSS VDD VDD _10355_ sky130_fd_sc_hd__o221ai_1
X_16442_ net860 _10354_ _10355_ VSS VSS VDD VDD _10356_ sky130_fd_sc_hd__o21ai_0
X_16443_ net979 net791 net788 _09818_ VSS VSS VDD VDD _10357_ sky130_fd_sc_hd__a22oi_1
X_16444_ _10250_ _10356_ _10357_ VSS VSS VDD VDD _1060_[3] sky130_fd_sc_hd__o21ai_0
X_16445_ u_core.u_top.u_core.r_pdata[5] u_core.u_top.u_core.r_pdata[4] VSS VSS VDD VDD _10358_ sky130_fd_sc_hd__nand2_1
X_16446_ _09900_ _10222_ _10358_ net721 net858 VSS VSS VDD VDD _10359_ sky130_fd_sc_hd__o221ai_1
X_16447_ net858 _10358_ _10359_ VSS VSS VDD VDD _10360_ sky130_fd_sc_hd__o21ai_0
X_16448_ u_core.arr_sa_n[2] _10217_ _10258_ _09865_ VSS VSS VDD VDD _10361_ sky130_fd_sc_hd__a22oi_1
X_16449_ _10250_ _10360_ _10361_ VSS VSS VDD VDD _1060_[2] sky130_fd_sc_hd__o21ai_0
X_16451_ u_core.u_top.u_core.r_pdata[3] u_core.u_top.u_core.r_pdata[2] VSS VSS VDD VDD _10363_ sky130_fd_sc_hd__nand2_1
X_16452_ _09935_ net703 _10363_ net720 net858 VSS VSS VDD VDD _10364_ sky130_fd_sc_hd__o221ai_1
X_16453_ net858 _10363_ _10364_ VSS VSS VDD VDD _10365_ sky130_fd_sc_hd__o21ai_0
X_16454_ u_core.arr_sa_n[1] net791 net788 _09886_ VSS VSS VDD VDD _10366_ sky130_fd_sc_hd__a22oi_1
X_16455_ _10250_ _10365_ _10366_ VSS VSS VDD VDD _1060_[1] sky130_fd_sc_hd__o21ai_0
X_16456_ u_core.u_top.u_core.r_pdata[1] u_core.u_top.u_core.r_pdata[0] VSS VSS VDD VDD _10367_ sky130_fd_sc_hd__nand2_1
X_16457_ _09902_ _10222_ _10367_ net721 net858 VSS VSS VDD VDD _10368_ sky130_fd_sc_hd__o221ai_1
X_16458_ net858 _10367_ _10368_ VSS VSS VDD VDD _10369_ sky130_fd_sc_hd__o21ai_0
X_16459_ u_core.arr_sa_n[0] _10217_ _10258_ _09883_ VSS VSS VDD VDD _10370_ sky130_fd_sc_hd__a22oi_1
X_16460_ _10250_ _10369_ _10370_ VSS VSS VDD VDD _1060_[0] sky130_fd_sc_hd__o21ai_0
X_16463_ u_core.u_top.u_core.r_pdata[45] u_core.u_top.u_core.r_pdata[44] VSS VSS VDD VDD _10373_ sky130_fd_sc_hd__nor2b_1
X_16464_ net720 _10373_ VSS VSS VDD VDD _10374_ sky130_fd_sc_hd__nand2b_1
X_16465_ _09918_ net703 _10374_ VSS VSS VDD VDD _10375_ sky130_fd_sc_hd__o21ai_0
X_16466_ net860 _10373_ VSS VSS VDD VDD _10376_ sky130_fd_sc_hd__nor2_1
X_16467_ net860 _10375_ _10376_ VSS VSS VDD VDD _10377_ sky130_fd_sc_hd__a21oi_1
X_16469_ u_core.arr_sa_p[22] net791 net788 _09861_ VSS VSS VDD VDD _10379_ sky130_fd_sc_hd__a22oi_1
X_16470_ _10250_ _10377_ _10379_ VSS VSS VDD VDD _1056_[22] sky130_fd_sc_hd__o21ai_0
X_16471_ u_core.u_top.u_core.r_pdata[43] u_core.u_top.u_core.r_pdata[42] VSS VSS VDD VDD _10380_ sky130_fd_sc_hd__nor2b_1
X_16472_ net720 _10380_ VSS VSS VDD VDD _10381_ sky130_fd_sc_hd__nand2b_1
X_16473_ _09892_ net703 _10381_ VSS VSS VDD VDD _10382_ sky130_fd_sc_hd__o21ai_0
X_16474_ net859 _10380_ VSS VSS VDD VDD _10383_ sky130_fd_sc_hd__nor2_1
X_16475_ net859 _10382_ _10383_ VSS VSS VDD VDD _10384_ sky130_fd_sc_hd__a21oi_1
X_16476_ u_core.arr_sa_p[21] net791 net788 _09843_ VSS VSS VDD VDD _10385_ sky130_fd_sc_hd__a22oi_1
X_16477_ net789 _10384_ _10385_ VSS VSS VDD VDD _1056_[21] sky130_fd_sc_hd__o21ai_0
X_16479_ u_core.u_top.u_core.r_pdata[41] u_core.u_top.u_core.r_pdata[40] VSS VSS VDD VDD _10387_ sky130_fd_sc_hd__nor2b_1
X_16480_ net720 _10387_ VSS VSS VDD VDD _10388_ sky130_fd_sc_hd__nand2b_1
X_16481_ _09916_ net703 _10388_ VSS VSS VDD VDD _10389_ sky130_fd_sc_hd__o21ai_0
X_16482_ net859 _10387_ VSS VSS VDD VDD _10390_ sky130_fd_sc_hd__nor2_1
X_16483_ net859 _10389_ _10390_ VSS VSS VDD VDD _10391_ sky130_fd_sc_hd__a21oi_1
X_16484_ u_core.arr_sa_p[20] net791 net788 _09872_ VSS VSS VDD VDD _10392_ sky130_fd_sc_hd__a22oi_1
X_16485_ net789 _10391_ _10392_ VSS VSS VDD VDD _1056_[20] sky130_fd_sc_hd__o21ai_0
X_16486_ u_core.u_top.u_core.r_pdata[39] u_core.u_top.u_core.r_pdata[38] VSS VSS VDD VDD _10393_ sky130_fd_sc_hd__nor2b_1
X_16487_ net720 _10393_ VSS VSS VDD VDD _10394_ sky130_fd_sc_hd__nand2b_1
X_16488_ _09936_ net703 _10394_ VSS VSS VDD VDD _10395_ sky130_fd_sc_hd__o21ai_0
X_16490_ net859 _10393_ VSS VSS VDD VDD _10397_ sky130_fd_sc_hd__nor2_1
X_16491_ net859 _10395_ _10397_ VSS VSS VDD VDD _10398_ sky130_fd_sc_hd__a21oi_1
X_16492_ u_core.arr_sa_p[19] net791 net788 _09826_ VSS VSS VDD VDD _10399_ sky130_fd_sc_hd__a22oi_1
X_16493_ net789 _10398_ _10399_ VSS VSS VDD VDD _1056_[19] sky130_fd_sc_hd__o21ai_0
X_16494_ u_core.u_top.u_core.r_pdata[37] u_core.u_top.u_core.r_pdata[36] VSS VSS VDD VDD _10400_ sky130_fd_sc_hd__nor2b_1
X_16495_ net720 _10400_ VSS VSS VDD VDD _10401_ sky130_fd_sc_hd__nand2b_1
X_16496_ _09927_ net703 _10401_ VSS VSS VDD VDD _10402_ sky130_fd_sc_hd__o21ai_0
X_16497_ net859 _10400_ VSS VSS VDD VDD _10403_ sky130_fd_sc_hd__nor2_1
X_16498_ net859 _10402_ _10403_ VSS VSS VDD VDD _10404_ sky130_fd_sc_hd__a21oi_1
X_16499_ u_core.arr_sa_p[18] net791 net788 _09849_ VSS VSS VDD VDD _10405_ sky130_fd_sc_hd__a22oi_1
X_16500_ net789 _10404_ _10405_ VSS VSS VDD VDD _1056_[18] sky130_fd_sc_hd__o21ai_0
X_16501_ u_core.u_top.u_core.r_pdata[35] u_core.u_top.u_core.r_pdata[34] VSS VSS VDD VDD _10406_ sky130_fd_sc_hd__nor2b_1
X_16502_ net720 _10406_ VSS VSS VDD VDD _10407_ sky130_fd_sc_hd__nand2b_1
X_16503_ _09952_ net703 _10407_ VSS VSS VDD VDD _10408_ sky130_fd_sc_hd__o21ai_0
X_16504_ net859 _10406_ VSS VSS VDD VDD _10409_ sky130_fd_sc_hd__nor2_1
X_16505_ net859 _10408_ _10409_ VSS VSS VDD VDD _10410_ sky130_fd_sc_hd__a21oi_1
X_16507_ u_core.arr_sa_p[17] net791 net788 _09822_ VSS VSS VDD VDD _10412_ sky130_fd_sc_hd__a22oi_1
X_16508_ net789 _10410_ _10412_ VSS VSS VDD VDD _1056_[17] sky130_fd_sc_hd__o21ai_0
X_16509_ u_core.u_top.u_core.r_pdata[33] u_core.u_top.u_core.r_pdata[32] VSS VSS VDD VDD _10413_ sky130_fd_sc_hd__nor2b_1
X_16510_ net720 _10413_ VSS VSS VDD VDD _10414_ sky130_fd_sc_hd__nand2b_1
X_16511_ _09921_ net703 _10414_ VSS VSS VDD VDD _10415_ sky130_fd_sc_hd__o21ai_0
X_16512_ net859 _10413_ VSS VSS VDD VDD _10416_ sky130_fd_sc_hd__nor2_1
X_16513_ net859 _10415_ _10416_ VSS VSS VDD VDD _10417_ sky130_fd_sc_hd__a21oi_1
X_16514_ u_core.arr_sa_p[16] net791 net788 _09835_ VSS VSS VDD VDD _10418_ sky130_fd_sc_hd__a22oi_1
X_16515_ net789 _10417_ _10418_ VSS VSS VDD VDD _1056_[16] sky130_fd_sc_hd__o21ai_0
X_16516_ u_core.u_top.u_core.r_pdata[31] u_core.u_top.u_core.r_pdata[30] VSS VSS VDD VDD _10419_ sky130_fd_sc_hd__nor2b_1
X_16517_ net720 _10419_ VSS VSS VDD VDD _10420_ sky130_fd_sc_hd__nand2b_1
X_16518_ _09895_ net703 _10420_ VSS VSS VDD VDD _10421_ sky130_fd_sc_hd__o21ai_0
X_16519_ net859 _10419_ VSS VSS VDD VDD _10422_ sky130_fd_sc_hd__nor2_1
X_16520_ net859 _10421_ _10422_ VSS VSS VDD VDD _10423_ sky130_fd_sc_hd__a21oi_1
X_16521_ u_core.arr_sa_p[15] net791 net788 _09867_ VSS VSS VDD VDD _10424_ sky130_fd_sc_hd__a22oi_1
X_16522_ net789 _10423_ _10424_ VSS VSS VDD VDD _1056_[15] sky130_fd_sc_hd__o21ai_0
X_16525_ u_core.u_top.u_core.r_pdata[29] u_core.u_top.u_core.r_pdata[28] VSS VSS VDD VDD _10427_ sky130_fd_sc_hd__nor2b_1
X_16526_ net720 _10427_ VSS VSS VDD VDD _10428_ sky130_fd_sc_hd__nand2b_1
X_16527_ _09893_ net703 _10428_ VSS VSS VDD VDD _10429_ sky130_fd_sc_hd__o21ai_0
X_16528_ net860 _10427_ VSS VSS VDD VDD _10430_ sky130_fd_sc_hd__nor2_1
X_16529_ net860 _10429_ _10430_ VSS VSS VDD VDD _10431_ sky130_fd_sc_hd__a21oi_1
X_16530_ u_core.arr_sa_p[14] net791 net788 _09858_ VSS VSS VDD VDD _10432_ sky130_fd_sc_hd__a22oi_1
X_16531_ _10250_ _10431_ _10432_ VSS VSS VDD VDD _1056_[14] sky130_fd_sc_hd__o21ai_0
X_16532_ u_core.u_top.u_core.r_pdata[27] u_core.u_top.u_core.r_pdata[26] VSS VSS VDD VDD _10433_ sky130_fd_sc_hd__nor2b_1
X_16533_ net720 _10433_ VSS VSS VDD VDD _10434_ sky130_fd_sc_hd__nand2b_1
X_16534_ _09894_ net703 _10434_ VSS VSS VDD VDD _10435_ sky130_fd_sc_hd__o21ai_0
X_16535_ net860 _10433_ VSS VSS VDD VDD _10436_ sky130_fd_sc_hd__nor2_1
X_16536_ net860 _10435_ _10436_ VSS VSS VDD VDD _10437_ sky130_fd_sc_hd__a21oi_1
X_16537_ u_core.arr_sa_p[13] net791 net788 _09855_ VSS VSS VDD VDD _10438_ sky130_fd_sc_hd__a22oi_1
X_16538_ _10250_ _10437_ _10438_ VSS VSS VDD VDD _1056_[13] sky130_fd_sc_hd__o21ai_0
X_16540_ u_core.u_top.u_core.r_pdata[25] u_core.u_top.u_core.r_pdata[24] VSS VSS VDD VDD _10440_ sky130_fd_sc_hd__nor2b_1
X_16541_ net720 _10440_ VSS VSS VDD VDD _10441_ sky130_fd_sc_hd__nand2b_1
X_16542_ _09924_ net703 _10441_ VSS VSS VDD VDD _10442_ sky130_fd_sc_hd__o21ai_0
X_16543_ net859 _10440_ VSS VSS VDD VDD _10443_ sky130_fd_sc_hd__nor2_1
X_16544_ net859 _10442_ _10443_ VSS VSS VDD VDD _10444_ sky130_fd_sc_hd__a21oi_1
X_16546_ u_core.arr_sa_p[12] net791 net788 _09870_ VSS VSS VDD VDD _10446_ sky130_fd_sc_hd__a22oi_1
X_16547_ net789 _10444_ _10446_ VSS VSS VDD VDD _1056_[12] sky130_fd_sc_hd__o21ai_0
X_16548_ u_core.u_top.u_core.r_pdata[23] u_core.u_top.u_core.r_pdata[22] VSS VSS VDD VDD _10447_ sky130_fd_sc_hd__nor2b_1
X_16549_ net720 _10447_ VSS VSS VDD VDD _10448_ sky130_fd_sc_hd__nand2b_1
X_16550_ _09930_ net703 _10448_ VSS VSS VDD VDD _10449_ sky130_fd_sc_hd__o21ai_0
X_16551_ net858 _10447_ VSS VSS VDD VDD _10450_ sky130_fd_sc_hd__nor2_1
X_16552_ net858 _10449_ _10450_ VSS VSS VDD VDD _10451_ sky130_fd_sc_hd__a21oi_1
X_16553_ u_core.arr_sa_p[11] net791 net788 _09876_ VSS VSS VDD VDD _10452_ sky130_fd_sc_hd__a22oi_1
X_16554_ _10250_ _10451_ _10452_ VSS VSS VDD VDD _1056_[11] sky130_fd_sc_hd__o21ai_0
X_16556_ u_core.u_top.u_core.r_pdata[21] u_core.u_top.u_core.r_pdata[20] VSS VSS VDD VDD _10454_ sky130_fd_sc_hd__nor2b_1
X_16557_ net721 _10454_ VSS VSS VDD VDD _10455_ sky130_fd_sc_hd__nand2b_1
X_16558_ _09907_ net702 _10455_ VSS VSS VDD VDD _10456_ sky130_fd_sc_hd__o21ai_0
X_16559_ net858 _10454_ VSS VSS VDD VDD _10457_ sky130_fd_sc_hd__nor2_1
X_16560_ net858 _10456_ _10457_ VSS VSS VDD VDD _10458_ sky130_fd_sc_hd__a21oi_1
X_16561_ u_core.arr_sa_p[10] net791 net788 _09829_ VSS VSS VDD VDD _10459_ sky130_fd_sc_hd__a22oi_1
X_16562_ _10250_ _10458_ _10459_ VSS VSS VDD VDD _1056_[10] sky130_fd_sc_hd__o21ai_0
X_16563_ u_core.u_top.u_core.r_pdata[19] u_core.u_top.u_core.r_pdata[18] VSS VSS VDD VDD _10460_ sky130_fd_sc_hd__nor2b_1
X_16564_ net721 _10460_ VSS VSS VDD VDD _10461_ sky130_fd_sc_hd__nand2b_1
X_16565_ _09898_ net702 _10461_ VSS VSS VDD VDD _10462_ sky130_fd_sc_hd__o21ai_0
X_16567_ net860 _10460_ VSS VSS VDD VDD _10464_ sky130_fd_sc_hd__nor2_1
X_16568_ net860 _10462_ _10464_ VSS VSS VDD VDD _10465_ sky130_fd_sc_hd__a21oi_1
X_16569_ u_core.arr_sa_p[9] _10217_ _10258_ _09841_ VSS VSS VDD VDD _10466_ sky130_fd_sc_hd__a22oi_1
X_16570_ net789 _10465_ _10466_ VSS VSS VDD VDD _1056_[9] sky130_fd_sc_hd__o21ai_0
X_16571_ u_core.u_top.u_core.r_pdata[17] u_core.u_top.u_core.r_pdata[16] VSS VSS VDD VDD _10467_ sky130_fd_sc_hd__nor2b_1
X_16572_ net721 _10467_ VSS VSS VDD VDD _10468_ sky130_fd_sc_hd__nand2b_1
X_16573_ _09951_ net702 _10468_ VSS VSS VDD VDD _10469_ sky130_fd_sc_hd__o21ai_0
X_16574_ net858 _10467_ VSS VSS VDD VDD _10470_ sky130_fd_sc_hd__nor2_1
X_16575_ net858 _10469_ _10470_ VSS VSS VDD VDD _10471_ sky130_fd_sc_hd__a21oi_1
X_16576_ u_core.arr_sa_p[8] _10217_ _10258_ _09846_ VSS VSS VDD VDD _10472_ sky130_fd_sc_hd__a22oi_1
X_16577_ _10250_ _10471_ _10472_ VSS VSS VDD VDD _1056_[8] sky130_fd_sc_hd__o21ai_0
X_16578_ u_core.u_top.u_core.r_pdata[15] u_core.u_top.u_core.r_pdata[14] VSS VSS VDD VDD _10473_ sky130_fd_sc_hd__nor2b_1
X_16579_ net721 _10473_ VSS VSS VDD VDD _10474_ sky130_fd_sc_hd__nand2b_1
X_16580_ _09899_ _10222_ _10474_ VSS VSS VDD VDD _10475_ sky130_fd_sc_hd__o21ai_0
X_16581_ net858 _10473_ VSS VSS VDD VDD _10476_ sky130_fd_sc_hd__nor2_1
X_16582_ net858 _10475_ _10476_ VSS VSS VDD VDD _10477_ sky130_fd_sc_hd__a21oi_1
X_16583_ u_core.arr_sa_p[7] _10217_ _10258_ _09832_ VSS VSS VDD VDD _10478_ sky130_fd_sc_hd__a22oi_1
X_16584_ _10250_ _10477_ _10478_ VSS VSS VDD VDD _1056_[7] sky130_fd_sc_hd__o21ai_0
X_16585_ u_core.u_top.u_core.r_pdata[13] u_core.u_top.u_core.r_pdata[12] VSS VSS VDD VDD _10479_ sky130_fd_sc_hd__nor2b_1
X_16586_ net721 _10479_ VSS VSS VDD VDD _10480_ sky130_fd_sc_hd__nand2b_1
X_16587_ _09940_ net702 _10480_ VSS VSS VDD VDD _10481_ sky130_fd_sc_hd__o21ai_0
X_16588_ net858 _10479_ VSS VSS VDD VDD _10482_ sky130_fd_sc_hd__nor2_1
X_16589_ net858 _10481_ _10482_ VSS VSS VDD VDD _10483_ sky130_fd_sc_hd__a21oi_1
X_16590_ u_core.arr_sa_p[6] _10217_ _10258_ _09879_ VSS VSS VDD VDD _10484_ sky130_fd_sc_hd__a22oi_1
X_16591_ _10250_ _10483_ _10484_ VSS VSS VDD VDD _1056_[6] sky130_fd_sc_hd__o21ai_0
X_16592_ u_core.u_top.u_core.r_pdata[11] u_core.u_top.u_core.r_pdata[10] VSS VSS VDD VDD _10485_ sky130_fd_sc_hd__nor2b_1
X_16593_ net721 _10485_ VSS VSS VDD VDD _10486_ sky130_fd_sc_hd__nand2b_1
X_16594_ _09937_ _10222_ _10486_ VSS VSS VDD VDD _10487_ sky130_fd_sc_hd__o21ai_0
X_16595_ net858 _10485_ VSS VSS VDD VDD _10488_ sky130_fd_sc_hd__nor2_1
X_16596_ net858 _10487_ _10488_ VSS VSS VDD VDD _10489_ sky130_fd_sc_hd__a21oi_1
X_16597_ u_core.arr_sa_p[5] _10217_ _10258_ _09814_ VSS VSS VDD VDD _10490_ sky130_fd_sc_hd__a22oi_1
X_16598_ _10250_ _10489_ _10490_ VSS VSS VDD VDD _1056_[5] sky130_fd_sc_hd__o21ai_0
X_16599_ u_core.u_top.u_core.r_pdata[9] u_core.u_top.u_core.r_pdata[8] VSS VSS VDD VDD _10491_ sky130_fd_sc_hd__nor2b_1
X_16600_ net720 _10491_ VSS VSS VDD VDD _10492_ sky130_fd_sc_hd__nand2b_1
X_16601_ _09947_ net703 _10492_ VSS VSS VDD VDD _10493_ sky130_fd_sc_hd__o21ai_0
X_16602_ net860 _10491_ VSS VSS VDD VDD _10494_ sky130_fd_sc_hd__nor2_1
X_16603_ net860 _10493_ _10494_ VSS VSS VDD VDD _10495_ sky130_fd_sc_hd__a21oi_1
X_16604_ _0511_ _10214_ _10216_ VSS VSS VDD VDD _10496_ sky130_fd_sc_hd__nor3_1
X_16605_ _0511_ u_core.u_top.u_core.pend_p[4] net788 _10496_ VSS VSS VDD VDD _10497_ sky130_fd_sc_hd__a31oi_1
X_16606_ net789 _10495_ _10497_ VSS VSS VDD VDD _1056_[4] sky130_fd_sc_hd__o21ai_0
X_16607_ u_core.u_top.u_core.r_pdata[7] u_core.u_top.u_core.r_pdata[6] VSS VSS VDD VDD _10498_ sky130_fd_sc_hd__nor2b_1
X_16608_ net720 _10498_ VSS VSS VDD VDD _10499_ sky130_fd_sc_hd__nand2b_1
X_16609_ _09913_ net703 _10499_ VSS VSS VDD VDD _10500_ sky130_fd_sc_hd__o21ai_0
X_16610_ net860 _10498_ VSS VSS VDD VDD _10501_ sky130_fd_sc_hd__nor2_1
X_16611_ net860 _10500_ _10501_ VSS VSS VDD VDD _10502_ sky130_fd_sc_hd__a21oi_1
X_16612_ net978 net791 net788 _09817_ VSS VSS VDD VDD _10503_ sky130_fd_sc_hd__a22oi_1
X_16613_ _10250_ _10502_ _10503_ VSS VSS VDD VDD _1056_[3] sky130_fd_sc_hd__o21ai_0
X_16614_ u_core.u_top.u_core.r_pdata[5] u_core.u_top.u_core.r_pdata[4] VSS VSS VDD VDD _10504_ sky130_fd_sc_hd__nor2b_1
X_16615_ net721 _10504_ VSS VSS VDD VDD _10505_ sky130_fd_sc_hd__nand2b_1
X_16616_ _09950_ _10222_ _10505_ VSS VSS VDD VDD _10506_ sky130_fd_sc_hd__o21ai_0
X_16617_ net858 _10504_ VSS VSS VDD VDD _10507_ sky130_fd_sc_hd__nor2_1
X_16618_ net858 _10506_ _10507_ VSS VSS VDD VDD _10508_ sky130_fd_sc_hd__a21oi_1
X_16619_ u_core.arr_sa_p[2] _10217_ _10258_ _09864_ VSS VSS VDD VDD _10509_ sky130_fd_sc_hd__a22oi_1
X_16620_ _10250_ _10508_ _10509_ VSS VSS VDD VDD _1056_[2] sky130_fd_sc_hd__o21ai_0
X_16621_ u_core.u_top.u_core.r_pdata[3] u_core.u_top.u_core.r_pdata[2] VSS VSS VDD VDD _10510_ sky130_fd_sc_hd__nor2b_1
X_16622_ net720 _10510_ VSS VSS VDD VDD _10511_ sky130_fd_sc_hd__nand2b_1
X_16623_ _09931_ net703 _10511_ VSS VSS VDD VDD _10512_ sky130_fd_sc_hd__o21ai_0
X_16624_ net858 _10510_ VSS VSS VDD VDD _10513_ sky130_fd_sc_hd__nor2_1
X_16625_ net858 _10512_ _10513_ VSS VSS VDD VDD _10514_ sky130_fd_sc_hd__a21oi_1
X_16626_ u_core.arr_sa_p[1] net791 net788 _09885_ VSS VSS VDD VDD _10515_ sky130_fd_sc_hd__a22oi_1
X_16627_ _10250_ _10514_ _10515_ VSS VSS VDD VDD _1056_[1] sky130_fd_sc_hd__o21ai_0
X_16628_ u_core.u_top.u_core.r_pdata[1] u_core.u_top.u_core.r_pdata[0] VSS VSS VDD VDD _10516_ sky130_fd_sc_hd__nor2b_1
X_16629_ net721 _10516_ VSS VSS VDD VDD _10517_ sky130_fd_sc_hd__nand2b_1
X_16630_ _09904_ _10222_ _10517_ VSS VSS VDD VDD _10518_ sky130_fd_sc_hd__o21ai_0
X_16631_ net860 _10516_ VSS VSS VDD VDD _10519_ sky130_fd_sc_hd__nor2_1
X_16632_ _10263_ _10518_ _10519_ VSS VSS VDD VDD _10520_ sky130_fd_sc_hd__a21oi_1
X_16633_ u_core.arr_sa_p[0] _10217_ _10258_ _09882_ VSS VSS VDD VDD _10521_ sky130_fd_sc_hd__a22oi_1
X_16634_ _10250_ _10520_ _10521_ VSS VSS VDD VDD _1056_[0] sky130_fd_sc_hd__o21ai_0
X_16635_ net896 net895 net885 VSS VSS VDD VDD _10522_ sky130_fd_sc_hd__nand3_2
X_16637_ u_core.arr_sa_p[22] VSS VSS VDD VDD _0630_ sky130_fd_sc_hd__inv_1
X_16638_ _0628_ u_core.u_top.u_core.pend_n[22] u_core.u_top.u_core.pend_p[22] _0630_ VSS VSS VDD VDD _10524_ sky130_fd_sc_hd__o22ai_1
X_16639_ u_core.u_top.u_core.m_fail[22] _10524_ VSS VSS VDD VDD _10525_ sky130_fd_sc_hd__nor2_1
X_16640_ net862 _09862_ net857 _10525_ VSS VSS VDD VDD _1052_[22] sky130_fd_sc_hd__o22ai_1
X_16641_ u_core.arr_sa_p[21] VSS VSS VDD VDD _0623_ sky130_fd_sc_hd__inv_1
X_16642_ _0621_ u_core.u_top.u_core.pend_n[21] u_core.u_top.u_core.pend_p[21] _0623_ VSS VSS VDD VDD _10526_ sky130_fd_sc_hd__o22ai_1
X_16643_ u_core.u_top.u_core.m_fail[21] _10526_ VSS VSS VDD VDD _10527_ sky130_fd_sc_hd__nor2_1
X_16644_ net862 _09845_ net857 _10527_ VSS VSS VDD VDD _1052_[21] sky130_fd_sc_hd__o22ai_1
X_16645_ _0615_ u_core.u_top.u_core.pend_n[20] u_core.u_top.u_core.pend_p[20] _0617_ VSS VSS VDD VDD _10528_ sky130_fd_sc_hd__o22ai_1
X_16646_ u_core.u_top.u_core.m_fail[20] _10528_ VSS VSS VDD VDD _10529_ sky130_fd_sc_hd__nor2_1
X_16647_ net862 _09874_ net857 _10529_ VSS VSS VDD VDD _1052_[20] sky130_fd_sc_hd__o22ai_1
X_16648_ u_core.arr_sa_n[19] VSS VSS VDD VDD _0608_ sky130_fd_sc_hd__inv_1
X_16649_ u_core.arr_sa_p[19] VSS VSS VDD VDD _0610_ sky130_fd_sc_hd__inv_1
X_16650_ _0608_ u_core.u_top.u_core.pend_n[19] u_core.u_top.u_core.pend_p[19] _0610_ VSS VSS VDD VDD _10530_ sky130_fd_sc_hd__o22ai_1
X_16651_ u_core.u_top.u_core.m_fail[19] _10530_ VSS VSS VDD VDD _10531_ sky130_fd_sc_hd__nor2_1
X_16652_ net862 _09828_ net857 _10531_ VSS VSS VDD VDD _1052_[19] sky130_fd_sc_hd__o22ai_1
X_16653_ u_core.arr_sa_p[18] VSS VSS VDD VDD _0604_ sky130_fd_sc_hd__inv_1
X_16654_ _0601_ u_core.u_top.u_core.pend_n[18] u_core.u_top.u_core.pend_p[18] _0604_ VSS VSS VDD VDD _10532_ sky130_fd_sc_hd__o22ai_1
X_16655_ u_core.u_top.u_core.m_fail[18] _10532_ VSS VSS VDD VDD _10533_ sky130_fd_sc_hd__nor2_1
X_16656_ net862 _09851_ net857 _10533_ VSS VSS VDD VDD _1052_[18] sky130_fd_sc_hd__o22ai_1
X_16657_ u_core.arr_sa_p[17] VSS VSS VDD VDD _0597_ sky130_fd_sc_hd__inv_1
X_16658_ _0595_ u_core.u_top.u_core.pend_n[17] u_core.u_top.u_core.pend_p[17] _0597_ VSS VSS VDD VDD _10534_ sky130_fd_sc_hd__o22ai_1
X_16659_ u_core.u_top.u_core.m_fail[17] _10534_ VSS VSS VDD VDD _10535_ sky130_fd_sc_hd__nor2_1
X_16660_ net862 _09824_ net857 _10535_ VSS VSS VDD VDD _1052_[17] sky130_fd_sc_hd__o22ai_1
X_16661_ u_core.arr_sa_n[16] VSS VSS VDD VDD _0588_ sky130_fd_sc_hd__inv_1
X_16662_ u_core.arr_sa_p[16] VSS VSS VDD VDD _0590_ sky130_fd_sc_hd__inv_1
X_16663_ _0588_ u_core.u_top.u_core.pend_n[16] u_core.u_top.u_core.pend_p[16] _0590_ VSS VSS VDD VDD _10536_ sky130_fd_sc_hd__o22ai_1
X_16664_ u_core.u_top.u_core.m_fail[16] _10536_ VSS VSS VDD VDD _10537_ sky130_fd_sc_hd__nor2_1
X_16665_ net862 _09837_ net857 _10537_ VSS VSS VDD VDD _1052_[16] sky130_fd_sc_hd__o22ai_1
X_16666_ u_core.arr_sa_n[15] VSS VSS VDD VDD _0582_ sky130_fd_sc_hd__inv_1
X_16667_ u_core.arr_sa_p[15] VSS VSS VDD VDD _0584_ sky130_fd_sc_hd__inv_1
X_16668_ _0582_ u_core.u_top.u_core.pend_n[15] u_core.u_top.u_core.pend_p[15] _0584_ VSS VSS VDD VDD _10538_ sky130_fd_sc_hd__o22ai_1
X_16669_ u_core.u_top.u_core.m_fail[15] _10538_ VSS VSS VDD VDD _10539_ sky130_fd_sc_hd__nor2_1
X_16670_ net862 _09869_ net857 _10539_ VSS VSS VDD VDD _1052_[15] sky130_fd_sc_hd__o22ai_1
X_16671_ u_core.arr_sa_n[14] VSS VSS VDD VDD _0575_ sky130_fd_sc_hd__inv_1
X_16672_ u_core.arr_sa_p[14] VSS VSS VDD VDD _0577_ sky130_fd_sc_hd__inv_1
X_16673_ _0575_ u_core.u_top.u_core.pend_n[14] u_core.u_top.u_core.pend_p[14] _0577_ VSS VSS VDD VDD _10540_ sky130_fd_sc_hd__o22ai_1
X_16674_ u_core.u_top.u_core.m_fail[14] _10540_ VSS VSS VDD VDD _10541_ sky130_fd_sc_hd__nor2_1
X_16675_ net862 _09860_ net857 _10541_ VSS VSS VDD VDD _1052_[14] sky130_fd_sc_hd__o22ai_1
X_16677_ u_core.arr_sa_n[13] VSS VSS VDD VDD _0568_ sky130_fd_sc_hd__inv_1
X_16678_ u_core.arr_sa_p[13] VSS VSS VDD VDD _0571_ sky130_fd_sc_hd__inv_1
X_16679_ _0568_ u_core.u_top.u_core.pend_n[13] u_core.u_top.u_core.pend_p[13] _0571_ VSS VSS VDD VDD _10543_ sky130_fd_sc_hd__o22ai_1
X_16680_ u_core.u_top.u_core.m_fail[13] _10543_ VSS VSS VDD VDD _10544_ sky130_fd_sc_hd__nor2_1
X_16681_ net862 _09857_ net857 _10544_ VSS VSS VDD VDD _1052_[13] sky130_fd_sc_hd__o22ai_1
X_16683_ u_core.arr_sa_p[12] VSS VSS VDD VDD _0564_ sky130_fd_sc_hd__inv_1
X_16684_ _0562_ u_core.u_top.u_core.pend_n[12] u_core.u_top.u_core.pend_p[12] _0564_ VSS VSS VDD VDD _10546_ sky130_fd_sc_hd__o22ai_1
X_16685_ u_core.u_top.u_core.m_fail[12] _10546_ VSS VSS VDD VDD _10547_ sky130_fd_sc_hd__nor2_1
X_16686_ net862 _09871_ net857 _10547_ VSS VSS VDD VDD _1052_[12] sky130_fd_sc_hd__o22ai_1
X_16687_ u_core.arr_sa_n[11] VSS VSS VDD VDD _0555_ sky130_fd_sc_hd__inv_1
X_16688_ u_core.arr_sa_p[11] VSS VSS VDD VDD _0557_ sky130_fd_sc_hd__inv_1
X_16689_ _0555_ u_core.u_top.u_core.pend_n[11] u_core.u_top.u_core.pend_p[11] _0557_ VSS VSS VDD VDD _10548_ sky130_fd_sc_hd__o22ai_1
X_16690_ u_core.u_top.u_core.m_fail[11] _10548_ VSS VSS VDD VDD _10549_ sky130_fd_sc_hd__nor2_1
X_16691_ net862 _09878_ net857 _10549_ VSS VSS VDD VDD _1052_[11] sky130_fd_sc_hd__o22ai_1
X_16692_ u_core.arr_sa_n[10] VSS VSS VDD VDD _0549_ sky130_fd_sc_hd__inv_1
X_16693_ u_core.arr_sa_p[10] VSS VSS VDD VDD _0551_ sky130_fd_sc_hd__inv_1
X_16694_ _0549_ u_core.u_top.u_core.pend_n[10] u_core.u_top.u_core.pend_p[10] _0551_ VSS VSS VDD VDD _10550_ sky130_fd_sc_hd__o22ai_1
X_16695_ u_core.u_top.u_core.m_fail[10] _10550_ VSS VSS VDD VDD _10551_ sky130_fd_sc_hd__nor2_1
X_16696_ net862 _09831_ net857 _10551_ VSS VSS VDD VDD _1052_[10] sky130_fd_sc_hd__o22ai_1
X_16697_ u_core.arr_sa_p[9] VSS VSS VDD VDD _0544_ sky130_fd_sc_hd__inv_1
X_16698_ _0542_ u_core.u_top.u_core.pend_n[9] u_core.u_top.u_core.pend_p[9] _0544_ VSS VSS VDD VDD _10552_ sky130_fd_sc_hd__o22ai_1
X_16699_ u_core.u_top.u_core.m_fail[9] _10552_ VSS VSS VDD VDD _10553_ sky130_fd_sc_hd__nor2_1
X_16700_ net862 _09842_ net857 _10553_ VSS VSS VDD VDD _1052_[9] sky130_fd_sc_hd__o22ai_1
X_16701_ u_core.arr_sa_n[8] VSS VSS VDD VDD _0535_ sky130_fd_sc_hd__inv_1
X_16702_ u_core.arr_sa_p[8] VSS VSS VDD VDD _0538_ sky130_fd_sc_hd__inv_1
X_16703_ _0535_ u_core.u_top.u_core.pend_n[8] u_core.u_top.u_core.pend_p[8] _0538_ VSS VSS VDD VDD _10554_ sky130_fd_sc_hd__o22ai_1
X_16704_ u_core.u_top.u_core.m_fail[8] _10554_ VSS VSS VDD VDD _10555_ sky130_fd_sc_hd__nor2_1
X_16705_ net862 _09848_ net857 _10555_ VSS VSS VDD VDD _1052_[8] sky130_fd_sc_hd__o22ai_1
X_16706_ u_core.arr_sa_n[7] VSS VSS VDD VDD _0529_ sky130_fd_sc_hd__inv_1
X_16707_ u_core.arr_sa_p[7] VSS VSS VDD VDD _0531_ sky130_fd_sc_hd__inv_1
X_16708_ _0529_ u_core.u_top.u_core.pend_n[7] u_core.u_top.u_core.pend_p[7] _0531_ VSS VSS VDD VDD _10556_ sky130_fd_sc_hd__o22ai_1
X_16709_ u_core.u_top.u_core.m_fail[7] _10556_ VSS VSS VDD VDD _10557_ sky130_fd_sc_hd__nor2_1
X_16710_ net862 _09834_ net857 _10557_ VSS VSS VDD VDD _1052_[7] sky130_fd_sc_hd__o22ai_1
X_16711_ _0522_ u_core.u_top.u_core.pend_n[6] u_core.u_top.u_core.pend_p[6] _0524_ VSS VSS VDD VDD _10558_ sky130_fd_sc_hd__o22ai_1
X_16712_ u_core.u_top.u_core.m_fail[6] _10558_ VSS VSS VDD VDD _10559_ sky130_fd_sc_hd__nor2_1
X_16713_ net862 _09881_ net857 _10559_ VSS VSS VDD VDD _1052_[6] sky130_fd_sc_hd__o22ai_1
X_16714_ u_core.arr_sa_n[5] VSS VSS VDD VDD _0516_ sky130_fd_sc_hd__inv_1
X_16715_ u_core.arr_sa_p[5] VSS VSS VDD VDD _0518_ sky130_fd_sc_hd__inv_1
X_16716_ _0516_ u_core.u_top.u_core.pend_n[5] u_core.u_top.u_core.pend_p[5] _0518_ VSS VSS VDD VDD _10560_ sky130_fd_sc_hd__o22ai_1
X_16717_ u_core.u_top.u_core.m_fail[5] _10560_ VSS VSS VDD VDD _10561_ sky130_fd_sc_hd__nor2_1
X_16718_ net862 _09816_ net857 _10561_ VSS VSS VDD VDD _1052_[5] sky130_fd_sc_hd__o22ai_1
X_16719_ _0509_ u_core.u_top.u_core.pend_n[4] u_core.u_top.u_core.pend_p[4] _0511_ VSS VSS VDD VDD _10562_ sky130_fd_sc_hd__o22ai_1
X_16720_ u_core.u_top.u_core.m_fail[4] _10562_ VSS VSS VDD VDD _10563_ sky130_fd_sc_hd__nor2_1
X_16721_ net862 _09821_ net857 _10563_ VSS VSS VDD VDD _1052_[4] sky130_fd_sc_hd__o22ai_1
X_16722_ net979 VSS VSS VDD VDD _0502_ sky130_fd_sc_hd__inv_1
X_16723_ net978 VSS VSS VDD VDD _0505_ sky130_fd_sc_hd__inv_1
X_16724_ _0502_ u_core.u_top.u_core.pend_n[3] u_core.u_top.u_core.pend_p[3] _0505_ VSS VSS VDD VDD _10564_ sky130_fd_sc_hd__o22ai_1
X_16725_ u_core.u_top.u_core.m_fail[3] _10564_ VSS VSS VDD VDD _10565_ sky130_fd_sc_hd__nor2_1
X_16726_ net862 _09819_ net857 _10565_ VSS VSS VDD VDD _1052_[3] sky130_fd_sc_hd__o22ai_1
X_16727_ u_core.arr_sa_p[2] VSS VSS VDD VDD _0498_ sky130_fd_sc_hd__inv_1
X_16728_ _0496_ u_core.u_top.u_core.pend_n[2] u_core.u_top.u_core.pend_p[2] _0498_ VSS VSS VDD VDD _10566_ sky130_fd_sc_hd__o22ai_1
X_16729_ u_core.u_top.u_core.m_fail[2] _10566_ VSS VSS VDD VDD _10567_ sky130_fd_sc_hd__nor2_1
X_16730_ net862 _09866_ net857 _10567_ VSS VSS VDD VDD _1052_[2] sky130_fd_sc_hd__o22ai_1
X_16731_ u_core.arr_sa_p[1] VSS VSS VDD VDD _0492_ sky130_fd_sc_hd__inv_1
X_16732_ _0490_ u_core.u_top.u_core.pend_n[1] u_core.u_top.u_core.pend_p[1] _0492_ VSS VSS VDD VDD _10568_ sky130_fd_sc_hd__o22ai_1
X_16733_ u_core.u_top.u_core.m_fail[1] _10568_ VSS VSS VDD VDD _10569_ sky130_fd_sc_hd__nor2_1
X_16734_ net862 _09887_ net857 _10569_ VSS VSS VDD VDD _1052_[1] sky130_fd_sc_hd__o22ai_1
X_16735_ u_core.arr_sa_n[0] VSS VSS VDD VDD _0484_ sky130_fd_sc_hd__inv_1
X_16736_ u_core.arr_sa_p[0] VSS VSS VDD VDD _0486_ sky130_fd_sc_hd__inv_1
X_16737_ _0484_ u_core.u_top.u_core.pend_n[0] u_core.u_top.u_core.pend_p[0] _0486_ VSS VSS VDD VDD _10570_ sky130_fd_sc_hd__o22ai_1
X_16738_ u_core.u_top.u_core.m_fail[0] _10570_ VSS VSS VDD VDD _10571_ sky130_fd_sc_hd__nor2_1
X_16739_ net862 _09884_ net857 _10571_ VSS VSS VDD VDD _1052_[0] sky130_fd_sc_hd__o22ai_1
X_16740_ _10215_ u_core.u_top.u_core.state[1] VSS VSS VDD VDD _10572_ sky130_fd_sc_hd__nor2_1
X_16741_ net883 _10572_ VSS VSS VDD VDD _10573_ sky130_fd_sc_hd__nand2_2
X_16744_ u_core.u_top.u_core.r_cnt[4] u_core.u_top.u_core.r_cnt[3] u_core.u_top.u_core.r_cnt[2] VSS VSS VDD VDD _10576_ sky130_fd_sc_hd__and3_1
X_16745_ u_core.u_top.u_core.r_cnt[1] u_core.u_top.u_core.r_cnt[0] _10576_ VSS VSS VDD VDD _10577_ sky130_fd_sc_hd__nand3_1
X_16746_ u_core.u_top.u_core.r_cnt[5] _10577_ VSS VSS VDD VDD _10578_ sky130_fd_sc_hd__xor2_1
X_16747_ _10573_ _10578_ VSS VSS VDD VDD _1049_[5] sky130_fd_sc_hd__nor2_1
X_16748_ u_core.u_top.u_core.r_cnt[3] u_core.u_top.u_core.r_cnt[2] _02901_ VSS VSS VDD VDD _10579_ sky130_fd_sc_hd__nand3_1
X_16749_ u_core.u_top.u_core.r_cnt[4] _10579_ VSS VSS VDD VDD _10580_ sky130_fd_sc_hd__xor2_1
X_16750_ _10573_ _10580_ VSS VSS VDD VDD _1049_[4] sky130_fd_sc_hd__nor2_1
X_16751_ u_core.u_top.u_core.r_cnt[2] u_core.u_top.u_core.r_cnt[1] u_core.u_top.u_core.r_cnt[0] VSS VSS VDD VDD _10581_ sky130_fd_sc_hd__nand3_1
X_16752_ u_core.u_top.u_core.r_cnt[3] _10581_ VSS VSS VDD VDD _10582_ sky130_fd_sc_hd__xor2_1
X_16753_ _10573_ _10582_ VSS VSS VDD VDD _1049_[3] sky130_fd_sc_hd__nor2_1
X_16754_ u_core.u_top.u_core.r_cnt[2] _02901_ VSS VSS VDD VDD _10583_ sky130_fd_sc_hd__xnor2_1
X_16755_ _10573_ _10583_ VSS VSS VDD VDD _1049_[2] sky130_fd_sc_hd__nor2_1
X_16756_ _0373_[1] net883 _10572_ VSS VSS VDD VDD _1049_[1] sky130_fd_sc_hd__and3_1
X_16757_ u_core.u_top.u_core.r_cnt[0] _10573_ VSS VSS VDD VDD _1049_[0] sky130_fd_sc_hd__nor2_1
X_16758_ u_core.u_top.u_core.r_piter[3] u_core.u_top.u_core.r_piter[2] _03024_ VSS VSS VDD VDD _10584_ sky130_fd_sc_hd__nand3_1
X_16759_ u_core.u_top.u_core.r_piter[4] _10584_ VSS VSS VDD VDD _10585_ sky130_fd_sc_hd__xor2_1
X_16760_ net790 _10585_ VSS VSS VDD VDD _1047_[4] sky130_fd_sc_hd__nor2_1
X_16761_ _0969_[1070] u_core.u_top.u_core.r_piter[2] _03023_ VSS VSS VDD VDD _10586_ sky130_fd_sc_hd__nand3_1
X_16762_ _07282_ _10586_ VSS VSS VDD VDD _10587_ sky130_fd_sc_hd__xnor2_1
X_16763_ net790 _10587_ VSS VSS VDD VDD _1047_[3] sky130_fd_sc_hd__nor2_1
X_16764_ u_core.u_top.u_core.r_piter[2] _03024_ VSS VSS VDD VDD _10588_ sky130_fd_sc_hd__xnor2_1
X_16765_ net790 _10588_ VSS VSS VDD VDD _1047_[2] sky130_fd_sc_hd__nor2_1
X_16766_ net898 _0391_[1] net861 VSS VSS VDD VDD _1047_[1] sky130_fd_sc_hd__and3_1
X_16767_ net898 _0391_[0] net861 VSS VSS VDD VDD _1047_[0] sky130_fd_sc_hd__and3_1
X_16768_ net958 VSS VSS VDD VDD _10589_ sky130_fd_sc_hd__inv_1
X_16769_ _10589_ _10236_ net1000 _09806_ _10215_ VSS VSS VDD VDD _10590_ sky130_fd_sc_hd__o2111ai_1
X_16773_ u_core.u_top.bus_we _06596_ net865 VSS VSS VDD VDD _10594_ sky130_fd_sc_hd__nand3_4
X_16775_ u_core.u_top.bus_wdata[46] u_core.u_top.u_core.r_pdata[46] net763 VSS VSS VDD VDD _10596_ sky130_fd_sc_hd__mux2_1
X_16776_ net856 _10596_ VSS VSS VDD VDD _10597_ sky130_fd_sc_hd__nand2_1
X_16777_ _03506_ net856 _10597_ VSS VSS VDD VDD _1044_[46] sky130_fd_sc_hd__o21ai_0
X_16780_ u_core.u_top.bus_wdata[45] u_core.u_top.u_core.r_pdata[45] _10594_ VSS VSS VDD VDD _10600_ sky130_fd_sc_hd__mux2i_1
X_16782_ net821 net855 VSS VSS VDD VDD _10602_ sky130_fd_sc_hd__nor2_1
X_16783_ net855 _10600_ _10602_ VSS VSS VDD VDD _1044_[45] sky130_fd_sc_hd__a21oi_1
X_16784_ u_core.u_top.bus_wdata[44] u_core.u_top.u_core.r_pdata[44] _10594_ VSS VSS VDD VDD _10603_ sky130_fd_sc_hd__mux2_1
X_16785_ net855 _10603_ VSS VSS VDD VDD _10604_ sky130_fd_sc_hd__nand2_1
X_16786_ _03505_ net855 _10604_ VSS VSS VDD VDD _1044_[44] sky130_fd_sc_hd__o21ai_0
X_16787_ u_core.u_top.bus_wdata[43] u_core.u_top.u_core.r_pdata[43] _10594_ VSS VSS VDD VDD _10605_ sky130_fd_sc_hd__mux2i_1
X_16788_ net822 net854 VSS VSS VDD VDD _10606_ sky130_fd_sc_hd__nor2_1
X_16789_ net854 _10605_ _10606_ VSS VSS VDD VDD _1044_[43] sky130_fd_sc_hd__a21oi_1
X_16791_ net967 u_core.u_top.u_core.r_pdata[42] _10594_ VSS VSS VDD VDD _10608_ sky130_fd_sc_hd__mux2_1
X_16792_ net854 _10608_ VSS VSS VDD VDD _10609_ sky130_fd_sc_hd__nand2_1
X_16793_ _03504_ net854 _10609_ VSS VSS VDD VDD _1044_[42] sky130_fd_sc_hd__o21ai_0
X_16794_ u_core.u_top.bus_wdata[41] u_core.u_top.u_core.r_pdata[41] _10594_ VSS VSS VDD VDD _10610_ sky130_fd_sc_hd__mux2i_1
X_16795_ _0180_ net854 VSS VSS VDD VDD _10611_ sky130_fd_sc_hd__nor2_1
X_16796_ net854 _10610_ _10611_ VSS VSS VDD VDD _1044_[41] sky130_fd_sc_hd__a21oi_1
X_16797_ u_core.u_top.bus_wdata[40] u_core.u_top.u_core.r_pdata[40] _10594_ VSS VSS VDD VDD _10612_ sky130_fd_sc_hd__mux2_1
X_16798_ net854 _10612_ VSS VSS VDD VDD _10613_ sky130_fd_sc_hd__nand2_1
X_16799_ _03503_ net854 _10613_ VSS VSS VDD VDD _1044_[40] sky130_fd_sc_hd__o21ai_0
X_16800_ u_core.u_top.bus_wdata[39] u_core.u_top.u_core.r_pdata[39] _10594_ VSS VSS VDD VDD _10614_ sky130_fd_sc_hd__mux2i_1
X_16801_ net824 net854 VSS VSS VDD VDD _10615_ sky130_fd_sc_hd__nor2_1
X_16802_ net854 _10614_ _10615_ VSS VSS VDD VDD _1044_[39] sky130_fd_sc_hd__a21oi_1
X_16804_ u_core.u_top.bus_wdata[38] u_core.u_top.u_core.r_pdata[38] _10594_ VSS VSS VDD VDD _10617_ sky130_fd_sc_hd__mux2_1
X_16805_ net854 _10617_ VSS VSS VDD VDD _10618_ sky130_fd_sc_hd__nand2_1
X_16806_ _03502_ net854 _10618_ VSS VSS VDD VDD _1044_[38] sky130_fd_sc_hd__o21ai_0
X_16807_ u_core.u_top.bus_wdata[37] u_core.u_top.u_core.r_pdata[37] _10594_ VSS VSS VDD VDD _10619_ sky130_fd_sc_hd__mux2i_1
X_16808_ net825 net854 VSS VSS VDD VDD _10620_ sky130_fd_sc_hd__nor2_1
X_16809_ net854 _10619_ _10620_ VSS VSS VDD VDD _1044_[37] sky130_fd_sc_hd__a21oi_1
X_16810_ net969 u_core.u_top.u_core.r_pdata[36] _10594_ VSS VSS VDD VDD _10621_ sky130_fd_sc_hd__mux2_1
X_16811_ net854 _10621_ VSS VSS VDD VDD _10622_ sky130_fd_sc_hd__nand2_1
X_16812_ _03501_ net854 _10622_ VSS VSS VDD VDD _1044_[36] sky130_fd_sc_hd__o21ai_0
X_16813_ u_core.u_top.bus_wdata[35] u_core.u_top.u_core.r_pdata[35] _10594_ VSS VSS VDD VDD _10623_ sky130_fd_sc_hd__mux2i_1
X_16814_ net826 net854 VSS VSS VDD VDD _10624_ sky130_fd_sc_hd__nor2_1
X_16815_ net854 _10623_ _10624_ VSS VSS VDD VDD _1044_[35] sky130_fd_sc_hd__a21oi_1
X_16817_ u_core.u_top.bus_wdata[34] u_core.u_top.u_core.r_pdata[34] _10594_ VSS VSS VDD VDD _10626_ sky130_fd_sc_hd__mux2_1
X_16818_ net854 _10626_ VSS VSS VDD VDD _10627_ sky130_fd_sc_hd__nand2_1
X_16819_ _03500_ net854 _10627_ VSS VSS VDD VDD _1044_[34] sky130_fd_sc_hd__o21ai_0
X_16820_ u_core.u_top.bus_wdata[33] u_core.u_top.u_core.r_pdata[33] _10594_ VSS VSS VDD VDD _10628_ sky130_fd_sc_hd__mux2i_1
X_16821_ net827 net854 VSS VSS VDD VDD _10629_ sky130_fd_sc_hd__nor2_1
X_16822_ net855 _10628_ _10629_ VSS VSS VDD VDD _1044_[33] sky130_fd_sc_hd__a21oi_1
X_16823_ u_core.u_top.bus_wdata[32] u_core.u_top.u_core.r_pdata[32] _10594_ VSS VSS VDD VDD _10630_ sky130_fd_sc_hd__mux2_1
X_16824_ net855 _10630_ VSS VSS VDD VDD _10631_ sky130_fd_sc_hd__nand2_1
X_16825_ _03499_ net854 _10631_ VSS VSS VDD VDD _1044_[32] sky130_fd_sc_hd__o21ai_0
X_16826_ u_core.u_top.bus_wdata[31] u_core.u_top.u_core.r_pdata[31] _10594_ VSS VSS VDD VDD _10632_ sky130_fd_sc_hd__mux2i_1
X_16827_ net828 net854 VSS VSS VDD VDD _10633_ sky130_fd_sc_hd__nor2_1
X_16828_ net854 _10632_ _10633_ VSS VSS VDD VDD _1044_[31] sky130_fd_sc_hd__a21oi_1
X_16829_ u_core.u_top.bus_wdata[30] u_core.u_top.u_core.r_pdata[30] _10594_ VSS VSS VDD VDD _10634_ sky130_fd_sc_hd__mux2_1
X_16830_ net854 _10634_ VSS VSS VDD VDD _10635_ sky130_fd_sc_hd__nand2_1
X_16831_ _03498_ net854 _10635_ VSS VSS VDD VDD _1044_[30] sky130_fd_sc_hd__o21ai_0
X_16832_ u_core.u_top.bus_wdata[29] u_core.u_top.u_core.r_pdata[29] net763 VSS VSS VDD VDD _10636_ sky130_fd_sc_hd__mux2i_1
X_16834_ net829 net855 VSS VSS VDD VDD _10638_ sky130_fd_sc_hd__nor2_1
X_16835_ net855 _10636_ _10638_ VSS VSS VDD VDD _1044_[29] sky130_fd_sc_hd__a21oi_1
X_16836_ u_core.u_top.bus_wdata[28] u_core.u_top.u_core.r_pdata[28] _10594_ VSS VSS VDD VDD _10639_ sky130_fd_sc_hd__mux2_1
X_16837_ net855 _10639_ VSS VSS VDD VDD _10640_ sky130_fd_sc_hd__nand2_1
X_16838_ _03497_ net855 _10640_ VSS VSS VDD VDD _1044_[28] sky130_fd_sc_hd__o21ai_0
X_16839_ u_core.u_top.bus_wdata[27] u_core.u_top.u_core.r_pdata[27] net763 VSS VSS VDD VDD _10641_ sky130_fd_sc_hd__mux2i_1
X_16840_ net831 net855 VSS VSS VDD VDD _10642_ sky130_fd_sc_hd__nor2_1
X_16841_ net855 _10641_ _10642_ VSS VSS VDD VDD _1044_[27] sky130_fd_sc_hd__a21oi_1
X_16842_ u_core.u_top.bus_wdata[26] u_core.u_top.u_core.r_pdata[26] _10594_ VSS VSS VDD VDD _10643_ sky130_fd_sc_hd__mux2_1
X_16843_ net854 _10643_ VSS VSS VDD VDD _10644_ sky130_fd_sc_hd__nand2_1
X_16844_ _03496_ net854 _10644_ VSS VSS VDD VDD _1044_[26] sky130_fd_sc_hd__o21ai_0
X_16847_ u_core.u_top.bus_wdata[25] u_core.u_top.u_core.r_pdata[25] _10594_ VSS VSS VDD VDD _10647_ sky130_fd_sc_hd__mux2i_1
X_16848_ net833 net854 VSS VSS VDD VDD _10648_ sky130_fd_sc_hd__nor2_1
X_16849_ net854 _10647_ _10648_ VSS VSS VDD VDD _1044_[25] sky130_fd_sc_hd__a21oi_1
X_16850_ u_core.u_top.bus_wdata[24] u_core.u_top.u_core.r_pdata[24] _10594_ VSS VSS VDD VDD _10649_ sky130_fd_sc_hd__mux2_1
X_16851_ net854 _10649_ VSS VSS VDD VDD _10650_ sky130_fd_sc_hd__nand2_1
X_16852_ _03495_ net854 _10650_ VSS VSS VDD VDD _1044_[24] sky130_fd_sc_hd__o21ai_0
X_16853_ u_core.u_top.bus_wdata[23] u_core.u_top.u_core.r_pdata[23] _10594_ VSS VSS VDD VDD _10651_ sky130_fd_sc_hd__mux2i_1
X_16854_ _0081_ net854 VSS VSS VDD VDD _10652_ sky130_fd_sc_hd__nor2_1
X_16855_ net854 _10651_ _10652_ VSS VSS VDD VDD _1044_[23] sky130_fd_sc_hd__a21oi_1
X_16857_ u_core.u_top.bus_wdata[22] u_core.u_top.u_core.r_pdata[22] _10594_ VSS VSS VDD VDD _10654_ sky130_fd_sc_hd__mux2_1
X_16858_ net855 _10654_ VSS VSS VDD VDD _10655_ sky130_fd_sc_hd__nand2_1
X_16859_ _03494_ net854 _10655_ VSS VSS VDD VDD _1044_[22] sky130_fd_sc_hd__o21ai_0
X_16860_ u_core.u_top.bus_wdata[21] u_core.u_top.u_core.r_pdata[21] net763 VSS VSS VDD VDD _10656_ sky130_fd_sc_hd__mux2i_1
X_16861_ net834 net856 VSS VSS VDD VDD _10657_ sky130_fd_sc_hd__nor2_1
X_16862_ net856 _10656_ _10657_ VSS VSS VDD VDD _1044_[21] sky130_fd_sc_hd__a21oi_1
X_16863_ u_core.u_top.bus_wdata[20] u_core.u_top.u_core.r_pdata[20] net763 VSS VSS VDD VDD _10658_ sky130_fd_sc_hd__mux2_1
X_16864_ net856 _10658_ VSS VSS VDD VDD _10659_ sky130_fd_sc_hd__nand2_1
X_16865_ _03493_ net856 _10659_ VSS VSS VDD VDD _1044_[20] sky130_fd_sc_hd__o21ai_0
X_16866_ u_core.u_top.bus_wdata[19] u_core.u_top.u_core.r_pdata[19] net763 VSS VSS VDD VDD _10660_ sky130_fd_sc_hd__mux2i_1
X_16867_ net835 net856 VSS VSS VDD VDD _10661_ sky130_fd_sc_hd__nor2_1
X_16868_ net856 _10660_ _10661_ VSS VSS VDD VDD _1044_[19] sky130_fd_sc_hd__a21oi_1
X_16870_ u_core.u_top.bus_wdata[18] u_core.u_top.u_core.r_pdata[18] net763 VSS VSS VDD VDD _10663_ sky130_fd_sc_hd__mux2_1
X_16871_ net856 _10663_ VSS VSS VDD VDD _10664_ sky130_fd_sc_hd__nand2_1
X_16872_ _03492_ net856 _10664_ VSS VSS VDD VDD _1044_[18] sky130_fd_sc_hd__o21ai_0
X_16873_ u_core.u_top.bus_wdata[17] u_core.u_top.u_core.r_pdata[17] net763 VSS VSS VDD VDD _10665_ sky130_fd_sc_hd__mux2i_1
X_16874_ net836 net856 VSS VSS VDD VDD _10666_ sky130_fd_sc_hd__nor2_1
X_16875_ net856 _10665_ _10666_ VSS VSS VDD VDD _1044_[17] sky130_fd_sc_hd__a21oi_1
X_16876_ u_core.u_top.bus_wdata[16] u_core.u_top.u_core.r_pdata[16] net763 VSS VSS VDD VDD _10667_ sky130_fd_sc_hd__mux2_1
X_16877_ net856 _10667_ VSS VSS VDD VDD _10668_ sky130_fd_sc_hd__nand2_1
X_16878_ _03491_ net856 _10668_ VSS VSS VDD VDD _1044_[16] sky130_fd_sc_hd__o21ai_0
X_16879_ u_core.u_top.bus_wdata[15] u_core.u_top.u_core.r_pdata[15] net763 VSS VSS VDD VDD _10669_ sky130_fd_sc_hd__mux2i_1
X_16880_ net837 net856 VSS VSS VDD VDD _10670_ sky130_fd_sc_hd__nor2_1
X_16881_ net856 _10669_ _10670_ VSS VSS VDD VDD _1044_[15] sky130_fd_sc_hd__a21oi_1
X_16882_ u_core.u_top.bus_wdata[14] u_core.u_top.u_core.r_pdata[14] net763 VSS VSS VDD VDD _10671_ sky130_fd_sc_hd__mux2_1
X_16883_ net856 _10671_ VSS VSS VDD VDD _10672_ sky130_fd_sc_hd__nand2_1
X_16884_ _03490_ net856 _10672_ VSS VSS VDD VDD _1044_[14] sky130_fd_sc_hd__o21ai_0
X_16885_ u_core.u_top.bus_wdata[13] u_core.u_top.u_core.r_pdata[13] net763 VSS VSS VDD VDD _10673_ sky130_fd_sc_hd__mux2i_1
X_16886_ net838 net856 VSS VSS VDD VDD _10674_ sky130_fd_sc_hd__nor2_1
X_16887_ net856 _10673_ _10674_ VSS VSS VDD VDD _1044_[13] sky130_fd_sc_hd__a21oi_1
X_16888_ u_core.u_top.bus_wdata[12] u_core.u_top.u_core.r_pdata[12] net763 VSS VSS VDD VDD _10675_ sky130_fd_sc_hd__mux2_1
X_16889_ net856 _10675_ VSS VSS VDD VDD _10676_ sky130_fd_sc_hd__nand2_1
X_16890_ _03489_ net856 _10676_ VSS VSS VDD VDD _1044_[12] sky130_fd_sc_hd__o21ai_0
X_16891_ u_core.u_top.bus_wdata[11] u_core.u_top.u_core.r_pdata[11] net763 VSS VSS VDD VDD _10677_ sky130_fd_sc_hd__mux2i_1
X_16892_ net839 net856 VSS VSS VDD VDD _10678_ sky130_fd_sc_hd__nor2_1
X_16893_ net856 _10677_ _10678_ VSS VSS VDD VDD _1044_[11] sky130_fd_sc_hd__a21oi_1
X_16894_ u_core.u_top.bus_wdata[10] u_core.u_top.u_core.r_pdata[10] net763 VSS VSS VDD VDD _10679_ sky130_fd_sc_hd__mux2_1
X_16895_ net855 _10679_ VSS VSS VDD VDD _10680_ sky130_fd_sc_hd__nand2_1
X_16896_ _03488_ net855 _10680_ VSS VSS VDD VDD _1044_[10] sky130_fd_sc_hd__o21ai_0
X_16897_ u_core.u_top.bus_wdata[9] u_core.u_top.u_core.r_pdata[9] _10594_ VSS VSS VDD VDD _10681_ sky130_fd_sc_hd__mux2i_1
X_16898_ net840 net855 VSS VSS VDD VDD _10682_ sky130_fd_sc_hd__nor2_1
X_16899_ net855 _10681_ _10682_ VSS VSS VDD VDD _1044_[9] sky130_fd_sc_hd__a21oi_1
X_16900_ u_core.u_top.bus_wdata[8] u_core.u_top.u_core.r_pdata[8] _10594_ VSS VSS VDD VDD _10683_ sky130_fd_sc_hd__mux2_1
X_16901_ net855 _10683_ VSS VSS VDD VDD _10684_ sky130_fd_sc_hd__nand2_1
X_16902_ _03487_ net854 _10684_ VSS VSS VDD VDD _1044_[8] sky130_fd_sc_hd__o21ai_0
X_16903_ net964 u_core.u_top.u_core.r_pdata[7] _10594_ VSS VSS VDD VDD _10685_ sky130_fd_sc_hd__mux2i_1
X_16904_ net842 net855 VSS VSS VDD VDD _10686_ sky130_fd_sc_hd__nor2_1
X_16905_ net855 _10685_ _10686_ VSS VSS VDD VDD _1044_[7] sky130_fd_sc_hd__a21oi_1
X_16906_ net965 u_core.u_top.u_core.r_pdata[6] _10594_ VSS VSS VDD VDD _10687_ sky130_fd_sc_hd__mux2_1
X_16907_ net855 _10687_ VSS VSS VDD VDD _10688_ sky130_fd_sc_hd__nand2_1
X_16908_ _03486_ net854 _10688_ VSS VSS VDD VDD _1044_[6] sky130_fd_sc_hd__o21ai_0
X_16909_ net966 u_core.u_top.u_core.r_pdata[5] net763 VSS VSS VDD VDD _10689_ sky130_fd_sc_hd__mux2i_1
X_16910_ net843 net856 VSS VSS VDD VDD _10690_ sky130_fd_sc_hd__nor2_1
X_16911_ net856 _10689_ _10690_ VSS VSS VDD VDD _1044_[5] sky130_fd_sc_hd__a21oi_1
X_16912_ u_core.u_top.bus_wdata[4] u_core.u_top.u_core.r_pdata[4] net763 VSS VSS VDD VDD _10691_ sky130_fd_sc_hd__mux2_1
X_16913_ net856 _10691_ VSS VSS VDD VDD _10692_ sky130_fd_sc_hd__nand2_1
X_16914_ _03485_ net856 _10692_ VSS VSS VDD VDD _1044_[4] sky130_fd_sc_hd__o21ai_0
X_16915_ net968 u_core.u_top.u_core.r_pdata[3] _10594_ VSS VSS VDD VDD _10693_ sky130_fd_sc_hd__mux2i_1
X_16916_ net845 net855 VSS VSS VDD VDD _10694_ sky130_fd_sc_hd__nor2_1
X_16917_ net855 _10693_ _10694_ VSS VSS VDD VDD _1044_[3] sky130_fd_sc_hd__a21oi_1
X_16918_ net970 u_core.u_top.u_core.r_pdata[2] _10594_ VSS VSS VDD VDD _10695_ sky130_fd_sc_hd__mux2_1
X_16919_ net854 _10695_ VSS VSS VDD VDD _10696_ sky130_fd_sc_hd__nand2_1
X_16920_ _03484_ net854 _10696_ VSS VSS VDD VDD _1044_[2] sky130_fd_sc_hd__o21ai_0
X_16921_ net971 u_core.u_top.u_core.r_pdata[1] net763 VSS VSS VDD VDD _10697_ sky130_fd_sc_hd__mux2i_1
X_16922_ net847 net856 VSS VSS VDD VDD _10698_ sky130_fd_sc_hd__nor2_1
X_16923_ net856 _10697_ _10698_ VSS VSS VDD VDD _1044_[1] sky130_fd_sc_hd__a21oi_1
X_16924_ net972 u_core.u_top.u_core.r_pdata[0] net763 VSS VSS VDD VDD _10699_ sky130_fd_sc_hd__mux2_1
X_16925_ net856 _10699_ VSS VSS VDD VDD _10700_ sky130_fd_sc_hd__nand2_1
X_16926_ _03483_ net856 _10700_ VSS VSS VDD VDD _1044_[0] sky130_fd_sc_hd__o21ai_0
X_16928_ _02308_ _02740_ VSS VSS VDD VDD _10702_ sky130_fd_sc_hd__nor2b_1
X_16929_ _02739_ _10702_ _03047_ VSS VSS VDD VDD _10703_ sky130_fd_sc_hd__o21ai_0
X_16930_ _03046_ _10703_ VSS VSS VDD VDD _10704_ sky130_fd_sc_hd__nand2b_1
X_16931_ _02519_ _10704_ _02518_ VSS VSS VDD VDD _10705_ sky130_fd_sc_hd__a21o_1
X_16932_ _03121_ _10705_ _03120_ VSS VSS VDD VDD _10706_ sky130_fd_sc_hd__a21o_1
X_16933_ _03123_ _10706_ _03122_ VSS VSS VDD VDD _10707_ sky130_fd_sc_hd__a21o_1
X_16934_ _02721_ _10707_ _02720_ VSS VSS VDD VDD _10708_ sky130_fd_sc_hd__a21oi_1
X_16935_ _02884_ _10708_ VSS VSS VDD VDD _10709_ sky130_fd_sc_hd__xnor2_1
X_16937_ net873 net985 VSS VSS VDD VDD _10711_ sky130_fd_sc_hd__xor2_1
X_16938_ u_core.u_top.u_core.r_cnt[4] u_core.u_top.u_core.r_cnt[3] u_core.u_top.u_core.r_cnt[5] _02900_ VSS VSS VDD VDD _10712_ sky130_fd_sc_hd__nor4b_1
X_16939_ u_core.u_top.u_core.r_cnt[2] u_core.u_top.u_core.r_cnt[6] _10712_ VSS VSS VDD VDD _10713_ sky130_fd_sc_hd__nand3_1
X_16940_ u_core.u_top.u_core.r_zskip VSS VSS VDD VDD _10714_ sky130_fd_sc_hd__inv_1
X_16941_ net958 _10714_ VSS VSS VDD VDD _10715_ sky130_fd_sc_hd__nor2_1
X_16942_ net981 net985 _02799_ net889 _10715_ VSS VSS VDD VDD _10716_ sky130_fd_sc_hd__a41oi_1
X_16943_ _10713_ _10716_ VSS VSS VDD VDD _10717_ sky130_fd_sc_hd__nand2_1
X_16944_ _10717_ VSS VSS VDD VDD _10718_ sky130_fd_sc_hd__inv_1
X_16945_ net986 net987 net983 VSS VSS VDD VDD _10719_ sky130_fd_sc_hd__a21boi_0
X_16946_ _02800_ net984 net985 VSS VSS VDD VDD _10720_ sky130_fd_sc_hd__nand3_1
X_16947_ _10719_ net890 _10720_ VSS VSS VDD VDD _10721_ sky130_fd_sc_hd__mux2i_1
X_16948_ net981 net982 _10721_ VSS VSS VDD VDD _10722_ sky130_fd_sc_hd__or3_1
X_16950_ net873 net985 VSS VSS VDD VDD _10724_ sky130_fd_sc_hd__and2_1
X_16951_ net986 net987 net984 VSS VSS VDD VDD _10725_ sky130_fd_sc_hd__a21bo_2
X_16952_ net984 net986 net987 VSS VSS VDD VDD _10726_ sky130_fd_sc_hd__nand3b_1
X_16954_ net873 net984 net985 VSS VSS VDD VDD _10728_ sky130_fd_sc_hd__nor3_1
X_16955_ _10724_ _10725_ _10726_ _10728_ VSS VSS VDD VDD _10729_ sky130_fd_sc_hd__a31oi_1
X_16956_ _02798_ _02797_ VSS VSS VDD VDD _10730_ sky130_fd_sc_hd__nand2b_1
X_16957_ net914 _10730_ net908 VSS VSS VDD VDD _10731_ sky130_fd_sc_hd__a21oi_1
X_16958_ _10722_ net781 _10731_ VSS VSS VDD VDD _10732_ sky130_fd_sc_hd__nor3_1
X_16959_ net981 net982 _10721_ VSS VSS VDD VDD _10733_ sky130_fd_sc_hd__nor3_1
X_16960_ _10724_ _10725_ _10726_ VSS VSS VDD VDD _10734_ sky130_fd_sc_hd__and3_1
X_16962_ net945 _10733_ _10734_ _10714_ net958 VSS VSS VDD VDD _10736_ sky130_fd_sc_hd__a311oi_1
X_16963_ _0731_[1] _10711_ VSS VSS VDD VDD _10737_ sky130_fd_sc_hd__nor2_1
X_16964_ net984 net985 net986 net987 VSS VSS VDD VDD _10738_ sky130_fd_sc_hd__nand4_1
X_16965_ net890 _10738_ VSS VSS VDD VDD _10739_ sky130_fd_sc_hd__nor2_1
X_16966_ net873 net983 net984 net985 VSS VSS VDD VDD _10740_ sky130_fd_sc_hd__nand4_1
X_16967_ net982 _10740_ VSS VSS VDD VDD _10741_ sky130_fd_sc_hd__nand2_1
X_16968_ net984 net985 net986 net987 VSS VSS VDD VDD _10742_ sky130_fd_sc_hd__and4_1
X_16969_ net983 _10742_ net982 VSS VSS VDD VDD _10743_ sky130_fd_sc_hd__a21boi_1
X_16970_ _10739_ _10741_ _10743_ u_core.arr_row[6] VSS VSS VDD VDD _10744_ sky130_fd_sc_hd__a211oi_4
X_16972_ net873 net983 VSS VSS VDD VDD _10746_ sky130_fd_sc_hd__nand2_1
X_16973_ net873 VSS VSS VDD VDD _10747_ sky130_fd_sc_hd__inv_1
X_16974_ net985 net986 net987 net984 VSS VSS VDD VDD _10748_ sky130_fd_sc_hd__a31oi_1
X_16975_ _10747_ _10742_ _10748_ VSS VSS VDD VDD _10749_ sky130_fd_sc_hd__a21oi_1
X_16976_ _10738_ _10746_ _10749_ net983 VSS VSS VDD VDD _10750_ sky130_fd_sc_hd__o22ai_1
X_16977_ u_core.u_top.u_core.r_x[2] _10737_ net762 _10750_ VSS VSS VDD VDD _10751_ sky130_fd_sc_hd__nand4_1
X_16978_ net735 _10751_ VSS VSS VDD VDD _10752_ sky130_fd_sc_hd__nand2_1
X_16979_ _10732_ _10752_ VSS VSS VDD VDD _10753_ sky130_fd_sc_hd__nor2_1
X_16980_ u_core.u_top.u_core.r_x[22] VSS VSS VDD VDD _10754_ sky130_fd_sc_hd__inv_1
X_16981_ net985 VSS VSS VDD VDD _10755_ sky130_fd_sc_hd__inv_1
X_16982_ _10725_ _10726_ net873 _10755_ VSS VSS VDD VDD _10756_ sky130_fd_sc_hd__a211oi_1
X_16983_ net985 net984 VSS VSS VDD VDD _10757_ sky130_fd_sc_hd__nor2b_1
X_16984_ net873 _10757_ VSS VSS VDD VDD _10758_ sky130_fd_sc_hd__and2_1
X_16985_ _10756_ _10758_ VSS VSS VDD VDD _10759_ sky130_fd_sc_hd__or2_2
X_16986_ net985 net986 net987 VSS VSS VDD VDD _10760_ sky130_fd_sc_hd__nand3_1
X_16987_ net984 _10760_ VSS VSS VDD VDD _10761_ sky130_fd_sc_hd__xor2_1
X_16988_ _02798_ _02797_ VSS VSS VDD VDD _10762_ sky130_fd_sc_hd__nor2b_1
X_16989_ _10711_ _10762_ VSS VSS VDD VDD _10763_ sky130_fd_sc_hd__nor2_1
X_16990_ _10761_ _10763_ net925 VSS VSS VDD VDD _10764_ sky130_fd_sc_hd__o21ai_0
X_16991_ _10754_ _10759_ _10764_ VSS VSS VDD VDD _10765_ sky130_fd_sc_hd__o21ai_0
X_16992_ _0731_[1] VSS VSS VDD VDD _10766_ sky130_fd_sc_hd__inv_1
X_16993_ net984 net986 net987 _10766_ net873 VSS VSS VDD VDD _10767_ sky130_fd_sc_hd__a32oi_1
X_16994_ _10747_ _10755_ _10766_ _10748_ VSS VSS VDD VDD _10768_ sky130_fd_sc_hd__a31oi_1
X_16995_ _10755_ _10767_ _10768_ VSS VSS VDD VDD _10769_ sky130_fd_sc_hd__o21ai_0
X_16996_ net926 net734 VSS VSS VDD VDD _10770_ sky130_fd_sc_hd__nand2_1
X_16997_ net984 _10760_ _10725_ VSS VSS VDD VDD _10771_ sky130_fd_sc_hd__o21a_1
X_16998_ net873 _10771_ _10755_ net984 VSS VSS VDD VDD _10772_ sky130_fd_sc_hd__a2bb2oi_1
X_16999_ net927 _10772_ VSS VSS VDD VDD _10773_ sky130_fd_sc_hd__nand2_1
X_17000_ _10770_ _10773_ VSS VSS VDD VDD _10774_ sky130_fd_sc_hd__nand2_1
X_17001_ _10765_ _10774_ VSS VSS VDD VDD _10775_ sky130_fd_sc_hd__nor2_1
X_17002_ _10722_ _10775_ VSS VSS VDD VDD _10776_ sky130_fd_sc_hd__nor2_1
X_17003_ _10747_ net985 VSS VSS VDD VDD _10777_ sky130_fd_sc_hd__nor2_1
X_17004_ net984 net873 VSS VSS VDD VDD _10778_ sky130_fd_sc_hd__nor2b_1
X_17005_ net986 net987 VSS VSS VDD VDD _10779_ sky130_fd_sc_hd__nand2_1
X_17006_ net984 net985 VSS VSS VDD VDD _10780_ sky130_fd_sc_hd__nor2_1
X_17007_ net873 _10742_ _10778_ _10779_ _10780_ VSS VSS VDD VDD _10781_ sky130_fd_sc_hd__a221oi_1
X_17008_ _10777_ net780 VSS VSS VDD VDD _10782_ sky130_fd_sc_hd__nor2_1
X_17009_ net890 _10720_ VSS VSS VDD VDD _10783_ sky130_fd_sc_hd__xnor2_1
X_17011_ _10782_ net779 _10744_ VSS VSS VDD VDD _10785_ sky130_fd_sc_hd__o21ai_0
X_17012_ _10730_ net779 net921 VSS VSS VDD VDD _10786_ sky130_fd_sc_hd__o21ai_0
X_17013_ net920 _10786_ VSS VSS VDD VDD _10787_ sky130_fd_sc_hd__nor2b_1
X_17014_ _10785_ _10787_ VSS VSS VDD VDD _10788_ sky130_fd_sc_hd__nor2_1
X_17015_ _0731_[1] _10729_ VSS VSS VDD VDD _10789_ sky130_fd_sc_hd__nor2_1
X_17016_ net779 _10789_ u_core.u_top.u_core.r_x[34] VSS VSS VDD VDD _10790_ sky130_fd_sc_hd__o21ai_0
X_17017_ _10734_ net779 net922 VSS VSS VDD VDD _10791_ sky130_fd_sc_hd__o21ai_0
X_17018_ _10739_ _10741_ _10743_ u_core.arr_row[6] VSS VSS VDD VDD _10792_ sky130_fd_sc_hd__a211o_1
X_17020_ _10790_ _10791_ net760 VSS VSS VDD VDD _10794_ sky130_fd_sc_hd__a21oi_1
X_17021_ net983 _10720_ VSS VSS VDD VDD _10795_ sky130_fd_sc_hd__xnor2_1
X_17022_ _10761_ _10763_ VSS VSS VDD VDD _10796_ sky130_fd_sc_hd__nor2_1
X_17023_ net778 _10796_ VSS VSS VDD VDD _10797_ sky130_fd_sc_hd__nand2_1
X_17024_ net983 _10759_ u_core.u_top.u_core.r_x[54] VSS VSS VDD VDD _10798_ sky130_fd_sc_hd__a21boi_0
X_17025_ net913 _10797_ _10798_ VSS VSS VDD VDD _10799_ sky130_fd_sc_hd__a21oi_1
X_17026_ net890 _10772_ net915 VSS VSS VDD VDD _10800_ sky130_fd_sc_hd__o21ai_0
X_17027_ _10747_ _10779_ _10755_ VSS VSS VDD VDD _10801_ sky130_fd_sc_hd__a21o_1
X_17028_ net983 net873 VSS VSS VDD VDD _10802_ sky130_fd_sc_hd__nand2b_1
X_17029_ net890 _10726_ _10802_ _10725_ VSS VSS VDD VDD _10803_ sky130_fd_sc_hd__o22ai_1
X_17030_ net983 net984 _10801_ _10803_ net985 VSS VSS VDD VDD _10804_ sky130_fd_sc_hd__a32oi_2
X_17031_ _10737_ _10804_ u_core.u_top.u_core.r_x[50] VSS VSS VDD VDD _10805_ sky130_fd_sc_hd__o21ai_0
X_17032_ _10800_ _10805_ VSS VSS VDD VDD _10806_ sky130_fd_sc_hd__and2_1
X_17034_ _10799_ _10806_ net760 VSS VSS VDD VDD _10808_ sky130_fd_sc_hd__a21oi_1
X_17035_ _10788_ _10794_ _10808_ VSS VSS VDD VDD _10809_ sky130_fd_sc_hd__nor3_1
X_17036_ _10739_ _10740_ net982 VSS VSS VDD VDD _10810_ sky130_fd_sc_hd__a21oi_1
X_17037_ net983 _10742_ VSS VSS VDD VDD _10811_ sky130_fd_sc_hd__nand2_1
X_17038_ net781 _10811_ net778 _10741_ VSS VSS VDD VDD _10812_ sky130_fd_sc_hd__a31oi_1
X_17039_ _10810_ _10812_ VSS VSS VDD VDD _10813_ sky130_fd_sc_hd__nor2_1
X_17040_ net984 net985 VSS VSS VDD VDD _10814_ sky130_fd_sc_hd__and2_1
X_17041_ net983 net986 net987 VSS VSS VDD VDD _10815_ sky130_fd_sc_hd__nand3_1
X_17042_ net873 net982 net983 VSS VSS VDD VDD _10816_ sky130_fd_sc_hd__and3_1
X_17043_ u_core.arr_row[6] _10814_ _10815_ _10816_ VSS VSS VDD VDD _10817_ sky130_fd_sc_hd__nand4_1
X_17044_ u_core.arr_row[6] _10813_ _10817_ VSS VSS VDD VDD _10818_ sky130_fd_sc_hd__o21ai_0
X_17045_ net982 net890 _10738_ VSS VSS VDD VDD _10819_ sky130_fd_sc_hd__nor3_1
X_17046_ _10743_ _10819_ net778 VSS VSS VDD VDD _10820_ sky130_fd_sc_hd__o21ai_1
X_17048_ _10766_ net759 u_core.u_top.u_core.r_x[98] VSS VSS VDD VDD _10822_ sky130_fd_sc_hd__o21ai_0
X_17049_ net943 _10822_ VSS VSS VDD VDD _10823_ sky130_fd_sc_hd__nand2b_1
X_17050_ _10734_ net759 net900 VSS VSS VDD VDD _10824_ sky130_fd_sc_hd__o21ai_0
X_17051_ net781 _10762_ VSS VSS VDD VDD _10825_ sky130_fd_sc_hd__nor2_1
X_17052_ net759 _10825_ net944 VSS VSS VDD VDD _10826_ sky130_fd_sc_hd__o21ai_0
X_17053_ net984 net985 VSS VSS VDD VDD _10827_ sky130_fd_sc_hd__nand2_1
X_17054_ net873 net982 net983 VSS VSS VDD VDD _10828_ sky130_fd_sc_hd__nand3_1
X_17055_ _10827_ _10828_ VSS VSS VDD VDD _10829_ sky130_fd_sc_hd__nor2_1
X_17056_ u_core.arr_row[6] _10829_ _10817_ VSS VSS VDD VDD _10830_ sky130_fd_sc_hd__o21a_1
X_17058_ _10824_ _10826_ _10830_ VSS VSS VDD VDD _10832_ sky130_fd_sc_hd__a21oi_1
X_17059_ _10818_ _10823_ _10832_ VSS VSS VDD VDD _10833_ sky130_fd_sc_hd__a21o_1
X_17060_ _10743_ _10819_ VSS VSS VDD VDD _10834_ sky130_fd_sc_hd__nor2_1
X_17061_ _10737_ _10804_ _10834_ u_core.u_top.u_core.r_x[114] VSS VSS VDD VDD _10835_ sky130_fd_sc_hd__o31a_1
X_17062_ _10724_ _10804_ _10834_ net938 VSS VSS VDD VDD _10836_ sky130_fd_sc_hd__o31a_1
X_17063_ _10763_ _10804_ _10834_ net937 VSS VSS VDD VDD _10837_ sky130_fd_sc_hd__o31a_1
X_17064_ _10756_ _10758_ VSS VSS VDD VDD _10838_ sky130_fd_sc_hd__nor2_1
X_17065_ _10838_ net759 net936 VSS VSS VDD VDD _10839_ sky130_fd_sc_hd__o21a_1
X_17066_ u_core.arr_row[6] _10829_ _10817_ VSS VSS VDD VDD _10840_ sky130_fd_sc_hd__o21ai_1
X_17067_ _10835_ _10836_ _10837_ _10839_ net758 VSS VSS VDD VDD _10841_ sky130_fd_sc_hd__o41ai_1
X_17068_ u_core.u_top.u_core.r_x[126] VSS VSS VDD VDD _10842_ sky130_fd_sc_hd__inv_1
X_17069_ _10725_ _10726_ _10755_ VSS VSS VDD VDD _10843_ sky130_fd_sc_hd__a21oi_1
X_17070_ _10747_ _10843_ VSS VSS VDD VDD _10844_ sky130_fd_sc_hd__nand2_1
X_17071_ _10844_ net759 net935 VSS VSS VDD VDD _10845_ sky130_fd_sc_hd__o21ai_0
X_17072_ _10756_ _10758_ _0731_[1] VSS VSS VDD VDD _10846_ sky130_fd_sc_hd__o21ai_1
X_17073_ net777 net759 u_core.u_top.u_core.r_x[122] VSS VSS VDD VDD _10847_ sky130_fd_sc_hd__o21ai_0
X_17074_ _10756_ _10758_ _10762_ VSS VSS VDD VDD _10848_ sky130_fd_sc_hd__o21ai_1
X_17075_ _10848_ net759 u_core.u_top.u_core.r_x[124] VSS VSS VDD VDD _10849_ sky130_fd_sc_hd__o21ai_0
X_17076_ _10842_ _10845_ _10847_ _10849_ _10830_ VSS VSS VDD VDD _10850_ sky130_fd_sc_hd__a41oi_1
X_17077_ net984 _10760_ VSS VSS VDD VDD _10851_ sky130_fd_sc_hd__xnor2_1
X_17078_ net873 net985 VSS VSS VDD VDD _10852_ sky130_fd_sc_hd__xnor2_1
X_17079_ _10852_ _10730_ VSS VSS VDD VDD _10853_ sky130_fd_sc_hd__nor2_1
X_17080_ _10851_ _10853_ VSS VSS VDD VDD _10854_ sky130_fd_sc_hd__nor2_1
X_17081_ net982 u_core.arr_row[6] VSS VSS VDD VDD _10855_ sky130_fd_sc_hd__nand2b_1
X_17082_ u_core.arr_row[6] _10827_ _10760_ _10828_ VSS VSS VDD VDD _10856_ sky130_fd_sc_hd__or4_1
X_17083_ _10721_ _10855_ _10856_ VSS VSS VDD VDD _10857_ sky130_fd_sc_hd__o21ai_0
X_17084_ net733 _10857_ net758 VSS VSS VDD VDD _10858_ sky130_fd_sc_hd__a21oi_1
X_17085_ net873 net982 net983 _10779_ VSS VSS VDD VDD _10859_ sky130_fd_sc_hd__or4_1
X_17086_ u_core.arr_row[6] _10779_ _10816_ VSS VSS VDD VDD _10860_ sky130_fd_sc_hd__nand3_1
X_17087_ _10859_ _10860_ _10827_ VSS VSS VDD VDD _10861_ sky130_fd_sc_hd__a21oi_1
X_17088_ u_core.arr_row[6] VSS VSS VDD VDD _10862_ sky130_fd_sc_hd__inv_1
X_17089_ net889 _10760_ _10862_ VSS VSS VDD VDD _10863_ sky130_fd_sc_hd__a21oi_1
X_17090_ _10811_ _10829_ _10863_ VSS VSS VDD VDD _10864_ sky130_fd_sc_hd__a21oi_1
X_17091_ _10861_ _10864_ u_core.u_top.u_core.r_x[142] VSS VSS VDD VDD _10865_ sky130_fd_sc_hd__o21ai_0
X_17092_ _06453_ _10858_ _10865_ VSS VSS VDD VDD _10866_ sky130_fd_sc_hd__o21ai_0
X_17093_ _10721_ _10855_ _10856_ VSS VSS VDD VDD _10867_ sky130_fd_sc_hd__o21a_1
X_17094_ net780 _10867_ _10830_ VSS VSS VDD VDD _10868_ sky130_fd_sc_hd__o21ai_0
X_17095_ net873 _10766_ _10726_ VSS VSS VDD VDD _10869_ sky130_fd_sc_hd__o21ai_0
X_17096_ net984 _10760_ _10869_ net985 _0731_[1] _10777_ VSS VSS VDD VDD _10870_ sky130_fd_sc_hd__a222oi_1
X_17097_ net732 _10857_ net758 VSS VSS VDD VDD _10871_ sky130_fd_sc_hd__a21o_1
X_17098_ net930 _10868_ _10871_ net929 VSS VSS VDD VDD _10872_ sky130_fd_sc_hd__a22oi_1
X_17099_ _10866_ _10872_ VSS VSS VDD VDD _10873_ sky130_fd_sc_hd__nand2b_1
X_17100_ _10734_ _10728_ _10766_ VSS VSS VDD VDD _10874_ sky130_fd_sc_hd__o21ai_0
X_17101_ _10874_ _10867_ _10830_ VSS VSS VDD VDD _10875_ sky130_fd_sc_hd__o21ai_0
X_17102_ _10814_ _10815_ _10816_ VSS VSS VDD VDD _10876_ sky130_fd_sc_hd__nand3_1
X_17103_ net889 _10724_ _10779_ _10862_ VSS VSS VDD VDD _10877_ sky130_fd_sc_hd__a31oi_1
X_17104_ u_core.arr_row[6] _10876_ VSS VSS VDD VDD _10878_ sky130_fd_sc_hd__nor2_1
X_17105_ _10876_ _10877_ _10878_ _06460_ VSS VSS VDD VDD _10879_ sky130_fd_sc_hd__a211oi_1
X_17106_ net933 _10875_ _10879_ VSS VSS VDD VDD _10880_ sky130_fd_sc_hd__a21oi_1
X_17107_ net781 _10867_ _10830_ VSS VSS VDD VDD _10881_ sky130_fd_sc_hd__o21ai_1
X_17108_ net873 net982 net983 u_core.arr_row[6] VSS VSS VDD VDD _10882_ sky130_fd_sc_hd__nor4b_1
X_17109_ u_core.arr_row[6] net982 net983 net873 VSS VSS VDD VDD _10883_ sky130_fd_sc_hd__and4b_1
X_17110_ _10882_ _10883_ _10742_ VSS VSS VDD VDD _10884_ sky130_fd_sc_hd__o21ai_0
X_17111_ u_core.arr_row[6] net889 _10760_ VSS VSS VDD VDD _10885_ sky130_fd_sc_hd__nand3_1
X_17112_ _10884_ _10885_ _10763_ VSS VSS VDD VDD _10886_ sky130_fd_sc_hd__a21boi_0
X_17113_ net758 _10886_ net932 VSS VSS VDD VDD _10887_ sky130_fd_sc_hd__o21a_1
X_17114_ net931 _10881_ _10887_ VSS VSS VDD VDD _10888_ sky130_fd_sc_hd__a21oi_1
X_17115_ _10841_ _10880_ _10888_ VSS VSS VDD VDD _10889_ sky130_fd_sc_hd__and3_1
X_17116_ net732 net759 net941 VSS VSS VDD VDD _10890_ sky130_fd_sc_hd__o21ai_0
X_17117_ _10804_ _10834_ u_core.u_top.u_core.r_x[110] VSS VSS VDD VDD _10891_ sky130_fd_sc_hd__o21ai_0
X_17118_ _10779_ _10778_ _10780_ VSS VSS VDD VDD _10892_ sky130_fd_sc_hd__a21oi_1
X_17119_ _10747_ _10738_ _10892_ VSS VSS VDD VDD _10893_ sky130_fd_sc_hd__o21ai_0
X_17120_ net757 net759 net942 VSS VSS VDD VDD _10894_ sky130_fd_sc_hd__o21ai_0
X_17121_ net733 net759 net940 VSS VSS VDD VDD _10895_ sky130_fd_sc_hd__o21ai_0
X_17122_ net719 _10891_ net731 _10895_ _10830_ VSS VSS VDD VDD _10896_ sky130_fd_sc_hd__a41oi_1
X_17123_ _10841_ _10850_ _10873_ _10889_ _10896_ VSS VSS VDD VDD _10897_ sky130_fd_sc_hd__a221oi_1
X_17124_ u_core.u_top.u_core.r_x[62] VSS VSS VDD VDD _10898_ sky130_fd_sc_hd__inv_1
X_17125_ net779 _10848_ net911 VSS VSS VDD VDD _10899_ sky130_fd_sc_hd__o21ai_1
X_17126_ _10898_ _10899_ VSS VSS VDD VDD _10900_ sky130_fd_sc_hd__and2_1
X_17127_ net779 _10844_ net912 VSS VSS VDD VDD _10901_ sky130_fd_sc_hd__o21ai_0
X_17128_ net779 net777 u_core.u_top.u_core.r_x[58] VSS VSS VDD VDD _10902_ sky130_fd_sc_hd__o21ai_0
X_17129_ _10900_ net756 net755 net760 VSS VSS VDD VDD _10903_ sky130_fd_sc_hd__a31oi_1
X_17130_ _10852_ _10730_ _10761_ VSS VSS VDD VDD _10904_ sky130_fd_sc_hd__o21ai_0
X_17131_ _10827_ _10828_ u_core.arr_row[6] VSS VSS VDD VDD _10905_ sky130_fd_sc_hd__o21ai_0
X_17132_ _10862_ _10814_ _10816_ VSS VSS VDD VDD _10906_ sky130_fd_sc_hd__nand3_1
X_17133_ _10743_ _10819_ _10905_ _10906_ _10783_ VSS VSS VDD VDD _10907_ sky130_fd_sc_hd__o2111ai_1
X_17134_ _10904_ _10907_ net760 VSS VSS VDD VDD _10908_ sky130_fd_sc_hd__o21ai_0
X_17135_ _10862_ net906 VSS VSS VDD VDD _10909_ sky130_fd_sc_hd__nand2_1
X_17136_ _10738_ _10746_ _10749_ net983 _10811_ VSS VSS VDD VDD _10910_ sky130_fd_sc_hd__o221ai_1
X_17137_ net982 _10740_ _10910_ _10810_ VSS VSS VDD VDD _10911_ sky130_fd_sc_hd__a31oi_1
X_17138_ u_core.u_top.u_core.r_x[76] _10908_ _10909_ _10911_ VSS VSS VDD VDD _10912_ sky130_fd_sc_hd__o2bb2ai_1
X_17139_ _10743_ _10819_ _10905_ _10906_ net779 VSS VSS VDD VDD _10913_ sky130_fd_sc_hd__o2111a_1
X_17140_ net732 _10913_ net762 VSS VSS VDD VDD _10914_ sky130_fd_sc_hd__a21o_1
X_17141_ net780 _10907_ net760 VSS VSS VDD VDD _10915_ sky130_fd_sc_hd__o21ai_0
X_17142_ u_core.u_top.u_core.r_x[74] _10914_ _10915_ net907 VSS VSS VDD VDD _10916_ sky130_fd_sc_hd__a22oi_1
X_17143_ _10912_ _10916_ VSS VSS VDD VDD _10917_ sky130_fd_sc_hd__nand2b_1
X_17144_ _10756_ _10907_ net760 VSS VSS VDD VDD _10918_ sky130_fd_sc_hd__o21ai_0
X_17145_ net903 _10918_ VSS VSS VDD VDD _10919_ sky130_fd_sc_hd__nand2_1
X_17146_ net777 _10913_ net762 VSS VSS VDD VDD _10920_ sky130_fd_sc_hd__a21o_1
X_17147_ u_core.u_top.u_core.r_x[90] _10920_ VSS VSS VDD VDD _10921_ sky130_fd_sc_hd__nand2_1
X_17148_ _10811_ net778 _10741_ VSS VSS VDD VDD _10922_ sky130_fd_sc_hd__a21oi_1
X_17149_ _10810_ _10922_ _10862_ VSS VSS VDD VDD _10923_ sky130_fd_sc_hd__o21ai_0
X_17150_ _10817_ _10923_ net901 VSS VSS VDD VDD _10924_ sky130_fd_sc_hd__a21bo_2
X_17151_ _10762_ _10759_ _10907_ VSS VSS VDD VDD _10925_ sky130_fd_sc_hd__a21oi_1
X_17152_ net762 _10925_ u_core.u_top.u_core.r_x[92] VSS VSS VDD VDD _10926_ sky130_fd_sc_hd__o21ai_0
X_17153_ _10919_ _10921_ _10924_ _10926_ VSS VSS VDD VDD _10927_ sky130_fd_sc_hd__nand4_1
X_17154_ _10903_ _10917_ _10927_ VSS VSS VDD VDD _10928_ sky130_fd_sc_hd__nor3_1
X_17155_ _10833_ _10897_ _10928_ VSS VSS VDD VDD _10929_ sky130_fd_sc_hd__o21ai_1
X_17156_ u_core.u_top.u_core.r_x[70] VSS VSS VDD VDD _10930_ sky130_fd_sc_hd__inv_1
X_17157_ _10730_ net762 net909 VSS VSS VDD VDD _10931_ sky130_fd_sc_hd__o21ai_0
X_17158_ net761 _10913_ net762 VSS VSS VDD VDD _10932_ sky130_fd_sc_hd__a21oi_1
X_17159_ _10930_ _10931_ _10932_ VSS VSS VDD VDD _10933_ sky130_fd_sc_hd__a21oi_1
X_17160_ _10874_ _10907_ net760 VSS VSS VDD VDD _10934_ sky130_fd_sc_hd__o21ai_1
X_17161_ _10734_ _10913_ net762 VSS VSS VDD VDD _10935_ sky130_fd_sc_hd__a21o_1
X_17162_ u_core.u_top.u_core.r_x[66] _10934_ _10935_ net910 VSS VSS VDD VDD _10936_ sky130_fd_sc_hd__a22oi_1
X_17163_ _10933_ _10936_ VSS VSS VDD VDD _10937_ sky130_fd_sc_hd__nand2b_1
X_17164_ net734 _10913_ net762 VSS VSS VDD VDD _10938_ sky130_fd_sc_hd__a21o_1
X_17165_ u_core.u_top.u_core.r_x[82] _10938_ VSS VSS VDD VDD _10939_ sky130_fd_sc_hd__nand2_1
X_17166_ net873 _10771_ _10757_ VSS VSS VDD VDD _10940_ sky130_fd_sc_hd__o21bai_1
X_17167_ _10940_ _10907_ net760 VSS VSS VDD VDD _10941_ sky130_fd_sc_hd__o21ai_0
X_17168_ u_core.u_top.u_core.r_x[80] _10941_ VSS VSS VDD VDD _10942_ sky130_fd_sc_hd__nand2_1
X_17169_ _10796_ _10907_ net760 VSS VSS VDD VDD _10943_ sky130_fd_sc_hd__o21ai_0
X_17170_ _10759_ _10907_ net760 VSS VSS VDD VDD _10944_ sky130_fd_sc_hd__o21ai_0
X_17171_ net905 _10943_ _10944_ net904 VSS VSS VDD VDD _10945_ sky130_fd_sc_hd__a22oi_1
X_17172_ _10939_ _10942_ _10945_ VSS VSS VDD VDD _10946_ sky130_fd_sc_hd__nand3_1
X_17173_ _10917_ _10946_ VSS VSS VDD VDD _10947_ sky130_fd_sc_hd__nor2b_1
X_17174_ _10937_ _10947_ _10903_ VSS VSS VDD VDD _10948_ sky130_fd_sc_hd__o21bai_1
X_17175_ u_core.u_top.u_core.r_x[26] net777 VSS VSS VDD VDD _10949_ sky130_fd_sc_hd__nand2_1
X_17176_ net924 _10844_ VSS VSS VDD VDD _10950_ sky130_fd_sc_hd__nand2_1
X_17177_ net923 _10848_ u_core.u_top.u_core.r_x[30] VSS VSS VDD VDD _10951_ sky130_fd_sc_hd__a21oi_1
X_17178_ _10949_ _10950_ _10951_ _10722_ VSS VSS VDD VDD _10952_ sky130_fd_sc_hd__a31oi_1
X_17179_ net983 _10853_ VSS VSS VDD VDD _10953_ sky130_fd_sc_hd__nand2_1
X_17180_ net917 _10953_ net916 VSS VSS VDD VDD _10954_ sky130_fd_sc_hd__a21o_1
X_17181_ net762 _10804_ _10954_ VSS VSS VDD VDD _10955_ sky130_fd_sc_hd__nand3_1
X_17183_ net779 net732 net918 VSS VSS VDD VDD _10957_ sky130_fd_sc_hd__o21ai_0
X_17184_ net757 net779 net919 VSS VSS VDD VDD _10958_ sky130_fd_sc_hd__o21ai_0
X_17185_ _10957_ _10958_ VSS VSS VDD VDD _10959_ sky130_fd_sc_hd__nand2_1
X_17186_ net762 _10959_ VSS VSS VDD VDD _10960_ sky130_fd_sc_hd__nand2_1
X_17187_ _10955_ _10960_ _10788_ _10794_ VSS VSS VDD VDD _10961_ sky130_fd_sc_hd__a211oi_1
X_17188_ _10952_ _10961_ VSS VSS VDD VDD _10962_ sky130_fd_sc_hd__or2_2
X_17189_ _10809_ _10929_ _10948_ _10962_ VSS VSS VDD VDD _10963_ sky130_fd_sc_hd__a31oi_1
X_17190_ net780 net902 VSS VSS VDD VDD _10964_ sky130_fd_sc_hd__nor2b_1
X_17191_ net934 _10854_ _10964_ VSS VSS VDD VDD _10965_ sky130_fd_sc_hd__a21oi_1
X_17192_ u_core.u_top.u_core.r_x[14] _10750_ VSS VSS VDD VDD _10966_ sky130_fd_sc_hd__nand2_1
X_17193_ net939 net779 net732 VSS VSS VDD VDD _10967_ sky130_fd_sc_hd__nand3_1
X_17194_ _10966_ _10967_ net760 VSS VSS VDD VDD _10968_ sky130_fd_sc_hd__a21o_1
X_17195_ _10722_ _10965_ _10968_ VSS VSS VDD VDD _10969_ sky130_fd_sc_hd__o21a_1
X_17196_ _10776_ _10963_ _10969_ VSS VSS VDD VDD _10970_ sky130_fd_sc_hd__o21ai_0
X_17197_ _10711_ _10718_ _10753_ _10970_ VSS VSS VDD VDD _10971_ sky130_fd_sc_hd__a22o_1
X_17198_ net933 _10875_ VSS VSS VDD VDD _10972_ sky130_fd_sc_hd__and2_1
X_17199_ net931 _10881_ VSS VSS VDD VDD _10973_ sky130_fd_sc_hd__nand2_1
X_17200_ net929 _10871_ VSS VSS VDD VDD _10974_ sky130_fd_sc_hd__and2_1
X_17201_ net754 _10867_ _10830_ VSS VSS VDD VDD _10975_ sky130_fd_sc_hd__o21ai_0
X_17202_ net928 _10975_ _10865_ VSS VSS VDD VDD _10976_ sky130_fd_sc_hd__a21oi_1
X_17203_ net930 _10868_ VSS VSS VDD VDD _10977_ sky130_fd_sc_hd__nand2_1
X_17204_ _10974_ _10976_ _10977_ VSS VSS VDD VDD _10978_ sky130_fd_sc_hd__o21ai_0
X_17205_ _10973_ _10978_ _10887_ VSS VSS VDD VDD _10979_ sky130_fd_sc_hd__a21oi_1
X_17206_ _10891_ _10836_ VSS VSS VDD VDD _10980_ sky130_fd_sc_hd__nand2_1
X_17207_ _10895_ _10980_ VSS VSS VDD VDD _10981_ sky130_fd_sc_hd__nand2_1
X_17208_ net719 _10981_ net731 VSS VSS VDD VDD _10982_ sky130_fd_sc_hd__a21boi_0
X_17209_ u_core.u_top.u_core.r_x[126] net758 VSS VSS VDD VDD _10983_ sky130_fd_sc_hd__nand2_1
X_17210_ _10763_ _10804_ _10834_ net937 VSS VSS VDD VDD _10984_ sky130_fd_sc_hd__o31ai_1
X_17211_ _10984_ _10845_ _10849_ _10830_ VSS VSS VDD VDD _10985_ sky130_fd_sc_hd__a31oi_1
X_17212_ _10879_ _10983_ _10985_ VSS VSS VDD VDD _10986_ sky130_fd_sc_hd__a21oi_1
X_17213_ _10972_ _10979_ _10982_ _10830_ _10986_ VSS VSS VDD VDD _10987_ sky130_fd_sc_hd__o221ai_1
X_17214_ net719 _10891_ VSS VSS VDD VDD _10988_ sky130_fd_sc_hd__nand2_1
X_17215_ u_core.u_top.u_core.r_x[122] _10845_ _10839_ VSS VSS VDD VDD _10989_ sky130_fd_sc_hd__a21oi_1
X_17216_ net777 net759 _10984_ VSS VSS VDD VDD _10990_ sky130_fd_sc_hd__o21ai_0
X_17217_ u_core.u_top.u_core.r_x[126] _10984_ _10845_ _10849_ VSS VSS VDD VDD _10991_ sky130_fd_sc_hd__nand4_1
X_17218_ _10989_ _10990_ _10991_ VSS VSS VDD VDD _10992_ sky130_fd_sc_hd__o21ai_0
X_17219_ _10988_ _10835_ _10992_ VSS VSS VDD VDD _10993_ sky130_fd_sc_hd__or3_1
X_17220_ net758 _10993_ _10982_ _10818_ net943 VSS VSS VDD VDD _10994_ sky130_fd_sc_hd__a32oi_1
X_17221_ _10987_ _10994_ _10832_ VSS VSS VDD VDD _10995_ sky130_fd_sc_hd__a21oi_1
X_17222_ _10789_ net759 u_core.u_top.u_core.r_x[98] VSS VSS VDD VDD _10996_ sky130_fd_sc_hd__o21ai_0
X_17223_ net758 _10824_ VSS VSS VDD VDD _10997_ sky130_fd_sc_hd__nand2_1
X_17224_ _10996_ _10997_ _10924_ VSS VSS VDD VDD _10998_ sky130_fd_sc_hd__o21ai_0
X_17225_ net909 VSS VSS VDD VDD _10999_ sky130_fd_sc_hd__inv_1
X_17226_ _10913_ _10825_ net762 VSS VSS VDD VDD _11000_ sky130_fd_sc_hd__a21oi_1
X_17227_ net761 net762 u_core.u_top.u_core.r_x[70] VSS VSS VDD VDD _11001_ sky130_fd_sc_hd__o21ai_0
X_17228_ net907 _10915_ _11001_ VSS VSS VDD VDD _11002_ sky130_fd_sc_hd__nand3_1
X_17229_ _10999_ _11000_ _11002_ VSS VSS VDD VDD _11003_ sky130_fd_sc_hd__o21ai_0
X_17230_ u_core.u_top.u_core.r_x[66] _10934_ VSS VSS VDD VDD _11004_ sky130_fd_sc_hd__nand2_1
X_17231_ _10899_ net756 net760 VSS VSS VDD VDD _11005_ sky130_fd_sc_hd__a21oi_1
X_17232_ net910 _10935_ _11003_ _11004_ _11005_ VSS VSS VDD VDD _11006_ sky130_fd_sc_hd__a221o_1
X_17233_ u_core.u_top.u_core.r_x[76] _10908_ VSS VSS VDD VDD _11007_ sky130_fd_sc_hd__nand2_1
X_17234_ net905 _10943_ VSS VSS VDD VDD _11008_ sky130_fd_sc_hd__nand2_1
X_17235_ net762 _10838_ net904 VSS VSS VDD VDD _11009_ sky130_fd_sc_hd__o21ai_0
X_17236_ net903 _10918_ _11009_ VSS VSS VDD VDD _11010_ sky130_fd_sc_hd__nand3_1
X_17237_ _11007_ _10942_ _11008_ _11010_ VSS VSS VDD VDD _11011_ sky130_fd_sc_hd__nand4_1
X_17238_ _11006_ _11011_ _10926_ VSS VSS VDD VDD _11012_ sky130_fd_sc_hd__nor3b_1
X_17239_ _10995_ _10998_ _11012_ VSS VSS VDD VDD _11013_ sky130_fd_sc_hd__o21ai_0
X_17240_ net735 VSS VSS VDD VDD _11014_ sky130_fd_sc_hd__inv_1
X_17241_ net987 _10717_ _11014_ _10751_ VSS VSS VDD VDD _11015_ sky130_fd_sc_hd__o22ai_1
X_17242_ u_core.u_top.u_core.r_x[90] _11009_ VSS VSS VDD VDD _11016_ sky130_fd_sc_hd__nand2b_1
X_17243_ _11011_ _11016_ _10920_ VSS VSS VDD VDD _11017_ sky130_fd_sc_hd__nand3b_1
X_17244_ net760 _10940_ _06415_ VSS VSS VDD VDD _11018_ sky130_fd_sc_hd__a21oi_1
X_17245_ _10909_ _10911_ _10939_ _11018_ VSS VSS VDD VDD _11019_ sky130_fd_sc_hd__o22ai_1
X_17246_ _10766_ net762 u_core.u_top.u_core.r_x[66] VSS VSS VDD VDD _11020_ sky130_fd_sc_hd__o21ai_0
X_17247_ _10930_ _11020_ _10932_ VSS VSS VDD VDD _11021_ sky130_fd_sc_hd__a21oi_1
X_17248_ u_core.u_top.u_core.r_x[74] _10914_ _11019_ _11007_ _11021_ VSS VSS VDD VDD _11022_ sky130_fd_sc_hd__a221oi_1
X_17249_ _11017_ _11022_ _11006_ VSS VSS VDD VDD _11023_ sky130_fd_sc_hd__a21oi_1
X_17250_ u_core.u_top.u_core.r_x[62] _10899_ VSS VSS VDD VDD _11024_ sky130_fd_sc_hd__nand2_1
X_17251_ net755 _11024_ VSS VSS VDD VDD _11025_ sky130_fd_sc_hd__nand2_1
X_17252_ net756 _11025_ VSS VSS VDD VDD _11026_ sky130_fd_sc_hd__nand2_1
X_17253_ net916 _10804_ _10798_ VSS VSS VDD VDD _11027_ sky130_fd_sc_hd__a21oi_1
X_17254_ _10805_ _11026_ _11027_ net760 VSS VSS VDD VDD _11028_ sky130_fd_sc_hd__a31oi_1
X_17255_ u_core.u_top.u_core.r_x[22] _10764_ _10838_ VSS VSS VDD VDD _11029_ sky130_fd_sc_hd__nand3_1
X_17256_ _10770_ _11029_ _10773_ VSS VSS VDD VDD _11030_ sky130_fd_sc_hd__a21boi_0
X_17257_ net908 net761 _11030_ VSS VSS VDD VDD _11031_ sky130_fd_sc_hd__a21oi_1
X_17258_ _10722_ _11031_ _10968_ VSS VSS VDD VDD _11032_ sky130_fd_sc_hd__o21ai_0
X_17259_ u_core.u_top.u_core.r_x[26] net777 u_core.u_top.u_core.r_x[30] VSS VSS VDD VDD _11033_ sky130_fd_sc_hd__a21oi_1
X_17260_ net920 _10786_ VSS VSS VDD VDD _11034_ sky130_fd_sc_hd__nand2_1
X_17261_ _10722_ _11033_ _11034_ _10785_ VSS VSS VDD VDD _11035_ sky130_fd_sc_hd__o22ai_1
X_17262_ net779 _10825_ net921 VSS VSS VDD VDD _11036_ sky130_fd_sc_hd__o21ai_0
X_17263_ _10957_ _10958_ _11036_ VSS VSS VDD VDD _11037_ sky130_fd_sc_hd__nand3b_1
X_17264_ _10790_ _11037_ net760 VSS VSS VDD VDD _11038_ sky130_fd_sc_hd__a21oi_1
X_17265_ _11032_ _11035_ _11038_ VSS VSS VDD VDD _11039_ sky130_fd_sc_hd__nor3_1
X_17266_ _11015_ _11023_ _11028_ _11039_ VSS VSS VDD VDD _11040_ sky130_fd_sc_hd__nor4b_1
X_17267_ net779 _10854_ net917 VSS VSS VDD VDD _11041_ sky130_fd_sc_hd__o21ai_0
X_17268_ net913 _10797_ _10805_ VSS VSS VDD VDD _11042_ sky130_fd_sc_hd__nand3_1
X_17269_ net916 _10804_ _11042_ _10800_ VSS VSS VDD VDD _11043_ sky130_fd_sc_hd__a22o_1
X_17270_ _10958_ _11036_ _11041_ _11043_ VSS VSS VDD VDD _11044_ sky130_fd_sc_hd__nand4_1
X_17271_ net922 VSS VSS VDD VDD _11045_ sky130_fd_sc_hd__inv_1
X_17272_ _10734_ _11033_ net779 VSS VSS VDD VDD _11046_ sky130_fd_sc_hd__mux2i_1
X_17273_ _11045_ net760 _11032_ _11046_ net735 VSS VSS VDD VDD _11047_ sky130_fd_sc_hd__o41ai_1
X_17274_ net762 _11039_ _11044_ _11047_ VSS VSS VDD VDD _11048_ sky130_fd_sc_hd__a31oi_1
X_17275_ _10764_ _10773_ _10950_ VSS VSS VDD VDD _11049_ sky130_fd_sc_hd__nand3_1
X_17276_ net923 _10848_ _10949_ _11049_ VSS VSS VDD VDD _11050_ sky130_fd_sc_hd__a31oi_1
X_17277_ net939 net732 VSS VSS VDD VDD _11051_ sky130_fd_sc_hd__nand2_1
X_17278_ net934 _11051_ _10854_ _10964_ VSS VSS VDD VDD _11052_ sky130_fd_sc_hd__a31oi_1
X_17279_ net908 net761 _11052_ VSS VSS VDD VDD _11053_ sky130_fd_sc_hd__a21oi_1
X_17280_ net914 net761 _10730_ _11053_ VSS VSS VDD VDD _11054_ sky130_fd_sc_hd__a31oi_1
X_17281_ _11032_ _11050_ _11054_ VSS VSS VDD VDD _11055_ sky130_fd_sc_hd__o21ai_0
X_17282_ _10733_ _11055_ VSS VSS VDD VDD _11056_ sky130_fd_sc_hd__nand2_1
X_17283_ _11048_ _11056_ _11015_ VSS VSS VDD VDD _11057_ sky130_fd_sc_hd__a21oi_1
X_17284_ _11013_ _11040_ _11057_ VSS VSS VDD VDD _11058_ sky130_fd_sc_hd__a21oi_1
X_17285_ _10919_ _10921_ VSS VSS VDD VDD _11059_ sky130_fd_sc_hd__nand2_1
X_17286_ _10866_ _10872_ _10888_ VSS VSS VDD VDD _11060_ sky130_fd_sc_hd__a21boi_0
X_17287_ _10730_ net759 net944 VSS VSS VDD VDD _11061_ sky130_fd_sc_hd__o21a_1
X_17288_ net943 _11061_ _10818_ VSS VSS VDD VDD _11062_ sky130_fd_sc_hd__o21ai_0
X_17289_ _10879_ _10972_ _11060_ _11062_ VSS VSS VDD VDD _11063_ sky130_fd_sc_hd__o31ai_1
X_17290_ _10835_ _10836_ _10845_ _10847_ VSS VSS VDD VDD _11064_ sky130_fd_sc_hd__and4bb_2
X_17291_ net719 net731 _11064_ VSS VSS VDD VDD _11065_ sky130_fd_sc_hd__nand3_1
X_17292_ net758 _11062_ _11065_ VSS VSS VDD VDD _11066_ sky130_fd_sc_hd__nand3_1
X_17293_ _10824_ _10996_ VSS VSS VDD VDD _11067_ sky130_fd_sc_hd__nand2_1
X_17294_ net758 _11067_ VSS VSS VDD VDD _11068_ sky130_fd_sc_hd__nand2_1
X_17295_ _10842_ _10849_ VSS VSS VDD VDD _11069_ sky130_fd_sc_hd__nand2_1
X_17296_ _10838_ net759 net936 VSS VSS VDD VDD _11070_ sky130_fd_sc_hd__o21ai_0
X_17297_ _10984_ _11070_ _10835_ _10836_ VSS VSS VDD VDD _11071_ sky130_fd_sc_hd__a211oi_1
X_17298_ _10891_ _10895_ VSS VSS VDD VDD _11072_ sky130_fd_sc_hd__nand2_1
X_17299_ _11069_ _11064_ _11071_ _11072_ VSS VSS VDD VDD _11073_ sky130_fd_sc_hd__a211oi_1
X_17300_ _10824_ net719 net731 _10996_ VSS VSS VDD VDD _11074_ sky130_fd_sc_hd__nand4_1
X_17301_ _10830_ _11073_ _11074_ _10924_ _10926_ VSS VSS VDD VDD _11075_ sky130_fd_sc_hd__o311ai_0
X_17302_ _11063_ _11066_ _11068_ _11075_ VSS VSS VDD VDD _11076_ sky130_fd_sc_hd__a31oi_1
X_17303_ _11059_ _11076_ _10945_ VSS VSS VDD VDD _11077_ sky130_fd_sc_hd__o21ai_0
X_17304_ _10799_ _10900_ net760 VSS VSS VDD VDD _11078_ sky130_fd_sc_hd__a21oi_1
X_17305_ _10785_ _10787_ _10955_ VSS VSS VDD VDD _11079_ sky130_fd_sc_hd__o21ai_0
X_17306_ _10933_ _10912_ _11078_ _11079_ VSS VSS VDD VDD _11080_ sky130_fd_sc_hd__or4_1
X_17307_ _10949_ _10950_ VSS VSS VDD VDD _11081_ sky130_fd_sc_hd__nand2_1
X_17308_ _11081_ _10951_ VSS VSS VDD VDD _11082_ sky130_fd_sc_hd__nor2_1
X_17309_ _10765_ _11082_ VSS VSS VDD VDD _11083_ sky130_fd_sc_hd__nor2_1
X_17310_ net934 VSS VSS VDD VDD _11084_ sky130_fd_sc_hd__inv_1
X_17311_ _11084_ net778 net754 _10966_ VSS VSS VDD VDD _11085_ sky130_fd_sc_hd__o31ai_1
X_17312_ _0731_[1] _10718_ net762 _11085_ _10732_ VSS VSS VDD VDD _11086_ sky130_fd_sc_hd__a221oi_1
X_17313_ _10722_ _10774_ _11083_ _11086_ VSS VSS VDD VDD _11087_ sky130_fd_sc_hd__o31ai_1
X_17314_ _10939_ _10942_ _11077_ _11080_ _11087_ VSS VSS VDD VDD _11088_ sky130_fd_sc_hd__a311oi_1
X_17315_ _11079_ VSS VSS VDD VDD _11089_ sky130_fd_sc_hd__inv_1
X_17316_ net756 net755 VSS VSS VDD VDD _11090_ sky130_fd_sc_hd__nand2_1
X_17317_ _10900_ net762 VSS VSS VDD VDD _11091_ sky130_fd_sc_hd__nand2b_1
X_17318_ _10933_ _10916_ _10936_ VSS VSS VDD VDD _11092_ sky130_fd_sc_hd__o21ai_0
X_17319_ net762 _11090_ _11091_ _11092_ VSS VSS VDD VDD _11093_ sky130_fd_sc_hd__a22oi_1
X_17320_ net760 _10799_ VSS VSS VDD VDD _11094_ sky130_fd_sc_hd__nor2_1
X_17321_ net760 _10806_ _11093_ _11094_ VSS VSS VDD VDD _11095_ sky130_fd_sc_hd__o22ai_1
X_17322_ _10774_ _11081_ _10733_ VSS VSS VDD VDD _11096_ sky130_fd_sc_hd__o21ai_0
X_17323_ _10788_ _10960_ _11096_ VSS VSS VDD VDD _11097_ sky130_fd_sc_hd__o21ai_0
X_17324_ _11089_ _11095_ _11097_ _10794_ VSS VSS VDD VDD _11098_ sky130_fd_sc_hd__a211oi_1
X_17325_ net939 net732 _10964_ VSS VSS VDD VDD _11099_ sky130_fd_sc_hd__a21oi_1
X_17326_ _10722_ _10732_ _11099_ VSS VSS VDD VDD _11100_ sky130_fd_sc_hd__nor3_1
X_17327_ _10766_ _10717_ _10752_ _11100_ VSS VSS VDD VDD _11101_ sky130_fd_sc_hd__o22ai_1
X_17328_ _11087_ _11098_ _11101_ VSS VSS VDD VDD _11102_ sky130_fd_sc_hd__o21ai_0
X_17329_ _11088_ _11102_ VSS VSS VDD VDD _11103_ sky130_fd_sc_hd__nor2_1
X_17330_ _10776_ _10952_ VSS VSS VDD VDD _11104_ sky130_fd_sc_hd__nor2_1
X_17331_ _10799_ _10806_ _10900_ VSS VSS VDD VDD _11105_ sky130_fd_sc_hd__nand3_1
X_17332_ _11090_ _11105_ net762 VSS VSS VDD VDD _11106_ sky130_fd_sc_hd__o21ai_0
X_17333_ _10753_ _10969_ VSS VSS VDD VDD _11107_ sky130_fd_sc_hd__nand2_1
X_17334_ _10794_ _11079_ _10960_ VSS VSS VDD VDD _11108_ sky130_fd_sc_hd__nor3b_1
X_17335_ _11107_ _11108_ VSS VSS VDD VDD _11109_ sky130_fd_sc_hd__nor2b_1
X_17336_ _11104_ _11106_ _11109_ VSS VSS VDD VDD _11110_ sky130_fd_sc_hd__nand3_1
X_17337_ _10713_ _10715_ VSS VSS VDD VDD _11111_ sky130_fd_sc_hd__nor2_1
X_17338_ _10905_ _10906_ _10716_ VSS VSS VDD VDD _11112_ sky130_fd_sc_hd__a21boi_0
X_17339_ _11111_ _11112_ VSS VSS VDD VDD _11113_ sky130_fd_sc_hd__nor2_1
X_17340_ _10833_ _10896_ VSS VSS VDD VDD _11114_ sky130_fd_sc_hd__nor2_1
X_17341_ _10837_ _10839_ VSS VSS VDD VDD _11115_ sky130_fd_sc_hd__nor2_1
X_17342_ _10842_ _11115_ _10849_ _11064_ _10830_ VSS VSS VDD VDD _11116_ sky130_fd_sc_hd__a41o_1
X_17343_ _10937_ _10917_ _10946_ _10927_ VSS VSS VDD VDD _11117_ sky130_fd_sc_hd__nor4_1
X_17344_ _11114_ _11116_ _11117_ VSS VSS VDD VDD _11118_ sky130_fd_sc_hd__and3_1
X_17345_ _10717_ _10834_ _11110_ _11118_ VSS VSS VDD VDD _11119_ sky130_fd_sc_hd__o22ai_1
X_17346_ _10880_ _10888_ VSS VSS VDD VDD _11120_ sky130_fd_sc_hd__nand2_1
X_17347_ _10873_ _11120_ _11116_ VSS VSS VDD VDD _11121_ sky130_fd_sc_hd__o21ai_0
X_17348_ _11114_ _11121_ _10946_ _10927_ VSS VSS VDD VDD _11122_ sky130_fd_sc_hd__a211oi_1
X_17349_ _10937_ _10917_ _11122_ _11106_ VSS VSS VDD VDD _11123_ sky130_fd_sc_hd__o31ai_1
X_17350_ _10716_ _10851_ _11111_ VSS VSS VDD VDD _11124_ sky130_fd_sc_hd__a21oi_1
X_17351_ _11107_ _11104_ _11124_ VSS VSS VDD VDD _11125_ sky130_fd_sc_hd__o21ai_0
X_17352_ _11123_ _11109_ _11125_ VSS VSS VDD VDD _11126_ sky130_fd_sc_hd__a21oi_1
X_17353_ _11114_ _11116_ VSS VSS VDD VDD _11127_ sky130_fd_sc_hd__nand2_1
X_17354_ _11106_ _11108_ VSS VSS VDD VDD _11128_ sky130_fd_sc_hd__nand2_1
X_17355_ _11127_ _11117_ _11128_ VSS VSS VDD VDD _11129_ sky130_fd_sc_hd__a21oi_1
X_17356_ _10718_ net778 VSS VSS VDD VDD _11130_ sky130_fd_sc_hd__nand2_1
X_17357_ _10776_ _10952_ _11107_ _11129_ _11130_ VSS VSS VDD VDD _11131_ sky130_fd_sc_hd__o41ai_1
X_17358_ _11110_ _11113_ _11119_ _11126_ _11131_ VSS VSS VDD VDD _11132_ sky130_fd_sc_hd__a2111oi_0
X_17359_ _10971_ _11058_ _11103_ _11132_ VSS VSS VDD VDD _11133_ sky130_fd_sc_hd__nor4b_2
X_17363_ u_core.u_top.u_core.acc_upd[238] _10709_ net636 VSS VSS VDD VDD _11137_ sky130_fd_sc_hd__mux2i_1
X_17364_ _10215_ _10236_ _08079_ VSS VSS VDD VDD _11138_ sky130_fd_sc_hd__nor3_4
X_17366_ _02693_ _08135_ u_core.u_top.u_core.acc[234] VSS VSS VDD VDD _11140_ sky130_fd_sc_hd__o21bai_1
X_17367_ u_core.u_top.u_core.acc[236] u_core.u_top.u_core.acc[235] _11140_ u_core.u_top.u_core.acc[237] VSS VSS VDD VDD _11141_ sky130_fd_sc_hd__a31oi_1
X_17368_ u_core.u_top.u_core.acc[239] _11141_ u_core.u_top.u_core.acc[238] VSS VSS VDD VDD _11142_ sky130_fd_sc_hd__nor3b_1
X_17369_ net853 _11142_ VSS VSS VDD VDD _11143_ sky130_fd_sc_hd__nand2_1
X_17370_ net926 net927 VSS VSS VDD VDD _11144_ sky130_fd_sc_hd__nor2_1
X_17371_ u_core.u_top.u_core.r_x[22] net925 VSS VSS VDD VDD _11145_ sky130_fd_sc_hd__nor2_1
X_17372_ _11144_ _11145_ VSS VSS VDD VDD _11146_ sky130_fd_sc_hd__nand2_1
X_17373_ net920 net921 VSS VSS VDD VDD _11147_ sky130_fd_sc_hd__nor2_1
X_17374_ u_core.u_top.u_core.r_x[34] net922 VSS VSS VDD VDD _11148_ sky130_fd_sc_hd__nor2_1
X_17375_ u_core.u_top.u_core.r_x[54] net913 VSS VSS VDD VDD _11149_ sky130_fd_sc_hd__nor2_1
X_17376_ u_core.u_top.u_core.r_x[50] net915 VSS VSS VDD VDD _11150_ sky130_fd_sc_hd__nor2_1
X_17377_ _11149_ _11150_ VSS VSS VDD VDD _11151_ sky130_fd_sc_hd__nand2_1
X_17378_ u_core.u_top.u_core.r_x[70] net909 u_core.u_top.u_core.r_x[66] net910 VSS VSS VDD VDD _11152_ sky130_fd_sc_hd__nor4_1
X_17379_ net904 net905 VSS VSS VDD VDD _11153_ sky130_fd_sc_hd__nor2_1
X_17380_ u_core.u_top.u_core.r_x[82] u_core.u_top.u_core.r_x[80] VSS VSS VDD VDD _11154_ sky130_fd_sc_hd__nor2_1
X_17381_ _11153_ _11154_ VSS VSS VDD VDD _11155_ sky130_fd_sc_hd__nand2_1
X_17382_ net943 net944 u_core.u_top.u_core.r_x[98] net900 VSS VSS VDD VDD _11156_ sky130_fd_sc_hd__nor4_1
X_17383_ net936 net937 VSS VSS VDD VDD _11157_ sky130_fd_sc_hd__nor2_1
X_17384_ u_core.u_top.u_core.r_x[114] net938 VSS VSS VDD VDD _11158_ sky130_fd_sc_hd__nor2_1
X_17385_ _11157_ _11158_ VSS VSS VDD VDD _11159_ sky130_fd_sc_hd__nand2_1
X_17386_ net931 net932 net933 u_core.u_top.u_core.r_x[128] VSS VSS VDD VDD _11160_ sky130_fd_sc_hd__nor4_1
X_17387_ u_core.u_top.u_core.r_x[142] net928 net929 net930 VSS VSS VDD VDD _11161_ sky130_fd_sc_hd__or4_1
X_17388_ u_core.u_top.u_core.r_x[126] u_core.u_top.u_core.r_x[124] u_core.u_top.u_core.r_x[122] net935 VSS VSS VDD VDD _11162_ sky130_fd_sc_hd__or4_1
X_17389_ _11160_ _11161_ _11162_ VSS VSS VDD VDD _11163_ sky130_fd_sc_hd__a21oi_1
X_17390_ u_core.u_top.u_core.r_x[110] net940 net941 net942 VSS VSS VDD VDD _11164_ sky130_fd_sc_hd__nor4_1
X_17391_ _11159_ _11163_ _11164_ VSS VSS VDD VDD _11165_ sky130_fd_sc_hd__o21ai_1
X_17392_ net901 u_core.u_top.u_core.r_x[92] u_core.u_top.u_core.r_x[90] net903 VSS VSS VDD VDD _11166_ sky130_fd_sc_hd__or4_1
X_17393_ _11156_ _11165_ _11166_ VSS VSS VDD VDD _11167_ sky130_fd_sc_hd__a21oi_1
X_17394_ net906 u_core.u_top.u_core.r_x[76] u_core.u_top.u_core.r_x[74] net907 VSS VSS VDD VDD _11168_ sky130_fd_sc_hd__nor4_1
X_17395_ _11155_ _11167_ _11168_ VSS VSS VDD VDD _11169_ sky130_fd_sc_hd__o21ai_1
X_17396_ u_core.u_top.u_core.r_x[62] net911 u_core.u_top.u_core.r_x[58] net912 VSS VSS VDD VDD _11170_ sky130_fd_sc_hd__or4_1
X_17397_ _11152_ _11169_ _11170_ VSS VSS VDD VDD _11171_ sky130_fd_sc_hd__a21oi_1
X_17398_ net916 net917 VSS VSS VDD VDD _11172_ sky130_fd_sc_hd__nor2_1
X_17399_ net918 net919 VSS VSS VDD VDD _11173_ sky130_fd_sc_hd__nor2_1
X_17400_ _11151_ _11171_ _11172_ _11173_ VSS VSS VDD VDD _11174_ sky130_fd_sc_hd__o211ai_1
X_17401_ u_core.u_top.u_core.r_x[26] net924 VSS VSS VDD VDD _11175_ sky130_fd_sc_hd__nor2_1
X_17402_ u_core.u_top.u_core.r_x[30] net923 VSS VSS VDD VDD _11176_ sky130_fd_sc_hd__nor2_1
X_17403_ _11175_ _11176_ VSS VSS VDD VDD _11177_ sky130_fd_sc_hd__nand2_1
X_17404_ _11147_ _11148_ _11174_ _11177_ VSS VSS VDD VDD _11178_ sky130_fd_sc_hd__a31oi_1
X_17405_ u_core.u_top.u_core.r_x[14] net934 net939 net902 VSS VSS VDD VDD _11179_ sky130_fd_sc_hd__nor4_1
X_17406_ _11146_ _11178_ _11179_ VSS VSS VDD VDD _11180_ sky130_fd_sc_hd__o21ai_0
X_17407_ net958 _10714_ net945 VSS VSS VDD VDD _11181_ sky130_fd_sc_hd__or3_1
X_17408_ u_core.u_top.u_core.r_x[2] _11181_ VSS VSS VDD VDD _11182_ sky130_fd_sc_hd__nor2_1
X_17409_ net908 net914 VSS VSS VDD VDD _11183_ sky130_fd_sc_hd__nor2_1
X_17410_ u_core.u_top.u_core.r_noshuf u_core.u_top.u_core.r_zskip _10589_ VSS VSS VDD VDD _11184_ sky130_fd_sc_hd__o21ai_2
X_17411_ _11180_ _11182_ _11183_ _11184_ net992 VSS VSS VDD VDD _11185_ sky130_fd_sc_hd__a32o_1
X_17412_ u_core.u_top.u_core.r_x[14] net934 VSS VSS VDD VDD _11186_ sky130_fd_sc_hd__nor2_1
X_17413_ net939 net902 u_core.u_top.u_core.r_x[2] _11181_ VSS VSS VDD VDD _11187_ sky130_fd_sc_hd__nor4_1
X_17414_ _11186_ _11183_ _11187_ VSS VSS VDD VDD _11188_ sky130_fd_sc_hd__and3_1
X_17415_ _11147_ _11148_ _11172_ _11173_ VSS VSS VDD VDD _11189_ sky130_fd_sc_hd__nand4_1
X_17416_ _11152_ _11168_ VSS VSS VDD VDD _11190_ sky130_fd_sc_hd__and2_1
X_17417_ _11156_ _11164_ VSS VSS VDD VDD _11191_ sky130_fd_sc_hd__nand2_1
X_17418_ net929 net930 VSS VSS VDD VDD _11192_ sky130_fd_sc_hd__nor2_1
X_17419_ u_core.u_top.u_core.r_x[142] net928 VSS VSS VDD VDD _11193_ sky130_fd_sc_hd__nor2_1
X_17420_ _11159_ _11162_ VSS VSS VDD VDD _11194_ sky130_fd_sc_hd__or2_2
X_17421_ _11160_ _11192_ _11193_ _11194_ VSS VSS VDD VDD _11195_ sky130_fd_sc_hd__a31oi_1
X_17422_ _11155_ _11166_ VSS VSS VDD VDD _11196_ sky130_fd_sc_hd__nor2_1
X_17423_ _11191_ _11195_ _11196_ VSS VSS VDD VDD _11197_ sky130_fd_sc_hd__o21ai_0
X_17424_ _11151_ _11170_ VSS VSS VDD VDD _11198_ sky130_fd_sc_hd__or2_2
X_17425_ _11190_ net730 _11198_ VSS VSS VDD VDD _11199_ sky130_fd_sc_hd__a21oi_1
X_17426_ u_core.u_top.u_core.r_x[26] net924 net926 net927 VSS VSS VDD VDD _11200_ sky130_fd_sc_hd__nor4_1
X_17427_ _11189_ _11199_ _11145_ _11176_ _11200_ VSS VSS VDD VDD _11201_ sky130_fd_sc_hd__o2111ai_1
X_17428_ u_core.u_top.u_core.lfsr_m72[3] _11184_ _11188_ _11201_ VSS VSS VDD VDD _11202_ sky130_fd_sc_hd__a22oi_1
X_17429_ net914 VSS VSS VDD VDD _11203_ sky130_fd_sc_hd__inv_1
X_17430_ u_core.u_top.u_core.r_x[14] _11084_ net939 VSS VSS VDD VDD _11204_ sky130_fd_sc_hd__a21oi_1
X_17431_ net902 _11204_ net908 VSS VSS VDD VDD _11205_ sky130_fd_sc_hd__o21bai_1
X_17432_ _11203_ _11205_ u_core.u_top.u_core.r_x[2] VSS VSS VDD VDD _11206_ sky130_fd_sc_hd__a21oi_1
X_17433_ _0725_[1] _11184_ VSS VSS VDD VDD _11207_ sky130_fd_sc_hd__nand2_1
X_17434_ _11181_ _11206_ _11207_ VSS VSS VDD VDD _11208_ sky130_fd_sc_hd__o21ai_0
X_17435_ u_core.u_top.u_core.lfsr_m72[5] u_core.u_top.u_core.lfsr_m72[4] _0725_[2] VSS VSS VDD VDD _11209_ sky130_fd_sc_hd__nor3_1
X_17436_ _11191_ _11194_ VSS VSS VDD VDD _11210_ sky130_fd_sc_hd__nor2_1
X_17437_ _11190_ _11196_ _11210_ VSS VSS VDD VDD _11211_ sky130_fd_sc_hd__nand3_1
X_17438_ _11189_ _11198_ VSS VSS VDD VDD _11212_ sky130_fd_sc_hd__nor2_1
X_17439_ _11145_ _11176_ _11188_ _11200_ VSS VSS VDD VDD _11213_ sky130_fd_sc_hd__and4_1
X_17440_ _11212_ _11213_ VSS VSS VDD VDD _11214_ sky130_fd_sc_hd__nand2_1
X_17441_ _11211_ _11214_ VSS VSS VDD VDD _11215_ sky130_fd_sc_hd__nor2_1
X_17442_ u_core.u_top.u_core.lfsr_m72[6] _11184_ _11209_ _11215_ VSS VSS VDD VDD _11216_ sky130_fd_sc_hd__a31oi_1
X_17443_ _11185_ _11202_ _11208_ _11216_ VSS VSS VDD VDD _11217_ sky130_fd_sc_hd__or4_1
X_17444_ _08109_ _11217_ VSS VSS VDD VDD _11218_ sky130_fd_sc_hd__nand2_1
X_17445_ _08079_ _09962_ VSS VSS VDD VDD _11219_ sky130_fd_sc_hd__nor2_1
X_17446_ _11218_ _11219_ VSS VSS VDD VDD _11220_ sky130_fd_sc_hd__nor2_4
X_17447_ u_core.u_top.u_core.lfsr[15] _11220_ VSS VSS VDD VDD _11221_ sky130_fd_sc_hd__nand2_2
X_17450_ net786 _11137_ _11143_ net635 VSS VSS VDD VDD _1042_[238] sky130_fd_sc_hd__o211ai_1
X_17451_ _02307_ _02570_ VSS VSS VDD VDD _11224_ sky130_fd_sc_hd__nor2b_1
X_17452_ _02906_ _11224_ _02740_ VSS VSS VDD VDD _11225_ sky130_fd_sc_hd__o21ai_0
X_17453_ _02739_ _11225_ VSS VSS VDD VDD _11226_ sky130_fd_sc_hd__nand2b_1
X_17454_ _03047_ _11226_ _03046_ VSS VSS VDD VDD _11227_ sky130_fd_sc_hd__a21o_1
X_17455_ _02519_ _11227_ _02518_ VSS VSS VDD VDD _11228_ sky130_fd_sc_hd__a21o_1
X_17456_ _03121_ _11228_ _03120_ VSS VSS VDD VDD _11229_ sky130_fd_sc_hd__a21o_1
X_17457_ _03123_ _11229_ _03122_ VSS VSS VDD VDD _11230_ sky130_fd_sc_hd__a21o_1
X_17458_ _02721_ _11230_ VSS VSS VDD VDD _11231_ sky130_fd_sc_hd__xor2_1
X_17459_ u_core.u_top.u_core.acc_upd[237] _11231_ net636 VSS VSS VDD VDD _11232_ sky130_fd_sc_hd__mux2i_1
X_17460_ _11142_ net853 VSS VSS VDD VDD _11233_ sky130_fd_sc_hd__nand2b_1
X_17461_ net786 _11232_ _11233_ net635 VSS VSS VDD VDD _1042_[237] sky130_fd_sc_hd__o211ai_1
X_17462_ _03123_ _10706_ VSS VSS VDD VDD _11234_ sky130_fd_sc_hd__xor2_1
X_17464_ u_core.u_top.u_core.acc_upd[236] _11234_ net636 VSS VSS VDD VDD _11236_ sky130_fd_sc_hd__mux2i_1
X_17465_ u_core.u_top.u_core.lfsr[14] _11220_ VSS VSS VDD VDD _11237_ sky130_fd_sc_hd__nand2_2
X_17466_ net786 _11236_ net633 _11143_ VSS VSS VDD VDD _1042_[236] sky130_fd_sc_hd__o211ai_1
X_17467_ _03121_ _11228_ VSS VSS VDD VDD _11238_ sky130_fd_sc_hd__xor2_1
X_17468_ u_core.u_top.u_core.acc_upd[235] _11238_ net636 VSS VSS VDD VDD _11239_ sky130_fd_sc_hd__mux2i_1
X_17469_ u_core.u_top.u_core.lfsr[13] _11220_ VSS VSS VDD VDD _11240_ sky130_fd_sc_hd__nand2_2
X_17470_ net786 _11239_ net632 _11143_ VSS VSS VDD VDD _1042_[235] sky130_fd_sc_hd__o211ai_1
X_17471_ _02519_ _10704_ VSS VSS VDD VDD _11241_ sky130_fd_sc_hd__xor2_1
X_17472_ u_core.u_top.u_core.acc_upd[234] _11241_ net636 VSS VSS VDD VDD _11242_ sky130_fd_sc_hd__mux2i_1
X_17473_ u_core.u_top.u_core.lfsr[12] _11220_ VSS VSS VDD VDD _11243_ sky130_fd_sc_hd__nand2_2
X_17474_ net786 _11242_ net631 _11233_ VSS VSS VDD VDD _1042_[234] sky130_fd_sc_hd__o211ai_1
X_17477_ _03047_ _11226_ VSS VSS VDD VDD _11246_ sky130_fd_sc_hd__xnor2_1
X_17478_ net636 _11246_ VSS VSS VDD VDD _11247_ sky130_fd_sc_hd__nand2_1
X_17479_ u_core.u_top.u_core.acc_upd[233] net636 _11247_ VSS VSS VDD VDD _11248_ sky130_fd_sc_hd__o21ai_0
X_17480_ u_core.u_top.u_core.lfsr[11] _11220_ VSS VSS VDD VDD _11249_ sky130_fd_sc_hd__nand2_2
X_17481_ net786 _11248_ net630 _11143_ VSS VSS VDD VDD _1042_[233] sky130_fd_sc_hd__o211ai_1
X_17483_ _02740_ _02308_ VSS VSS VDD VDD _11251_ sky130_fd_sc_hd__xnor2_1
X_17485_ u_core.u_top.u_core.acc_upd[232] _11251_ net636 VSS VSS VDD VDD _11253_ sky130_fd_sc_hd__mux2i_1
X_17486_ u_core.u_top.u_core.lfsr[10] _11220_ net852 VSS VSS VDD VDD _11254_ sky130_fd_sc_hd__a21oi_4
X_17488_ net786 _11253_ _11254_ VSS VSS VDD VDD _1042_[232] sky130_fd_sc_hd__o21ai_0
X_17489_ net991 _11220_ VSS VSS VDD VDD _11256_ sky130_fd_sc_hd__nand2_4
X_17491_ net898 _10236_ VSS VSS VDD VDD _11258_ sky130_fd_sc_hd__nand2_1
X_17492_ _08079_ _11258_ VSS VSS VDD VDD _11259_ sky130_fd_sc_hd__nor2_4
X_17495_ u_core.u_top.u_core.acc_upd[231] VSS VSS VDD VDD _02306_ sky130_fd_sc_hd__inv_1
X_17498_ _02306_ _02309_ net636 VSS VSS VDD VDD _11264_ sky130_fd_sc_hd__mux2i_1
X_17499_ net776 _11264_ VSS VSS VDD VDD _11265_ sky130_fd_sc_hd__nand2_1
X_17500_ _11256_ _11265_ VSS VSS VDD VDD _1042_[231] sky130_fd_sc_hd__nand2_1
X_17501_ u_core.u_top.u_core.acc[230] _08131_ VSS VSS VDD VDD _03479_ sky130_fd_sc_hd__xnor2_1
X_17503_ _03479_ _03480_ net638 VSS VSS VDD VDD _11267_ sky130_fd_sc_hd__mux2_1
X_17504_ u_core.u_top.u_core.lfsr[8] _11220_ VSS VSS VDD VDD _11268_ sky130_fd_sc_hd__nand2_4
X_17506_ net786 _11267_ _11268_ VSS VSS VDD VDD _1042_[230] sky130_fd_sc_hd__o21ai_0
X_17508_ u_core.u_top.u_core.r_off[7] VSS VSS VDD VDD _11271_ sky130_fd_sc_hd__inv_2
X_17510_ _02413_ _03069_ VSS VSS VDD VDD _11272_ sky130_fd_sc_hd__nor2b_1
X_17511_ _03339_ _11272_ _02785_ VSS VSS VDD VDD _11273_ sky130_fd_sc_hd__o21ai_0
X_17512_ _02784_ _11273_ VSS VSS VDD VDD _11274_ sky130_fd_sc_hd__nand2b_1
X_17513_ _02523_ _11274_ _02522_ VSS VSS VDD VDD _11275_ sky130_fd_sc_hd__a21o_1
X_17514_ _03402_ _11275_ _03401_ VSS VSS VDD VDD _11276_ sky130_fd_sc_hd__a21o_1
X_17515_ _03380_ _11276_ _03379_ VSS VSS VDD VDD _11277_ sky130_fd_sc_hd__a21o_1
X_17516_ _02827_ _11277_ _02826_ VSS VSS VDD VDD _11278_ sky130_fd_sc_hd__a21o_1
X_17517_ _02733_ _11278_ _02732_ VSS VSS VDD VDD _11279_ sky130_fd_sc_hd__a21o_1
X_17518_ _02761_ _11279_ _02760_ VSS VSS VDD VDD _11280_ sky130_fd_sc_hd__a21oi_1
X_17519_ net881 _11280_ VSS VSS VDD VDD _11281_ sky130_fd_sc_hd__xnor2_1
X_17520_ net637 _11281_ VSS VSS VDD VDD _11282_ sky130_fd_sc_hd__nand2_1
X_17521_ u_core.u_top.u_core.acc[228] u_core.u_top.u_core.acc[227] _08207_ VSS VSS VDD VDD _11283_ sky130_fd_sc_hd__nor3_1
X_17522_ u_core.u_top.u_core.acc[228] u_core.u_top.u_core.acc[227] _08203_ VSS VSS VDD VDD _11284_ sky130_fd_sc_hd__and3_1
X_17523_ net697 _11283_ _11284_ _08180_ VSS VSS VDD VDD _11285_ sky130_fd_sc_hd__o22ai_1
X_17524_ u_core.u_top.u_core.acc[229] VSS VSS VDD VDD _11286_ sky130_fd_sc_hd__inv_1
X_17525_ _08194_ _11283_ _11284_ _08193_ _11286_ VSS VSS VDD VDD _11287_ sky130_fd_sc_hd__a221oi_1
X_17526_ u_core.u_top.u_core.acc[229] _11285_ _11287_ VSS VSS VDD VDD _11288_ sky130_fd_sc_hd__o21bai_1
X_17528_ u_core.u_top.u_core.acc[229] net662 _11288_ net671 VSS VSS VDD VDD _11290_ sky130_fd_sc_hd__o22ai_1
X_17529_ _11282_ _11290_ VSS VSS VDD VDD _11291_ sky130_fd_sc_hd__xnor2_1
X_17530_ _02673_ u_core.u_top.u_core.acc[222] u_core.u_top.u_core.acc[223] VSS VSS VDD VDD _11292_ sky130_fd_sc_hd__nand3b_1
X_17531_ _08181_ _11292_ _08200_ VSS VSS VDD VDD _11293_ sky130_fd_sc_hd__a21oi_1
X_17532_ u_core.u_top.u_core.acc[227] _11293_ _11286_ u_core.u_top.u_core.acc[228] VSS VSS VDD VDD _11294_ sky130_fd_sc_hd__o211a_1
X_17534_ _11294_ net852 VSS VSS VDD VDD _11296_ sky130_fd_sc_hd__nand2b_1
X_17535_ net783 _11291_ _11296_ net634 VSS VSS VDD VDD _1042_[229] sky130_fd_sc_hd__o211ai_1
X_17536_ _02414_ _02785_ VSS VSS VDD VDD _11297_ sky130_fd_sc_hd__nor2b_1
X_17537_ _02784_ _11297_ _02523_ VSS VSS VDD VDD _11298_ sky130_fd_sc_hd__o21ai_0
X_17538_ _02522_ _11298_ VSS VSS VDD VDD _11299_ sky130_fd_sc_hd__nand2b_1
X_17539_ _03402_ _11299_ _03401_ VSS VSS VDD VDD _11300_ sky130_fd_sc_hd__a21o_1
X_17540_ _03380_ _11300_ _03379_ VSS VSS VDD VDD _11301_ sky130_fd_sc_hd__a21o_1
X_17541_ _02827_ _11301_ _02826_ VSS VSS VDD VDD _11302_ sky130_fd_sc_hd__a21o_1
X_17542_ _02733_ _11302_ _02732_ VSS VSS VDD VDD _11303_ sky130_fd_sc_hd__a21oi_1
X_17543_ _02761_ _11303_ VSS VSS VDD VDD _11304_ sky130_fd_sc_hd__xnor2_1
X_17544_ u_core.u_top.u_core.acc_upd[228] _11304_ net637 VSS VSS VDD VDD _11305_ sky130_fd_sc_hd__mux2i_1
X_17546_ net852 _11294_ VSS VSS VDD VDD _11307_ sky130_fd_sc_hd__nand2_1
X_17547_ net783 _11305_ _11307_ net634 VSS VSS VDD VDD _1042_[228] sky130_fd_sc_hd__o211ai_1
X_17548_ _02733_ _11278_ VSS VSS VDD VDD _11308_ sky130_fd_sc_hd__xor2_1
X_17549_ u_core.u_top.u_core.acc_upd[227] _11308_ net637 VSS VSS VDD VDD _11309_ sky130_fd_sc_hd__mux2i_1
X_17550_ net783 _11309_ _11296_ net634 VSS VSS VDD VDD _1042_[227] sky130_fd_sc_hd__o211ai_1
X_17552_ _02827_ _11301_ VSS VSS VDD VDD _11311_ sky130_fd_sc_hd__xor2_1
X_17553_ u_core.u_top.u_core.acc_upd[226] _11311_ net637 VSS VSS VDD VDD _11312_ sky130_fd_sc_hd__mux2i_1
X_17555_ net783 _11312_ _11307_ _11237_ VSS VSS VDD VDD _1042_[226] sky130_fd_sc_hd__o211ai_1
X_17556_ _03380_ _11276_ VSS VSS VDD VDD _11314_ sky130_fd_sc_hd__xor2_1
X_17557_ u_core.u_top.u_core.acc_upd[225] _11314_ net637 VSS VSS VDD VDD _11315_ sky130_fd_sc_hd__mux2i_1
X_17559_ net783 _11315_ _11307_ _11240_ VSS VSS VDD VDD _1042_[225] sky130_fd_sc_hd__o211ai_1
X_17560_ _03402_ _11299_ VSS VSS VDD VDD _11317_ sky130_fd_sc_hd__xor2_1
X_17561_ u_core.u_top.u_core.acc_upd[224] _11317_ net637 VSS VSS VDD VDD _11318_ sky130_fd_sc_hd__mux2i_1
X_17563_ net783 _11318_ _11296_ _11243_ VSS VSS VDD VDD _1042_[224] sky130_fd_sc_hd__o211ai_1
X_17564_ _02523_ _11274_ VSS VSS VDD VDD _11320_ sky130_fd_sc_hd__xnor2_1
X_17565_ net637 _11320_ VSS VSS VDD VDD _11321_ sky130_fd_sc_hd__nand2_1
X_17566_ u_core.u_top.u_core.acc_upd[223] net637 _11321_ VSS VSS VDD VDD _11322_ sky130_fd_sc_hd__o21ai_0
X_17568_ net783 _11322_ _11307_ _11249_ VSS VSS VDD VDD _1042_[223] sky130_fd_sc_hd__o211ai_1
X_17569_ _02785_ _02414_ VSS VSS VDD VDD _11324_ sky130_fd_sc_hd__xnor2_1
X_17570_ u_core.u_top.u_core.acc_upd[222] _11324_ net637 VSS VSS VDD VDD _11325_ sky130_fd_sc_hd__mux2i_1
X_17571_ net783 _11325_ _11254_ VSS VSS VDD VDD _1042_[222] sky130_fd_sc_hd__o21ai_0
X_17572_ u_core.u_top.u_core.acc_upd[221] VSS VSS VDD VDD _02412_ sky130_fd_sc_hd__inv_1
X_17573_ _02412_ _02415_ net637 VSS VSS VDD VDD _11326_ sky130_fd_sc_hd__mux2i_1
X_17574_ net776 _11326_ VSS VSS VDD VDD _11327_ sky130_fd_sc_hd__nand2_1
X_17575_ _11256_ _11327_ VSS VSS VDD VDD _1042_[221] sky130_fd_sc_hd__nand2_1
X_17578_ u_core.u_top.u_core.acc[220] net662 VSS VSS VDD VDD _02670_ sky130_fd_sc_hd__xnor2_1
X_17579_ _02670_ _02671_ net637 VSS VSS VDD VDD _11330_ sky130_fd_sc_hd__mux2_1
X_17580_ net783 _11330_ _11268_ VSS VSS VDD VDD _1042_[220] sky130_fd_sc_hd__o21ai_0
X_17581_ _02385_ _02810_ VSS VSS VDD VDD _11331_ sky130_fd_sc_hd__nor2b_1
X_17582_ _02809_ _11331_ _02939_ VSS VSS VDD VDD _11332_ sky130_fd_sc_hd__o21ai_0
X_17583_ _02938_ _11332_ VSS VSS VDD VDD _11333_ sky130_fd_sc_hd__nand2b_1
X_17584_ _03398_ _11333_ _03397_ VSS VSS VDD VDD _11334_ sky130_fd_sc_hd__a21o_1
X_17585_ _02745_ _11334_ _02744_ VSS VSS VDD VDD _11335_ sky130_fd_sc_hd__a21o_1
X_17586_ _03400_ _11335_ _03399_ VSS VSS VDD VDD _11336_ sky130_fd_sc_hd__a21o_1
X_17587_ _03396_ _11336_ _03395_ VSS VSS VDD VDD _11337_ sky130_fd_sc_hd__a21o_1
X_17588_ _02715_ _11337_ _02714_ VSS VSS VDD VDD _11338_ sky130_fd_sc_hd__a21o_1
X_17589_ _03341_ _11338_ _03340_ VSS VSS VDD VDD _11339_ sky130_fd_sc_hd__a21oi_1
X_17590_ net881 _11339_ VSS VSS VDD VDD _11340_ sky130_fd_sc_hd__xnor2_1
X_17591_ net637 _11340_ VSS VSS VDD VDD _11341_ sky130_fd_sc_hd__nand2_1
X_17592_ u_core.u_top.u_core.acc[218] u_core.u_top.u_core.acc[217] _08266_ VSS VSS VDD VDD _11342_ sky130_fd_sc_hd__nand3_1
X_17593_ u_core.u_top.u_core.acc[219] _11342_ VSS VSS VDD VDD _11343_ sky130_fd_sc_hd__xor2_1
X_17594_ u_core.u_top.u_core.acc[218] u_core.u_top.u_core.acc[217] _08261_ VSS VSS VDD VDD _11344_ sky130_fd_sc_hd__nor3_1
X_17595_ u_core.u_top.u_core.acc[219] _11344_ VSS VSS VDD VDD _03521_ sky130_fd_sc_hd__xnor2_1
X_17596_ _08254_ _11343_ _03521_ _08255_ VSS VSS VDD VDD _03522_ sky130_fd_sc_hd__a22oi_1
X_17597_ u_core.u_top.u_core.acc[219] _08258_ _03522_ net673 VSS VSS VDD VDD _03523_ sky130_fd_sc_hd__o22ai_1
X_17598_ _11341_ _03523_ VSS VSS VDD VDD _03524_ sky130_fd_sc_hd__xnor2_1
X_17599_ _02645_ _08262_ u_core.u_top.u_core.acc[214] VSS VSS VDD VDD _03525_ sky130_fd_sc_hd__o21bai_1
X_17600_ u_core.u_top.u_core.acc[216] u_core.u_top.u_core.acc[215] _03525_ u_core.u_top.u_core.acc[217] VSS VSS VDD VDD _03526_ sky130_fd_sc_hd__a31oi_1
X_17601_ _08240_ u_core.u_top.u_core.acc[219] _03526_ VSS VSS VDD VDD _03527_ sky130_fd_sc_hd__nor3_1
X_17602_ _03527_ net852 VSS VSS VDD VDD _03528_ sky130_fd_sc_hd__nand2b_1
X_17603_ net783 _03524_ _03528_ net634 VSS VSS VDD VDD _1042_[219] sky130_fd_sc_hd__o211ai_1
X_17604_ _02386_ _02939_ VSS VSS VDD VDD _03529_ sky130_fd_sc_hd__nor2b_1
X_17605_ _02938_ _03529_ _03398_ VSS VSS VDD VDD _03530_ sky130_fd_sc_hd__o21ai_0
X_17606_ _03397_ _03530_ VSS VSS VDD VDD _03531_ sky130_fd_sc_hd__nand2b_1
X_17607_ _02745_ _03531_ _02744_ VSS VSS VDD VDD _03532_ sky130_fd_sc_hd__a21o_1
X_17608_ _03400_ _03532_ _03399_ VSS VSS VDD VDD _03533_ sky130_fd_sc_hd__a21o_1
X_17609_ _03396_ _03533_ _03395_ VSS VSS VDD VDD _03534_ sky130_fd_sc_hd__a21o_1
X_17610_ _02715_ _03534_ _02714_ VSS VSS VDD VDD _03535_ sky130_fd_sc_hd__a21oi_1
X_17611_ _03341_ _03535_ VSS VSS VDD VDD _03536_ sky130_fd_sc_hd__xnor2_1
X_17612_ u_core.u_top.u_core.acc_upd[218] _03536_ net637 VSS VSS VDD VDD _03537_ sky130_fd_sc_hd__mux2i_1
X_17613_ net852 _03527_ VSS VSS VDD VDD _03538_ sky130_fd_sc_hd__nand2_1
X_17614_ net783 _03537_ _03538_ net634 VSS VSS VDD VDD _1042_[218] sky130_fd_sc_hd__o211ai_1
X_17615_ _02715_ _11337_ VSS VSS VDD VDD _03539_ sky130_fd_sc_hd__xor2_1
X_17616_ u_core.u_top.u_core.acc_upd[217] _03539_ net637 VSS VSS VDD VDD _03540_ sky130_fd_sc_hd__mux2i_1
X_17617_ net783 _03540_ _03528_ net634 VSS VSS VDD VDD _1042_[217] sky130_fd_sc_hd__o211ai_1
X_17618_ _03396_ _03533_ VSS VSS VDD VDD _03541_ sky130_fd_sc_hd__xor2_1
X_17620_ u_core.u_top.u_core.acc_upd[216] _03541_ net637 VSS VSS VDD VDD _03543_ sky130_fd_sc_hd__mux2i_1
X_17621_ net783 _03543_ _03538_ _11237_ VSS VSS VDD VDD _1042_[216] sky130_fd_sc_hd__o211ai_1
X_17622_ _03400_ _11335_ VSS VSS VDD VDD _03544_ sky130_fd_sc_hd__xor2_1
X_17623_ u_core.u_top.u_core.acc_upd[215] _03544_ net637 VSS VSS VDD VDD _03545_ sky130_fd_sc_hd__mux2i_1
X_17624_ net783 _03545_ _03538_ _11240_ VSS VSS VDD VDD _1042_[215] sky130_fd_sc_hd__o211ai_1
X_17625_ _02745_ _03531_ VSS VSS VDD VDD _03546_ sky130_fd_sc_hd__xor2_1
X_17626_ u_core.u_top.u_core.acc_upd[214] _03546_ net637 VSS VSS VDD VDD _03547_ sky130_fd_sc_hd__mux2i_1
X_17627_ net783 _03547_ _03528_ _11243_ VSS VSS VDD VDD _1042_[214] sky130_fd_sc_hd__o211ai_1
X_17630_ _03398_ _11333_ VSS VSS VDD VDD _03550_ sky130_fd_sc_hd__xnor2_1
X_17631_ net637 _03550_ VSS VSS VDD VDD _03551_ sky130_fd_sc_hd__nand2_1
X_17632_ u_core.u_top.u_core.acc_upd[213] net637 _03551_ VSS VSS VDD VDD _03552_ sky130_fd_sc_hd__o21ai_0
X_17633_ net783 _03552_ _03538_ _11249_ VSS VSS VDD VDD _1042_[213] sky130_fd_sc_hd__o211ai_1
X_17634_ _02939_ _02386_ VSS VSS VDD VDD _03553_ sky130_fd_sc_hd__xnor2_1
X_17635_ u_core.u_top.u_core.acc_upd[212] _03553_ net637 VSS VSS VDD VDD _03554_ sky130_fd_sc_hd__mux2i_1
X_17636_ net783 _03554_ _11254_ VSS VSS VDD VDD _1042_[212] sky130_fd_sc_hd__o21ai_0
X_17637_ u_core.u_top.u_core.acc_upd[211] VSS VSS VDD VDD _02384_ sky130_fd_sc_hd__inv_1
X_17638_ _02384_ _02387_ net637 VSS VSS VDD VDD _03555_ sky130_fd_sc_hd__mux2i_1
X_17639_ net776 _03555_ VSS VSS VDD VDD _03556_ sky130_fd_sc_hd__nand2_1
X_17640_ _11256_ _03556_ VSS VSS VDD VDD _1042_[211] sky130_fd_sc_hd__nand2_1
X_17641_ u_core.u_top.u_core.acc[210] _08258_ VSS VSS VDD VDD _02498_ sky130_fd_sc_hd__xnor2_1
X_17642_ _02498_ _02499_ net637 VSS VSS VDD VDD _03557_ sky130_fd_sc_hd__mux2_1
X_17643_ net783 _03557_ _11268_ VSS VSS VDD VDD _1042_[210] sky130_fd_sc_hd__o21ai_0
X_17644_ _02316_ _02600_ VSS VSS VDD VDD _03558_ sky130_fd_sc_hd__nor2b_1
X_17645_ _02794_ _03558_ _03447_ VSS VSS VDD VDD _03559_ sky130_fd_sc_hd__o21ai_0
X_17646_ _03446_ _03559_ VSS VSS VDD VDD _03560_ sky130_fd_sc_hd__nand2b_1
X_17647_ _02497_ _03560_ _02496_ VSS VSS VDD VDD _03561_ sky130_fd_sc_hd__a21o_1
X_17648_ _02492_ _03561_ _02491_ VSS VSS VDD VDD _03562_ sky130_fd_sc_hd__a21o_1
X_17649_ _02517_ _03562_ _02516_ VSS VSS VDD VDD _03563_ sky130_fd_sc_hd__a21o_1
X_17650_ _02949_ _03563_ _02948_ VSS VSS VDD VDD _03564_ sky130_fd_sc_hd__a21o_1
X_17651_ _02680_ _03564_ _02679_ VSS VSS VDD VDD _03565_ sky130_fd_sc_hd__a21o_1
X_17652_ _03321_ _03565_ _03320_ VSS VSS VDD VDD _03566_ sky130_fd_sc_hd__a21oi_1
X_17653_ net881 _03566_ VSS VSS VDD VDD _03567_ sky130_fd_sc_hd__xnor2_1
X_17654_ net637 _03567_ VSS VSS VDD VDD _03568_ sky130_fd_sc_hd__nand2_1
X_17655_ u_core.u_top.u_core.acc[208] u_core.u_top.u_core.acc[207] _08308_ VSS VSS VDD VDD _03569_ sky130_fd_sc_hd__nand3_1
X_17656_ u_core.u_top.u_core.acc[209] _03569_ VSS VSS VDD VDD _03570_ sky130_fd_sc_hd__xor2_1
X_17657_ u_core.u_top.u_core.acc[208] u_core.u_top.u_core.acc[207] _08303_ VSS VSS VDD VDD _03571_ sky130_fd_sc_hd__nor3_1
X_17658_ u_core.u_top.u_core.acc[209] _03571_ VSS VSS VDD VDD _03572_ sky130_fd_sc_hd__xnor2_1
X_17659_ _06496_ _03570_ _03572_ _08299_ VSS VSS VDD VDD _03573_ sky130_fd_sc_hd__a22oi_1
X_17660_ u_core.u_top.u_core.acc[209] net663 _03573_ net674 VSS VSS VDD VDD _03574_ sky130_fd_sc_hd__o22ai_1
X_17661_ _03568_ _03574_ VSS VSS VDD VDD _03575_ sky130_fd_sc_hd__xnor2_1
X_17662_ _02602_ _08304_ u_core.u_top.u_core.acc[204] VSS VSS VDD VDD _03576_ sky130_fd_sc_hd__o21bai_1
X_17663_ u_core.u_top.u_core.acc[206] u_core.u_top.u_core.acc[205] _03576_ u_core.u_top.u_core.acc[207] VSS VSS VDD VDD _03577_ sky130_fd_sc_hd__a31oi_1
X_17664_ u_core.u_top.u_core.acc[209] _03577_ u_core.u_top.u_core.acc[208] VSS VSS VDD VDD _03578_ sky130_fd_sc_hd__nor3b_1
X_17665_ _03578_ net852 VSS VSS VDD VDD _03579_ sky130_fd_sc_hd__nand2b_1
X_17666_ net783 _03575_ _03579_ net634 VSS VSS VDD VDD _1042_[209] sky130_fd_sc_hd__o211ai_1
X_17667_ _02317_ _03447_ VSS VSS VDD VDD _03580_ sky130_fd_sc_hd__nor2b_1
X_17668_ _03446_ _03580_ _02497_ VSS VSS VDD VDD _03581_ sky130_fd_sc_hd__o21ai_0
X_17669_ _02496_ _03581_ VSS VSS VDD VDD _03582_ sky130_fd_sc_hd__nand2b_1
X_17670_ _02492_ _03582_ _02491_ VSS VSS VDD VDD _03583_ sky130_fd_sc_hd__a21o_1
X_17671_ _02517_ _03583_ _02516_ VSS VSS VDD VDD _03584_ sky130_fd_sc_hd__a21o_1
X_17672_ _02949_ _03584_ _02948_ VSS VSS VDD VDD _03585_ sky130_fd_sc_hd__a21o_1
X_17673_ _02680_ _03585_ _02679_ VSS VSS VDD VDD _03586_ sky130_fd_sc_hd__a21oi_1
X_17674_ _03321_ _03586_ VSS VSS VDD VDD _03587_ sky130_fd_sc_hd__xnor2_1
X_17675_ u_core.u_top.u_core.acc_upd[208] _03587_ net637 VSS VSS VDD VDD _03588_ sky130_fd_sc_hd__mux2i_1
X_17676_ net852 _03578_ VSS VSS VDD VDD _03589_ sky130_fd_sc_hd__nand2_1
X_17678_ net783 _03588_ _03589_ net634 VSS VSS VDD VDD _1042_[208] sky130_fd_sc_hd__o211ai_1
X_17679_ _02680_ _03564_ VSS VSS VDD VDD _03591_ sky130_fd_sc_hd__xor2_1
X_17680_ u_core.u_top.u_core.acc_upd[207] _03591_ net637 VSS VSS VDD VDD _03592_ sky130_fd_sc_hd__mux2i_1
X_17681_ net783 _03592_ _03579_ net634 VSS VSS VDD VDD _1042_[207] sky130_fd_sc_hd__o211ai_1
X_17682_ _02949_ _03584_ VSS VSS VDD VDD _03593_ sky130_fd_sc_hd__xor2_1
X_17683_ u_core.u_top.u_core.acc_upd[206] _03593_ net637 VSS VSS VDD VDD _03594_ sky130_fd_sc_hd__mux2i_1
X_17684_ net783 _03594_ _03589_ _11237_ VSS VSS VDD VDD _1042_[206] sky130_fd_sc_hd__o211ai_1
X_17685_ _02517_ _03562_ VSS VSS VDD VDD _03595_ sky130_fd_sc_hd__xor2_1
X_17686_ u_core.u_top.u_core.acc_upd[205] _03595_ net637 VSS VSS VDD VDD _03596_ sky130_fd_sc_hd__mux2i_1
X_17687_ net783 _03596_ _03589_ _11240_ VSS VSS VDD VDD _1042_[205] sky130_fd_sc_hd__o211ai_1
X_17688_ _02492_ _03582_ VSS VSS VDD VDD _03597_ sky130_fd_sc_hd__xor2_1
X_17689_ u_core.u_top.u_core.acc_upd[204] _03597_ net637 VSS VSS VDD VDD _03598_ sky130_fd_sc_hd__mux2i_1
X_17690_ net783 _03598_ _03579_ _11243_ VSS VSS VDD VDD _1042_[204] sky130_fd_sc_hd__o211ai_1
X_17691_ _02497_ _03560_ VSS VSS VDD VDD _03599_ sky130_fd_sc_hd__xnor2_1
X_17692_ net637 _03599_ VSS VSS VDD VDD _03600_ sky130_fd_sc_hd__nand2_1
X_17693_ u_core.u_top.u_core.acc_upd[203] net637 _03600_ VSS VSS VDD VDD _03601_ sky130_fd_sc_hd__o21ai_0
X_17694_ net783 _03601_ _03589_ _11249_ VSS VSS VDD VDD _1042_[203] sky130_fd_sc_hd__o211ai_1
X_17695_ _03447_ _02317_ VSS VSS VDD VDD _03602_ sky130_fd_sc_hd__xnor2_1
X_17696_ u_core.u_top.u_core.acc_upd[202] _03602_ net637 VSS VSS VDD VDD _03603_ sky130_fd_sc_hd__mux2i_1
X_17697_ net783 _03603_ _11254_ VSS VSS VDD VDD _1042_[202] sky130_fd_sc_hd__o21ai_0
X_17700_ _02318_ net637 VSS VSS VDD VDD _03606_ sky130_fd_sc_hd__nand2_1
X_17701_ u_core.u_top.u_core.acc_upd[201] net637 _03606_ VSS VSS VDD VDD _03607_ sky130_fd_sc_hd__o21ai_0
X_17703_ net783 _03607_ _11256_ VSS VSS VDD VDD _1042_[201] sky130_fd_sc_hd__o21ai_0
X_17704_ _03124_ _03125_ net637 VSS VSS VDD VDD _03609_ sky130_fd_sc_hd__mux2_1
X_17705_ net783 _03609_ _11268_ VSS VSS VDD VDD _1042_[200] sky130_fd_sc_hd__o21ai_0
X_17706_ _02424_ _02662_ VSS VSS VDD VDD _03610_ sky130_fd_sc_hd__nor2b_1
X_17707_ _02661_ _03610_ _02489_ VSS VSS VDD VDD _03611_ sky130_fd_sc_hd__o21ai_0
X_17708_ _02488_ _03611_ VSS VSS VDD VDD _03612_ sky130_fd_sc_hd__nand2b_1
X_17709_ _02635_ _03612_ _02634_ VSS VSS VDD VDD _03613_ sky130_fd_sc_hd__a21o_1
X_17710_ _02910_ _03613_ _02909_ VSS VSS VDD VDD _03614_ sky130_fd_sc_hd__a21o_1
X_17711_ _02686_ _03614_ _02685_ VSS VSS VDD VDD _03615_ sky130_fd_sc_hd__a21o_1
X_17712_ _02871_ _03615_ _02870_ VSS VSS VDD VDD _03616_ sky130_fd_sc_hd__a21o_1
X_17713_ _02955_ _03616_ _02954_ VSS VSS VDD VDD _03617_ sky130_fd_sc_hd__a21o_1
X_17714_ _03246_ _03617_ _03245_ VSS VSS VDD VDD _03618_ sky130_fd_sc_hd__a21oi_1
X_17715_ net882 _03618_ VSS VSS VDD VDD _03619_ sky130_fd_sc_hd__xnor2_1
X_17716_ net636 _03619_ VSS VSS VDD VDD _03620_ sky130_fd_sc_hd__nand2_1
X_17717_ u_core.u_top.u_core.acc[198] u_core.u_top.u_core.acc[197] _08359_ VSS VSS VDD VDD _03621_ sky130_fd_sc_hd__nand3_1
X_17718_ u_core.u_top.u_core.acc[199] _03621_ VSS VSS VDD VDD _03622_ sky130_fd_sc_hd__xor2_1
X_17719_ u_core.u_top.u_core.acc[198] u_core.u_top.u_core.acc[197] _08354_ VSS VSS VDD VDD _03623_ sky130_fd_sc_hd__nor3b_1
X_17720_ u_core.u_top.u_core.acc[199] _03623_ VSS VSS VDD VDD _03624_ sky130_fd_sc_hd__xnor2_1
X_17721_ _08345_ _03622_ _03624_ _08346_ VSS VSS VDD VDD _03625_ sky130_fd_sc_hd__a22oi_1
X_17722_ u_core.u_top.u_core.acc[199] _08349_ _03625_ net672 VSS VSS VDD VDD _03626_ sky130_fd_sc_hd__o22ai_1
X_17723_ _03620_ _03626_ VSS VSS VDD VDD _03627_ sky130_fd_sc_hd__xnor2_1
X_17724_ _02566_ _08355_ u_core.u_top.u_core.acc[194] VSS VSS VDD VDD _03628_ sky130_fd_sc_hd__o21bai_1
X_17725_ u_core.u_top.u_core.acc[196] u_core.u_top.u_core.acc[195] _03628_ u_core.u_top.u_core.acc[197] VSS VSS VDD VDD _03629_ sky130_fd_sc_hd__a31oi_1
X_17726_ _08331_ u_core.u_top.u_core.acc[199] _03629_ VSS VSS VDD VDD _03630_ sky130_fd_sc_hd__nor3_1
X_17727_ _03630_ net853 VSS VSS VDD VDD _03631_ sky130_fd_sc_hd__nand2b_1
X_17728_ net785 _03627_ _03631_ net635 VSS VSS VDD VDD _1042_[199] sky130_fd_sc_hd__o211ai_1
X_17729_ _02425_ _02489_ VSS VSS VDD VDD _03632_ sky130_fd_sc_hd__nor2b_1
X_17730_ _02488_ _03632_ _02635_ VSS VSS VDD VDD _03633_ sky130_fd_sc_hd__o21ai_0
X_17731_ _02634_ _03633_ VSS VSS VDD VDD _03634_ sky130_fd_sc_hd__nand2b_1
X_17732_ _02910_ _03634_ _02909_ VSS VSS VDD VDD _03635_ sky130_fd_sc_hd__a21o_1
X_17733_ _02686_ _03635_ _02685_ VSS VSS VDD VDD _03636_ sky130_fd_sc_hd__a21o_1
X_17734_ _02871_ _03636_ _02870_ VSS VSS VDD VDD _03637_ sky130_fd_sc_hd__a21o_1
X_17735_ _02955_ _03637_ _02954_ VSS VSS VDD VDD _03638_ sky130_fd_sc_hd__a21oi_1
X_17736_ _03246_ _03638_ VSS VSS VDD VDD _03639_ sky130_fd_sc_hd__xnor2_1
X_17737_ u_core.u_top.u_core.acc_upd[198] _03639_ net636 VSS VSS VDD VDD _03640_ sky130_fd_sc_hd__mux2i_1
X_17738_ net853 _03630_ VSS VSS VDD VDD _03641_ sky130_fd_sc_hd__nand2_1
X_17739_ net785 _03640_ _03641_ net635 VSS VSS VDD VDD _1042_[198] sky130_fd_sc_hd__o211ai_1
X_17741_ _02955_ _03616_ VSS VSS VDD VDD _03643_ sky130_fd_sc_hd__xor2_1
X_17742_ u_core.u_top.u_core.acc_upd[197] _03643_ net636 VSS VSS VDD VDD _03644_ sky130_fd_sc_hd__mux2i_1
X_17743_ net785 _03644_ _03631_ net635 VSS VSS VDD VDD _1042_[197] sky130_fd_sc_hd__o211ai_1
X_17744_ _02871_ _03636_ VSS VSS VDD VDD _03645_ sky130_fd_sc_hd__xor2_1
X_17746_ u_core.u_top.u_core.acc_upd[196] _03645_ net636 VSS VSS VDD VDD _03647_ sky130_fd_sc_hd__mux2i_1
X_17747_ net785 _03647_ _03641_ net633 VSS VSS VDD VDD _1042_[196] sky130_fd_sc_hd__o211ai_1
X_17748_ _02686_ _03614_ VSS VSS VDD VDD _03648_ sky130_fd_sc_hd__xor2_1
X_17749_ u_core.u_top.u_core.acc_upd[195] _03648_ net636 VSS VSS VDD VDD _03649_ sky130_fd_sc_hd__mux2i_1
X_17750_ net785 _03649_ _03641_ net632 VSS VSS VDD VDD _1042_[195] sky130_fd_sc_hd__o211ai_1
X_17751_ _02910_ _03634_ VSS VSS VDD VDD _03650_ sky130_fd_sc_hd__xor2_1
X_17752_ u_core.u_top.u_core.acc_upd[194] _03650_ net636 VSS VSS VDD VDD _03651_ sky130_fd_sc_hd__mux2i_1
X_17753_ net785 _03651_ _03631_ net631 VSS VSS VDD VDD _1042_[194] sky130_fd_sc_hd__o211ai_1
X_17754_ _02635_ _03612_ VSS VSS VDD VDD _03652_ sky130_fd_sc_hd__xnor2_1
X_17755_ net636 _03652_ VSS VSS VDD VDD _03653_ sky130_fd_sc_hd__nand2_1
X_17756_ u_core.u_top.u_core.acc_upd[193] net636 _03653_ VSS VSS VDD VDD _03654_ sky130_fd_sc_hd__o21ai_0
X_17757_ net785 _03654_ _03641_ net630 VSS VSS VDD VDD _1042_[193] sky130_fd_sc_hd__o211ai_1
X_17758_ _02425_ _02489_ VSS VSS VDD VDD _03655_ sky130_fd_sc_hd__xnor2_1
X_17759_ u_core.u_top.u_core.acc_upd[192] _03655_ net636 VSS VSS VDD VDD _03656_ sky130_fd_sc_hd__mux2i_1
X_17760_ net785 _03656_ _11254_ VSS VSS VDD VDD _1042_[192] sky130_fd_sc_hd__o21ai_0
X_17761_ u_core.u_top.u_core.acc_upd[191] VSS VSS VDD VDD _02423_ sky130_fd_sc_hd__inv_1
X_17762_ _02423_ _02426_ net636 VSS VSS VDD VDD _03657_ sky130_fd_sc_hd__mux2i_1
X_17763_ net776 _03657_ VSS VSS VDD VDD _03658_ sky130_fd_sc_hd__nand2_1
X_17764_ _11256_ _03658_ VSS VSS VDD VDD _1042_[191] sky130_fd_sc_hd__nand2_1
X_17765_ _02493_ _02494_ net636 VSS VSS VDD VDD _03659_ sky130_fd_sc_hd__mux2_1
X_17766_ net785 _03659_ _11268_ VSS VSS VDD VDD _1042_[190] sky130_fd_sc_hd__o21ai_0
X_17767_ _02454_ _02682_ VSS VSS VDD VDD _03660_ sky130_fd_sc_hd__nor2b_1
X_17768_ _02681_ _03660_ _03288_ VSS VSS VDD VDD _03661_ sky130_fd_sc_hd__o21ai_0
X_17769_ _03287_ _03661_ VSS VSS VDD VDD _03662_ sky130_fd_sc_hd__nand2b_1
X_17770_ _02688_ _03662_ _02687_ VSS VSS VDD VDD _03663_ sky130_fd_sc_hd__a21o_1
X_17771_ _03302_ _03663_ _03301_ VSS VSS VDD VDD _03664_ sky130_fd_sc_hd__a21o_1
X_17772_ _02624_ _03664_ _02623_ VSS VSS VDD VDD _03665_ sky130_fd_sc_hd__a21o_1
X_17773_ _02627_ _03665_ _02626_ VSS VSS VDD VDD _03666_ sky130_fd_sc_hd__a21o_1
X_17774_ _02684_ _03666_ _02683_ VSS VSS VDD VDD _03667_ sky130_fd_sc_hd__a21o_1
X_17775_ _02678_ _03667_ _02677_ VSS VSS VDD VDD _03668_ sky130_fd_sc_hd__a21oi_1
X_17776_ net882 _03668_ VSS VSS VDD VDD _03669_ sky130_fd_sc_hd__xnor2_1
X_17777_ net643 _03669_ VSS VSS VDD VDD _03670_ sky130_fd_sc_hd__nand2_1
X_17778_ u_core.u_top.u_core.acc[188] u_core.u_top.u_core.acc[187] _08412_ VSS VSS VDD VDD _03671_ sky130_fd_sc_hd__nor3b_1
X_17779_ u_core.u_top.u_core.acc[189] _03671_ VSS VSS VDD VDD _03672_ sky130_fd_sc_hd__xnor2_1
X_17780_ u_core.u_top.u_core.acc[188] u_core.u_top.u_core.acc[187] _08409_ VSS VSS VDD VDD _03673_ sky130_fd_sc_hd__nand3_1
X_17781_ u_core.u_top.u_core.acc[189] _03673_ VSS VSS VDD VDD _03674_ sky130_fd_sc_hd__xor2_1
X_17782_ _08401_ _03672_ _03674_ _08400_ VSS VSS VDD VDD _03675_ sky130_fd_sc_hd__a22oi_1
X_17783_ u_core.u_top.u_core.acc[189] _08404_ _03675_ net672 VSS VSS VDD VDD _03676_ sky130_fd_sc_hd__o22ai_1
X_17784_ _03670_ _03676_ VSS VSS VDD VDD _03677_ sky130_fd_sc_hd__xnor2_1
X_17785_ _02538_ _08405_ u_core.u_top.u_core.acc[184] VSS VSS VDD VDD _03678_ sky130_fd_sc_hd__o21bai_1
X_17786_ u_core.u_top.u_core.acc[186] u_core.u_top.u_core.acc[185] _03678_ u_core.u_top.u_core.acc[187] VSS VSS VDD VDD _03679_ sky130_fd_sc_hd__a31oi_1
X_17787_ _08386_ u_core.u_top.u_core.acc[189] _03679_ VSS VSS VDD VDD _03680_ sky130_fd_sc_hd__nor3_1
X_17788_ _03680_ net853 VSS VSS VDD VDD _03681_ sky130_fd_sc_hd__nand2b_1
X_17789_ net785 _03677_ _03681_ net635 VSS VSS VDD VDD _1042_[189] sky130_fd_sc_hd__o211ai_1
X_17790_ _02455_ _03288_ VSS VSS VDD VDD _03682_ sky130_fd_sc_hd__nor2b_1
X_17791_ _03287_ _03682_ _02688_ VSS VSS VDD VDD _03683_ sky130_fd_sc_hd__o21ai_0
X_17792_ _02687_ _03683_ VSS VSS VDD VDD _03684_ sky130_fd_sc_hd__nand2b_1
X_17793_ _03302_ _03684_ _03301_ VSS VSS VDD VDD _03685_ sky130_fd_sc_hd__a21o_1
X_17794_ _02624_ _03685_ _02623_ VSS VSS VDD VDD _03686_ sky130_fd_sc_hd__a21o_1
X_17795_ _02627_ _03686_ _02626_ VSS VSS VDD VDD _03687_ sky130_fd_sc_hd__a21o_1
X_17796_ _02684_ _03687_ _02683_ VSS VSS VDD VDD _03688_ sky130_fd_sc_hd__a21oi_1
X_17797_ _02678_ _03688_ VSS VSS VDD VDD _03689_ sky130_fd_sc_hd__xnor2_1
X_17798_ u_core.u_top.u_core.acc_upd[188] _03689_ net643 VSS VSS VDD VDD _03690_ sky130_fd_sc_hd__mux2i_1
X_17799_ net853 _03680_ VSS VSS VDD VDD _03691_ sky130_fd_sc_hd__nand2_1
X_17800_ net785 _03690_ _03691_ net635 VSS VSS VDD VDD _1042_[188] sky130_fd_sc_hd__o211ai_1
X_17801_ _02684_ _03666_ VSS VSS VDD VDD _03692_ sky130_fd_sc_hd__xor2_1
X_17802_ u_core.u_top.u_core.acc_upd[187] _03692_ net643 VSS VSS VDD VDD _03693_ sky130_fd_sc_hd__mux2i_1
X_17803_ net785 _03693_ _03681_ net635 VSS VSS VDD VDD _1042_[187] sky130_fd_sc_hd__o211ai_1
X_17804_ _02627_ _03686_ VSS VSS VDD VDD _03694_ sky130_fd_sc_hd__xor2_1
X_17805_ u_core.u_top.u_core.acc_upd[186] _03694_ net643 VSS VSS VDD VDD _03695_ sky130_fd_sc_hd__mux2i_1
X_17806_ net785 _03695_ _03691_ net633 VSS VSS VDD VDD _1042_[186] sky130_fd_sc_hd__o211ai_1
X_17807_ _02624_ _03664_ VSS VSS VDD VDD _03696_ sky130_fd_sc_hd__xor2_1
X_17808_ u_core.u_top.u_core.acc_upd[185] _03696_ net643 VSS VSS VDD VDD _03697_ sky130_fd_sc_hd__mux2i_1
X_17809_ net785 _03697_ _03691_ net632 VSS VSS VDD VDD _1042_[185] sky130_fd_sc_hd__o211ai_1
X_17811_ _03302_ _03684_ VSS VSS VDD VDD _03699_ sky130_fd_sc_hd__xor2_1
X_17812_ u_core.u_top.u_core.acc_upd[184] _03699_ net643 VSS VSS VDD VDD _03700_ sky130_fd_sc_hd__mux2i_1
X_17813_ net785 _03700_ _03681_ net631 VSS VSS VDD VDD _1042_[184] sky130_fd_sc_hd__o211ai_1
X_17814_ _02688_ _03662_ VSS VSS VDD VDD _03701_ sky130_fd_sc_hd__xnor2_1
X_17815_ net643 _03701_ VSS VSS VDD VDD _03702_ sky130_fd_sc_hd__nand2_1
X_17816_ u_core.u_top.u_core.acc_upd[183] net643 _03702_ VSS VSS VDD VDD _03703_ sky130_fd_sc_hd__o21ai_0
X_17817_ net785 _03703_ _03691_ net630 VSS VSS VDD VDD _1042_[183] sky130_fd_sc_hd__o211ai_1
X_17818_ _03288_ _02455_ VSS VSS VDD VDD _03704_ sky130_fd_sc_hd__xnor2_1
X_17819_ u_core.u_top.u_core.acc_upd[182] _03704_ net643 VSS VSS VDD VDD _03705_ sky130_fd_sc_hd__mux2i_1
X_17820_ net785 _03705_ net629 VSS VSS VDD VDD _1042_[182] sky130_fd_sc_hd__o21ai_0
X_17821_ u_core.u_top.u_core.acc_upd[181] VSS VSS VDD VDD _02453_ sky130_fd_sc_hd__inv_1
X_17822_ _02453_ _02456_ net643 VSS VSS VDD VDD _03706_ sky130_fd_sc_hd__mux2i_1
X_17823_ net776 _03706_ VSS VSS VDD VDD _03707_ sky130_fd_sc_hd__nand2_1
X_17824_ _11256_ _03707_ VSS VSS VDD VDD _1042_[181] sky130_fd_sc_hd__nand2_1
X_17825_ u_core.u_top.u_core.acc[180] _08404_ VSS VSS VDD VDD _02546_ sky130_fd_sc_hd__xnor2_1
X_17826_ _02546_ _02547_ net643 VSS VSS VDD VDD _03708_ sky130_fd_sc_hd__mux2_1
X_17827_ net785 _03708_ _11268_ VSS VSS VDD VDD _1042_[180] sky130_fd_sc_hd__o21ai_0
X_17828_ _02447_ _02594_ VSS VSS VDD VDD _03709_ sky130_fd_sc_hd__nor2b_1
X_17829_ _02593_ _03709_ _03429_ VSS VSS VDD VDD _03710_ sky130_fd_sc_hd__o21ai_0
X_17830_ _03428_ _03710_ VSS VSS VDD VDD _03711_ sky130_fd_sc_hd__nand2b_1
X_17831_ _03370_ _03711_ _03369_ VSS VSS VDD VDD _03712_ sky130_fd_sc_hd__a21o_1
X_17832_ _02559_ _03712_ _02558_ VSS VSS VDD VDD _03713_ sky130_fd_sc_hd__a21o_1
X_17833_ _02965_ _03713_ _02964_ VSS VSS VDD VDD _03714_ sky130_fd_sc_hd__a21o_1
X_17834_ _02755_ _03714_ _02754_ VSS VSS VDD VDD _03715_ sky130_fd_sc_hd__a21o_1
X_17835_ _02979_ _03715_ _02978_ VSS VSS VDD VDD _03716_ sky130_fd_sc_hd__a21o_1
X_17836_ _03308_ _03716_ _03307_ VSS VSS VDD VDD _03717_ sky130_fd_sc_hd__a21oi_1
X_17837_ net882 _03717_ VSS VSS VDD VDD _03718_ sky130_fd_sc_hd__xnor2_1
X_17838_ net642 _03718_ VSS VSS VDD VDD _03719_ sky130_fd_sc_hd__nand2_1
X_17839_ u_core.u_top.u_core.acc[177] net962 _08470_ VSS VSS VDD VDD _03720_ sky130_fd_sc_hd__nand3_1
X_17840_ u_core.u_top.u_core.acc[177] net962 _08464_ VSS VSS VDD VDD _03721_ sky130_fd_sc_hd__or3_1
X_17841_ _03720_ _03721_ net706 VSS VSS VDD VDD _03722_ sky130_fd_sc_hd__mux2i_1
X_17842_ _03721_ _03720_ net706 VSS VSS VDD VDD _03723_ sky130_fd_sc_hd__mux2i_1
X_17843_ _0140_ _03722_ _03723_ _08460_ VSS VSS VDD VDD _03724_ sky130_fd_sc_hd__a22oi_1
X_17844_ net672 _03724_ VSS VSS VDD VDD _03725_ sky130_fd_sc_hd__nor2_1
X_17845_ u_core.u_top.u_core.acc[179] _03725_ VSS VSS VDD VDD _03726_ sky130_fd_sc_hd__xor2_1
X_17846_ _03719_ _03726_ VSS VSS VDD VDD _03727_ sky130_fd_sc_hd__xnor2_1
X_17847_ net898 net897 net883 VSS VSS VDD VDD _03728_ sky130_fd_sc_hd__nand3_2
X_17848_ _03007_ _08467_ u_core.u_top.u_core.acc[174] VSS VSS VDD VDD _03729_ sky130_fd_sc_hd__o21bai_1
X_17849_ net963 u_core.u_top.u_core.acc[176] _03729_ u_core.u_top.u_core.acc[177] VSS VSS VDD VDD _03730_ sky130_fd_sc_hd__a31oi_1
X_17850_ u_core.u_top.u_core.acc[179] _03730_ net962 VSS VSS VDD VDD _03731_ sky130_fd_sc_hd__nor3b_1
X_17851_ net851 net729 VSS VSS VDD VDD _03732_ sky130_fd_sc_hd__nor2_1
X_17852_ u_core.u_top.u_core.lfsr[15] VSS VSS VDD VDD _02391_ sky130_fd_sc_hd__inv_1
X_17853_ net988 _11218_ _11219_ VSS VSS VDD VDD _03733_ sky130_fd_sc_hd__nor3_1
X_17854_ net776 _03727_ _03732_ net647 VSS VSS VDD VDD _1042_[179] sky130_fd_sc_hd__a211o_1
X_17855_ _02448_ _03429_ VSS VSS VDD VDD _03734_ sky130_fd_sc_hd__nor2b_1
X_17856_ _03428_ _03734_ _03370_ VSS VSS VDD VDD _03735_ sky130_fd_sc_hd__o21ai_0
X_17857_ _03369_ _03735_ VSS VSS VDD VDD _03736_ sky130_fd_sc_hd__nand2b_1
X_17858_ _02559_ _03736_ _02558_ VSS VSS VDD VDD _03737_ sky130_fd_sc_hd__a21o_1
X_17859_ _02965_ _03737_ _02964_ VSS VSS VDD VDD _03738_ sky130_fd_sc_hd__a21o_1
X_17860_ _02755_ _03738_ _02754_ VSS VSS VDD VDD _03739_ sky130_fd_sc_hd__a21o_1
X_17861_ _02979_ _03739_ _02978_ VSS VSS VDD VDD _03740_ sky130_fd_sc_hd__a21oi_1
X_17862_ _03308_ _03740_ VSS VSS VDD VDD _03741_ sky130_fd_sc_hd__xor2_1
X_17863_ net642 _03741_ VSS VSS VDD VDD _03742_ sky130_fd_sc_hd__nand2_1
X_17864_ u_core.u_top.u_core.acc_upd[178] net642 _03742_ VSS VSS VDD VDD _03743_ sky130_fd_sc_hd__o21ai_0
X_17865_ net853 net729 VSS VSS VDD VDD _03744_ sky130_fd_sc_hd__nand2_1
X_17866_ net786 _03743_ _03744_ net635 VSS VSS VDD VDD _1042_[178] sky130_fd_sc_hd__o211ai_1
X_17868_ _02979_ _03715_ VSS VSS VDD VDD _03746_ sky130_fd_sc_hd__xor2_1
X_17870_ u_core.u_top.u_core.acc_upd[177] _03746_ net642 VSS VSS VDD VDD _03748_ sky130_fd_sc_hd__mux2i_1
X_17871_ net851 net729 _03748_ net786 net635 VSS VSS VDD VDD _1042_[177] sky130_fd_sc_hd__o221ai_1
X_17872_ _02755_ _03738_ VSS VSS VDD VDD _03749_ sky130_fd_sc_hd__xor2_1
X_17873_ u_core.u_top.u_core.acc_upd[176] _03749_ net642 VSS VSS VDD VDD _03750_ sky130_fd_sc_hd__mux2i_1
X_17874_ net785 _03750_ _03744_ net633 VSS VSS VDD VDD _1042_[176] sky130_fd_sc_hd__o211ai_1
X_17875_ _02965_ _03713_ VSS VSS VDD VDD _03751_ sky130_fd_sc_hd__xor2_1
X_17876_ u_core.u_top.u_core.acc_upd[175] _03751_ net642 VSS VSS VDD VDD _03752_ sky130_fd_sc_hd__mux2i_1
X_17877_ net785 _03752_ _03744_ net632 VSS VSS VDD VDD _1042_[175] sky130_fd_sc_hd__o211ai_1
X_17878_ _02559_ _03736_ VSS VSS VDD VDD _03753_ sky130_fd_sc_hd__xor2_1
X_17879_ u_core.u_top.u_core.acc_upd[174] _03753_ net643 VSS VSS VDD VDD _03754_ sky130_fd_sc_hd__mux2i_1
X_17881_ net851 net729 _03754_ net785 net631 VSS VSS VDD VDD _1042_[174] sky130_fd_sc_hd__o221ai_1
X_17882_ _03370_ _03711_ VSS VSS VDD VDD _03756_ sky130_fd_sc_hd__xnor2_1
X_17883_ net643 _03756_ VSS VSS VDD VDD _03757_ sky130_fd_sc_hd__nand2_1
X_17884_ u_core.u_top.u_core.acc_upd[173] net643 _03757_ VSS VSS VDD VDD _03758_ sky130_fd_sc_hd__o21ai_0
X_17885_ net785 _03758_ _03744_ net630 VSS VSS VDD VDD _1042_[173] sky130_fd_sc_hd__o211ai_1
X_17887_ _03429_ _02448_ VSS VSS VDD VDD _03760_ sky130_fd_sc_hd__xnor2_1
X_17888_ u_core.u_top.u_core.acc_upd[172] _03760_ net643 VSS VSS VDD VDD _03761_ sky130_fd_sc_hd__mux2i_1
X_17889_ net785 _03761_ net629 VSS VSS VDD VDD _1042_[172] sky130_fd_sc_hd__o21ai_0
X_17891_ _02446_ _02449_ net643 VSS VSS VDD VDD _03763_ sky130_fd_sc_hd__mux2_1
X_17892_ net785 _03763_ _11256_ VSS VSS VDD VDD _1042_[171] sky130_fd_sc_hd__o21ai_0
X_17893_ u_core.u_top.u_core.acc[170] _08478_ VSS VSS VDD VDD _03206_ sky130_fd_sc_hd__xnor2_1
X_17894_ _03206_ _03207_ net643 VSS VSS VDD VDD _03764_ sky130_fd_sc_hd__mux2_1
X_17895_ net785 _03764_ _11268_ VSS VSS VDD VDD _1042_[170] sky130_fd_sc_hd__o21ai_0
X_17896_ _02331_ _02643_ VSS VSS VDD VDD _03765_ sky130_fd_sc_hd__nor2b_1
X_17897_ _03452_ _03765_ _02555_ VSS VSS VDD VDD _03766_ sky130_fd_sc_hd__o21ai_0
X_17898_ _02554_ _03766_ VSS VSS VDD VDD _03767_ sky130_fd_sc_hd__nand2b_1
X_17899_ _03214_ _03767_ _03213_ VSS VSS VDD VDD _03768_ sky130_fd_sc_hd__a21o_1
X_17900_ _02947_ _03768_ _02946_ VSS VSS VDD VDD _03769_ sky130_fd_sc_hd__a21o_1
X_17901_ _02696_ _03769_ _02695_ VSS VSS VDD VDD _03770_ sky130_fd_sc_hd__a21o_1
X_17902_ _03252_ _03770_ _03251_ VSS VSS VDD VDD _03771_ sky130_fd_sc_hd__a21o_1
X_17903_ _03248_ _03771_ _03247_ VSS VSS VDD VDD _03772_ sky130_fd_sc_hd__a21o_1
X_17904_ _02963_ _03772_ _02962_ VSS VSS VDD VDD _03773_ sky130_fd_sc_hd__a21oi_1
X_17905_ net882 _03773_ VSS VSS VDD VDD _03774_ sky130_fd_sc_hd__xnor2_1
X_17906_ net638 _03774_ VSS VSS VDD VDD _03775_ sky130_fd_sc_hd__nand2_1
X_17907_ u_core.u_top.u_core.acc[168] u_core.u_top.u_core.acc[167] VSS VSS VDD VDD _03776_ sky130_fd_sc_hd__nand2_1
X_17908_ _08527_ _03776_ VSS VSS VDD VDD _03777_ sky130_fd_sc_hd__or2_2
X_17909_ u_core.u_top.u_core.acc[168] u_core.u_top.u_core.acc[167] _08524_ VSS VSS VDD VDD _03778_ sky130_fd_sc_hd__or3_1
X_17910_ _03777_ _03778_ net706 VSS VSS VDD VDD _03779_ sky130_fd_sc_hd__mux2i_1
X_17911_ _03778_ _03777_ net706 VSS VSS VDD VDD _03780_ sky130_fd_sc_hd__mux2i_1
X_17912_ _0129_ _03779_ _03780_ _08503_ VSS VSS VDD VDD _03781_ sky130_fd_sc_hd__a22oi_1
X_17913_ net672 _03781_ VSS VSS VDD VDD _03782_ sky130_fd_sc_hd__nor2_1
X_17914_ u_core.u_top.u_core.acc[169] _03782_ VSS VSS VDD VDD _03783_ sky130_fd_sc_hd__xnor2_1
X_17915_ _03775_ _03783_ VSS VSS VDD VDD _03784_ sky130_fd_sc_hd__xnor2_1
X_17916_ u_core.u_top.u_core.acc[167] u_core.u_top.u_core.acc[169] VSS VSS VDD VDD _03785_ sky130_fd_sc_hd__nor2_1
X_17917_ u_core.u_top.u_core.acc[168] u_core.u_top.u_core.acc[166] u_core.u_top.u_core.acc[165] _03785_ VSS VSS VDD VDD _03786_ sky130_fd_sc_hd__nand4_1
X_17918_ u_core.u_top.u_core.acc[163] u_core.u_top.u_core.acc[162] _02891_ VSS VSS VDD VDD _03787_ sky130_fd_sc_hd__nand3_1
X_17919_ _08525_ _03776_ VSS VSS VDD VDD _03788_ sky130_fd_sc_hd__nand2_1
X_17920_ _03786_ _03787_ _03788_ VSS VSS VDD VDD _03789_ sky130_fd_sc_hd__o21ai_0
X_17921_ _03776_ _03786_ _03789_ _08521_ u_core.u_top.u_core.acc[169] VSS VSS VDD VDD _03790_ sky130_fd_sc_hd__a221oi_1
X_17922_ net728 net853 VSS VSS VDD VDD _03791_ sky130_fd_sc_hd__nand2b_1
X_17923_ net785 _03784_ _03791_ net635 VSS VSS VDD VDD _1042_[169] sky130_fd_sc_hd__o211ai_1
X_17924_ _02332_ _02555_ VSS VSS VDD VDD _03792_ sky130_fd_sc_hd__nor2b_1
X_17925_ _02554_ _03792_ _03214_ VSS VSS VDD VDD _03793_ sky130_fd_sc_hd__o21ai_0
X_17926_ _03213_ _03793_ VSS VSS VDD VDD _03794_ sky130_fd_sc_hd__nand2b_1
X_17927_ _02947_ _03794_ _02946_ VSS VSS VDD VDD _03795_ sky130_fd_sc_hd__a21o_1
X_17928_ _02696_ _03795_ _02695_ VSS VSS VDD VDD _03796_ sky130_fd_sc_hd__a21o_1
X_17929_ _03252_ _03796_ _03251_ VSS VSS VDD VDD _03797_ sky130_fd_sc_hd__a21o_1
X_17930_ _03248_ _03797_ _03247_ VSS VSS VDD VDD _03798_ sky130_fd_sc_hd__a21oi_1
X_17931_ _02963_ _03798_ VSS VSS VDD VDD _03799_ sky130_fd_sc_hd__xnor2_1
X_17933_ u_core.u_top.u_core.acc_upd[168] _03799_ net638 VSS VSS VDD VDD _03801_ sky130_fd_sc_hd__mux2i_1
X_17934_ net853 net728 VSS VSS VDD VDD _03802_ sky130_fd_sc_hd__nand2_1
X_17936_ net785 _03801_ _03802_ net635 VSS VSS VDD VDD _1042_[168] sky130_fd_sc_hd__o211ai_1
X_17938_ _03248_ _03771_ VSS VSS VDD VDD _03805_ sky130_fd_sc_hd__xnor2_1
X_17939_ net638 _03805_ VSS VSS VDD VDD _03806_ sky130_fd_sc_hd__nand2_1
X_17940_ u_core.u_top.u_core.acc_upd[167] net638 _03806_ VSS VSS VDD VDD _03807_ sky130_fd_sc_hd__o21ai_0
X_17941_ net785 _03807_ _03791_ net635 VSS VSS VDD VDD _1042_[167] sky130_fd_sc_hd__o211ai_1
X_17943_ _03252_ _03796_ VSS VSS VDD VDD _03809_ sky130_fd_sc_hd__xnor2_1
X_17944_ net638 _03809_ VSS VSS VDD VDD _03810_ sky130_fd_sc_hd__nand2_1
X_17945_ u_core.u_top.u_core.acc_upd[166] net638 _03810_ VSS VSS VDD VDD _03811_ sky130_fd_sc_hd__o21ai_0
X_17946_ net785 _03811_ _03802_ net633 VSS VSS VDD VDD _1042_[166] sky130_fd_sc_hd__o211ai_1
X_17948_ _02696_ _03769_ VSS VSS VDD VDD _03813_ sky130_fd_sc_hd__xnor2_1
X_17949_ net638 _03813_ VSS VSS VDD VDD _03814_ sky130_fd_sc_hd__nand2_1
X_17950_ u_core.u_top.u_core.acc_upd[165] net638 _03814_ VSS VSS VDD VDD _03815_ sky130_fd_sc_hd__o21ai_0
X_17951_ net785 _03815_ _03802_ net632 VSS VSS VDD VDD _1042_[165] sky130_fd_sc_hd__o211ai_1
X_17952_ _02947_ _03794_ VSS VSS VDD VDD _03816_ sky130_fd_sc_hd__xor2_1
X_17953_ u_core.u_top.u_core.acc_upd[164] _03816_ net636 VSS VSS VDD VDD _03817_ sky130_fd_sc_hd__mux2i_1
X_17954_ net785 _03817_ _03791_ net631 VSS VSS VDD VDD _1042_[164] sky130_fd_sc_hd__o211ai_1
X_17955_ _03214_ _03767_ VSS VSS VDD VDD _03818_ sky130_fd_sc_hd__xnor2_1
X_17956_ net636 _03818_ VSS VSS VDD VDD _03819_ sky130_fd_sc_hd__nand2_1
X_17957_ u_core.u_top.u_core.acc_upd[163] net636 _03819_ VSS VSS VDD VDD _03820_ sky130_fd_sc_hd__o21ai_0
X_17958_ net785 _03820_ _03802_ net630 VSS VSS VDD VDD _1042_[163] sky130_fd_sc_hd__o211ai_1
X_17959_ _02555_ _02332_ VSS VSS VDD VDD _03821_ sky130_fd_sc_hd__xnor2_1
X_17961_ u_core.u_top.u_core.acc_upd[162] _03821_ net643 VSS VSS VDD VDD _03823_ sky130_fd_sc_hd__mux2i_1
X_17962_ net785 _03823_ net629 VSS VSS VDD VDD _1042_[162] sky130_fd_sc_hd__o21ai_0
X_17963_ u_core.u_top.u_core.acc_upd[161] VSS VSS VDD VDD _02330_ sky130_fd_sc_hd__inv_1
X_17964_ _02330_ _02333_ net643 VSS VSS VDD VDD _03824_ sky130_fd_sc_hd__mux2i_1
X_17965_ net776 _03824_ VSS VSS VDD VDD _03825_ sky130_fd_sc_hd__nand2_1
X_17966_ _11256_ _03825_ VSS VSS VDD VDD _1042_[161] sky130_fd_sc_hd__nand2_1
X_17967_ u_core.u_top.u_core.acc[160] _08520_ VSS VSS VDD VDD _03249_ sky130_fd_sc_hd__xnor2_1
X_17968_ _03249_ _03250_ net643 VSS VSS VDD VDD _03826_ sky130_fd_sc_hd__mux2_1
X_17969_ net785 _03826_ _11268_ VSS VSS VDD VDD _1042_[160] sky130_fd_sc_hd__o21ai_0
X_17970_ _02377_ _02669_ VSS VSS VDD VDD _03827_ sky130_fd_sc_hd__nor2b_1
X_17971_ _02668_ _03827_ _03433_ VSS VSS VDD VDD _03828_ sky130_fd_sc_hd__o21ai_0
X_17972_ _03432_ _03828_ VSS VSS VDD VDD _03829_ sky130_fd_sc_hd__nand2b_1
X_17973_ _02575_ _03829_ _02574_ VSS VSS VDD VDD _03830_ sky130_fd_sc_hd__a21o_1
X_17974_ _03028_ _03830_ _03027_ VSS VSS VDD VDD _03831_ sky130_fd_sc_hd__a21o_1
X_17975_ _03053_ _03831_ _03052_ VSS VSS VDD VDD _03832_ sky130_fd_sc_hd__a21o_1
X_17976_ _02930_ _03832_ _02929_ VSS VSS VDD VDD _03833_ sky130_fd_sc_hd__a21o_1
X_17977_ _02935_ _03833_ _02934_ VSS VSS VDD VDD _03834_ sky130_fd_sc_hd__a21o_1
X_17978_ _02731_ _03834_ _02730_ VSS VSS VDD VDD _03835_ sky130_fd_sc_hd__a21oi_1
X_17979_ net881 _03835_ VSS VSS VDD VDD _03836_ sky130_fd_sc_hd__xnor2_1
X_17980_ net640 _03836_ VSS VSS VDD VDD _03837_ sky130_fd_sc_hd__nand2_1
X_17981_ u_core.u_top.u_core.acc[158] u_core.u_top.u_core.acc[157] _08580_ VSS VSS VDD VDD _03838_ sky130_fd_sc_hd__nand3_1
X_17982_ u_core.u_top.u_core.acc[158] _08568_ _08583_ VSS VSS VDD VDD _03839_ sky130_fd_sc_hd__nor3_1
X_17983_ net709 _03839_ VSS VSS VDD VDD _03840_ sky130_fd_sc_hd__nand2_1
X_17984_ net709 _03838_ _03840_ VSS VSS VDD VDD _03841_ sky130_fd_sc_hd__o21ai_0
X_17985_ _03839_ VSS VSS VDD VDD _03842_ sky130_fd_sc_hd__inv_1
X_17986_ _03842_ _03838_ net709 VSS VSS VDD VDD _03843_ sky130_fd_sc_hd__mux2i_1
X_17987_ net828 _03843_ VSS VSS VDD VDD _03844_ sky130_fd_sc_hd__nand2_1
X_17988_ _0118_ _03844_ VSS VSS VDD VDD _03845_ sky130_fd_sc_hd__nor2_1
X_17989_ _0118_ _03841_ _03845_ VSS VSS VDD VDD _03846_ sky130_fd_sc_hd__a21oi_1
X_17990_ net670 _03846_ VSS VSS VDD VDD _03847_ sky130_fd_sc_hd__nor2_1
X_17991_ u_core.u_top.u_core.acc[159] _03847_ VSS VSS VDD VDD _03848_ sky130_fd_sc_hd__xnor2_1
X_17992_ _03837_ _03848_ VSS VSS VDD VDD _03849_ sky130_fd_sc_hd__xnor2_1
X_17993_ _02850_ VSS VSS VDD VDD _03850_ sky130_fd_sc_hd__inv_1
X_17994_ u_core.u_top.u_core.acc[153] u_core.u_top.u_core.acc[152] _03850_ u_core.u_top.u_core.acc[154] VSS VSS VDD VDD _03851_ sky130_fd_sc_hd__a31oi_1
X_17995_ _08576_ _03851_ VSS VSS VDD VDD _03852_ sky130_fd_sc_hd__nor2_1
X_17996_ u_core.u_top.u_core.acc[157] _03852_ VSS VSS VDD VDD _03853_ sky130_fd_sc_hd__nor2_1
X_17997_ u_core.u_top.u_core.acc[159] _03853_ u_core.u_top.u_core.acc[158] VSS VSS VDD VDD _03854_ sky130_fd_sc_hd__nor3b_2
X_17998_ _03854_ net852 VSS VSS VDD VDD _03855_ sky130_fd_sc_hd__nand2b_1
X_17999_ net782 _03849_ _03855_ net634 VSS VSS VDD VDD _1042_[159] sky130_fd_sc_hd__o211ai_1
X_18000_ _02378_ _03433_ VSS VSS VDD VDD _03856_ sky130_fd_sc_hd__nor2b_1
X_18001_ _03432_ _03856_ _02575_ VSS VSS VDD VDD _03857_ sky130_fd_sc_hd__o21ai_0
X_18002_ _02574_ _03857_ VSS VSS VDD VDD _03858_ sky130_fd_sc_hd__nand2b_1
X_18003_ _03028_ _03858_ _03027_ VSS VSS VDD VDD _03859_ sky130_fd_sc_hd__a21o_1
X_18004_ _03053_ _03859_ _03052_ VSS VSS VDD VDD _03860_ sky130_fd_sc_hd__a21o_1
X_18005_ _02930_ _03860_ _02929_ VSS VSS VDD VDD _03861_ sky130_fd_sc_hd__a21o_1
X_18006_ _02935_ _03861_ _02934_ VSS VSS VDD VDD _03862_ sky130_fd_sc_hd__a21oi_1
X_18007_ _02731_ _03862_ VSS VSS VDD VDD _03863_ sky130_fd_sc_hd__xnor2_1
X_18008_ u_core.u_top.u_core.acc_upd[158] _03863_ net640 VSS VSS VDD VDD _03864_ sky130_fd_sc_hd__mux2i_1
X_18010_ net852 _03854_ VSS VSS VDD VDD _03866_ sky130_fd_sc_hd__nand2_1
X_18011_ net782 _03864_ _03866_ net634 VSS VSS VDD VDD _1042_[158] sky130_fd_sc_hd__o211ai_1
X_18012_ _02935_ _03833_ VSS VSS VDD VDD _03867_ sky130_fd_sc_hd__xor2_1
X_18013_ u_core.u_top.u_core.acc_upd[157] _03867_ net640 VSS VSS VDD VDD _03868_ sky130_fd_sc_hd__mux2i_1
X_18014_ net782 _03868_ _03855_ net634 VSS VSS VDD VDD _1042_[157] sky130_fd_sc_hd__o211ai_1
X_18015_ _02930_ _03860_ VSS VSS VDD VDD _03869_ sky130_fd_sc_hd__xnor2_1
X_18016_ net640 _03869_ VSS VSS VDD VDD _03870_ sky130_fd_sc_hd__nand2_1
X_18017_ u_core.u_top.u_core.acc_upd[156] net640 _03870_ VSS VSS VDD VDD _03871_ sky130_fd_sc_hd__o21ai_0
X_18018_ net782 _03871_ _03866_ _11237_ VSS VSS VDD VDD _1042_[156] sky130_fd_sc_hd__o211ai_1
X_18019_ _03053_ _03831_ VSS VSS VDD VDD _03872_ sky130_fd_sc_hd__xor2_1
X_18020_ u_core.u_top.u_core.acc_upd[155] _03872_ net640 VSS VSS VDD VDD _03873_ sky130_fd_sc_hd__mux2i_1
X_18021_ net782 _03873_ _03866_ _11240_ VSS VSS VDD VDD _1042_[155] sky130_fd_sc_hd__o211ai_1
X_18022_ _03028_ _03858_ VSS VSS VDD VDD _03874_ sky130_fd_sc_hd__xor2_1
X_18023_ u_core.u_top.u_core.acc_upd[154] _03874_ net640 VSS VSS VDD VDD _03875_ sky130_fd_sc_hd__mux2i_1
X_18024_ net782 _03875_ _03855_ _11243_ VSS VSS VDD VDD _1042_[154] sky130_fd_sc_hd__o211ai_1
X_18025_ _02575_ _03829_ VSS VSS VDD VDD _03876_ sky130_fd_sc_hd__xnor2_1
X_18026_ net640 _03876_ VSS VSS VDD VDD _03877_ sky130_fd_sc_hd__nand2_1
X_18027_ u_core.u_top.u_core.acc_upd[153] net640 _03877_ VSS VSS VDD VDD _03878_ sky130_fd_sc_hd__o21ai_0
X_18028_ net782 _03878_ _03866_ _11249_ VSS VSS VDD VDD _1042_[153] sky130_fd_sc_hd__o211ai_1
X_18029_ _03433_ _02378_ VSS VSS VDD VDD _03879_ sky130_fd_sc_hd__xnor2_1
X_18030_ u_core.u_top.u_core.acc_upd[152] _03879_ net640 VSS VSS VDD VDD _03880_ sky130_fd_sc_hd__mux2i_1
X_18031_ net782 _03880_ _11254_ VSS VSS VDD VDD _1042_[152] sky130_fd_sc_hd__o21ai_0
X_18033_ _02379_ net640 VSS VSS VDD VDD _03882_ sky130_fd_sc_hd__nand2_1
X_18034_ u_core.u_top.u_core.acc_upd[151] net640 _03882_ VSS VSS VDD VDD _03883_ sky130_fd_sc_hd__o21ai_0
X_18035_ net782 _03883_ _11256_ VSS VSS VDD VDD _1042_[151] sky130_fd_sc_hd__o21ai_0
X_18036_ u_core.u_top.u_core.acc[150] _08574_ VSS VSS VDD VDD _02728_ sky130_fd_sc_hd__xnor2_1
X_18037_ _02728_ _02729_ net640 VSS VSS VDD VDD _03884_ sky130_fd_sc_hd__mux2_1
X_18038_ net782 _03884_ _11268_ VSS VSS VDD VDD _1042_[150] sky130_fd_sc_hd__o21ai_0
X_18041_ _02339_ _02665_ VSS VSS VDD VDD _03887_ sky130_fd_sc_hd__nor2b_1
X_18042_ _02734_ _03887_ _03076_ VSS VSS VDD VDD _03888_ sky130_fd_sc_hd__o21ai_0
X_18043_ _03075_ _03888_ VSS VSS VDD VDD _03889_ sky130_fd_sc_hd__nand2b_1
X_18044_ _02719_ _03889_ _02718_ VSS VSS VDD VDD _03890_ sky130_fd_sc_hd__a21o_1
X_18045_ _03422_ _03890_ _03421_ VSS VSS VDD VDD _03891_ sky130_fd_sc_hd__a21o_1
X_18046_ _02527_ _03891_ _02526_ VSS VSS VDD VDD _03892_ sky130_fd_sc_hd__a21o_1
X_18047_ _02961_ _03892_ _02960_ VSS VSS VDD VDD _03893_ sky130_fd_sc_hd__a21o_1
X_18048_ _02727_ _03893_ _02726_ VSS VSS VDD VDD _03894_ sky130_fd_sc_hd__a21o_1
X_18049_ _02857_ _03894_ _02856_ VSS VSS VDD VDD _03895_ sky130_fd_sc_hd__a21oi_1
X_18050_ net881 _03895_ VSS VSS VDD VDD _03896_ sky130_fd_sc_hd__xnor2_1
X_18051_ net639 _03896_ VSS VSS VDD VDD _03897_ sky130_fd_sc_hd__nand2_1
X_18052_ u_core.u_top.u_core.acc[148] u_core.u_top.u_core.acc[147] VSS VSS VDD VDD _03898_ sky130_fd_sc_hd__nor2_1
X_18053_ _08640_ _03898_ VSS VSS VDD VDD _03899_ sky130_fd_sc_hd__nand2_1
X_18054_ u_core.u_top.u_core.acc[149] _03899_ VSS VSS VDD VDD _03900_ sky130_fd_sc_hd__xor2_1
X_18055_ u_core.u_top.u_core.acc[141] u_core.u_top.u_core.acc[148] u_core.u_top.u_core.acc[140] _08629_ VSS VSS VDD VDD _03901_ sky130_fd_sc_hd__nand4_1
X_18056_ u_core.u_top.u_core.acc[149] _03901_ VSS VSS VDD VDD _03902_ sky130_fd_sc_hd__xor2_1
X_18057_ _03900_ _03902_ net709 VSS VSS VDD VDD _03903_ sky130_fd_sc_hd__mux2_1
X_18058_ net829 u_core.u_top.u_core.acc[149] VSS VSS VDD VDD _03904_ sky130_fd_sc_hd__nor2_1
X_18059_ net829 net678 _03903_ _03904_ VSS VSS VDD VDD _03905_ sky130_fd_sc_hd__a31oi_1
X_18060_ _03902_ _03900_ net709 VSS VSS VDD VDD _03906_ sky130_fd_sc_hd__mux2i_1
X_18061_ u_core.u_top.u_core.acc[149] net678 _08618_ _03906_ VSS VSS VDD VDD _03907_ sky130_fd_sc_hd__o22a_1
X_18062_ net830 _03905_ _03907_ VSS VSS VDD VDD _03908_ sky130_fd_sc_hd__o21ai_0
X_18063_ _03897_ _03908_ VSS VSS VDD VDD _03909_ sky130_fd_sc_hd__xnor2_1
X_18064_ u_core.u_top.u_core.acc[143] u_core.u_top.u_core.acc[142] VSS VSS VDD VDD _03910_ sky130_fd_sc_hd__nand2_1
X_18065_ _02915_ _03910_ u_core.u_top.u_core.acc[144] VSS VSS VDD VDD _03911_ sky130_fd_sc_hd__o21bai_1
X_18066_ u_core.u_top.u_core.acc[146] u_core.u_top.u_core.acc[145] _03911_ u_core.u_top.u_core.acc[147] VSS VSS VDD VDD _03912_ sky130_fd_sc_hd__a31oi_1
X_18067_ _08626_ u_core.u_top.u_core.acc[149] _03912_ VSS VSS VDD VDD _03913_ sky130_fd_sc_hd__nor3_1
X_18068_ _03913_ net852 VSS VSS VDD VDD _03914_ sky130_fd_sc_hd__nand2b_1
X_18069_ net782 _03909_ _03914_ net634 VSS VSS VDD VDD _1042_[149] sky130_fd_sc_hd__o211ai_1
X_18070_ _02340_ _03076_ VSS VSS VDD VDD _03915_ sky130_fd_sc_hd__nor2b_1
X_18071_ _03075_ _03915_ _02719_ VSS VSS VDD VDD _03916_ sky130_fd_sc_hd__o21ai_0
X_18072_ _02718_ _03916_ VSS VSS VDD VDD _03917_ sky130_fd_sc_hd__nand2b_1
X_18073_ _03422_ _03917_ _03421_ VSS VSS VDD VDD _03918_ sky130_fd_sc_hd__a21o_1
X_18074_ _02527_ _03918_ _02526_ VSS VSS VDD VDD _03919_ sky130_fd_sc_hd__a21o_1
X_18075_ _02961_ _03919_ _02960_ VSS VSS VDD VDD _03920_ sky130_fd_sc_hd__a21o_1
X_18076_ _02727_ _03920_ _02726_ VSS VSS VDD VDD _03921_ sky130_fd_sc_hd__a21oi_1
X_18077_ _02857_ _03921_ VSS VSS VDD VDD _03922_ sky130_fd_sc_hd__xor2_1
X_18078_ net639 _03922_ VSS VSS VDD VDD _03923_ sky130_fd_sc_hd__nand2_1
X_18079_ u_core.u_top.u_core.acc_upd[148] net639 _03923_ VSS VSS VDD VDD _03924_ sky130_fd_sc_hd__o21ai_0
X_18080_ net852 _03913_ VSS VSS VDD VDD _03925_ sky130_fd_sc_hd__nand2_1
X_18081_ net782 _03924_ _03925_ net634 VSS VSS VDD VDD _1042_[148] sky130_fd_sc_hd__o211ai_1
X_18082_ _02727_ _03893_ VSS VSS VDD VDD _03926_ sky130_fd_sc_hd__xnor2_1
X_18083_ net639 _03926_ VSS VSS VDD VDD _03927_ sky130_fd_sc_hd__nand2_1
X_18084_ u_core.u_top.u_core.acc_upd[147] net639 _03927_ VSS VSS VDD VDD _03928_ sky130_fd_sc_hd__o21ai_0
X_18085_ net782 _03928_ _03914_ net634 VSS VSS VDD VDD _1042_[147] sky130_fd_sc_hd__o211ai_1
X_18086_ _02961_ _03919_ VSS VSS VDD VDD _03929_ sky130_fd_sc_hd__xnor2_1
X_18087_ net639 _03929_ VSS VSS VDD VDD _03930_ sky130_fd_sc_hd__nand2_1
X_18088_ u_core.u_top.u_core.acc_upd[146] net639 _03930_ VSS VSS VDD VDD _03931_ sky130_fd_sc_hd__o21ai_0
X_18089_ net782 _03931_ _03925_ _11237_ VSS VSS VDD VDD _1042_[146] sky130_fd_sc_hd__o211ai_1
X_18090_ _02527_ _03891_ VSS VSS VDD VDD _03932_ sky130_fd_sc_hd__xnor2_1
X_18091_ net639 _03932_ VSS VSS VDD VDD _03933_ sky130_fd_sc_hd__nand2_1
X_18092_ u_core.u_top.u_core.acc_upd[145] net639 _03933_ VSS VSS VDD VDD _03934_ sky130_fd_sc_hd__o21ai_0
X_18093_ net782 _03934_ _03925_ _11240_ VSS VSS VDD VDD _1042_[145] sky130_fd_sc_hd__o211ai_1
X_18095_ _03422_ _03917_ VSS VSS VDD VDD _03936_ sky130_fd_sc_hd__xnor2_1
X_18096_ net639 _03936_ VSS VSS VDD VDD _03937_ sky130_fd_sc_hd__nand2_1
X_18097_ u_core.u_top.u_core.acc_upd[144] net639 _03937_ VSS VSS VDD VDD _03938_ sky130_fd_sc_hd__o21ai_0
X_18098_ net782 _03938_ _03914_ _11243_ VSS VSS VDD VDD _1042_[144] sky130_fd_sc_hd__o211ai_1
X_18100_ _02719_ _03889_ VSS VSS VDD VDD _03940_ sky130_fd_sc_hd__xnor2_1
X_18101_ net639 _03940_ VSS VSS VDD VDD _03941_ sky130_fd_sc_hd__nand2_1
X_18102_ u_core.u_top.u_core.acc_upd[143] net639 _03941_ VSS VSS VDD VDD _03942_ sky130_fd_sc_hd__o21ai_0
X_18103_ net782 _03942_ _03925_ _11249_ VSS VSS VDD VDD _1042_[143] sky130_fd_sc_hd__o211ai_1
X_18104_ _03076_ _02340_ VSS VSS VDD VDD _03943_ sky130_fd_sc_hd__xnor2_1
X_18105_ u_core.u_top.u_core.acc_upd[142] _03943_ net639 VSS VSS VDD VDD _03944_ sky130_fd_sc_hd__mux2i_1
X_18106_ net782 _03944_ _11254_ VSS VSS VDD VDD _1042_[142] sky130_fd_sc_hd__o21ai_0
X_18107_ _02341_ net639 VSS VSS VDD VDD _03945_ sky130_fd_sc_hd__nand2_1
X_18108_ u_core.u_top.u_core.acc_upd[141] net639 _03945_ VSS VSS VDD VDD _03946_ sky130_fd_sc_hd__o21ai_0
X_18109_ net782 _03946_ _11256_ VSS VSS VDD VDD _1042_[141] sky130_fd_sc_hd__o21ai_0
X_18111_ u_core.u_top.u_core.acc[140] _08673_ VSS VSS VDD VDD _02641_ sky130_fd_sc_hd__xnor2_1
X_18112_ _02641_ _02642_ net639 VSS VSS VDD VDD _03948_ sky130_fd_sc_hd__mux2_1
X_18113_ net782 _03948_ _11268_ VSS VSS VDD VDD _1042_[140] sky130_fd_sc_hd__o21ai_0
X_18115_ _02324_ _02604_ VSS VSS VDD VDD _03950_ sky130_fd_sc_hd__nor2b_1
X_18116_ _03255_ _03950_ _02717_ VSS VSS VDD VDD _03951_ sky130_fd_sc_hd__o21ai_0
X_18117_ _02716_ _03951_ VSS VSS VDD VDD _03952_ sky130_fd_sc_hd__nand2b_1
X_18118_ _03458_ _03952_ _03457_ VSS VSS VDD VDD _03953_ sky130_fd_sc_hd__a21o_1
X_18119_ _03349_ _03953_ _03348_ VSS VSS VDD VDD _03954_ sky130_fd_sc_hd__a21o_1
X_18120_ _03201_ _03954_ _03200_ VSS VSS VDD VDD _03955_ sky130_fd_sc_hd__a21o_1
X_18121_ _03144_ _03955_ _03143_ VSS VSS VDD VDD _03956_ sky130_fd_sc_hd__a21o_1
X_18122_ _03382_ _03956_ _03381_ VSS VSS VDD VDD _03957_ sky130_fd_sc_hd__a21o_1
X_18123_ _02534_ _03957_ _02533_ VSS VSS VDD VDD _03958_ sky130_fd_sc_hd__a21oi_1
X_18124_ net881 _03958_ VSS VSS VDD VDD _03959_ sky130_fd_sc_hd__xnor2_1
X_18125_ net639 _03959_ VSS VSS VDD VDD _03960_ sky130_fd_sc_hd__nand2_1
X_18126_ u_core.u_top.u_core.acc[138] u_core.u_top.u_core.acc[137] _08702_ VSS VSS VDD VDD _03961_ sky130_fd_sc_hd__or3_1
X_18127_ _08699_ VSS VSS VDD VDD _03962_ sky130_fd_sc_hd__inv_1
X_18128_ u_core.u_top.u_core.acc[138] u_core.u_top.u_core.acc[137] _03962_ VSS VSS VDD VDD _03963_ sky130_fd_sc_hd__nand3_1
X_18129_ _03961_ _03963_ net709 VSS VSS VDD VDD _03964_ sky130_fd_sc_hd__mux2i_1
X_18130_ _03963_ _03961_ net709 VSS VSS VDD VDD _03965_ sky130_fd_sc_hd__mux2i_1
X_18131_ net795 _03964_ _03965_ net832 VSS VSS VDD VDD _03966_ sky130_fd_sc_hd__a22oi_1
X_18132_ net670 _03966_ VSS VSS VDD VDD _03967_ sky130_fd_sc_hd__nor2_1
X_18133_ u_core.u_top.u_core.acc[139] _03967_ VSS VSS VDD VDD _03968_ sky130_fd_sc_hd__xnor2_1
X_18134_ _03960_ _03968_ VSS VSS VDD VDD _03969_ sky130_fd_sc_hd__xnor2_1
X_18135_ u_core.u_top.u_core.acc[133] u_core.u_top.u_core.acc[132] VSS VSS VDD VDD _03970_ sky130_fd_sc_hd__nand2_1
X_18136_ _02802_ _03970_ u_core.u_top.u_core.acc[134] VSS VSS VDD VDD _03971_ sky130_fd_sc_hd__o21bai_1
X_18137_ u_core.u_top.u_core.acc[136] u_core.u_top.u_core.acc[135] _03971_ u_core.u_top.u_core.acc[137] VSS VSS VDD VDD _03972_ sky130_fd_sc_hd__a31oi_1
X_18138_ u_core.u_top.u_core.acc[139] _03972_ VSS VSS VDD VDD _03973_ sky130_fd_sc_hd__nor2_1
X_18139_ u_core.u_top.u_core.acc[138] _03973_ VSS VSS VDD VDD _03974_ sky130_fd_sc_hd__nand2_1
X_18140_ net852 _03974_ VSS VSS VDD VDD _03975_ sky130_fd_sc_hd__nand2_1
X_18141_ net782 _03969_ _03975_ net634 VSS VSS VDD VDD _1042_[139] sky130_fd_sc_hd__o211ai_1
X_18142_ _02325_ _02717_ VSS VSS VDD VDD _03976_ sky130_fd_sc_hd__nor2b_1
X_18143_ _02716_ _03976_ _03458_ VSS VSS VDD VDD _03977_ sky130_fd_sc_hd__o21ai_0
X_18144_ _03457_ _03977_ VSS VSS VDD VDD _03978_ sky130_fd_sc_hd__nand2b_1
X_18145_ _03349_ _03978_ _03348_ VSS VSS VDD VDD _03979_ sky130_fd_sc_hd__a21o_1
X_18146_ _03201_ _03979_ _03200_ VSS VSS VDD VDD _03980_ sky130_fd_sc_hd__a21o_1
X_18147_ _03144_ _03980_ _03143_ VSS VSS VDD VDD _03981_ sky130_fd_sc_hd__a21o_1
X_18148_ _03382_ _03981_ _03381_ VSS VSS VDD VDD _03982_ sky130_fd_sc_hd__a21oi_1
X_18149_ _02534_ _03982_ VSS VSS VDD VDD _03983_ sky130_fd_sc_hd__xor2_1
X_18150_ net639 _03983_ VSS VSS VDD VDD _03984_ sky130_fd_sc_hd__nand2_1
X_18151_ u_core.u_top.u_core.acc_upd[138] net639 _03984_ VSS VSS VDD VDD _03985_ sky130_fd_sc_hd__o21ai_0
X_18152_ u_core.u_top.u_core.acc[138] net852 _03973_ VSS VSS VDD VDD _03986_ sky130_fd_sc_hd__nand3_1
X_18153_ net782 _03985_ _03986_ net634 VSS VSS VDD VDD _1042_[138] sky130_fd_sc_hd__o211ai_1
X_18154_ _03382_ _03956_ VSS VSS VDD VDD _03987_ sky130_fd_sc_hd__xnor2_1
X_18155_ net639 _03987_ VSS VSS VDD VDD _03988_ sky130_fd_sc_hd__nand2_1
X_18156_ u_core.u_top.u_core.acc_upd[137] net639 _03988_ VSS VSS VDD VDD _03989_ sky130_fd_sc_hd__o21ai_0
X_18158_ net782 _03989_ _03975_ net634 VSS VSS VDD VDD _1042_[137] sky130_fd_sc_hd__o211ai_1
X_18160_ _03144_ _03980_ VSS VSS VDD VDD _03992_ sky130_fd_sc_hd__xnor2_1
X_18161_ net639 _03992_ VSS VSS VDD VDD _03993_ sky130_fd_sc_hd__nand2_1
X_18162_ u_core.u_top.u_core.acc_upd[136] net639 _03993_ VSS VSS VDD VDD _03994_ sky130_fd_sc_hd__o21ai_0
X_18163_ net782 _03994_ _03986_ _11237_ VSS VSS VDD VDD _1042_[136] sky130_fd_sc_hd__o211ai_1
X_18164_ _03201_ _03954_ VSS VSS VDD VDD _03995_ sky130_fd_sc_hd__xnor2_1
X_18165_ net639 _03995_ VSS VSS VDD VDD _03996_ sky130_fd_sc_hd__nand2_1
X_18166_ u_core.u_top.u_core.acc_upd[135] net639 _03996_ VSS VSS VDD VDD _03997_ sky130_fd_sc_hd__o21ai_0
X_18168_ net782 _03997_ _03986_ _11240_ VSS VSS VDD VDD _1042_[135] sky130_fd_sc_hd__o211ai_1
X_18169_ _03349_ _03978_ VSS VSS VDD VDD _03999_ sky130_fd_sc_hd__xnor2_1
X_18170_ net639 _03999_ VSS VSS VDD VDD _04000_ sky130_fd_sc_hd__nand2_1
X_18171_ u_core.u_top.u_core.acc_upd[134] net639 _04000_ VSS VSS VDD VDD _04001_ sky130_fd_sc_hd__o21ai_0
X_18172_ net782 _04001_ _03975_ _11243_ VSS VSS VDD VDD _1042_[134] sky130_fd_sc_hd__o211ai_1
X_18173_ _03458_ _03952_ VSS VSS VDD VDD _04002_ sky130_fd_sc_hd__xnor2_1
X_18174_ net639 _04002_ VSS VSS VDD VDD _04003_ sky130_fd_sc_hd__nand2_1
X_18175_ u_core.u_top.u_core.acc_upd[133] net639 _04003_ VSS VSS VDD VDD _04004_ sky130_fd_sc_hd__o21ai_0
X_18176_ net782 _04004_ _03986_ _11249_ VSS VSS VDD VDD _1042_[133] sky130_fd_sc_hd__o211ai_1
X_18177_ _02717_ _02325_ VSS VSS VDD VDD _04005_ sky130_fd_sc_hd__xnor2_1
X_18178_ u_core.u_top.u_core.acc_upd[132] _04005_ net640 VSS VSS VDD VDD _04006_ sky130_fd_sc_hd__mux2i_1
X_18180_ net782 _04006_ _11254_ VSS VSS VDD VDD _1042_[132] sky130_fd_sc_hd__o21ai_0
X_18181_ _02326_ net640 VSS VSS VDD VDD _04008_ sky130_fd_sc_hd__nand2_1
X_18182_ u_core.u_top.u_core.acc_upd[131] net640 _04008_ VSS VSS VDD VDD _04009_ sky130_fd_sc_hd__o21ai_0
X_18183_ net782 _04009_ _11256_ VSS VSS VDD VDD _1042_[131] sky130_fd_sc_hd__o21ai_0
X_18184_ _0098_[0] _08733_ VSS VSS VDD VDD _03285_ sky130_fd_sc_hd__xnor2_1
X_18185_ _03285_ _03286_ net640 VSS VSS VDD VDD _04010_ sky130_fd_sc_hd__mux2_1
X_18187_ net782 _04010_ _11268_ VSS VSS VDD VDD _1042_[130] sky130_fd_sc_hd__o21ai_0
X_18188_ _02435_ _02711_ VSS VSS VDD VDD _04012_ sky130_fd_sc_hd__nor2b_1
X_18189_ _02710_ _04012_ _02585_ VSS VSS VDD VDD _04013_ sky130_fd_sc_hd__o21ai_0
X_18190_ _02584_ _04013_ VSS VSS VDD VDD _04014_ sky130_fd_sc_hd__nand2b_1
X_18191_ _03203_ _04014_ _03202_ VSS VSS VDD VDD _04015_ sky130_fd_sc_hd__a21o_1
X_18192_ _03100_ _04015_ _03099_ VSS VSS VDD VDD _04016_ sky130_fd_sc_hd__a21o_1
X_18193_ _03088_ _04016_ _03087_ VSS VSS VDD VDD _04017_ sky130_fd_sc_hd__a21o_1
X_18194_ _03300_ _04017_ _03299_ VSS VSS VDD VDD _04018_ sky130_fd_sc_hd__a21o_1
X_18195_ _02736_ _04018_ _02735_ VSS VSS VDD VDD _04019_ sky130_fd_sc_hd__a21o_1
X_18196_ _03343_ _04019_ _03342_ VSS VSS VDD VDD _04020_ sky130_fd_sc_hd__a21oi_1
X_18197_ net881 _04020_ VSS VSS VDD VDD _04021_ sky130_fd_sc_hd__xnor2_1
X_18198_ net640 _04021_ VSS VSS VDD VDD _04022_ sky130_fd_sc_hd__nand2_1
X_18199_ u_core.u_top.u_core.acc[128] _08775_ u_core.u_top.u_core.acc[127] _08744_ VSS VSS VDD VDD _04023_ sky130_fd_sc_hd__nor4b_1
X_18200_ u_core.u_top.u_core.acc[129] _04023_ VSS VSS VDD VDD _04024_ sky130_fd_sc_hd__xnor2_1
X_18201_ _08739_ _08749_ _08759_ VSS VSS VDD VDD _04025_ sky130_fd_sc_hd__nor3_1
X_18202_ u_core.u_top.u_core.acc[129] _04025_ VSS VSS VDD VDD _04026_ sky130_fd_sc_hd__xnor2_1
X_18203_ _04024_ _04026_ net709 VSS VSS VDD VDD _04027_ sky130_fd_sc_hd__mux2_1
X_18204_ net833 u_core.u_top.u_core.acc[129] VSS VSS VDD VDD _04028_ sky130_fd_sc_hd__nor2_1
X_18205_ net833 net679 _04027_ _04028_ VSS VSS VDD VDD _04029_ sky130_fd_sc_hd__a31oi_1
X_18206_ _04026_ _04024_ net709 VSS VSS VDD VDD _04030_ sky130_fd_sc_hd__mux2_1
X_18207_ u_core.u_top.u_core.acc[129] net679 VSS VSS VDD VDD _04031_ sky130_fd_sc_hd__nor2_1
X_18208_ _0086_ net679 _04030_ _04031_ VSS VSS VDD VDD _04032_ sky130_fd_sc_hd__a31oi_1
X_18209_ _0086_ _04029_ _04032_ VSS VSS VDD VDD _04033_ sky130_fd_sc_hd__o21ai_0
X_18210_ _04022_ _04033_ VSS VSS VDD VDD _04034_ sky130_fd_sc_hd__xnor2_1
X_18211_ _02607_ _08757_ u_core.u_top.u_core.acc[124] VSS VSS VDD VDD _04035_ sky130_fd_sc_hd__o21bai_1
X_18212_ u_core.u_top.u_core.acc[126] u_core.u_top.u_core.acc[125] _04035_ u_core.u_top.u_core.acc[127] VSS VSS VDD VDD _04036_ sky130_fd_sc_hd__a31oi_1
X_18213_ _08739_ u_core.u_top.u_core.acc[129] _04036_ VSS VSS VDD VDD _04037_ sky130_fd_sc_hd__nor3_1
X_18214_ _04037_ net852 VSS VSS VDD VDD _04038_ sky130_fd_sc_hd__nand2b_1
X_18215_ net784 _04034_ _04038_ net634 VSS VSS VDD VDD _1042_[129] sky130_fd_sc_hd__o211ai_1
X_18216_ _02436_ _02585_ VSS VSS VDD VDD _04039_ sky130_fd_sc_hd__nor2b_1
X_18217_ _02584_ _04039_ _03203_ VSS VSS VDD VDD _04040_ sky130_fd_sc_hd__o21ai_0
X_18218_ _03202_ _04040_ VSS VSS VDD VDD _04041_ sky130_fd_sc_hd__nand2b_1
X_18219_ _03100_ _04041_ _03099_ VSS VSS VDD VDD _04042_ sky130_fd_sc_hd__a21o_1
X_18220_ _03088_ _04042_ _03087_ VSS VSS VDD VDD _04043_ sky130_fd_sc_hd__a21o_1
X_18221_ _03300_ _04043_ _03299_ VSS VSS VDD VDD _04044_ sky130_fd_sc_hd__a21o_1
X_18222_ _02736_ _04044_ _02735_ VSS VSS VDD VDD _04045_ sky130_fd_sc_hd__a21oi_1
X_18223_ _03343_ _04045_ VSS VSS VDD VDD _04046_ sky130_fd_sc_hd__xnor2_1
X_18224_ u_core.u_top.u_core.acc_upd[128] _04046_ net639 VSS VSS VDD VDD _04047_ sky130_fd_sc_hd__mux2i_1
X_18225_ net852 _04037_ VSS VSS VDD VDD _04048_ sky130_fd_sc_hd__nand2_1
X_18226_ net784 _04047_ _04048_ net634 VSS VSS VDD VDD _1042_[128] sky130_fd_sc_hd__o211ai_1
X_18227_ _02736_ _04018_ VSS VSS VDD VDD _04049_ sky130_fd_sc_hd__xnor2_1
X_18228_ net639 _04049_ VSS VSS VDD VDD _04050_ sky130_fd_sc_hd__nand2_1
X_18229_ u_core.u_top.u_core.acc_upd[127] net639 _04050_ VSS VSS VDD VDD _04051_ sky130_fd_sc_hd__o21ai_0
X_18230_ net784 _04051_ _04038_ net634 VSS VSS VDD VDD _1042_[127] sky130_fd_sc_hd__o211ai_1
X_18231_ _03300_ _04043_ VSS VSS VDD VDD _04052_ sky130_fd_sc_hd__xor2_1
X_18232_ u_core.u_top.u_core.acc_upd[126] _04052_ net639 VSS VSS VDD VDD _04053_ sky130_fd_sc_hd__mux2i_1
X_18234_ net784 _04053_ _04048_ _11237_ VSS VSS VDD VDD _1042_[126] sky130_fd_sc_hd__o211ai_1
X_18235_ _03088_ _04016_ VSS VSS VDD VDD _04055_ sky130_fd_sc_hd__xnor2_1
X_18236_ net639 _04055_ VSS VSS VDD VDD _04056_ sky130_fd_sc_hd__nand2_1
X_18237_ u_core.u_top.u_core.acc_upd[125] net640 _04056_ VSS VSS VDD VDD _04057_ sky130_fd_sc_hd__o21ai_0
X_18238_ net784 _04057_ _04048_ _11240_ VSS VSS VDD VDD _1042_[125] sky130_fd_sc_hd__o211ai_1
X_18239_ _03100_ _04041_ VSS VSS VDD VDD _04058_ sky130_fd_sc_hd__xor2_1
X_18240_ u_core.u_top.u_core.acc_upd[124] _04058_ net640 VSS VSS VDD VDD _04059_ sky130_fd_sc_hd__mux2i_1
X_18241_ net784 _04059_ _04038_ _11243_ VSS VSS VDD VDD _1042_[124] sky130_fd_sc_hd__o211ai_1
X_18244_ _03203_ _04014_ VSS VSS VDD VDD _04062_ sky130_fd_sc_hd__xnor2_1
X_18245_ net640 _04062_ VSS VSS VDD VDD _04063_ sky130_fd_sc_hd__nand2_1
X_18246_ u_core.u_top.u_core.acc_upd[123] net640 _04063_ VSS VSS VDD VDD _04064_ sky130_fd_sc_hd__o21ai_0
X_18248_ net784 _04064_ _04048_ net630 VSS VSS VDD VDD _1042_[123] sky130_fd_sc_hd__o211ai_1
X_18249_ _02585_ _02436_ VSS VSS VDD VDD _04066_ sky130_fd_sc_hd__xnor2_1
X_18250_ u_core.u_top.u_core.acc_upd[122] _04066_ net640 VSS VSS VDD VDD _04067_ sky130_fd_sc_hd__mux2i_1
X_18251_ net784 _04067_ _11254_ VSS VSS VDD VDD _1042_[122] sky130_fd_sc_hd__o21ai_0
X_18252_ _02437_ net640 VSS VSS VDD VDD _04068_ sky130_fd_sc_hd__nand2_1
X_18253_ u_core.u_top.u_core.acc_upd[121] net640 _04068_ VSS VSS VDD VDD _04069_ sky130_fd_sc_hd__o21ai_0
X_18254_ net784 _04069_ _11256_ VSS VSS VDD VDD _1042_[121] sky130_fd_sc_hd__o21ai_0
X_18255_ u_core.u_top.u_core.acc[120] _08755_ VSS VSS VDD VDD _03009_ sky130_fd_sc_hd__xnor2_1
X_18256_ _03009_ _03010_ net640 VSS VSS VDD VDD _04070_ sky130_fd_sc_hd__mux2_1
X_18257_ net784 _04070_ _11268_ VSS VSS VDD VDD _1042_[120] sky130_fd_sc_hd__o21ai_0
X_18258_ _02346_ _02541_ VSS VSS VDD VDD _04071_ sky130_fd_sc_hd__nor2b_1
X_18259_ _02540_ _04071_ _02853_ VSS VSS VDD VDD _04072_ sky130_fd_sc_hd__o21ai_0
X_18260_ _02852_ _04072_ VSS VSS VDD VDD _04073_ sky130_fd_sc_hd__nand2b_1
X_18261_ _03472_ _04073_ _03471_ VSS VSS VDD VDD _04074_ sky130_fd_sc_hd__a21o_1
X_18262_ _02757_ _04074_ _02756_ VSS VSS VDD VDD _04075_ sky130_fd_sc_hd__a21o_1
X_18263_ _03086_ _04075_ _03085_ VSS VSS VDD VDD _04076_ sky130_fd_sc_hd__a21o_1
X_18264_ _03372_ _04076_ _03371_ VSS VSS VDD VDD _04077_ sky130_fd_sc_hd__a21o_1
X_18265_ _03165_ _04077_ _03164_ VSS VSS VDD VDD _04078_ sky130_fd_sc_hd__a21o_1
X_18266_ _02922_ _04078_ _02921_ VSS VSS VDD VDD _04079_ sky130_fd_sc_hd__a21oi_1
X_18267_ _11271_ _04079_ VSS VSS VDD VDD _04080_ sky130_fd_sc_hd__xnor2_1
X_18268_ net641 _04080_ VSS VSS VDD VDD _04081_ sky130_fd_sc_hd__nand2_1
X_18269_ u_core.u_top.u_core.acc[117] u_core.u_top.u_core.acc[118] _08816_ VSS VSS VDD VDD _04082_ sky130_fd_sc_hd__nand3_1
X_18270_ u_core.u_top.u_core.acc[117] u_core.u_top.u_core.acc[118] _08811_ VSS VSS VDD VDD _04083_ sky130_fd_sc_hd__or3_1
X_18271_ _04082_ _04083_ net710 VSS VSS VDD VDD _04084_ sky130_fd_sc_hd__mux2i_1
X_18272_ _04083_ _04082_ net710 VSS VSS VDD VDD _04085_ sky130_fd_sc_hd__mux2i_1
X_18273_ _0076_ _04084_ _04085_ _08794_ VSS VSS VDD VDD _04086_ sky130_fd_sc_hd__a22oi_1
X_18274_ net669 _04086_ VSS VSS VDD VDD _04087_ sky130_fd_sc_hd__nor2_1
X_18275_ u_core.u_top.u_core.acc[119] _04087_ VSS VSS VDD VDD _04088_ sky130_fd_sc_hd__xnor2_1
X_18276_ _04081_ _04088_ VSS VSS VDD VDD _04089_ sky130_fd_sc_hd__xnor2_1
X_18277_ _02924_ _08812_ u_core.u_top.u_core.acc[114] VSS VSS VDD VDD _04090_ sky130_fd_sc_hd__o21bai_1
X_18278_ u_core.u_top.u_core.acc[116] u_core.u_top.u_core.acc[115] _04090_ u_core.u_top.u_core.acc[117] VSS VSS VDD VDD _04091_ sky130_fd_sc_hd__a31oi_1
X_18279_ u_core.u_top.u_core.acc[119] _04091_ VSS VSS VDD VDD _04092_ sky130_fd_sc_hd__nor2_1
X_18280_ u_core.u_top.u_core.acc[118] _04092_ VSS VSS VDD VDD _04093_ sky130_fd_sc_hd__nand2_1
X_18281_ net853 _04093_ VSS VSS VDD VDD _04094_ sky130_fd_sc_hd__nand2_1
X_18282_ net787 _04089_ _04094_ _11221_ VSS VSS VDD VDD _1042_[119] sky130_fd_sc_hd__o211ai_1
X_18283_ _02347_ _02853_ VSS VSS VDD VDD _04095_ sky130_fd_sc_hd__nor2b_1
X_18284_ _02852_ _04095_ _03472_ VSS VSS VDD VDD _04096_ sky130_fd_sc_hd__o21ai_0
X_18285_ _03471_ _04096_ VSS VSS VDD VDD _04097_ sky130_fd_sc_hd__nand2b_1
X_18286_ _02757_ _04097_ _02756_ VSS VSS VDD VDD _04098_ sky130_fd_sc_hd__a21o_1
X_18287_ _03086_ _04098_ _03085_ VSS VSS VDD VDD _04099_ sky130_fd_sc_hd__a21o_1
X_18288_ _03372_ _04099_ _03371_ VSS VSS VDD VDD _04100_ sky130_fd_sc_hd__a21o_1
X_18289_ _03165_ _04100_ _03164_ VSS VSS VDD VDD _04101_ sky130_fd_sc_hd__a21oi_1
X_18290_ _02922_ _04101_ VSS VSS VDD VDD _04102_ sky130_fd_sc_hd__xnor2_1
X_18291_ u_core.u_top.u_core.acc_upd[118] _04102_ net641 VSS VSS VDD VDD _04103_ sky130_fd_sc_hd__mux2i_1
X_18292_ u_core.u_top.u_core.acc[118] net853 _04092_ VSS VSS VDD VDD _04104_ sky130_fd_sc_hd__nand3_1
X_18293_ net782 _04103_ _04104_ _11221_ VSS VSS VDD VDD _1042_[118] sky130_fd_sc_hd__o211ai_1
X_18294_ _03165_ _04077_ VSS VSS VDD VDD _04105_ sky130_fd_sc_hd__xor2_1
X_18296_ u_core.u_top.u_core.acc_upd[117] _04105_ net641 VSS VSS VDD VDD _04107_ sky130_fd_sc_hd__mux2i_1
X_18297_ net782 _04107_ _04094_ _11221_ VSS VSS VDD VDD _1042_[117] sky130_fd_sc_hd__o211ai_1
X_18298_ _03372_ _04099_ VSS VSS VDD VDD _04108_ sky130_fd_sc_hd__xor2_1
X_18299_ u_core.u_top.u_core.acc_upd[116] _04108_ net641 VSS VSS VDD VDD _04109_ sky130_fd_sc_hd__mux2i_1
X_18300_ net782 _04109_ _04104_ net633 VSS VSS VDD VDD _1042_[116] sky130_fd_sc_hd__o211ai_1
X_18301_ _03086_ _04075_ VSS VSS VDD VDD _04110_ sky130_fd_sc_hd__xor2_1
X_18302_ u_core.u_top.u_core.acc_upd[115] _04110_ net641 VSS VSS VDD VDD _04111_ sky130_fd_sc_hd__mux2i_1
X_18303_ net787 _04111_ _04104_ net632 VSS VSS VDD VDD _1042_[115] sky130_fd_sc_hd__o211ai_1
X_18305_ _02757_ _04097_ VSS VSS VDD VDD _04113_ sky130_fd_sc_hd__xnor2_1
X_18306_ net641 _04113_ VSS VSS VDD VDD _04114_ sky130_fd_sc_hd__nand2_1
X_18307_ u_core.u_top.u_core.acc_upd[114] net641 _04114_ VSS VSS VDD VDD _04115_ sky130_fd_sc_hd__o21ai_0
X_18308_ net787 _04115_ _04094_ net631 VSS VSS VDD VDD _1042_[114] sky130_fd_sc_hd__o211ai_1
X_18309_ _03472_ _04073_ VSS VSS VDD VDD _04116_ sky130_fd_sc_hd__xnor2_1
X_18310_ net641 _04116_ VSS VSS VDD VDD _04117_ sky130_fd_sc_hd__nand2_1
X_18311_ u_core.u_top.u_core.acc_upd[113] net641 _04117_ VSS VSS VDD VDD _04118_ sky130_fd_sc_hd__o21ai_0
X_18312_ net787 _04118_ _04104_ net630 VSS VSS VDD VDD _1042_[113] sky130_fd_sc_hd__o211ai_1
X_18313_ _02853_ _02347_ VSS VSS VDD VDD _04119_ sky130_fd_sc_hd__xnor2_1
X_18314_ u_core.u_top.u_core.acc_upd[112] _04119_ net641 VSS VSS VDD VDD _04120_ sky130_fd_sc_hd__mux2i_1
X_18315_ net787 _04120_ net629 VSS VSS VDD VDD _1042_[112] sky130_fd_sc_hd__o21ai_0
X_18316_ u_core.u_top.u_core.acc_upd[111] VSS VSS VDD VDD _02345_ sky130_fd_sc_hd__inv_1
X_18317_ _02345_ _02348_ net641 VSS VSS VDD VDD _04121_ sky130_fd_sc_hd__mux2i_1
X_18318_ _11259_ _04121_ VSS VSS VDD VDD _04122_ sky130_fd_sc_hd__nand2_1
X_18319_ _11256_ _04122_ VSS VSS VDD VDD _1042_[111] sky130_fd_sc_hd__nand2_1
X_18320_ _03160_ _03161_ net641 VSS VSS VDD VDD _04123_ sky130_fd_sc_hd__mux2_1
X_18321_ net787 _04123_ _11268_ VSS VSS VDD VDD _1042_[110] sky130_fd_sc_hd__o21ai_0
X_18322_ _02312_ _02573_ VSS VSS VDD VDD _04124_ sky130_fd_sc_hd__nor2b_1
X_18323_ _02975_ _04124_ _02531_ VSS VSS VDD VDD _04125_ sky130_fd_sc_hd__o21ai_0
X_18324_ _02530_ _04125_ VSS VSS VDD VDD _04126_ sky130_fd_sc_hd__nand2b_1
X_18325_ _03359_ _04126_ _03358_ VSS VSS VDD VDD _04127_ sky130_fd_sc_hd__a21o_1
X_18326_ _02981_ _04127_ _02980_ VSS VSS VDD VDD _04128_ sky130_fd_sc_hd__a21o_1
X_18327_ _02867_ _04128_ _02866_ VSS VSS VDD VDD _04129_ sky130_fd_sc_hd__a21o_1
X_18328_ _03388_ _04129_ _03387_ VSS VSS VDD VDD _04130_ sky130_fd_sc_hd__a21o_1
X_18329_ _03347_ _04130_ _03346_ VSS VSS VDD VDD _04131_ sky130_fd_sc_hd__a21o_1
X_18330_ _03355_ _04131_ _03354_ VSS VSS VDD VDD _04132_ sky130_fd_sc_hd__a21oi_1
X_18331_ net881 _04132_ VSS VSS VDD VDD _04133_ sky130_fd_sc_hd__xnor2_1
X_18332_ net641 _04133_ VSS VSS VDD VDD _04134_ sky130_fd_sc_hd__nand2_1
X_18333_ u_core.u_top.u_core.acc[108] _08854_ _08867_ VSS VSS VDD VDD _04135_ sky130_fd_sc_hd__nand3b_1
X_18334_ u_core.u_top.u_core.acc[109] _04135_ VSS VSS VDD VDD _04136_ sky130_fd_sc_hd__xor2_1
X_18335_ u_core.u_top.u_core.acc[108] u_core.u_top.u_core.acc[107] VSS VSS VDD VDD _04137_ sky130_fd_sc_hd__nand2_1
X_18336_ _08864_ _04137_ VSS VSS VDD VDD _04138_ sky130_fd_sc_hd__nor2_1
X_18337_ u_core.u_top.u_core.acc[109] _04138_ VSS VSS VDD VDD _04139_ sky130_fd_sc_hd__xnor2_1
X_18338_ _04136_ _04139_ net711 VSS VSS VDD VDD _04140_ sky130_fd_sc_hd__mux2_1
X_18339_ net834 u_core.u_top.u_core.acc[109] VSS VSS VDD VDD _04141_ sky130_fd_sc_hd__nor2_1
X_18340_ net834 net679 _04140_ _04141_ VSS VSS VDD VDD _04142_ sky130_fd_sc_hd__a31oi_1
X_18341_ _04139_ _04136_ net711 VSS VSS VDD VDD _04143_ sky130_fd_sc_hd__mux2_1
X_18342_ u_core.u_top.u_core.acc[109] net679 VSS VSS VDD VDD _04144_ sky130_fd_sc_hd__nor2_1
X_18343_ _0065_ net679 _04143_ _04144_ VSS VSS VDD VDD _04145_ sky130_fd_sc_hd__a31oi_1
X_18344_ _0065_ _04142_ _04145_ VSS VSS VDD VDD _04146_ sky130_fd_sc_hd__o21ai_0
X_18345_ _04134_ _04146_ VSS VSS VDD VDD _04147_ sky130_fd_sc_hd__xnor2_1
X_18346_ _02814_ _08862_ _08847_ VSS VSS VDD VDD _04148_ sky130_fd_sc_hd__o21ai_0
X_18347_ u_core.u_top.u_core.acc[105] u_core.u_top.u_core.acc[106] _04148_ u_core.u_top.u_core.acc[107] VSS VSS VDD VDD _04149_ sky130_fd_sc_hd__a31oi_1
X_18348_ u_core.u_top.u_core.acc[109] _04149_ VSS VSS VDD VDD _04150_ sky130_fd_sc_hd__nor2_1
X_18349_ u_core.u_top.u_core.acc[108] _04150_ VSS VSS VDD VDD _04151_ sky130_fd_sc_hd__nand2_1
X_18350_ net852 _04151_ VSS VSS VDD VDD _04152_ sky130_fd_sc_hd__nand2_1
X_18351_ net782 _04147_ _04152_ _11221_ VSS VSS VDD VDD _1042_[109] sky130_fd_sc_hd__o211ai_1
X_18352_ _02313_ _02531_ VSS VSS VDD VDD _04153_ sky130_fd_sc_hd__nor2b_1
X_18353_ _02530_ _04153_ _03359_ VSS VSS VDD VDD _04154_ sky130_fd_sc_hd__o21ai_0
X_18354_ _03358_ _04154_ VSS VSS VDD VDD _04155_ sky130_fd_sc_hd__nand2b_1
X_18355_ _02981_ _04155_ _02980_ VSS VSS VDD VDD _04156_ sky130_fd_sc_hd__a21o_1
X_18356_ _02867_ _04156_ _02866_ VSS VSS VDD VDD _04157_ sky130_fd_sc_hd__a21o_1
X_18357_ _03388_ _04157_ _03387_ VSS VSS VDD VDD _04158_ sky130_fd_sc_hd__a21o_1
X_18358_ _03347_ _04158_ _03346_ VSS VSS VDD VDD _04159_ sky130_fd_sc_hd__a21oi_1
X_18359_ _03355_ _04159_ VSS VSS VDD VDD _04160_ sky130_fd_sc_hd__xnor2_1
X_18360_ u_core.u_top.u_core.acc_upd[108] _04160_ net641 VSS VSS VDD VDD _04161_ sky130_fd_sc_hd__mux2i_1
X_18361_ u_core.u_top.u_core.acc[108] net852 _04150_ VSS VSS VDD VDD _04162_ sky130_fd_sc_hd__nand3_1
X_18362_ net782 _04161_ _04162_ _11221_ VSS VSS VDD VDD _1042_[108] sky130_fd_sc_hd__o211ai_1
X_18364_ _03347_ _04130_ VSS VSS VDD VDD _04164_ sky130_fd_sc_hd__xnor2_1
X_18365_ net641 _04164_ VSS VSS VDD VDD _04165_ sky130_fd_sc_hd__nand2_1
X_18366_ u_core.u_top.u_core.acc_upd[107] net641 _04165_ VSS VSS VDD VDD _04166_ sky130_fd_sc_hd__o21ai_0
X_18367_ net782 _04166_ _04152_ _11221_ VSS VSS VDD VDD _1042_[107] sky130_fd_sc_hd__o211ai_1
X_18368_ _03388_ _04157_ VSS VSS VDD VDD _04167_ sky130_fd_sc_hd__xnor2_1
X_18369_ net641 _04167_ VSS VSS VDD VDD _04168_ sky130_fd_sc_hd__nand2_1
X_18370_ u_core.u_top.u_core.acc_upd[106] net641 _04168_ VSS VSS VDD VDD _04169_ sky130_fd_sc_hd__o21ai_0
X_18371_ net782 _04169_ _04162_ net633 VSS VSS VDD VDD _1042_[106] sky130_fd_sc_hd__o211ai_1
X_18372_ _02867_ _04128_ VSS VSS VDD VDD _04170_ sky130_fd_sc_hd__xor2_1
X_18373_ u_core.u_top.u_core.acc_upd[105] _04170_ net641 VSS VSS VDD VDD _04171_ sky130_fd_sc_hd__mux2i_1
X_18374_ net782 _04171_ _04162_ net632 VSS VSS VDD VDD _1042_[105] sky130_fd_sc_hd__o211ai_1
X_18375_ _02981_ _04155_ VSS VSS VDD VDD _04172_ sky130_fd_sc_hd__xnor2_1
X_18376_ net641 _04172_ VSS VSS VDD VDD _04173_ sky130_fd_sc_hd__nand2_1
X_18377_ u_core.u_top.u_core.acc_upd[104] net641 _04173_ VSS VSS VDD VDD _04174_ sky130_fd_sc_hd__o21ai_0
X_18378_ net782 _04174_ _04152_ net631 VSS VSS VDD VDD _1042_[104] sky130_fd_sc_hd__o211ai_1
X_18379_ _03359_ _04126_ VSS VSS VDD VDD _04175_ sky130_fd_sc_hd__xnor2_1
X_18380_ net641 _04175_ VSS VSS VDD VDD _04176_ sky130_fd_sc_hd__nand2_1
X_18381_ u_core.u_top.u_core.acc_upd[103] net641 _04176_ VSS VSS VDD VDD _04177_ sky130_fd_sc_hd__o21ai_0
X_18382_ net782 _04177_ _04162_ net630 VSS VSS VDD VDD _1042_[103] sky130_fd_sc_hd__o211ai_1
X_18383_ _02531_ _02313_ VSS VSS VDD VDD _04178_ sky130_fd_sc_hd__xnor2_1
X_18384_ u_core.u_top.u_core.acc_upd[102] _04178_ net641 VSS VSS VDD VDD _04179_ sky130_fd_sc_hd__mux2i_1
X_18385_ net782 _04179_ net629 VSS VSS VDD VDD _1042_[102] sky130_fd_sc_hd__o21ai_0
X_18387_ _02314_ net641 VSS VSS VDD VDD _04181_ sky130_fd_sc_hd__nand2_1
X_18388_ u_core.u_top.u_core.acc_upd[101] net641 _04181_ VSS VSS VDD VDD _04182_ sky130_fd_sc_hd__o21ai_0
X_18389_ net782 _04182_ _11256_ VSS VSS VDD VDD _1042_[101] sky130_fd_sc_hd__o21ai_0
X_18390_ u_core.u_top.u_core.acc[100] _08860_ VSS VSS VDD VDD _03337_ sky130_fd_sc_hd__xnor2_1
X_18391_ _03337_ _03338_ net641 VSS VSS VDD VDD _04183_ sky130_fd_sc_hd__mux2_1
X_18392_ net782 _04183_ _11268_ VSS VSS VDD VDD _1042_[100] sky130_fd_sc_hd__o21ai_0
X_18393_ u_core.u_top.u_core.acc[98] _02596_ VSS VSS VDD VDD _04184_ sky130_fd_sc_hd__nand2_1
X_18394_ u_core.u_top.u_core.acc[93] u_core.u_top.u_core.acc[92] _04184_ VSS VSS VDD VDD _04185_ sky130_fd_sc_hd__nand3_1
X_18395_ _08905_ _04185_ _08918_ VSS VSS VDD VDD _04186_ sky130_fd_sc_hd__a21oi_1
X_18396_ u_core.u_top.u_core.acc[97] _04186_ VSS VSS VDD VDD _04187_ sky130_fd_sc_hd__nor2_1
X_18397_ u_core.u_top.u_core.acc[99] _08897_ _04187_ VSS VSS VDD VDD _04188_ sky130_fd_sc_hd__nor3_1
X_18398_ _02439_ _02767_ VSS VSS VDD VDD _04189_ sky130_fd_sc_hd__nor2b_1
X_18399_ _02766_ _04189_ _02777_ VSS VSS VDD VDD _04190_ sky130_fd_sc_hd__o21ai_0
X_18400_ _02776_ _04190_ VSS VSS VDD VDD _04191_ sky130_fd_sc_hd__nand2b_1
X_18401_ _03049_ _04191_ _03048_ VSS VSS VDD VDD _04192_ sky130_fd_sc_hd__a21o_1
X_18402_ _03117_ _04192_ _03116_ VSS VSS VDD VDD _04193_ sky130_fd_sc_hd__a21o_1
X_18403_ _03220_ _04193_ _03219_ VSS VSS VDD VDD _04194_ sky130_fd_sc_hd__a21o_1
X_18404_ _02836_ _04194_ _02835_ VSS VSS VDD VDD _04195_ sky130_fd_sc_hd__a21o_1
X_18405_ _03071_ _04195_ _03070_ VSS VSS VDD VDD _04196_ sky130_fd_sc_hd__a21o_1
X_18406_ _03218_ _04196_ _03217_ VSS VSS VDD VDD _04197_ sky130_fd_sc_hd__a21oi_1
X_18407_ net881 _04197_ VSS VSS VDD VDD _04198_ sky130_fd_sc_hd__xnor2_1
X_18408_ net641 _04198_ VSS VSS VDD VDD _04199_ sky130_fd_sc_hd__nand2_1
X_18409_ u_core.u_top.u_core.acc[97] u_core.u_top.u_core.acc[98] _08921_ VSS VSS VDD VDD _04200_ sky130_fd_sc_hd__nand3_1
X_18410_ u_core.u_top.u_core.acc[97] u_core.u_top.u_core.acc[98] _08917_ VSS VSS VDD VDD _04201_ sky130_fd_sc_hd__or3_1
X_18411_ _08904_ _04200_ _04201_ _08899_ u_core.u_top.u_core.acc[99] VSS VSS VDD VDD _04202_ sky130_fd_sc_hd__o221ai_1
X_18412_ _08912_ _04200_ _04201_ _08911_ u_core.u_top.u_core.acc[99] VSS VSS VDD VDD _04203_ sky130_fd_sc_hd__a221o_1
X_18413_ _04202_ _04203_ VSS VSS VDD VDD _04204_ sky130_fd_sc_hd__nand2_1
X_18414_ u_core.u_top.u_core.acc[99] _08915_ _04204_ net670 VSS VSS VDD VDD _04205_ sky130_fd_sc_hd__o22ai_1
X_18415_ _04199_ _04205_ VSS VSS VDD VDD _04206_ sky130_fd_sc_hd__xnor2_1
X_18416_ net851 _04188_ _04206_ net787 _11221_ VSS VSS VDD VDD _1042_[99] sky130_fd_sc_hd__o221ai_1
X_18417_ _02440_ _02777_ VSS VSS VDD VDD _04207_ sky130_fd_sc_hd__nor2b_1
X_18418_ _02776_ _04207_ _03049_ VSS VSS VDD VDD _04208_ sky130_fd_sc_hd__o21ai_0
X_18419_ _03048_ _04208_ VSS VSS VDD VDD _04209_ sky130_fd_sc_hd__nand2b_1
X_18420_ _03117_ _04209_ _03116_ VSS VSS VDD VDD _04210_ sky130_fd_sc_hd__a21o_1
X_18421_ _03220_ _04210_ _03219_ VSS VSS VDD VDD _04211_ sky130_fd_sc_hd__a21o_1
X_18422_ _02836_ _04211_ _02835_ VSS VSS VDD VDD _04212_ sky130_fd_sc_hd__a21o_1
X_18423_ _03071_ _04212_ _03070_ VSS VSS VDD VDD _04213_ sky130_fd_sc_hd__a21oi_1
X_18424_ _03218_ _04213_ VSS VSS VDD VDD _04214_ sky130_fd_sc_hd__xnor2_1
X_18425_ u_core.u_top.u_core.acc_upd[98] _04214_ net641 VSS VSS VDD VDD _04215_ sky130_fd_sc_hd__mux2i_1
X_18426_ net853 _04188_ VSS VSS VDD VDD _04216_ sky130_fd_sc_hd__nand2_1
X_18428_ net787 _04215_ _04216_ net634 VSS VSS VDD VDD _1042_[98] sky130_fd_sc_hd__o211ai_1
X_18429_ _03071_ _04195_ VSS VSS VDD VDD _04218_ sky130_fd_sc_hd__xor2_1
X_18430_ u_core.u_top.u_core.acc_upd[97] _04218_ net641 VSS VSS VDD VDD _04219_ sky130_fd_sc_hd__mux2i_1
X_18431_ net851 _04188_ _04219_ net787 _11221_ VSS VSS VDD VDD _1042_[97] sky130_fd_sc_hd__o221ai_1
X_18432_ _02836_ _04211_ VSS VSS VDD VDD _04220_ sky130_fd_sc_hd__xor2_1
X_18433_ u_core.u_top.u_core.acc_upd[96] _04220_ net641 VSS VSS VDD VDD _04221_ sky130_fd_sc_hd__mux2i_1
X_18434_ net787 _04221_ _04216_ net633 VSS VSS VDD VDD _1042_[96] sky130_fd_sc_hd__o211ai_1
X_18435_ _03220_ _04193_ VSS VSS VDD VDD _04222_ sky130_fd_sc_hd__xnor2_1
X_18436_ net641 _04222_ VSS VSS VDD VDD _04223_ sky130_fd_sc_hd__nand2_1
X_18437_ u_core.u_top.u_core.acc_upd[95] net641 _04223_ VSS VSS VDD VDD _04224_ sky130_fd_sc_hd__o21ai_0
X_18438_ net787 _04224_ _04216_ net632 VSS VSS VDD VDD _1042_[95] sky130_fd_sc_hd__o211ai_1
X_18439_ _03117_ _04209_ VSS VSS VDD VDD _04225_ sky130_fd_sc_hd__xor2_1
X_18440_ u_core.u_top.u_core.acc_upd[94] _04225_ net641 VSS VSS VDD VDD _04226_ sky130_fd_sc_hd__mux2i_1
X_18441_ net851 _04188_ _04226_ net787 net631 VSS VSS VDD VDD _1042_[94] sky130_fd_sc_hd__o221ai_1
X_18442_ _03049_ _04191_ VSS VSS VDD VDD _04227_ sky130_fd_sc_hd__xnor2_1
X_18443_ net641 _04227_ VSS VSS VDD VDD _04228_ sky130_fd_sc_hd__nand2_1
X_18444_ u_core.u_top.u_core.acc_upd[93] net641 _04228_ VSS VSS VDD VDD _04229_ sky130_fd_sc_hd__o21ai_0
X_18445_ net787 _04229_ _04216_ net630 VSS VSS VDD VDD _1042_[93] sky130_fd_sc_hd__o211ai_1
X_18446_ _02440_ _02777_ VSS VSS VDD VDD _04230_ sky130_fd_sc_hd__xnor2_1
X_18447_ u_core.u_top.u_core.acc_upd[92] _04230_ net641 VSS VSS VDD VDD _04231_ sky130_fd_sc_hd__mux2i_1
X_18448_ net787 _04231_ net629 VSS VSS VDD VDD _1042_[92] sky130_fd_sc_hd__o21ai_0
X_18449_ u_core.u_top.u_core.acc_upd[91] VSS VSS VDD VDD _02438_ sky130_fd_sc_hd__inv_1
X_18450_ _02438_ _02441_ net641 VSS VSS VDD VDD _04232_ sky130_fd_sc_hd__mux2i_1
X_18451_ net776 _04232_ VSS VSS VDD VDD _04233_ sky130_fd_sc_hd__nand2_1
X_18452_ _11256_ _04233_ VSS VSS VDD VDD _1042_[91] sky130_fd_sc_hd__nand2_1
X_18453_ u_core.u_top.u_core.acc[90] _08915_ VSS VSS VDD VDD _03097_ sky130_fd_sc_hd__xnor2_1
X_18454_ _03097_ _03098_ net641 VSS VSS VDD VDD _04234_ sky130_fd_sc_hd__mux2_1
X_18455_ net787 _04234_ _11268_ VSS VSS VDD VDD _1042_[90] sky130_fd_sc_hd__o21ai_0
X_18456_ _02431_ _03199_ VSS VSS VDD VDD _04235_ sky130_fd_sc_hd__nor2b_1
X_18457_ _03262_ _04235_ _03259_ VSS VSS VDD VDD _04236_ sky130_fd_sc_hd__o21ai_0
X_18458_ _03258_ _04236_ VSS VSS VDD VDD _04237_ sky130_fd_sc_hd__nand2b_1
X_18459_ _03454_ _04237_ _03453_ VSS VSS VDD VDD _04238_ sky130_fd_sc_hd__a21o_1
X_18460_ _03040_ _04238_ _03039_ VSS VSS VDD VDD _04239_ sky130_fd_sc_hd__a21o_1
X_18461_ _02525_ _04239_ _02524_ VSS VSS VDD VDD _04240_ sky130_fd_sc_hd__a21o_1
X_18462_ _03186_ _04240_ _03185_ VSS VSS VDD VDD _04241_ sky130_fd_sc_hd__a21o_1
X_18463_ _02713_ _04241_ _02712_ VSS VSS VDD VDD _04242_ sky130_fd_sc_hd__a21o_1
X_18464_ _03264_ _04242_ _03263_ VSS VSS VDD VDD _04243_ sky130_fd_sc_hd__a21oi_1
X_18465_ _11271_ _04243_ VSS VSS VDD VDD _04244_ sky130_fd_sc_hd__xnor2_1
X_18466_ net642 _04244_ VSS VSS VDD VDD _04245_ sky130_fd_sc_hd__nand2_1
X_18467_ u_core.u_top.u_core.acc[87] u_core.u_top.u_core.acc[88] _08985_ VSS VSS VDD VDD _04246_ sky130_fd_sc_hd__nand3_1
X_18468_ u_core.u_top.u_core.acc[87] u_core.u_top.u_core.acc[88] _08981_ VSS VSS VDD VDD _04247_ sky130_fd_sc_hd__or3_1
X_18469_ _08955_ _04246_ _04247_ net692 u_core.u_top.u_core.acc[89] VSS VSS VDD VDD _04248_ sky130_fd_sc_hd__o221ai_1
X_18470_ _08984_ _04246_ _04247_ _08978_ u_core.u_top.u_core.acc[89] VSS VSS VDD VDD _04249_ sky130_fd_sc_hd__a221o_1
X_18471_ _04248_ _04249_ VSS VSS VDD VDD _04250_ sky130_fd_sc_hd__nand2_1
X_18472_ u_core.u_top.u_core.acc[89] _08970_ _04250_ net675 VSS VSS VDD VDD _04251_ sky130_fd_sc_hd__o22ai_1
X_18473_ _04245_ _04251_ VSS VSS VDD VDD _04252_ sky130_fd_sc_hd__xnor2_1
X_18474_ _03128_ _08972_ u_core.u_top.u_core.acc[84] VSS VSS VDD VDD _04253_ sky130_fd_sc_hd__o21bai_1
X_18475_ u_core.u_top.u_core.acc[86] u_core.u_top.u_core.acc[85] _04253_ u_core.u_top.u_core.acc[87] VSS VSS VDD VDD _04254_ sky130_fd_sc_hd__a31oi_1
X_18476_ u_core.u_top.u_core.acc[89] _04254_ u_core.u_top.u_core.acc[88] VSS VSS VDD VDD _04255_ sky130_fd_sc_hd__nor3b_2
X_18477_ _04255_ net853 VSS VSS VDD VDD _04256_ sky130_fd_sc_hd__nand2b_1
X_18478_ net787 _04252_ _04256_ _11221_ VSS VSS VDD VDD _1042_[89] sky130_fd_sc_hd__o211ai_1
X_18480_ _02432_ _03259_ VSS VSS VDD VDD _04258_ sky130_fd_sc_hd__nor2b_1
X_18481_ _03258_ _04258_ _03454_ VSS VSS VDD VDD _04259_ sky130_fd_sc_hd__o21ai_0
X_18482_ _03453_ _04259_ VSS VSS VDD VDD _04260_ sky130_fd_sc_hd__nand2b_1
X_18483_ _03040_ _04260_ _03039_ VSS VSS VDD VDD _04261_ sky130_fd_sc_hd__a21o_1
X_18484_ _02525_ _04261_ _02524_ VSS VSS VDD VDD _04262_ sky130_fd_sc_hd__a21o_1
X_18485_ _03186_ _04262_ _03185_ VSS VSS VDD VDD _04263_ sky130_fd_sc_hd__a21o_1
X_18486_ _02713_ _04263_ _02712_ VSS VSS VDD VDD _04264_ sky130_fd_sc_hd__a21oi_1
X_18487_ _03264_ _04264_ VSS VSS VDD VDD _04265_ sky130_fd_sc_hd__xnor2_1
X_18488_ u_core.u_top.u_core.acc_upd[88] _04265_ net642 VSS VSS VDD VDD _04266_ sky130_fd_sc_hd__mux2i_1
X_18489_ net853 _04255_ VSS VSS VDD VDD _04267_ sky130_fd_sc_hd__nand2_1
X_18490_ net787 _04266_ _04267_ _11221_ VSS VSS VDD VDD _1042_[88] sky130_fd_sc_hd__o211ai_1
X_18491_ _02713_ _04241_ VSS VSS VDD VDD _04268_ sky130_fd_sc_hd__xor2_1
X_18492_ u_core.u_top.u_core.acc_upd[87] _04268_ net642 VSS VSS VDD VDD _04269_ sky130_fd_sc_hd__mux2i_1
X_18493_ net787 _04269_ _04256_ _11221_ VSS VSS VDD VDD _1042_[87] sky130_fd_sc_hd__o211ai_1
X_18494_ _03186_ _04262_ VSS VSS VDD VDD _04270_ sky130_fd_sc_hd__xnor2_1
X_18495_ net642 _04270_ VSS VSS VDD VDD _04271_ sky130_fd_sc_hd__nand2_1
X_18496_ u_core.u_top.u_core.acc_upd[86] net642 _04271_ VSS VSS VDD VDD _04272_ sky130_fd_sc_hd__o21ai_0
X_18497_ net787 _04272_ _04267_ net633 VSS VSS VDD VDD _1042_[86] sky130_fd_sc_hd__o211ai_1
X_18499_ _02525_ _04239_ VSS VSS VDD VDD _04274_ sky130_fd_sc_hd__xnor2_1
X_18500_ net642 _04274_ VSS VSS VDD VDD _04275_ sky130_fd_sc_hd__nand2_1
X_18501_ u_core.u_top.u_core.acc_upd[85] net642 _04275_ VSS VSS VDD VDD _04276_ sky130_fd_sc_hd__o21ai_0
X_18502_ net787 _04276_ _04267_ net632 VSS VSS VDD VDD _1042_[85] sky130_fd_sc_hd__o211ai_1
X_18503_ _03040_ _04260_ VSS VSS VDD VDD _04277_ sky130_fd_sc_hd__xor2_1
X_18504_ u_core.u_top.u_core.acc_upd[84] _04277_ net642 VSS VSS VDD VDD _04278_ sky130_fd_sc_hd__mux2i_1
X_18505_ net787 _04278_ _04256_ net631 VSS VSS VDD VDD _1042_[84] sky130_fd_sc_hd__o211ai_1
X_18507_ _03454_ _04237_ VSS VSS VDD VDD _04280_ sky130_fd_sc_hd__xnor2_1
X_18508_ net642 _04280_ VSS VSS VDD VDD _04281_ sky130_fd_sc_hd__nand2_1
X_18509_ u_core.u_top.u_core.acc_upd[83] net642 _04281_ VSS VSS VDD VDD _04282_ sky130_fd_sc_hd__o21ai_0
X_18510_ net787 _04282_ _04267_ net630 VSS VSS VDD VDD _1042_[83] sky130_fd_sc_hd__o211ai_1
X_18511_ _03259_ _02432_ VSS VSS VDD VDD _04283_ sky130_fd_sc_hd__xnor2_1
X_18512_ u_core.u_top.u_core.acc_upd[82] _04283_ net642 VSS VSS VDD VDD _04284_ sky130_fd_sc_hd__mux2i_1
X_18513_ net787 _04284_ net629 VSS VSS VDD VDD _1042_[82] sky130_fd_sc_hd__o21ai_0
X_18514_ u_core.u_top.u_core.acc_upd[81] VSS VSS VDD VDD _02430_ sky130_fd_sc_hd__inv_1
X_18516_ _02430_ _02433_ net641 VSS VSS VDD VDD _04286_ sky130_fd_sc_hd__mux2_1
X_18517_ net787 _04286_ _11256_ VSS VSS VDD VDD _1042_[81] sky130_fd_sc_hd__o21ai_0
X_18518_ _02535_ _02536_ net641 VSS VSS VDD VDD _04287_ sky130_fd_sc_hd__mux2_1
X_18519_ net787 _04287_ _11268_ VSS VSS VDD VDD _1042_[80] sky130_fd_sc_hd__o21ai_0
X_18520_ _02381_ _02968_ VSS VSS VDD VDD _04288_ sky130_fd_sc_hd__nor2b_1
X_18521_ _03313_ _04288_ _03060_ VSS VSS VDD VDD _04289_ sky130_fd_sc_hd__o21ai_0
X_18522_ _03059_ _04289_ VSS VSS VDD VDD _04290_ sky130_fd_sc_hd__nand2b_1
X_18523_ _03062_ _04290_ _03061_ VSS VSS VDD VDD _04291_ sky130_fd_sc_hd__a21o_1
X_18524_ _03133_ _04291_ _03132_ VSS VSS VDD VDD _04292_ sky130_fd_sc_hd__a21o_1
X_18525_ _03142_ _04292_ _03141_ VSS VSS VDD VDD _04293_ sky130_fd_sc_hd__a21o_1
X_18526_ _02765_ _04293_ _02764_ VSS VSS VDD VDD _04294_ sky130_fd_sc_hd__a21o_1
X_18527_ _03135_ _04294_ _03134_ VSS VSS VDD VDD _04295_ sky130_fd_sc_hd__a21o_1
X_18528_ _03329_ _04295_ _03328_ VSS VSS VDD VDD _04296_ sky130_fd_sc_hd__a21oi_1
X_18529_ net882 _04296_ VSS VSS VDD VDD _04297_ sky130_fd_sc_hd__xnor2_1
X_18530_ net638 _04297_ VSS VSS VDD VDD _04298_ sky130_fd_sc_hd__nand2_1
X_18531_ _09034_ VSS VSS VDD VDD _04299_ sky130_fd_sc_hd__inv_1
X_18532_ u_core.u_top.u_core.acc[78] u_core.u_top.u_core.acc[77] _04299_ VSS VSS VDD VDD _04300_ sky130_fd_sc_hd__nand3_1
X_18533_ u_core.u_top.u_core.acc[78] u_core.u_top.u_core.acc[77] _09029_ VSS VSS VDD VDD _04301_ sky130_fd_sc_hd__or3_1
X_18534_ _04300_ _04301_ net707 VSS VSS VDD VDD _04302_ sky130_fd_sc_hd__mux2i_1
X_18535_ _04301_ _04300_ net707 VSS VSS VDD VDD _04303_ sky130_fd_sc_hd__mux2i_1
X_18536_ _0031_ _04302_ _04303_ _09037_ VSS VSS VDD VDD _04304_ sky130_fd_sc_hd__a22oi_1
X_18537_ net674 _04304_ VSS VSS VDD VDD _04305_ sky130_fd_sc_hd__nor2_1
X_18538_ u_core.u_top.u_core.acc[79] _04305_ VSS VSS VDD VDD _04306_ sky130_fd_sc_hd__xnor2_1
X_18539_ _04298_ _04306_ VSS VSS VDD VDD _04307_ sky130_fd_sc_hd__xnor2_1
X_18540_ _02879_ _09031_ _09016_ VSS VSS VDD VDD _04308_ sky130_fd_sc_hd__o21ai_0
X_18541_ u_core.u_top.u_core.acc[75] u_core.u_top.u_core.acc[76] _04308_ u_core.u_top.u_core.acc[77] VSS VSS VDD VDD _04309_ sky130_fd_sc_hd__a31oi_1
X_18542_ _09011_ u_core.u_top.u_core.acc[79] _04309_ VSS VSS VDD VDD _04310_ sky130_fd_sc_hd__nor3_1
X_18543_ net786 _04307_ _04310_ net851 net635 VSS VSS VDD VDD _1042_[79] sky130_fd_sc_hd__o221ai_1
X_18544_ _02382_ _03060_ VSS VSS VDD VDD _04311_ sky130_fd_sc_hd__nor2b_1
X_18545_ _03059_ _04311_ _03062_ VSS VSS VDD VDD _04312_ sky130_fd_sc_hd__o21ai_0
X_18546_ _03061_ _04312_ VSS VSS VDD VDD _04313_ sky130_fd_sc_hd__nand2b_1
X_18547_ _03133_ _04313_ _03132_ VSS VSS VDD VDD _04314_ sky130_fd_sc_hd__a21o_1
X_18548_ _03142_ _04314_ _03141_ VSS VSS VDD VDD _04315_ sky130_fd_sc_hd__a21o_1
X_18549_ _02765_ _04315_ _02764_ VSS VSS VDD VDD _04316_ sky130_fd_sc_hd__a21o_1
X_18550_ _03135_ _04316_ _03134_ VSS VSS VDD VDD _04317_ sky130_fd_sc_hd__a21oi_1
X_18551_ _03329_ _04317_ VSS VSS VDD VDD _04318_ sky130_fd_sc_hd__xor2_1
X_18552_ net638 _04318_ VSS VSS VDD VDD _04319_ sky130_fd_sc_hd__nand2_1
X_18553_ u_core.u_top.u_core.acc_upd[78] net638 _04319_ VSS VSS VDD VDD _04320_ sky130_fd_sc_hd__o21ai_0
X_18554_ net853 _04310_ VSS VSS VDD VDD _04321_ sky130_fd_sc_hd__nand2_1
X_18555_ net786 _04320_ _04321_ net635 VSS VSS VDD VDD _1042_[78] sky130_fd_sc_hd__o211ai_1
X_18556_ _03135_ _04294_ VSS VSS VDD VDD _04322_ sky130_fd_sc_hd__xnor2_1
X_18557_ net638 _04322_ VSS VSS VDD VDD _04323_ sky130_fd_sc_hd__nand2_1
X_18558_ u_core.u_top.u_core.acc_upd[77] net638 _04323_ VSS VSS VDD VDD _04324_ sky130_fd_sc_hd__o21ai_0
X_18559_ net851 _04310_ _04324_ net786 net635 VSS VSS VDD VDD _1042_[77] sky130_fd_sc_hd__o221ai_1
X_18560_ _02765_ _04315_ VSS VSS VDD VDD _04325_ sky130_fd_sc_hd__xnor2_1
X_18561_ net638 _04325_ VSS VSS VDD VDD _04326_ sky130_fd_sc_hd__nand2_1
X_18562_ u_core.u_top.u_core.acc_upd[76] net638 _04326_ VSS VSS VDD VDD _04327_ sky130_fd_sc_hd__o21ai_0
X_18563_ net786 _04327_ _04321_ net633 VSS VSS VDD VDD _1042_[76] sky130_fd_sc_hd__o211ai_1
X_18564_ _03142_ _04292_ VSS VSS VDD VDD _04328_ sky130_fd_sc_hd__xor2_1
X_18566_ u_core.u_top.u_core.acc_upd[75] _04328_ net638 VSS VSS VDD VDD _04330_ sky130_fd_sc_hd__mux2i_1
X_18567_ net786 _04330_ _04321_ net632 VSS VSS VDD VDD _1042_[75] sky130_fd_sc_hd__o211ai_1
X_18568_ _03133_ _04313_ VSS VSS VDD VDD _04331_ sky130_fd_sc_hd__xor2_1
X_18569_ u_core.u_top.u_core.acc_upd[74] _04331_ net638 VSS VSS VDD VDD _04332_ sky130_fd_sc_hd__mux2i_1
X_18570_ net851 _04310_ _04332_ net786 net631 VSS VSS VDD VDD _1042_[74] sky130_fd_sc_hd__o221ai_1
X_18571_ _03062_ _04290_ VSS VSS VDD VDD _04333_ sky130_fd_sc_hd__xnor2_1
X_18572_ net638 _04333_ VSS VSS VDD VDD _04334_ sky130_fd_sc_hd__nand2_1
X_18573_ u_core.u_top.u_core.acc_upd[73] net638 _04334_ VSS VSS VDD VDD _04335_ sky130_fd_sc_hd__o21ai_0
X_18574_ net786 _04335_ _04321_ net630 VSS VSS VDD VDD _1042_[73] sky130_fd_sc_hd__o211ai_1
X_18575_ _03060_ _02382_ VSS VSS VDD VDD _04336_ sky130_fd_sc_hd__xnor2_1
X_18576_ u_core.u_top.u_core.acc_upd[72] _04336_ net638 VSS VSS VDD VDD _04337_ sky130_fd_sc_hd__mux2i_1
X_18577_ net786 _04337_ _11254_ VSS VSS VDD VDD _1042_[72] sky130_fd_sc_hd__o21ai_0
X_18578_ u_core.u_top.u_core.acc_upd[71] VSS VSS VDD VDD _02380_ sky130_fd_sc_hd__inv_1
X_18579_ _02380_ _02383_ net638 VSS VSS VDD VDD _04338_ sky130_fd_sc_hd__mux2i_1
X_18580_ net776 _04338_ VSS VSS VDD VDD _04339_ sky130_fd_sc_hd__nand2_1
X_18581_ _11256_ _04339_ VSS VSS VDD VDD _1042_[71] sky130_fd_sc_hd__nand2_1
X_18582_ u_core.u_top.u_core.acc[70] _09049_ VSS VSS VDD VDD _03330_ sky130_fd_sc_hd__xnor2_1
X_18583_ _03330_ _03331_ net638 VSS VSS VDD VDD _04340_ sky130_fd_sc_hd__mux2_1
X_18584_ net786 _04340_ _11268_ VSS VSS VDD VDD _1042_[70] sky130_fd_sc_hd__o21ai_0
X_18586_ _02478_ _02793_ VSS VSS VDD VDD _04342_ sky130_fd_sc_hd__nor2b_1
X_18587_ _02792_ _04342_ _02487_ VSS VSS VDD VDD _04343_ sky130_fd_sc_hd__o21ai_0
X_18588_ _02486_ _04343_ VSS VSS VDD VDD _04344_ sky130_fd_sc_hd__nand2b_1
X_18589_ _03384_ _04344_ _03383_ VSS VSS VDD VDD _04345_ sky130_fd_sc_hd__a21o_1
X_18590_ _03310_ _04345_ _03309_ VSS VSS VDD VDD _04346_ sky130_fd_sc_hd__a21o_1
X_18591_ _03353_ _04346_ _03352_ VSS VSS VDD VDD _04347_ sky130_fd_sc_hd__a21o_1
X_18592_ _02789_ _04347_ _02788_ VSS VSS VDD VDD _04348_ sky130_fd_sc_hd__a21o_1
X_18593_ _03312_ _04348_ _03311_ VSS VSS VDD VDD _04349_ sky130_fd_sc_hd__a21o_1
X_18594_ _03198_ _04349_ _03197_ VSS VSS VDD VDD _04350_ sky130_fd_sc_hd__a21oi_1
X_18595_ net881 _04350_ VSS VSS VDD VDD _04351_ sky130_fd_sc_hd__xnor2_1
X_18596_ net640 _04351_ VSS VSS VDD VDD _04352_ sky130_fd_sc_hd__nand2_1
X_18597_ u_core.u_top.u_core.acc[68] net959 _09091_ VSS VSS VDD VDD _04353_ sky130_fd_sc_hd__or3_1
X_18598_ _09095_ VSS VSS VDD VDD _04354_ sky130_fd_sc_hd__inv_1
X_18599_ u_core.u_top.u_core.acc[68] net959 _04354_ VSS VSS VDD VDD _04355_ sky130_fd_sc_hd__nand3_1
X_18600_ _04353_ _04355_ net708 VSS VSS VDD VDD _04356_ sky130_fd_sc_hd__mux2i_1
X_18601_ _04355_ _04353_ net708 VSS VSS VDD VDD _04357_ sky130_fd_sc_hd__mux2i_1
X_18602_ _09070_ _04356_ _04357_ _0020_ VSS VSS VDD VDD _04358_ sky130_fd_sc_hd__a22oi_1
X_18603_ net673 _04358_ VSS VSS VDD VDD _04359_ sky130_fd_sc_hd__nor2_1
X_18604_ u_core.u_top.u_core.acc[69] _04359_ VSS VSS VDD VDD _04360_ sky130_fd_sc_hd__xnor2_1
X_18605_ _04352_ _04360_ VSS VSS VDD VDD _04361_ sky130_fd_sc_hd__xnor2_1
X_18606_ _02708_ _09092_ net960 VSS VSS VDD VDD _04362_ sky130_fd_sc_hd__o21bai_1
X_18607_ u_core.u_top.u_core.acc[66] u_core.u_top.u_core.acc[65] _04362_ net959 VSS VSS VDD VDD _04363_ sky130_fd_sc_hd__a31oi_1
X_18608_ u_core.u_top.u_core.acc[69] _04363_ u_core.u_top.u_core.acc[68] VSS VSS VDD VDD _04364_ sky130_fd_sc_hd__nor3b_1
X_18609_ net727 net853 VSS VSS VDD VDD _04365_ sky130_fd_sc_hd__nand2b_1
X_18610_ net784 _04361_ _04365_ net634 VSS VSS VDD VDD _1042_[69] sky130_fd_sc_hd__o211ai_1
X_18611_ _02479_ _02487_ VSS VSS VDD VDD _04366_ sky130_fd_sc_hd__nor2b_1
X_18612_ _02486_ _04366_ _03384_ VSS VSS VDD VDD _04367_ sky130_fd_sc_hd__o21ai_0
X_18613_ _03383_ _04367_ VSS VSS VDD VDD _04368_ sky130_fd_sc_hd__nand2b_1
X_18614_ _03310_ _04368_ _03309_ VSS VSS VDD VDD _04369_ sky130_fd_sc_hd__a21o_1
X_18615_ _03353_ _04369_ _03352_ VSS VSS VDD VDD _04370_ sky130_fd_sc_hd__a21o_1
X_18616_ _02789_ _04370_ _02788_ VSS VSS VDD VDD _04371_ sky130_fd_sc_hd__a21o_1
X_18617_ _03312_ _04371_ _03311_ VSS VSS VDD VDD _04372_ sky130_fd_sc_hd__a21oi_1
X_18618_ _03198_ _04372_ VSS VSS VDD VDD _04373_ sky130_fd_sc_hd__xnor2_1
X_18619_ u_core.u_top.u_core.acc_upd[68] _04373_ net640 VSS VSS VDD VDD _04374_ sky130_fd_sc_hd__mux2i_1
X_18620_ net852 net727 VSS VSS VDD VDD _04375_ sky130_fd_sc_hd__nand2_1
X_18621_ net784 _04374_ _04375_ net634 VSS VSS VDD VDD _1042_[68] sky130_fd_sc_hd__o211ai_1
X_18622_ _03312_ _04348_ VSS VSS VDD VDD _04376_ sky130_fd_sc_hd__xor2_1
X_18623_ u_core.u_top.u_core.acc_upd[67] _04376_ net640 VSS VSS VDD VDD _04377_ sky130_fd_sc_hd__mux2i_1
X_18624_ net784 _04377_ _04365_ net634 VSS VSS VDD VDD _1042_[67] sky130_fd_sc_hd__o211ai_1
X_18625_ _02789_ _04370_ VSS VSS VDD VDD _04378_ sky130_fd_sc_hd__xor2_1
X_18626_ u_core.u_top.u_core.acc_upd[66] _04378_ net640 VSS VSS VDD VDD _04379_ sky130_fd_sc_hd__mux2i_1
X_18627_ net784 _04379_ _04375_ _11237_ VSS VSS VDD VDD _1042_[66] sky130_fd_sc_hd__o211ai_1
X_18628_ _03353_ _04346_ VSS VSS VDD VDD _04380_ sky130_fd_sc_hd__xnor2_1
X_18629_ net640 _04380_ VSS VSS VDD VDD _04381_ sky130_fd_sc_hd__nand2_1
X_18630_ u_core.u_top.u_core.acc_upd[65] net640 _04381_ VSS VSS VDD VDD _04382_ sky130_fd_sc_hd__o21ai_0
X_18631_ net784 _04382_ _04375_ _11240_ VSS VSS VDD VDD _1042_[65] sky130_fd_sc_hd__o211ai_1
X_18632_ _03310_ _04368_ VSS VSS VDD VDD _04383_ sky130_fd_sc_hd__xor2_1
X_18633_ u_core.u_top.u_core.acc_upd[64] _04383_ net640 VSS VSS VDD VDD _04384_ sky130_fd_sc_hd__mux2i_1
X_18634_ net784 _04384_ _04365_ _11243_ VSS VSS VDD VDD _1042_[64] sky130_fd_sc_hd__o211ai_1
X_18635_ _03384_ _04344_ VSS VSS VDD VDD _04385_ sky130_fd_sc_hd__xnor2_1
X_18636_ net640 _04385_ VSS VSS VDD VDD _04386_ sky130_fd_sc_hd__nand2_1
X_18637_ u_core.u_top.u_core.acc_upd[63] net640 _04386_ VSS VSS VDD VDD _04387_ sky130_fd_sc_hd__o21ai_0
X_18638_ net784 _04387_ _04375_ _11249_ VSS VSS VDD VDD _1042_[63] sky130_fd_sc_hd__o211ai_1
X_18639_ _02487_ _02479_ VSS VSS VDD VDD _04388_ sky130_fd_sc_hd__xnor2_1
X_18640_ u_core.u_top.u_core.acc_upd[62] _04388_ net640 VSS VSS VDD VDD _04389_ sky130_fd_sc_hd__mux2i_1
X_18641_ net784 _04389_ _11254_ VSS VSS VDD VDD _1042_[62] sky130_fd_sc_hd__o21ai_0
X_18642_ _02477_ _02480_ net640 VSS VSS VDD VDD _04390_ sky130_fd_sc_hd__mux2i_1
X_18643_ net776 _04390_ VSS VSS VDD VDD _04391_ sky130_fd_sc_hd__nand2_1
X_18644_ _11256_ _04391_ VSS VSS VDD VDD _1042_[61] sky130_fd_sc_hd__nand2_1
X_18646_ u_core.u_top.u_core.acc[60] _09087_ VSS VSS VDD VDD _03356_ sky130_fd_sc_hd__xnor2_1
X_18647_ _03356_ _03357_ net640 VSS VSS VDD VDD _04393_ sky130_fd_sc_hd__mux2_1
X_18648_ net784 _04393_ _11268_ VSS VSS VDD VDD _1042_[60] sky130_fd_sc_hd__o21ai_0
X_18649_ _02350_ _02834_ VSS VSS VDD VDD _04394_ sky130_fd_sc_hd__nor2b_1
X_18650_ _03184_ _04394_ _03361_ VSS VSS VDD VDD _04395_ sky130_fd_sc_hd__o21ai_0
X_18651_ _03360_ _04395_ VSS VSS VDD VDD _04396_ sky130_fd_sc_hd__nand2b_1
X_18652_ _03032_ _04396_ _03031_ VSS VSS VDD VDD _04397_ sky130_fd_sc_hd__a21o_1
X_18653_ _02738_ _04397_ _02737_ VSS VSS VDD VDD _04398_ sky130_fd_sc_hd__a21o_1
X_18654_ _03404_ _04398_ _03403_ VSS VSS VDD VDD _04399_ sky130_fd_sc_hd__a21o_1
X_18655_ _02639_ _04399_ _02638_ VSS VSS VDD VDD _04400_ sky130_fd_sc_hd__a21o_1
X_18656_ _03327_ _04400_ _03326_ VSS VSS VDD VDD _04401_ sky130_fd_sc_hd__a21o_1
X_18657_ _03336_ _04401_ _03335_ VSS VSS VDD VDD _04402_ sky130_fd_sc_hd__a21oi_1
X_18658_ net882 _04402_ VSS VSS VDD VDD _04403_ sky130_fd_sc_hd__xnor2_1
X_18659_ net642 _04403_ VSS VSS VDD VDD _04404_ sky130_fd_sc_hd__nand2_1
X_18660_ u_core.u_top.u_core.acc[57] u_core.u_top.u_core.acc[58] _09142_ VSS VSS VDD VDD _04405_ sky130_fd_sc_hd__nand3_1
X_18661_ u_core.u_top.u_core.acc[57] u_core.u_top.u_core.acc[58] VSS VSS VDD VDD _04406_ sky130_fd_sc_hd__nor2_1
X_18662_ _09147_ _04406_ VSS VSS VDD VDD _04407_ sky130_fd_sc_hd__nand2_1
X_18663_ _04405_ _04407_ net707 VSS VSS VDD VDD _04408_ sky130_fd_sc_hd__mux2i_1
X_18664_ _04407_ _04405_ net707 VSS VSS VDD VDD _04409_ sky130_fd_sc_hd__mux2i_1
X_18665_ _0434_ _04408_ _04409_ _09135_ VSS VSS VDD VDD _04410_ sky130_fd_sc_hd__a22oi_1
X_18666_ net674 _04410_ VSS VSS VDD VDD _04411_ sky130_fd_sc_hd__nor2_1
X_18667_ u_core.u_top.u_core.acc[59] _04411_ VSS VSS VDD VDD _04412_ sky130_fd_sc_hd__xnor2_1
X_18668_ _04404_ _04412_ VSS VSS VDD VDD _04413_ sky130_fd_sc_hd__xnor2_1
X_18669_ u_core.u_top.u_core.acc[57] u_core.u_top.u_core.acc[58] VSS VSS VDD VDD _04414_ sky130_fd_sc_hd__nand2_1
X_18670_ u_core.u_top.u_core.acc[57] u_core.u_top.u_core.acc[59] _09140_ u_core.u_top.u_core.acc[58] VSS VSS VDD VDD _04415_ sky130_fd_sc_hd__or4b_2
X_18671_ _04415_ VSS VSS VDD VDD _04416_ sky130_fd_sc_hd__inv_1
X_18672_ u_core.u_top.u_core.acc[57] u_core.u_top.u_core.acc[58] _09129_ VSS VSS VDD VDD _04417_ sky130_fd_sc_hd__a21oi_1
X_18673_ _02847_ _09129_ _04416_ _04417_ VSS VSS VDD VDD _04418_ sky130_fd_sc_hd__a31oi_1
X_18674_ u_core.u_top.u_core.acc[54] _04418_ VSS VSS VDD VDD _04419_ sky130_fd_sc_hd__nor2_1
X_18675_ _04414_ _04415_ _04419_ u_core.u_top.u_core.acc[59] VSS VSS VDD VDD _04420_ sky130_fd_sc_hd__a211oi_1
X_18676_ net851 _04420_ VSS VSS VDD VDD _04421_ sky130_fd_sc_hd__nor2_1
X_18677_ net647 _04421_ VSS VSS VDD VDD _04422_ sky130_fd_sc_hd__nor2_1
X_18678_ net784 _04413_ _04422_ VSS VSS VDD VDD _1042_[59] sky130_fd_sc_hd__o21ai_0
X_18679_ _02351_ _03361_ VSS VSS VDD VDD _04423_ sky130_fd_sc_hd__nor2b_1
X_18680_ _03360_ _04423_ _03032_ VSS VSS VDD VDD _04424_ sky130_fd_sc_hd__o21ai_0
X_18681_ _03031_ _04424_ VSS VSS VDD VDD _04425_ sky130_fd_sc_hd__nand2b_1
X_18682_ _02738_ _04425_ _02737_ VSS VSS VDD VDD _04426_ sky130_fd_sc_hd__a21o_1
X_18683_ _03404_ _04426_ _03403_ VSS VSS VDD VDD _04427_ sky130_fd_sc_hd__a21o_1
X_18684_ _02639_ _04427_ _02638_ VSS VSS VDD VDD _04428_ sky130_fd_sc_hd__a21o_1
X_18685_ _03327_ _04428_ _03326_ VSS VSS VDD VDD _04429_ sky130_fd_sc_hd__a21oi_1
X_18686_ _03336_ _04429_ VSS VSS VDD VDD _04430_ sky130_fd_sc_hd__xor2_1
X_18687_ net642 _04430_ VSS VSS VDD VDD _04431_ sky130_fd_sc_hd__nand2_1
X_18688_ u_core.u_top.u_core.acc_upd[58] net642 _04431_ VSS VSS VDD VDD _04432_ sky130_fd_sc_hd__o21ai_0
X_18689_ net853 _04420_ VSS VSS VDD VDD _04433_ sky130_fd_sc_hd__nand2_1
X_18690_ net785 _04432_ _04433_ net635 VSS VSS VDD VDD _1042_[58] sky130_fd_sc_hd__o211ai_1
X_18691_ _03327_ _04400_ VSS VSS VDD VDD _04434_ sky130_fd_sc_hd__xor2_1
X_18692_ u_core.u_top.u_core.acc_upd[57] _04434_ net642 VSS VSS VDD VDD _04435_ sky130_fd_sc_hd__mux2i_1
X_18693_ net784 _04435_ _04422_ VSS VSS VDD VDD _1042_[57] sky130_fd_sc_hd__o21ai_1
X_18694_ _02639_ _04427_ VSS VSS VDD VDD _04436_ sky130_fd_sc_hd__xnor2_1
X_18695_ net642 _04436_ VSS VSS VDD VDD _04437_ sky130_fd_sc_hd__nand2_1
X_18696_ u_core.u_top.u_core.acc_upd[56] net642 _04437_ VSS VSS VDD VDD _04438_ sky130_fd_sc_hd__o21ai_0
X_18697_ net785 _04438_ _04433_ net633 VSS VSS VDD VDD _1042_[56] sky130_fd_sc_hd__o211ai_1
X_18698_ _03404_ _04398_ VSS VSS VDD VDD _04439_ sky130_fd_sc_hd__xnor2_1
X_18699_ net642 _04439_ VSS VSS VDD VDD _04440_ sky130_fd_sc_hd__nand2_1
X_18700_ u_core.u_top.u_core.acc_upd[55] net642 _04440_ VSS VSS VDD VDD _04441_ sky130_fd_sc_hd__o21ai_0
X_18701_ net785 _04441_ _04433_ net632 VSS VSS VDD VDD _1042_[55] sky130_fd_sc_hd__o211ai_1
X_18702_ _02738_ _04425_ VSS VSS VDD VDD _04442_ sky130_fd_sc_hd__xnor2_1
X_18703_ net642 _04442_ VSS VSS VDD VDD _04443_ sky130_fd_sc_hd__nand2_1
X_18704_ u_core.u_top.u_core.acc_upd[54] net642 _04443_ VSS VSS VDD VDD _04444_ sky130_fd_sc_hd__o21ai_0
X_18705_ net851 _04420_ _04444_ net784 net631 VSS VSS VDD VDD _1042_[54] sky130_fd_sc_hd__o221ai_1
X_18708_ _03032_ _04396_ VSS VSS VDD VDD _04447_ sky130_fd_sc_hd__xnor2_1
X_18709_ net642 _04447_ VSS VSS VDD VDD _04448_ sky130_fd_sc_hd__nand2_1
X_18710_ u_core.u_top.u_core.acc_upd[53] net642 _04448_ VSS VSS VDD VDD _04449_ sky130_fd_sc_hd__o21ai_0
X_18711_ net784 _04449_ _04433_ net630 VSS VSS VDD VDD _1042_[53] sky130_fd_sc_hd__o211ai_1
X_18712_ _02351_ _03361_ VSS VSS VDD VDD _04450_ sky130_fd_sc_hd__xnor2_1
X_18713_ u_core.u_top.u_core.acc_upd[52] _04450_ net642 VSS VSS VDD VDD _04451_ sky130_fd_sc_hd__mux2i_1
X_18714_ net784 _04451_ net629 VSS VSS VDD VDD _1042_[52] sky130_fd_sc_hd__o21ai_0
X_18715_ _02352_ net642 VSS VSS VDD VDD _04452_ sky130_fd_sc_hd__nand2_1
X_18716_ u_core.u_top.u_core.acc_upd[51] net642 _04452_ VSS VSS VDD VDD _04453_ sky130_fd_sc_hd__o21ai_0
X_18717_ net784 _04453_ _11256_ VSS VSS VDD VDD _1042_[51] sky130_fd_sc_hd__o21ai_0
X_18718_ _03437_ _03438_ net642 VSS VSS VDD VDD _04454_ sky130_fd_sc_hd__mux2_1
X_18719_ net784 _04454_ _11268_ VSS VSS VDD VDD _1042_[50] sky130_fd_sc_hd__o21ai_0
X_18720_ _02469_ _03266_ VSS VSS VDD VDD _04455_ sky130_fd_sc_hd__nor2b_1
X_18721_ _03265_ _04455_ _02886_ VSS VSS VDD VDD _04456_ sky130_fd_sc_hd__o21ai_0
X_18722_ _02885_ _04456_ VSS VSS VDD VDD _04457_ sky130_fd_sc_hd__nand2b_1
X_18723_ _02933_ _04457_ _02932_ VSS VSS VDD VDD _04458_ sky130_fd_sc_hd__a21o_1
X_18724_ _02920_ _04458_ _02919_ VSS VSS VDD VDD _04459_ sky130_fd_sc_hd__a21o_1
X_18725_ _03115_ _04459_ _03114_ VSS VSS VDD VDD _04460_ sky130_fd_sc_hd__a21o_1
X_18726_ _03451_ _04460_ _03450_ VSS VSS VDD VDD _04461_ sky130_fd_sc_hd__a21o_1
X_18727_ _03449_ _04461_ _03448_ VSS VSS VDD VDD _04462_ sky130_fd_sc_hd__a21o_1
X_18728_ _03290_ _04462_ _03289_ VSS VSS VDD VDD _04463_ sky130_fd_sc_hd__a21oi_1
X_18729_ net881 _04463_ VSS VSS VDD VDD _04464_ sky130_fd_sc_hd__xnor2_1
X_18730_ net637 _04464_ VSS VSS VDD VDD _04465_ sky130_fd_sc_hd__nand2_1
X_18731_ u_core.u_top.u_core.acc[48] u_core.u_top.u_core.acc[47] _09202_ VSS VSS VDD VDD _04466_ sky130_fd_sc_hd__or3_1
X_18732_ u_core.u_top.u_core.acc[48] u_core.u_top.u_core.acc[47] _09200_ VSS VSS VDD VDD _04467_ sky130_fd_sc_hd__nand3_1
X_18733_ _04466_ _04467_ net708 VSS VSS VDD VDD _04468_ sky130_fd_sc_hd__mux2i_1
X_18734_ _04467_ _04466_ net708 VSS VSS VDD VDD _04469_ sky130_fd_sc_hd__mux2i_1
X_18735_ _09207_ _04468_ _04469_ net841 VSS VSS VDD VDD _04470_ sky130_fd_sc_hd__a22oi_1
X_18736_ net673 _04470_ VSS VSS VDD VDD _04471_ sky130_fd_sc_hd__nor2_1
X_18737_ u_core.u_top.u_core.acc[49] _04471_ VSS VSS VDD VDD _04472_ sky130_fd_sc_hd__xnor2_1
X_18738_ _04465_ _04472_ VSS VSS VDD VDD _04473_ sky130_fd_sc_hd__xnor2_1
X_18739_ _03441_ u_core.u_top.u_core.acc[42] u_core.u_top.u_core.acc[43] VSS VSS VDD VDD _04474_ sky130_fd_sc_hd__nand3b_1
X_18740_ _09180_ _04474_ _09197_ VSS VSS VDD VDD _04475_ sky130_fd_sc_hd__a21oi_1
X_18741_ u_core.u_top.u_core.acc[47] _04475_ VSS VSS VDD VDD _04476_ sky130_fd_sc_hd__nor2_1
X_18742_ u_core.u_top.u_core.acc[49] _04476_ u_core.u_top.u_core.acc[48] VSS VSS VDD VDD _04477_ sky130_fd_sc_hd__nor3b_1
X_18743_ net718 net852 VSS VSS VDD VDD _04478_ sky130_fd_sc_hd__nand2b_1
X_18744_ net783 _04473_ _04478_ net634 VSS VSS VDD VDD _1042_[49] sky130_fd_sc_hd__o211ai_1
X_18746_ _02470_ _02886_ VSS VSS VDD VDD _04480_ sky130_fd_sc_hd__nor2b_1
X_18747_ _02885_ _04480_ _02933_ VSS VSS VDD VDD _04481_ sky130_fd_sc_hd__o21ai_0
X_18748_ _02932_ _04481_ VSS VSS VDD VDD _04482_ sky130_fd_sc_hd__nand2b_1
X_18749_ _02920_ _04482_ _02919_ VSS VSS VDD VDD _04483_ sky130_fd_sc_hd__a21o_1
X_18750_ _03115_ _04483_ _03114_ VSS VSS VDD VDD _04484_ sky130_fd_sc_hd__a21o_1
X_18751_ _03451_ _04484_ _03450_ VSS VSS VDD VDD _04485_ sky130_fd_sc_hd__a21o_1
X_18752_ _03449_ _04485_ _03448_ VSS VSS VDD VDD _04486_ sky130_fd_sc_hd__a21oi_1
X_18753_ _03290_ _04486_ VSS VSS VDD VDD _04487_ sky130_fd_sc_hd__xor2_1
X_18754_ net637 _04487_ VSS VSS VDD VDD _04488_ sky130_fd_sc_hd__nand2_1
X_18755_ u_core.u_top.u_core.acc_upd[48] net637 _04488_ VSS VSS VDD VDD _04489_ sky130_fd_sc_hd__o21ai_0
X_18756_ net852 net718 VSS VSS VDD VDD _04490_ sky130_fd_sc_hd__nand2_1
X_18758_ net783 _04489_ _04490_ net634 VSS VSS VDD VDD _1042_[48] sky130_fd_sc_hd__o211ai_1
X_18759_ _03449_ _04461_ VSS VSS VDD VDD _04492_ sky130_fd_sc_hd__xnor2_1
X_18760_ net637 _04492_ VSS VSS VDD VDD _04493_ sky130_fd_sc_hd__nand2_1
X_18761_ u_core.u_top.u_core.acc_upd[47] net637 _04493_ VSS VSS VDD VDD _04494_ sky130_fd_sc_hd__o21ai_0
X_18762_ net783 _04494_ _04478_ net634 VSS VSS VDD VDD _1042_[47] sky130_fd_sc_hd__o211ai_1
X_18763_ _03451_ _04484_ VSS VSS VDD VDD _04495_ sky130_fd_sc_hd__xor2_1
X_18764_ u_core.u_top.u_core.acc_upd[46] _04495_ net637 VSS VSS VDD VDD _04496_ sky130_fd_sc_hd__mux2i_1
X_18765_ net783 _04496_ _04490_ _11237_ VSS VSS VDD VDD _1042_[46] sky130_fd_sc_hd__o211ai_1
X_18766_ _03115_ _04459_ VSS VSS VDD VDD _04497_ sky130_fd_sc_hd__xnor2_1
X_18767_ net637 _04497_ VSS VSS VDD VDD _04498_ sky130_fd_sc_hd__nand2_1
X_18768_ u_core.u_top.u_core.acc_upd[45] net637 _04498_ VSS VSS VDD VDD _04499_ sky130_fd_sc_hd__o21ai_0
X_18769_ net783 _04499_ _04490_ _11240_ VSS VSS VDD VDD _1042_[45] sky130_fd_sc_hd__o211ai_1
X_18770_ _02920_ _04482_ VSS VSS VDD VDD _04500_ sky130_fd_sc_hd__xnor2_1
X_18771_ net637 _04500_ VSS VSS VDD VDD _04501_ sky130_fd_sc_hd__nand2_1
X_18772_ u_core.u_top.u_core.acc_upd[44] net637 _04501_ VSS VSS VDD VDD _04502_ sky130_fd_sc_hd__o21ai_0
X_18773_ net783 _04502_ _04478_ _11243_ VSS VSS VDD VDD _1042_[44] sky130_fd_sc_hd__o211ai_1
X_18774_ _02933_ _04457_ VSS VSS VDD VDD _04503_ sky130_fd_sc_hd__xnor2_1
X_18775_ net637 _04503_ VSS VSS VDD VDD _04504_ sky130_fd_sc_hd__nand2_1
X_18776_ u_core.u_top.u_core.acc_upd[43] net637 _04504_ VSS VSS VDD VDD _04505_ sky130_fd_sc_hd__o21ai_0
X_18777_ net783 _04505_ _04490_ _11249_ VSS VSS VDD VDD _1042_[43] sky130_fd_sc_hd__o211ai_1
X_18778_ _02886_ _02470_ VSS VSS VDD VDD _04506_ sky130_fd_sc_hd__xnor2_1
X_18779_ u_core.u_top.u_core.acc_upd[42] _04506_ net637 VSS VSS VDD VDD _04507_ sky130_fd_sc_hd__mux2i_1
X_18780_ net783 _04507_ _11254_ VSS VSS VDD VDD _1042_[42] sky130_fd_sc_hd__o21ai_0
X_18781_ _02471_ net637 VSS VSS VDD VDD _04508_ sky130_fd_sc_hd__nand2_1
X_18782_ u_core.u_top.u_core.acc_upd[41] net637 _04508_ VSS VSS VDD VDD _04509_ sky130_fd_sc_hd__o21ai_0
X_18783_ net783 _04509_ _11256_ VSS VSS VDD VDD _1042_[41] sky130_fd_sc_hd__o21ai_0
X_18784_ u_core.u_top.u_core.acc[40] _09219_ VSS VSS VDD VDD _03037_ sky130_fd_sc_hd__xnor2_1
X_18785_ _03037_ _03038_ net637 VSS VSS VDD VDD _04510_ sky130_fd_sc_hd__mux2_1
X_18786_ net783 _04510_ _11268_ VSS VSS VDD VDD _1042_[40] sky130_fd_sc_hd__o21ai_0
X_18787_ _02482_ _02510_ VSS VSS VDD VDD _04511_ sky130_fd_sc_hd__nor2b_1
X_18788_ _02509_ _04511_ _02997_ VSS VSS VDD VDD _04512_ sky130_fd_sc_hd__o21ai_0
X_18789_ _02996_ _04512_ VSS VSS VDD VDD _04513_ sky130_fd_sc_hd__nand2b_1
X_18790_ _03051_ _04513_ _03050_ VSS VSS VDD VDD _04514_ sky130_fd_sc_hd__a21o_1
X_18791_ _02514_ _04514_ _02513_ VSS VSS VDD VDD _04515_ sky130_fd_sc_hd__a21o_1
X_18792_ _03306_ _04515_ _03305_ VSS VSS VDD VDD _04516_ sky130_fd_sc_hd__a21o_1
X_18793_ _03209_ _04516_ _03208_ VSS VSS VDD VDD _04517_ sky130_fd_sc_hd__a21o_1
X_18794_ _03188_ _04517_ _03187_ VSS VSS VDD VDD _04518_ sky130_fd_sc_hd__a21o_1
X_18795_ _02823_ _04518_ _02822_ VSS VSS VDD VDD _04519_ sky130_fd_sc_hd__a21oi_1
X_18796_ _11271_ _04519_ VSS VSS VDD VDD _04520_ sky130_fd_sc_hd__xnor2_1
X_18797_ net641 _04520_ VSS VSS VDD VDD _04521_ sky130_fd_sc_hd__nand2_1
X_18798_ u_core.u_top.u_core.acc[37] u_core.u_top.u_core.acc[38] _09261_ VSS VSS VDD VDD _04522_ sky130_fd_sc_hd__or3_1
X_18799_ u_core.u_top.u_core.acc[37] u_core.u_top.u_core.acc[38] _09266_ VSS VSS VDD VDD _04523_ sky130_fd_sc_hd__nand3_1
X_18800_ _09248_ _04522_ _04523_ net689 u_core.u_top.u_core.acc[39] VSS VSS VDD VDD _04524_ sky130_fd_sc_hd__o221ai_1
X_18801_ _09256_ _04522_ _04523_ _09255_ u_core.u_top.u_core.acc[39] VSS VSS VDD VDD _04525_ sky130_fd_sc_hd__a221o_1
X_18802_ _04524_ _04525_ VSS VSS VDD VDD _04526_ sky130_fd_sc_hd__nand2_1
X_18803_ u_core.u_top.u_core.acc[39] _09259_ _04526_ net670 VSS VSS VDD VDD _04527_ sky130_fd_sc_hd__o22ai_1
X_18804_ _04521_ _04527_ VSS VSS VDD VDD _04528_ sky130_fd_sc_hd__xnor2_1
X_18805_ _02970_ u_core.u_top.u_core.acc[32] u_core.u_top.u_core.acc[33] VSS VSS VDD VDD _04529_ sky130_fd_sc_hd__nand3b_1
X_18806_ _09244_ _04529_ _09263_ VSS VSS VDD VDD _04530_ sky130_fd_sc_hd__a21oi_1
X_18807_ u_core.u_top.u_core.acc[37] _04530_ u_core.u_top.u_core.acc[38] VSS VSS VDD VDD _04531_ sky130_fd_sc_hd__o21ai_0
X_18808_ u_core.u_top.u_core.acc[39] _04531_ net853 VSS VSS VDD VDD _04532_ sky130_fd_sc_hd__o21ai_0
X_18809_ net787 _04528_ _04532_ net635 VSS VSS VDD VDD _1042_[39] sky130_fd_sc_hd__o211ai_1
X_18810_ _02483_ _02997_ VSS VSS VDD VDD _04533_ sky130_fd_sc_hd__nor2b_1
X_18811_ _02996_ _04533_ _03051_ VSS VSS VDD VDD _04534_ sky130_fd_sc_hd__o21ai_0
X_18812_ _03050_ _04534_ VSS VSS VDD VDD _04535_ sky130_fd_sc_hd__nand2b_1
X_18813_ _02514_ _04535_ _02513_ VSS VSS VDD VDD _04536_ sky130_fd_sc_hd__a21o_1
X_18814_ _03306_ _04536_ _03305_ VSS VSS VDD VDD _04537_ sky130_fd_sc_hd__a21o_1
X_18815_ _03209_ _04537_ _03208_ VSS VSS VDD VDD _04538_ sky130_fd_sc_hd__a21o_1
X_18816_ _03188_ _04538_ _03187_ VSS VSS VDD VDD _04539_ sky130_fd_sc_hd__a21oi_1
X_18817_ _02823_ _04539_ VSS VSS VDD VDD _04540_ sky130_fd_sc_hd__xnor2_1
X_18818_ u_core.u_top.u_core.acc_upd[38] _04540_ net641 VSS VSS VDD VDD _04541_ sky130_fd_sc_hd__mux2i_1
X_18819_ u_core.u_top.u_core.acc[39] _04531_ VSS VSS VDD VDD _04542_ sky130_fd_sc_hd__nor2_1
X_18820_ net853 _04542_ VSS VSS VDD VDD _04543_ sky130_fd_sc_hd__nand2_1
X_18821_ net787 _04541_ _04543_ net635 VSS VSS VDD VDD _1042_[38] sky130_fd_sc_hd__o211ai_1
X_18823_ _03188_ _04517_ VSS VSS VDD VDD _04545_ sky130_fd_sc_hd__xor2_1
X_18824_ u_core.u_top.u_core.acc_upd[37] _04545_ net641 VSS VSS VDD VDD _04546_ sky130_fd_sc_hd__mux2i_1
X_18825_ net787 _04546_ _04532_ net635 VSS VSS VDD VDD _1042_[37] sky130_fd_sc_hd__o211ai_1
X_18826_ _03209_ _04537_ VSS VSS VDD VDD _04547_ sky130_fd_sc_hd__xor2_1
X_18827_ u_core.u_top.u_core.acc_upd[36] _04547_ net641 VSS VSS VDD VDD _04548_ sky130_fd_sc_hd__mux2i_1
X_18828_ net787 _04548_ _04543_ net633 VSS VSS VDD VDD _1042_[36] sky130_fd_sc_hd__o211ai_1
X_18829_ _03306_ _04515_ VSS VSS VDD VDD _04549_ sky130_fd_sc_hd__xor2_1
X_18830_ u_core.u_top.u_core.acc_upd[35] _04549_ net641 VSS VSS VDD VDD _04550_ sky130_fd_sc_hd__mux2i_1
X_18831_ net787 _04550_ _04543_ net632 VSS VSS VDD VDD _1042_[35] sky130_fd_sc_hd__o211ai_1
X_18832_ _02514_ _04535_ VSS VSS VDD VDD _04551_ sky130_fd_sc_hd__xnor2_1
X_18833_ net641 _04551_ VSS VSS VDD VDD _04552_ sky130_fd_sc_hd__nand2_1
X_18834_ u_core.u_top.u_core.acc_upd[34] net641 _04552_ VSS VSS VDD VDD _04553_ sky130_fd_sc_hd__o21ai_0
X_18835_ net787 _04553_ _04532_ net631 VSS VSS VDD VDD _1042_[34] sky130_fd_sc_hd__o211ai_1
X_18836_ _03051_ _04513_ VSS VSS VDD VDD _04554_ sky130_fd_sc_hd__xnor2_1
X_18837_ net642 _04554_ VSS VSS VDD VDD _04555_ sky130_fd_sc_hd__nand2_1
X_18838_ u_core.u_top.u_core.acc_upd[33] net642 _04555_ VSS VSS VDD VDD _04556_ sky130_fd_sc_hd__o21ai_0
X_18839_ net787 _04556_ _04543_ net630 VSS VSS VDD VDD _1042_[33] sky130_fd_sc_hd__o211ai_1
X_18840_ _02997_ _02483_ VSS VSS VDD VDD _04557_ sky130_fd_sc_hd__xnor2_1
X_18841_ u_core.u_top.u_core.acc_upd[32] _04557_ net642 VSS VSS VDD VDD _04558_ sky130_fd_sc_hd__mux2i_1
X_18842_ net787 _04558_ net629 VSS VSS VDD VDD _1042_[32] sky130_fd_sc_hd__o21ai_0
X_18844_ _02484_ net642 VSS VSS VDD VDD _04560_ sky130_fd_sc_hd__nand2_1
X_18845_ u_core.u_top.u_core.acc_upd[31] net642 _04560_ VSS VSS VDD VDD _04561_ sky130_fd_sc_hd__o21ai_0
X_18846_ net787 _04561_ _11256_ VSS VSS VDD VDD _1042_[31] sky130_fd_sc_hd__o21ai_0
X_18847_ u_core.u_top.u_core.acc[30] _09259_ VSS VSS VDD VDD _02902_ sky130_fd_sc_hd__xnor2_1
X_18848_ _02902_ _02903_ net641 VSS VSS VDD VDD _04562_ sky130_fd_sc_hd__mux2_1
X_18849_ net787 _04562_ _11268_ VSS VSS VDD VDD _1042_[30] sky130_fd_sc_hd__o21ai_0
X_18850_ _02373_ _02942_ VSS VSS VDD VDD _04563_ sky130_fd_sc_hd__nor2b_1
X_18851_ _03332_ _04563_ _03334_ VSS VSS VDD VDD _04564_ sky130_fd_sc_hd__o21ai_0
X_18852_ _03333_ _04564_ VSS VSS VDD VDD _04565_ sky130_fd_sc_hd__nand2b_1
X_18853_ _02905_ _04565_ _02904_ VSS VSS VDD VDD _04566_ sky130_fd_sc_hd__a21o_1
X_18854_ _02918_ _04566_ _02917_ VSS VSS VDD VDD _04567_ sky130_fd_sc_hd__a21o_1
X_18855_ _03003_ _04567_ _03002_ VSS VSS VDD VDD _04568_ sky130_fd_sc_hd__a21o_1
X_18856_ _03236_ _04568_ _03235_ VSS VSS VDD VDD _04569_ sky130_fd_sc_hd__a21o_1
X_18857_ _02993_ _04569_ _02992_ VSS VSS VDD VDD _04570_ sky130_fd_sc_hd__a21o_1
X_18858_ _02877_ _04570_ _02876_ VSS VSS VDD VDD _04571_ sky130_fd_sc_hd__a21oi_1
X_18859_ net882 _04571_ VSS VSS VDD VDD _04572_ sky130_fd_sc_hd__xnor2_1
X_18860_ net642 _04572_ VSS VSS VDD VDD _04573_ sky130_fd_sc_hd__nand2_1
X_18861_ _09301_ _09333_ VSS VSS VDD VDD _04574_ sky130_fd_sc_hd__nor2_1
X_18862_ u_core.u_top.u_core.acc[29] _04574_ VSS VSS VDD VDD _04575_ sky130_fd_sc_hd__xnor2_1
X_18863_ _09306_ _09330_ _09301_ VSS VSS VDD VDD _04576_ sky130_fd_sc_hd__nand3b_1
X_18864_ u_core.u_top.u_core.acc[29] _04576_ VSS VSS VDD VDD _04577_ sky130_fd_sc_hd__xor2_1
X_18865_ _09342_ _04575_ _04577_ _09343_ VSS VSS VDD VDD _04578_ sky130_fd_sc_hd__a22oi_1
X_18866_ u_core.u_top.u_core.acc[29] _09353_ _04578_ net675 VSS VSS VDD VDD _04579_ sky130_fd_sc_hd__o22ai_1
X_18867_ _04573_ _04579_ VSS VSS VDD VDD _04580_ sky130_fd_sc_hd__xor2_1
X_18868_ _03043_ _09321_ u_core.u_top.u_core.acc[24] VSS VSS VDD VDD _04581_ sky130_fd_sc_hd__o21bai_1
X_18869_ u_core.u_top.u_core.acc[26] u_core.u_top.u_core.acc[25] _04581_ u_core.u_top.u_core.acc[27] VSS VSS VDD VDD _04582_ sky130_fd_sc_hd__a31oi_1
X_18870_ u_core.u_top.u_core.acc[29] _09301_ _04582_ VSS VSS VDD VDD _04583_ sky130_fd_sc_hd__nor3_1
X_18871_ net851 net726 VSS VSS VDD VDD _04584_ sky130_fd_sc_hd__nor2_1
X_18872_ net776 _04580_ _04584_ net647 VSS VSS VDD VDD _1042_[29] sky130_fd_sc_hd__a211o_1
X_18873_ _02374_ _03334_ VSS VSS VDD VDD _04585_ sky130_fd_sc_hd__nor2b_1
X_18874_ _03333_ _04585_ _02905_ VSS VSS VDD VDD _04586_ sky130_fd_sc_hd__o21ai_0
X_18875_ _02904_ _04586_ VSS VSS VDD VDD _04587_ sky130_fd_sc_hd__nand2b_1
X_18876_ _02918_ _04587_ _02917_ VSS VSS VDD VDD _04588_ sky130_fd_sc_hd__a21o_1
X_18877_ _03003_ _04588_ _03002_ VSS VSS VDD VDD _04589_ sky130_fd_sc_hd__a21o_1
X_18878_ _03236_ _04589_ _03235_ VSS VSS VDD VDD _04590_ sky130_fd_sc_hd__a21o_1
X_18879_ _02993_ _04590_ _02992_ VSS VSS VDD VDD _04591_ sky130_fd_sc_hd__a21oi_1
X_18880_ _02877_ _04591_ VSS VSS VDD VDD _04592_ sky130_fd_sc_hd__xor2_1
X_18881_ net642 _04592_ VSS VSS VDD VDD _04593_ sky130_fd_sc_hd__nand2_1
X_18882_ u_core.u_top.u_core.acc_upd[28] net642 _04593_ VSS VSS VDD VDD _04594_ sky130_fd_sc_hd__o21ai_0
X_18883_ net853 net726 VSS VSS VDD VDD _04595_ sky130_fd_sc_hd__nand2_1
X_18884_ net787 _04594_ _04595_ net635 VSS VSS VDD VDD _1042_[28] sky130_fd_sc_hd__o211ai_1
X_18885_ _02993_ _04569_ VSS VSS VDD VDD _04596_ sky130_fd_sc_hd__xor2_1
X_18886_ u_core.u_top.u_core.acc_upd[27] _04596_ net642 VSS VSS VDD VDD _04597_ sky130_fd_sc_hd__mux2i_1
X_18887_ net851 net726 _04597_ net786 net635 VSS VSS VDD VDD _1042_[27] sky130_fd_sc_hd__o221ai_1
X_18888_ _03236_ _04589_ VSS VSS VDD VDD _04598_ sky130_fd_sc_hd__xnor2_1
X_18889_ net642 _04598_ VSS VSS VDD VDD _04599_ sky130_fd_sc_hd__nand2_1
X_18890_ u_core.u_top.u_core.acc_upd[26] net642 _04599_ VSS VSS VDD VDD _04600_ sky130_fd_sc_hd__o21ai_0
X_18891_ net786 _04600_ _04595_ net633 VSS VSS VDD VDD _1042_[26] sky130_fd_sc_hd__o211ai_1
X_18893_ _03003_ _04567_ VSS VSS VDD VDD _04602_ sky130_fd_sc_hd__xnor2_1
X_18894_ net643 _04602_ VSS VSS VDD VDD _04603_ sky130_fd_sc_hd__nand2_1
X_18895_ u_core.u_top.u_core.acc_upd[25] net643 _04603_ VSS VSS VDD VDD _04604_ sky130_fd_sc_hd__o21ai_0
X_18896_ net786 _04604_ _04595_ net632 VSS VSS VDD VDD _1042_[25] sky130_fd_sc_hd__o211ai_1
X_18897_ _02918_ _04587_ VSS VSS VDD VDD _04605_ sky130_fd_sc_hd__xor2_1
X_18898_ u_core.u_top.u_core.acc_upd[24] _04605_ net643 VSS VSS VDD VDD _04606_ sky130_fd_sc_hd__mux2i_1
X_18899_ net851 net726 _04606_ net786 net631 VSS VSS VDD VDD _1042_[24] sky130_fd_sc_hd__o221ai_1
X_18900_ _02905_ _04565_ VSS VSS VDD VDD _04607_ sky130_fd_sc_hd__xnor2_1
X_18901_ net643 _04607_ VSS VSS VDD VDD _04608_ sky130_fd_sc_hd__nand2_1
X_18902_ u_core.u_top.u_core.acc_upd[23] net643 _04608_ VSS VSS VDD VDD _04609_ sky130_fd_sc_hd__o21ai_0
X_18903_ net786 _04609_ _04595_ net630 VSS VSS VDD VDD _1042_[23] sky130_fd_sc_hd__o211ai_1
X_18904_ _03334_ _02374_ VSS VSS VDD VDD _04610_ sky130_fd_sc_hd__xnor2_1
X_18905_ u_core.u_top.u_core.acc_upd[22] _04610_ net643 VSS VSS VDD VDD _04611_ sky130_fd_sc_hd__mux2i_1
X_18906_ net786 _04611_ net629 VSS VSS VDD VDD _1042_[22] sky130_fd_sc_hd__o21ai_0
X_18907_ _02375_ net643 VSS VSS VDD VDD _04612_ sky130_fd_sc_hd__nand2_1
X_18908_ u_core.u_top.u_core.acc_upd[21] net643 _04612_ VSS VSS VDD VDD _04613_ sky130_fd_sc_hd__o21ai_0
X_18909_ net786 _04613_ _11256_ VSS VSS VDD VDD _1042_[21] sky130_fd_sc_hd__o21ai_0
X_18910_ u_core.u_top.u_core.acc[20] _09353_ VSS VSS VDD VDD _03267_ sky130_fd_sc_hd__xnor2_1
X_18911_ _03267_ _03268_ net643 VSS VSS VDD VDD _04614_ sky130_fd_sc_hd__mux2_1
X_18912_ net786 _04614_ _11268_ VSS VSS VDD VDD _1042_[20] sky130_fd_sc_hd__o21ai_0
X_18913_ _02320_ _02501_ VSS VSS VDD VDD _04615_ sky130_fd_sc_hd__nor2b_1
X_18914_ _02500_ _04615_ _02977_ VSS VSS VDD VDD _04616_ sky130_fd_sc_hd__o21ai_0
X_18915_ _02976_ _04616_ VSS VSS VDD VDD _04617_ sky130_fd_sc_hd__nand2b_1
X_18916_ _02989_ _04617_ _02988_ VSS VSS VDD VDD _04618_ sky130_fd_sc_hd__a21o_1
X_18917_ _03414_ _04618_ _03413_ VSS VSS VDD VDD _04619_ sky130_fd_sc_hd__a21o_1
X_18918_ _03482_ _04619_ _03481_ VSS VSS VDD VDD _04620_ sky130_fd_sc_hd__a21o_1
X_18919_ _03418_ _04620_ _03417_ VSS VSS VDD VDD _04621_ sky130_fd_sc_hd__a21o_1
X_18920_ _02908_ _04621_ _02907_ VSS VSS VDD VDD _04622_ sky130_fd_sc_hd__a21o_1
X_18921_ _02838_ _04622_ _02837_ VSS VSS VDD VDD _04623_ sky130_fd_sc_hd__a21oi_1
X_18922_ net881 _04623_ VSS VSS VDD VDD _04624_ sky130_fd_sc_hd__xnor2_1
X_18923_ net640 _04624_ VSS VSS VDD VDD _04625_ sky130_fd_sc_hd__nand2_1
X_18924_ u_core.u_top.u_core.acc[18] u_core.u_top.u_core.acc[17] VSS VSS VDD VDD _04626_ sky130_fd_sc_hd__nand2_1
X_18925_ _09387_ _04626_ VSS VSS VDD VDD _04627_ sky130_fd_sc_hd__nor2_1
X_18926_ u_core.u_top.u_core.acc[19] _04627_ VSS VSS VDD VDD _04628_ sky130_fd_sc_hd__xnor2_1
X_18927_ u_core.u_top.u_core.acc[18] u_core.u_top.u_core.acc[17] _09382_ VSS VSS VDD VDD _04629_ sky130_fd_sc_hd__nor3_1
X_18928_ u_core.u_top.u_core.acc[19] _04629_ VSS VSS VDD VDD _04630_ sky130_fd_sc_hd__xnor2_1
X_18929_ _09376_ _04628_ _04630_ _09364_ VSS VSS VDD VDD _04631_ sky130_fd_sc_hd__a22oi_1
X_18930_ u_core.u_top.u_core.acc[19] _09379_ _04631_ net674 VSS VSS VDD VDD _04632_ sky130_fd_sc_hd__o22ai_1
X_18931_ _04625_ _04632_ VSS VSS VDD VDD _04633_ sky130_fd_sc_hd__xnor2_1
X_18932_ _03460_ _09383_ u_core.u_top.u_core.acc[14] VSS VSS VDD VDD _04634_ sky130_fd_sc_hd__o21bai_1
X_18933_ u_core.u_top.u_core.acc[15] u_core.u_top.u_core.acc[16] _04634_ u_core.u_top.u_core.acc[17] VSS VSS VDD VDD _04635_ sky130_fd_sc_hd__a31oi_1
X_18934_ u_core.u_top.u_core.acc[19] _04635_ u_core.u_top.u_core.acc[18] VSS VSS VDD VDD _04636_ sky130_fd_sc_hd__nor3b_1
X_18935_ _04636_ net853 VSS VSS VDD VDD _04637_ sky130_fd_sc_hd__nand2b_1
X_18936_ net784 _04633_ _04637_ _11221_ VSS VSS VDD VDD _1042_[19] sky130_fd_sc_hd__o211ai_1
X_18938_ _02321_ _02977_ VSS VSS VDD VDD _04639_ sky130_fd_sc_hd__nor2b_1
X_18939_ _02976_ _04639_ _02989_ VSS VSS VDD VDD _04640_ sky130_fd_sc_hd__o21ai_0
X_18940_ _02988_ _04640_ VSS VSS VDD VDD _04641_ sky130_fd_sc_hd__nand2b_1
X_18941_ _03414_ _04641_ _03413_ VSS VSS VDD VDD _04642_ sky130_fd_sc_hd__a21o_1
X_18942_ _03482_ _04642_ _03481_ VSS VSS VDD VDD _04643_ sky130_fd_sc_hd__a21o_1
X_18943_ _03418_ _04643_ _03417_ VSS VSS VDD VDD _04644_ sky130_fd_sc_hd__a21o_1
X_18944_ _02908_ _04644_ _02907_ VSS VSS VDD VDD _04645_ sky130_fd_sc_hd__a21oi_1
X_18945_ _02838_ _04645_ VSS VSS VDD VDD _04646_ sky130_fd_sc_hd__xnor2_1
X_18946_ u_core.u_top.u_core.acc_upd[18] _04646_ net640 VSS VSS VDD VDD _04647_ sky130_fd_sc_hd__mux2i_1
X_18947_ net853 _04636_ VSS VSS VDD VDD _04648_ sky130_fd_sc_hd__nand2_1
X_18948_ net784 _04647_ _04648_ _11221_ VSS VSS VDD VDD _1042_[18] sky130_fd_sc_hd__o211ai_1
X_18949_ _02908_ _04621_ VSS VSS VDD VDD _04649_ sky130_fd_sc_hd__xnor2_1
X_18950_ net640 _04649_ VSS VSS VDD VDD _04650_ sky130_fd_sc_hd__nand2_1
X_18951_ u_core.u_top.u_core.acc_upd[17] net640 _04650_ VSS VSS VDD VDD _04651_ sky130_fd_sc_hd__o21ai_0
X_18952_ net784 _04651_ _04637_ _11221_ VSS VSS VDD VDD _1042_[17] sky130_fd_sc_hd__o211ai_1
X_18953_ _03418_ _04643_ VSS VSS VDD VDD _04652_ sky130_fd_sc_hd__xnor2_1
X_18954_ net640 _04652_ VSS VSS VDD VDD _04653_ sky130_fd_sc_hd__nand2_1
X_18955_ u_core.u_top.u_core.acc_upd[16] net640 _04653_ VSS VSS VDD VDD _04654_ sky130_fd_sc_hd__o21ai_0
X_18956_ net784 _04654_ _04648_ net633 VSS VSS VDD VDD _1042_[16] sky130_fd_sc_hd__o211ai_1
X_18957_ _03482_ _04619_ VSS VSS VDD VDD _04655_ sky130_fd_sc_hd__xor2_1
X_18958_ u_core.u_top.u_core.acc_upd[15] _04655_ net640 VSS VSS VDD VDD _04656_ sky130_fd_sc_hd__mux2i_1
X_18959_ net784 _04656_ _04648_ net632 VSS VSS VDD VDD _1042_[15] sky130_fd_sc_hd__o211ai_1
X_18960_ _03414_ _04641_ VSS VSS VDD VDD _04657_ sky130_fd_sc_hd__xnor2_1
X_18961_ net640 _04657_ VSS VSS VDD VDD _04658_ sky130_fd_sc_hd__nand2_1
X_18962_ u_core.u_top.u_core.acc_upd[14] net640 _04658_ VSS VSS VDD VDD _04659_ sky130_fd_sc_hd__o21ai_0
X_18963_ net784 _04659_ _04637_ net631 VSS VSS VDD VDD _1042_[14] sky130_fd_sc_hd__o211ai_1
X_18964_ _02989_ _04617_ VSS VSS VDD VDD _04660_ sky130_fd_sc_hd__xnor2_1
X_18965_ net640 _04660_ VSS VSS VDD VDD _04661_ sky130_fd_sc_hd__nand2_1
X_18966_ u_core.u_top.u_core.acc_upd[13] net640 _04661_ VSS VSS VDD VDD _04662_ sky130_fd_sc_hd__o21ai_0
X_18967_ net784 _04662_ _04648_ net630 VSS VSS VDD VDD _1042_[13] sky130_fd_sc_hd__o211ai_1
X_18968_ _02977_ _02321_ VSS VSS VDD VDD _04663_ sky130_fd_sc_hd__xnor2_1
X_18969_ u_core.u_top.u_core.acc_upd[12] _04663_ net642 VSS VSS VDD VDD _04664_ sky130_fd_sc_hd__mux2i_1
X_18970_ net784 _04664_ net629 VSS VSS VDD VDD _1042_[12] sky130_fd_sc_hd__o21ai_0
X_18971_ _02322_ net642 VSS VSS VDD VDD _04665_ sky130_fd_sc_hd__nand2_1
X_18972_ u_core.u_top.u_core.acc_upd[11] net642 _04665_ VSS VSS VDD VDD _04666_ sky130_fd_sc_hd__o21ai_0
X_18973_ net786 _04666_ _11256_ VSS VSS VDD VDD _1042_[11] sky130_fd_sc_hd__o21ai_0
X_18974_ u_core.u_top.u_core.acc[10] _09379_ VSS VSS VDD VDD _02617_ sky130_fd_sc_hd__xnor2_1
X_18975_ _02617_ _02618_ net642 VSS VSS VDD VDD _04667_ sky130_fd_sc_hd__mux2_1
X_18976_ net784 _04667_ _11268_ VSS VSS VDD VDD _1042_[10] sky130_fd_sc_hd__o21ai_0
X_18977_ _02461_ _03140_ VSS VSS VDD VDD _04668_ sky130_fd_sc_hd__nor2b_1
X_18978_ _03139_ _04668_ _02897_ VSS VSS VDD VDD _04669_ sky130_fd_sc_hd__o21ai_0
X_18979_ _02896_ _04669_ VSS VSS VDD VDD _04670_ sky130_fd_sc_hd__nand2b_1
X_18980_ _03016_ _04670_ _03015_ VSS VSS VDD VDD _04671_ sky130_fd_sc_hd__a21o_1
X_18981_ _02959_ _04671_ _02958_ VSS VSS VDD VDD _04672_ sky130_fd_sc_hd__a21o_1
X_18982_ _02859_ _04672_ _02858_ VSS VSS VDD VDD _04673_ sky130_fd_sc_hd__a21o_1
X_18983_ _03406_ _04673_ _03405_ VSS VSS VDD VDD _04674_ sky130_fd_sc_hd__a21o_1
X_18984_ _02987_ _04674_ _02986_ VSS VSS VDD VDD _04675_ sky130_fd_sc_hd__a21o_1
X_18985_ _03408_ _04675_ _03407_ VSS VSS VDD VDD _04676_ sky130_fd_sc_hd__a21oi_1
X_18986_ net882 _04676_ VSS VSS VDD VDD _04677_ sky130_fd_sc_hd__xnor2_1
X_18987_ net643 _04677_ VSS VSS VDD VDD _04678_ sky130_fd_sc_hd__nand2_1
X_18988_ u_core.u_top.u_core.acc[8] u_core.u_top.u_core.acc[7] _09438_ VSS VSS VDD VDD _04679_ sky130_fd_sc_hd__nor3b_1
X_18989_ u_core.u_top.u_core.acc[8] u_core.u_top.u_core.acc[7] _09442_ VSS VSS VDD VDD _04680_ sky130_fd_sc_hd__and3_1
X_18990_ _09426_ _04679_ _04680_ net688 u_core.u_top.u_core.acc[9] VSS VSS VDD VDD _04681_ sky130_fd_sc_hd__o221ai_1
X_18991_ _09433_ _04679_ _04680_ _09432_ u_core.u_top.u_core.acc[9] VSS VSS VDD VDD _04682_ sky130_fd_sc_hd__a221o_1
X_18992_ net678 _04681_ _04682_ net661 u_core.u_top.u_core.acc[9] VSS VSS VDD VDD _04683_ sky130_fd_sc_hd__a32oi_1
X_18993_ _04678_ _04683_ VSS VSS VDD VDD _04684_ sky130_fd_sc_hd__xnor2_1
X_18994_ _02690_ _09439_ u_core.u_top.u_core.acc[4] VSS VSS VDD VDD _04685_ sky130_fd_sc_hd__o21bai_1
X_18995_ u_core.u_top.u_core.acc[5] u_core.u_top.u_core.acc[6] _04685_ u_core.u_top.u_core.acc[7] VSS VSS VDD VDD _04686_ sky130_fd_sc_hd__a31oi_1
X_18996_ u_core.u_top.u_core.acc[9] _04686_ u_core.u_top.u_core.acc[8] VSS VSS VDD VDD _04687_ sky130_fd_sc_hd__nor3b_1
X_18997_ _04687_ net853 VSS VSS VDD VDD _04688_ sky130_fd_sc_hd__nand2b_1
X_18998_ net786 _04684_ _04688_ net635 VSS VSS VDD VDD _1042_[9] sky130_fd_sc_hd__o211ai_1
X_18999_ _02462_ _02897_ VSS VSS VDD VDD _04689_ sky130_fd_sc_hd__nor2b_1
X_19000_ _02896_ _04689_ _03016_ VSS VSS VDD VDD _04690_ sky130_fd_sc_hd__o21ai_0
X_19001_ _03015_ _04690_ VSS VSS VDD VDD _04691_ sky130_fd_sc_hd__nand2b_1
X_19002_ _02959_ _04691_ _02958_ VSS VSS VDD VDD _04692_ sky130_fd_sc_hd__a21o_1
X_19003_ _02859_ _04692_ _02858_ VSS VSS VDD VDD _04693_ sky130_fd_sc_hd__a21o_1
X_19004_ _03406_ _04693_ _03405_ VSS VSS VDD VDD _04694_ sky130_fd_sc_hd__a21o_1
X_19005_ _02987_ _04694_ _02986_ VSS VSS VDD VDD _04695_ sky130_fd_sc_hd__a21oi_1
X_19006_ _03408_ _04695_ VSS VSS VDD VDD _04696_ sky130_fd_sc_hd__xnor2_1
X_19007_ net776 net644 VSS VSS VDD VDD _04697_ sky130_fd_sc_hd__and2_1
X_19008_ net786 net643 VSS VSS VDD VDD _04698_ sky130_fd_sc_hd__nor2_1
X_19009_ _04696_ _04697_ _04698_ u_core.u_top.u_core.acc_upd[8] VSS VSS VDD VDD _04699_ sky130_fd_sc_hd__a22oi_1
X_19010_ net853 _04687_ VSS VSS VDD VDD _04700_ sky130_fd_sc_hd__nand2_1
X_19011_ net635 _04699_ _04700_ VSS VSS VDD VDD _1042_[8] sky130_fd_sc_hd__nand3_1
X_19012_ _02987_ _04674_ VSS VSS VDD VDD _04701_ sky130_fd_sc_hd__xnor2_1
X_19013_ net643 _04701_ VSS VSS VDD VDD _04702_ sky130_fd_sc_hd__nand2_1
X_19014_ u_core.u_top.u_core.acc_upd[7] net643 _04702_ VSS VSS VDD VDD _04703_ sky130_fd_sc_hd__o21ai_0
X_19015_ net786 _04703_ _04688_ net635 VSS VSS VDD VDD _1042_[7] sky130_fd_sc_hd__o211ai_1
X_19016_ _03406_ _04693_ VSS VSS VDD VDD _04704_ sky130_fd_sc_hd__xnor2_1
X_19017_ net643 _04704_ VSS VSS VDD VDD _04705_ sky130_fd_sc_hd__nand2_1
X_19018_ u_core.u_top.u_core.acc_upd[6] net643 _04705_ VSS VSS VDD VDD _04706_ sky130_fd_sc_hd__o21ai_0
X_19019_ net786 _04706_ _04700_ net633 VSS VSS VDD VDD _1042_[6] sky130_fd_sc_hd__o211ai_1
X_19020_ _02859_ _04672_ VSS VSS VDD VDD _04707_ sky130_fd_sc_hd__xor2_1
X_19021_ u_core.u_top.u_core.acc_upd[5] _04698_ _04707_ _04697_ VSS VSS VDD VDD _04708_ sky130_fd_sc_hd__a22oi_1
X_19022_ net632 _04700_ _04708_ VSS VSS VDD VDD _1042_[5] sky130_fd_sc_hd__nand3_1
X_19023_ _02959_ _04691_ VSS VSS VDD VDD _04709_ sky130_fd_sc_hd__xnor2_1
X_19024_ net643 _04709_ VSS VSS VDD VDD _04710_ sky130_fd_sc_hd__nand2_1
X_19025_ u_core.u_top.u_core.acc_upd[4] net643 _04710_ VSS VSS VDD VDD _04711_ sky130_fd_sc_hd__o21ai_0
X_19026_ net786 _04711_ _04688_ net631 VSS VSS VDD VDD _1042_[4] sky130_fd_sc_hd__o211ai_1
X_19027_ _03016_ _04670_ VSS VSS VDD VDD _04712_ sky130_fd_sc_hd__xnor2_1
X_19028_ net643 _04712_ VSS VSS VDD VDD _04713_ sky130_fd_sc_hd__nand2_1
X_19029_ u_core.u_top.u_core.acc_upd[3] net643 _04713_ VSS VSS VDD VDD _04714_ sky130_fd_sc_hd__o21ai_0
X_19030_ net786 _04714_ _04700_ net630 VSS VSS VDD VDD _1042_[3] sky130_fd_sc_hd__o211ai_1
X_19031_ _02897_ _02462_ VSS VSS VDD VDD _04715_ sky130_fd_sc_hd__xnor2_1
X_19032_ u_core.u_top.u_core.acc_upd[2] _04715_ net643 VSS VSS VDD VDD _04716_ sky130_fd_sc_hd__mux2i_1
X_19033_ net786 _04716_ net629 VSS VSS VDD VDD _1042_[2] sky130_fd_sc_hd__o21ai_0
X_19034_ _02463_ net643 VSS VSS VDD VDD _04717_ sky130_fd_sc_hd__nand2_1
X_19035_ u_core.u_top.u_core.acc_upd[1] net643 _04717_ VSS VSS VDD VDD _04718_ sky130_fd_sc_hd__o21ai_0
X_19036_ net786 _04718_ _11256_ VSS VSS VDD VDD _1042_[1] sky130_fd_sc_hd__o21ai_0
X_19037_ _0912_[0] net661 VSS VSS VDD VDD _03000_ sky130_fd_sc_hd__xnor2_1
X_19038_ _03000_ _03001_ net643 VSS VSS VDD VDD _04719_ sky130_fd_sc_hd__mux2_1
X_19039_ net786 _04719_ _11268_ VSS VSS VDD VDD _1042_[0] sky130_fd_sc_hd__o21ai_0
X_19040_ _10222_ _10263_ VSS VSS VDD VDD _04720_ sky130_fd_sc_hd__nand2_1
X_19042_ _10215_ net897 net861 VSS VSS VDD VDD _04722_ sky130_fd_sc_hd__nand3_4
X_19045_ _10222_ _10253_ VSS VSS VDD VDD _04725_ sky130_fd_sc_hd__nor2_4
X_19048_ net980 net682 VSS VSS VDD VDD _04728_ sky130_fd_sc_hd__nand2_1
X_19049_ net980 net775 _04728_ VSS VSS VDD VDD _04729_ sky130_fd_sc_hd__o21ai_0
X_19050_ u_core.u_top.u_core.pend_n[22] _04729_ VSS VSS VDD VDD _04730_ sky130_fd_sc_hd__nand2_1
X_19051_ net884 net704 VSS VSS VDD VDD _04731_ sky130_fd_sc_hd__nand2_1
X_19053_ _10215_ net861 VSS VSS VDD VDD _04733_ sky130_fd_sc_hd__nand2_1
X_19055_ net681 _10252_ net774 VSS VSS VDD VDD _04735_ sky130_fd_sc_hd__o21ai_0
X_19056_ _10252_ net683 _04730_ _04735_ VSS VSS VDD VDD _1025_[22] sky130_fd_sc_hd__o211ai_1
X_19057_ u_core.arr_sa_n[21] net682 VSS VSS VDD VDD _04736_ sky130_fd_sc_hd__nand2_1
X_19058_ u_core.arr_sa_n[21] net775 _04736_ VSS VSS VDD VDD _04737_ sky130_fd_sc_hd__o21ai_0
X_19059_ u_core.u_top.u_core.pend_n[21] _04737_ VSS VSS VDD VDD _04738_ sky130_fd_sc_hd__nand2_1
X_19060_ _04731_ _10265_ net774 VSS VSS VDD VDD _04739_ sky130_fd_sc_hd__o21ai_0
X_19061_ _10265_ net683 _04738_ _04739_ VSS VSS VDD VDD _1025_[21] sky130_fd_sc_hd__o211ai_1
X_19062_ u_core.arr_sa_n[20] net682 VSS VSS VDD VDD _04740_ sky130_fd_sc_hd__nand2_1
X_19063_ u_core.arr_sa_n[20] net775 _04740_ VSS VSS VDD VDD _04741_ sky130_fd_sc_hd__o21ai_0
X_19064_ u_core.u_top.u_core.pend_n[20] _04741_ VSS VSS VDD VDD _04742_ sky130_fd_sc_hd__nand2_1
X_19065_ _04731_ _10273_ net774 VSS VSS VDD VDD _04743_ sky130_fd_sc_hd__o21ai_0
X_19066_ _10273_ net683 _04742_ _04743_ VSS VSS VDD VDD _1025_[20] sky130_fd_sc_hd__o211ai_1
X_19067_ u_core.arr_sa_n[19] net682 VSS VSS VDD VDD _04744_ sky130_fd_sc_hd__nand2_1
X_19068_ u_core.arr_sa_n[19] net775 _04744_ VSS VSS VDD VDD _04745_ sky130_fd_sc_hd__o21ai_0
X_19069_ u_core.u_top.u_core.pend_n[19] _04745_ VSS VSS VDD VDD _04746_ sky130_fd_sc_hd__nand2_1
X_19070_ _04731_ _10277_ net774 VSS VSS VDD VDD _04747_ sky130_fd_sc_hd__o21ai_0
X_19071_ _10277_ net683 _04746_ _04747_ VSS VSS VDD VDD _1025_[19] sky130_fd_sc_hd__o211ai_1
X_19072_ u_core.arr_sa_n[18] net682 VSS VSS VDD VDD _04748_ sky130_fd_sc_hd__nand2_1
X_19073_ u_core.arr_sa_n[18] net775 _04748_ VSS VSS VDD VDD _04749_ sky130_fd_sc_hd__o21ai_0
X_19074_ u_core.u_top.u_core.pend_n[18] _04749_ VSS VSS VDD VDD _04750_ sky130_fd_sc_hd__nand2_1
X_19075_ _04731_ _10281_ net774 VSS VSS VDD VDD _04751_ sky130_fd_sc_hd__o21ai_0
X_19076_ _10281_ net683 _04750_ _04751_ VSS VSS VDD VDD _1025_[18] sky130_fd_sc_hd__o211ai_1
X_19077_ u_core.arr_sa_n[17] net682 VSS VSS VDD VDD _04752_ sky130_fd_sc_hd__nand2_1
X_19078_ u_core.arr_sa_n[17] net775 _04752_ VSS VSS VDD VDD _04753_ sky130_fd_sc_hd__o21ai_0
X_19079_ u_core.u_top.u_core.pend_n[17] _04753_ VSS VSS VDD VDD _04754_ sky130_fd_sc_hd__nand2_1
X_19080_ _04731_ _10285_ net774 VSS VSS VDD VDD _04755_ sky130_fd_sc_hd__o21ai_0
X_19081_ _10285_ net683 _04754_ _04755_ VSS VSS VDD VDD _1025_[17] sky130_fd_sc_hd__o211ai_1
X_19082_ u_core.arr_sa_n[16] net682 VSS VSS VDD VDD _04756_ sky130_fd_sc_hd__nand2_1
X_19083_ u_core.arr_sa_n[16] net775 _04756_ VSS VSS VDD VDD _04757_ sky130_fd_sc_hd__o21ai_0
X_19084_ u_core.u_top.u_core.pend_n[16] _04757_ VSS VSS VDD VDD _04758_ sky130_fd_sc_hd__nand2_1
X_19085_ _04731_ _10289_ net774 VSS VSS VDD VDD _04759_ sky130_fd_sc_hd__o21ai_0
X_19086_ _10289_ net683 _04758_ _04759_ VSS VSS VDD VDD _1025_[16] sky130_fd_sc_hd__o211ai_1
X_19087_ u_core.arr_sa_n[15] net682 VSS VSS VDD VDD _04760_ sky130_fd_sc_hd__nand2_1
X_19088_ u_core.arr_sa_n[15] net775 _04760_ VSS VSS VDD VDD _04761_ sky130_fd_sc_hd__o21ai_0
X_19089_ u_core.u_top.u_core.pend_n[15] _04761_ VSS VSS VDD VDD _04762_ sky130_fd_sc_hd__nand2_1
X_19091_ _04731_ _10295_ net774 VSS VSS VDD VDD _04764_ sky130_fd_sc_hd__o21ai_0
X_19092_ _10295_ net683 _04762_ _04764_ VSS VSS VDD VDD _1025_[15] sky130_fd_sc_hd__o211ai_1
X_19093_ u_core.arr_sa_n[14] net682 VSS VSS VDD VDD _04765_ sky130_fd_sc_hd__nand2_1
X_19094_ u_core.arr_sa_n[14] net775 _04765_ VSS VSS VDD VDD _04766_ sky130_fd_sc_hd__o21ai_0
X_19095_ u_core.u_top.u_core.pend_n[14] _04766_ VSS VSS VDD VDD _04767_ sky130_fd_sc_hd__nand2_1
X_19096_ _04731_ _10301_ net774 VSS VSS VDD VDD _04768_ sky130_fd_sc_hd__o21ai_0
X_19097_ _10301_ net683 _04767_ _04768_ VSS VSS VDD VDD _1025_[14] sky130_fd_sc_hd__o211ai_1
X_19099_ u_core.arr_sa_n[13] net682 VSS VSS VDD VDD _04770_ sky130_fd_sc_hd__nand2_1
X_19100_ u_core.arr_sa_n[13] net775 _04770_ VSS VSS VDD VDD _04771_ sky130_fd_sc_hd__o21ai_0
X_19101_ u_core.u_top.u_core.pend_n[13] _04771_ VSS VSS VDD VDD _04772_ sky130_fd_sc_hd__nand2_1
X_19102_ _04731_ _10305_ net774 VSS VSS VDD VDD _04773_ sky130_fd_sc_hd__o21ai_0
X_19103_ _10305_ net683 _04772_ _04773_ VSS VSS VDD VDD _1025_[13] sky130_fd_sc_hd__o211ai_1
X_19106_ u_core.arr_sa_n[12] net682 VSS VSS VDD VDD _04776_ sky130_fd_sc_hd__nand2_1
X_19107_ u_core.arr_sa_n[12] net775 _04776_ VSS VSS VDD VDD _04777_ sky130_fd_sc_hd__o21ai_0
X_19108_ u_core.u_top.u_core.pend_n[12] _04777_ VSS VSS VDD VDD _04778_ sky130_fd_sc_hd__nand2_1
X_19110_ _04731_ _10309_ net774 VSS VSS VDD VDD _04780_ sky130_fd_sc_hd__o21ai_0
X_19111_ _10309_ net683 _04778_ _04780_ VSS VSS VDD VDD _1025_[12] sky130_fd_sc_hd__o211ai_1
X_19112_ u_core.arr_sa_n[11] net682 VSS VSS VDD VDD _04781_ sky130_fd_sc_hd__nand2_1
X_19113_ u_core.arr_sa_n[11] net775 _04781_ VSS VSS VDD VDD _04782_ sky130_fd_sc_hd__o21ai_0
X_19114_ u_core.u_top.u_core.pend_n[11] _04782_ VSS VSS VDD VDD _04783_ sky130_fd_sc_hd__nand2_1
X_19115_ net681 _10316_ net774 VSS VSS VDD VDD _04784_ sky130_fd_sc_hd__o21ai_0
X_19116_ _10316_ net683 _04783_ _04784_ VSS VSS VDD VDD _1025_[11] sky130_fd_sc_hd__o211ai_1
X_19117_ u_core.arr_sa_n[10] net682 VSS VSS VDD VDD _04785_ sky130_fd_sc_hd__nand2_1
X_19118_ u_core.arr_sa_n[10] net775 _04785_ VSS VSS VDD VDD _04786_ sky130_fd_sc_hd__o21ai_0
X_19119_ u_core.u_top.u_core.pend_n[10] _04786_ VSS VSS VDD VDD _04787_ sky130_fd_sc_hd__nand2_1
X_19120_ net681 _10321_ net774 VSS VSS VDD VDD _04788_ sky130_fd_sc_hd__o21ai_0
X_19121_ _10321_ net683 _04787_ _04788_ VSS VSS VDD VDD _1025_[10] sky130_fd_sc_hd__o211ai_1
X_19122_ u_core.arr_sa_n[9] net682 VSS VSS VDD VDD _04789_ sky130_fd_sc_hd__nand2_1
X_19123_ u_core.arr_sa_n[9] net775 _04789_ VSS VSS VDD VDD _04790_ sky130_fd_sc_hd__o21ai_0
X_19124_ u_core.u_top.u_core.pend_n[9] _04790_ VSS VSS VDD VDD _04791_ sky130_fd_sc_hd__nand2_1
X_19125_ net681 _10326_ net774 VSS VSS VDD VDD _04792_ sky130_fd_sc_hd__o21ai_0
X_19126_ _10326_ net683 _04791_ _04792_ VSS VSS VDD VDD _1025_[9] sky130_fd_sc_hd__o211ai_1
X_19127_ u_core.arr_sa_n[8] net682 VSS VSS VDD VDD _04793_ sky130_fd_sc_hd__nand2_1
X_19128_ u_core.arr_sa_n[8] net775 _04793_ VSS VSS VDD VDD _04794_ sky130_fd_sc_hd__o21ai_0
X_19129_ u_core.u_top.u_core.pend_n[8] _04794_ VSS VSS VDD VDD _04795_ sky130_fd_sc_hd__nand2_1
X_19130_ net681 _10331_ net774 VSS VSS VDD VDD _04796_ sky130_fd_sc_hd__o21ai_0
X_19131_ _10331_ net683 _04795_ _04796_ VSS VSS VDD VDD _1025_[8] sky130_fd_sc_hd__o211ai_1
X_19132_ u_core.arr_sa_n[7] net682 VSS VSS VDD VDD _04797_ sky130_fd_sc_hd__nand2_1
X_19133_ u_core.arr_sa_n[7] net775 _04797_ VSS VSS VDD VDD _04798_ sky130_fd_sc_hd__o21ai_0
X_19134_ u_core.u_top.u_core.pend_n[7] _04798_ VSS VSS VDD VDD _04799_ sky130_fd_sc_hd__nand2_1
X_19135_ net681 _10335_ net774 VSS VSS VDD VDD _04800_ sky130_fd_sc_hd__o21ai_0
X_19136_ _10335_ net683 _04799_ _04800_ VSS VSS VDD VDD _1025_[7] sky130_fd_sc_hd__o211ai_1
X_19137_ u_core.arr_sa_n[6] net682 VSS VSS VDD VDD _04801_ sky130_fd_sc_hd__nand2_1
X_19138_ u_core.arr_sa_n[6] net775 _04801_ VSS VSS VDD VDD _04802_ sky130_fd_sc_hd__o21ai_0
X_19139_ u_core.u_top.u_core.pend_n[6] _04802_ VSS VSS VDD VDD _04803_ sky130_fd_sc_hd__nand2_1
X_19140_ net681 _10339_ net774 VSS VSS VDD VDD _04804_ sky130_fd_sc_hd__o21ai_0
X_19141_ _10339_ net683 _04803_ _04804_ VSS VSS VDD VDD _1025_[6] sky130_fd_sc_hd__o211ai_1
X_19142_ u_core.arr_sa_n[5] _04725_ VSS VSS VDD VDD _04805_ sky130_fd_sc_hd__nand2_1
X_19143_ u_core.arr_sa_n[5] _04722_ _04805_ VSS VSS VDD VDD _04806_ sky130_fd_sc_hd__o21ai_0
X_19144_ u_core.u_top.u_core.pend_n[5] _04806_ VSS VSS VDD VDD _04807_ sky130_fd_sc_hd__nand2_1
X_19145_ net681 _10344_ net774 VSS VSS VDD VDD _04808_ sky130_fd_sc_hd__o21ai_0
X_19146_ _10344_ _04720_ _04807_ _04808_ VSS VSS VDD VDD _1025_[5] sky130_fd_sc_hd__o211ai_1
X_19147_ u_core.arr_sa_n[4] net682 VSS VSS VDD VDD _04809_ sky130_fd_sc_hd__nand2_1
X_19148_ u_core.arr_sa_n[4] net775 _04809_ VSS VSS VDD VDD _04810_ sky130_fd_sc_hd__o21ai_0
X_19149_ u_core.u_top.u_core.pend_n[4] _04810_ VSS VSS VDD VDD _04811_ sky130_fd_sc_hd__nand2_1
X_19150_ _04731_ _10349_ net774 VSS VSS VDD VDD _04812_ sky130_fd_sc_hd__o21ai_0
X_19151_ _10349_ net683 _04811_ _04812_ VSS VSS VDD VDD _1025_[4] sky130_fd_sc_hd__o211ai_1
X_19153_ net979 net682 VSS VSS VDD VDD _04814_ sky130_fd_sc_hd__nand2_1
X_19154_ net979 net775 _04814_ VSS VSS VDD VDD _04815_ sky130_fd_sc_hd__o21ai_0
X_19155_ u_core.u_top.u_core.pend_n[3] _04815_ VSS VSS VDD VDD _04816_ sky130_fd_sc_hd__nand2_1
X_19156_ net681 _10354_ net774 VSS VSS VDD VDD _04817_ sky130_fd_sc_hd__o21ai_0
X_19157_ _10354_ net683 _04816_ _04817_ VSS VSS VDD VDD _1025_[3] sky130_fd_sc_hd__o211ai_1
X_19159_ u_core.arr_sa_n[2] _04725_ VSS VSS VDD VDD _04819_ sky130_fd_sc_hd__nand2_1
X_19160_ u_core.arr_sa_n[2] _04722_ _04819_ VSS VSS VDD VDD _04820_ sky130_fd_sc_hd__o21ai_0
X_19161_ u_core.u_top.u_core.pend_n[2] _04820_ VSS VSS VDD VDD _04821_ sky130_fd_sc_hd__nand2_1
X_19162_ net681 _10358_ net774 VSS VSS VDD VDD _04822_ sky130_fd_sc_hd__o21ai_0
X_19163_ _10358_ _04720_ _04821_ _04822_ VSS VSS VDD VDD _1025_[2] sky130_fd_sc_hd__o211ai_1
X_19164_ u_core.arr_sa_n[1] net682 VSS VSS VDD VDD _04823_ sky130_fd_sc_hd__nand2_1
X_19165_ u_core.arr_sa_n[1] net775 _04823_ VSS VSS VDD VDD _04824_ sky130_fd_sc_hd__o21ai_0
X_19166_ u_core.u_top.u_core.pend_n[1] _04824_ VSS VSS VDD VDD _04825_ sky130_fd_sc_hd__nand2_1
X_19167_ net681 _10363_ net774 VSS VSS VDD VDD _04826_ sky130_fd_sc_hd__o21ai_0
X_19168_ _10363_ net683 _04825_ _04826_ VSS VSS VDD VDD _1025_[1] sky130_fd_sc_hd__o211ai_1
X_19169_ u_core.arr_sa_n[0] _04725_ VSS VSS VDD VDD _04827_ sky130_fd_sc_hd__nand2_1
X_19170_ u_core.arr_sa_n[0] _04722_ _04827_ VSS VSS VDD VDD _04828_ sky130_fd_sc_hd__o21ai_0
X_19171_ u_core.u_top.u_core.pend_n[0] _04828_ VSS VSS VDD VDD _04829_ sky130_fd_sc_hd__nand2_1
X_19172_ net681 _10367_ net774 VSS VSS VDD VDD _04830_ sky130_fd_sc_hd__o21ai_0
X_19173_ _10367_ _04720_ _04829_ _04830_ VSS VSS VDD VDD _1025_[0] sky130_fd_sc_hd__o211ai_1
X_19174_ _09957_ _10253_ VSS VSS VDD VDD _04831_ sky130_fd_sc_hd__nor2_2
X_19176_ u_core.arr_sa_p[22] net682 VSS VSS VDD VDD _04833_ sky130_fd_sc_hd__nand2_1
X_19177_ u_core.arr_sa_p[22] net775 _04833_ VSS VSS VDD VDD _04834_ sky130_fd_sc_hd__o21ai_0
X_19178_ net898 _10249_ VSS VSS VDD VDD _04835_ sky130_fd_sc_hd__nor2_4
X_19180_ net686 _10373_ net850 VSS VSS VDD VDD _04837_ sky130_fd_sc_hd__a21oi_1
X_19181_ _10373_ net680 _04834_ u_core.u_top.u_core.pend_p[22] _04837_ VSS VSS VDD VDD _1022_[22] sky130_fd_sc_hd__a221o_1
X_19182_ u_core.arr_sa_p[21] net682 VSS VSS VDD VDD _04838_ sky130_fd_sc_hd__nand2_1
X_19183_ u_core.arr_sa_p[21] net775 _04838_ VSS VSS VDD VDD _04839_ sky130_fd_sc_hd__o21ai_0
X_19184_ net686 _10380_ net850 VSS VSS VDD VDD _04840_ sky130_fd_sc_hd__a21oi_1
X_19185_ _10380_ net680 _04839_ u_core.u_top.u_core.pend_p[21] _04840_ VSS VSS VDD VDD _1022_[21] sky130_fd_sc_hd__a221o_1
X_19186_ u_core.arr_sa_p[20] net682 VSS VSS VDD VDD _04841_ sky130_fd_sc_hd__nand2_1
X_19187_ u_core.arr_sa_p[20] net775 _04841_ VSS VSS VDD VDD _04842_ sky130_fd_sc_hd__o21ai_0
X_19188_ net686 _10387_ net850 VSS VSS VDD VDD _04843_ sky130_fd_sc_hd__a21oi_1
X_19189_ _10387_ net680 _04842_ u_core.u_top.u_core.pend_p[20] _04843_ VSS VSS VDD VDD _1022_[20] sky130_fd_sc_hd__a221o_1
X_19190_ u_core.arr_sa_p[19] net682 VSS VSS VDD VDD _04844_ sky130_fd_sc_hd__nand2_1
X_19191_ u_core.arr_sa_p[19] net775 _04844_ VSS VSS VDD VDD _04845_ sky130_fd_sc_hd__o21ai_0
X_19192_ net686 _10393_ net850 VSS VSS VDD VDD _04846_ sky130_fd_sc_hd__a21oi_1
X_19193_ _10393_ net680 _04845_ u_core.u_top.u_core.pend_p[19] _04846_ VSS VSS VDD VDD _1022_[19] sky130_fd_sc_hd__a221o_1
X_19194_ u_core.arr_sa_p[18] net682 VSS VSS VDD VDD _04847_ sky130_fd_sc_hd__nand2_1
X_19195_ u_core.arr_sa_p[18] net775 _04847_ VSS VSS VDD VDD _04848_ sky130_fd_sc_hd__o21ai_0
X_19196_ net686 _10400_ net850 VSS VSS VDD VDD _04849_ sky130_fd_sc_hd__a21oi_1
X_19197_ _10400_ net680 _04848_ u_core.u_top.u_core.pend_p[18] _04849_ VSS VSS VDD VDD _1022_[18] sky130_fd_sc_hd__a221o_1
X_19200_ u_core.arr_sa_p[17] net682 VSS VSS VDD VDD _04852_ sky130_fd_sc_hd__nand2_1
X_19201_ u_core.arr_sa_p[17] net775 _04852_ VSS VSS VDD VDD _04853_ sky130_fd_sc_hd__o21ai_0
X_19202_ net686 _10406_ net850 VSS VSS VDD VDD _04854_ sky130_fd_sc_hd__a21oi_1
X_19203_ _10406_ net680 _04853_ u_core.u_top.u_core.pend_p[17] _04854_ VSS VSS VDD VDD _1022_[17] sky130_fd_sc_hd__a221o_1
X_19204_ u_core.arr_sa_p[16] net682 VSS VSS VDD VDD _04855_ sky130_fd_sc_hd__nand2_1
X_19205_ u_core.arr_sa_p[16] net775 _04855_ VSS VSS VDD VDD _04856_ sky130_fd_sc_hd__o21ai_0
X_19206_ net686 _10413_ net850 VSS VSS VDD VDD _04857_ sky130_fd_sc_hd__a21oi_1
X_19207_ _10413_ net680 _04856_ u_core.u_top.u_core.pend_p[16] _04857_ VSS VSS VDD VDD _1022_[16] sky130_fd_sc_hd__a221o_1
X_19208_ u_core.arr_sa_p[15] net682 VSS VSS VDD VDD _04858_ sky130_fd_sc_hd__nand2_1
X_19209_ u_core.arr_sa_p[15] net775 _04858_ VSS VSS VDD VDD _04859_ sky130_fd_sc_hd__o21ai_0
X_19211_ net686 _10419_ net850 VSS VSS VDD VDD _04861_ sky130_fd_sc_hd__a21oi_1
X_19212_ _10419_ net680 _04859_ u_core.u_top.u_core.pend_p[15] _04861_ VSS VSS VDD VDD _1022_[15] sky130_fd_sc_hd__a221o_1
X_19213_ u_core.arr_sa_p[14] net682 VSS VSS VDD VDD _04862_ sky130_fd_sc_hd__nand2_1
X_19214_ u_core.arr_sa_p[14] net775 _04862_ VSS VSS VDD VDD _04863_ sky130_fd_sc_hd__o21ai_0
X_19216_ net686 _10427_ net850 VSS VSS VDD VDD _04865_ sky130_fd_sc_hd__a21oi_1
X_19217_ _10427_ net680 _04863_ u_core.u_top.u_core.pend_p[14] _04865_ VSS VSS VDD VDD _1022_[14] sky130_fd_sc_hd__a221o_1
X_19218_ u_core.arr_sa_p[13] net682 VSS VSS VDD VDD _04866_ sky130_fd_sc_hd__nand2_1
X_19219_ u_core.arr_sa_p[13] net775 _04866_ VSS VSS VDD VDD _04867_ sky130_fd_sc_hd__o21ai_0
X_19220_ net686 _10433_ net850 VSS VSS VDD VDD _04868_ sky130_fd_sc_hd__a21oi_1
X_19221_ _10433_ net680 _04867_ u_core.u_top.u_core.pend_p[13] _04868_ VSS VSS VDD VDD _1022_[13] sky130_fd_sc_hd__a221o_1
X_19223_ u_core.arr_sa_p[12] net682 VSS VSS VDD VDD _04870_ sky130_fd_sc_hd__nand2_1
X_19224_ u_core.arr_sa_p[12] net775 _04870_ VSS VSS VDD VDD _04871_ sky130_fd_sc_hd__o21ai_0
X_19225_ net686 _10440_ net850 VSS VSS VDD VDD _04872_ sky130_fd_sc_hd__a21oi_1
X_19226_ _10440_ net680 _04871_ u_core.u_top.u_core.pend_p[12] _04872_ VSS VSS VDD VDD _1022_[12] sky130_fd_sc_hd__a221o_1
X_19227_ u_core.arr_sa_p[11] net682 VSS VSS VDD VDD _04873_ sky130_fd_sc_hd__nand2_1
X_19228_ u_core.arr_sa_p[11] net775 _04873_ VSS VSS VDD VDD _04874_ sky130_fd_sc_hd__o21ai_0
X_19229_ net686 _10447_ net850 VSS VSS VDD VDD _04875_ sky130_fd_sc_hd__a21oi_1
X_19230_ _10447_ net680 _04874_ u_core.u_top.u_core.pend_p[11] _04875_ VSS VSS VDD VDD _1022_[11] sky130_fd_sc_hd__a221o_1
X_19231_ u_core.arr_sa_p[10] net682 VSS VSS VDD VDD _04876_ sky130_fd_sc_hd__nand2_1
X_19232_ u_core.arr_sa_p[10] net775 _04876_ VSS VSS VDD VDD _04877_ sky130_fd_sc_hd__o21ai_0
X_19233_ net686 _10454_ net850 VSS VSS VDD VDD _04878_ sky130_fd_sc_hd__a21oi_1
X_19234_ _10454_ net680 _04877_ u_core.u_top.u_core.pend_p[10] _04878_ VSS VSS VDD VDD _1022_[10] sky130_fd_sc_hd__a221o_1
X_19235_ u_core.arr_sa_p[9] _04725_ VSS VSS VDD VDD _04879_ sky130_fd_sc_hd__nand2_1
X_19236_ u_core.arr_sa_p[9] _04722_ _04879_ VSS VSS VDD VDD _04880_ sky130_fd_sc_hd__o21ai_0
X_19237_ net686 _10460_ net850 VSS VSS VDD VDD _04881_ sky130_fd_sc_hd__a21oi_1
X_19238_ _10460_ net680 _04880_ u_core.u_top.u_core.pend_p[9] _04881_ VSS VSS VDD VDD _1022_[9] sky130_fd_sc_hd__a221o_1
X_19239_ u_core.arr_sa_p[8] _04725_ VSS VSS VDD VDD _04882_ sky130_fd_sc_hd__nand2_1
X_19240_ u_core.arr_sa_p[8] _04722_ _04882_ VSS VSS VDD VDD _04883_ sky130_fd_sc_hd__o21ai_0
X_19241_ net686 _10467_ net850 VSS VSS VDD VDD _04884_ sky130_fd_sc_hd__a21oi_1
X_19242_ _10467_ net680 _04883_ u_core.u_top.u_core.pend_p[8] _04884_ VSS VSS VDD VDD _1022_[8] sky130_fd_sc_hd__a221o_1
X_19243_ u_core.arr_sa_p[7] net682 VSS VSS VDD VDD _04885_ sky130_fd_sc_hd__nand2_1
X_19244_ u_core.arr_sa_p[7] net775 _04885_ VSS VSS VDD VDD _04886_ sky130_fd_sc_hd__o21ai_0
X_19245_ net686 _10473_ net850 VSS VSS VDD VDD _04887_ sky130_fd_sc_hd__a21oi_1
X_19246_ _10473_ net680 _04886_ u_core.u_top.u_core.pend_p[7] _04887_ VSS VSS VDD VDD _1022_[7] sky130_fd_sc_hd__a221o_1
X_19247_ u_core.arr_sa_p[6] _04725_ VSS VSS VDD VDD _04888_ sky130_fd_sc_hd__nand2_1
X_19248_ u_core.arr_sa_p[6] _04722_ _04888_ VSS VSS VDD VDD _04889_ sky130_fd_sc_hd__o21ai_0
X_19249_ net686 _10479_ net850 VSS VSS VDD VDD _04890_ sky130_fd_sc_hd__a21oi_1
X_19250_ _10479_ net680 _04889_ u_core.u_top.u_core.pend_p[6] _04890_ VSS VSS VDD VDD _1022_[6] sky130_fd_sc_hd__a221o_1
X_19251_ u_core.arr_sa_p[5] net682 VSS VSS VDD VDD _04891_ sky130_fd_sc_hd__nand2_1
X_19252_ u_core.arr_sa_p[5] net775 _04891_ VSS VSS VDD VDD _04892_ sky130_fd_sc_hd__o21ai_0
X_19253_ net686 _10485_ net850 VSS VSS VDD VDD _04893_ sky130_fd_sc_hd__a21oi_1
X_19254_ _10485_ net680 _04892_ u_core.u_top.u_core.pend_p[5] _04893_ VSS VSS VDD VDD _1022_[5] sky130_fd_sc_hd__a221o_1
X_19255_ u_core.arr_sa_p[4] net682 VSS VSS VDD VDD _04894_ sky130_fd_sc_hd__nand2_1
X_19256_ u_core.arr_sa_p[4] net775 _04894_ VSS VSS VDD VDD _04895_ sky130_fd_sc_hd__o21ai_0
X_19257_ net686 _10491_ net850 VSS VSS VDD VDD _04896_ sky130_fd_sc_hd__a21oi_1
X_19258_ _10491_ net680 _04895_ u_core.u_top.u_core.pend_p[4] _04896_ VSS VSS VDD VDD _1022_[4] sky130_fd_sc_hd__a221o_1
X_19259_ net978 net682 VSS VSS VDD VDD _04897_ sky130_fd_sc_hd__nand2_1
X_19260_ net978 net775 _04897_ VSS VSS VDD VDD _04898_ sky130_fd_sc_hd__o21ai_0
X_19261_ net686 _10498_ net850 VSS VSS VDD VDD _04899_ sky130_fd_sc_hd__a21oi_1
X_19262_ _10498_ net680 _04898_ u_core.u_top.u_core.pend_p[3] _04899_ VSS VSS VDD VDD _1022_[3] sky130_fd_sc_hd__a221o_1
X_19263_ u_core.arr_sa_p[2] _04725_ VSS VSS VDD VDD _04900_ sky130_fd_sc_hd__nand2_1
X_19264_ u_core.arr_sa_p[2] _04722_ _04900_ VSS VSS VDD VDD _04901_ sky130_fd_sc_hd__o21ai_0
X_19265_ net686 _10504_ net850 VSS VSS VDD VDD _04902_ sky130_fd_sc_hd__a21oi_1
X_19266_ _10504_ net680 _04901_ u_core.u_top.u_core.pend_p[2] _04902_ VSS VSS VDD VDD _1022_[2] sky130_fd_sc_hd__a221o_1
X_19267_ u_core.arr_sa_p[1] net682 VSS VSS VDD VDD _04903_ sky130_fd_sc_hd__nand2_1
X_19268_ u_core.arr_sa_p[1] net775 _04903_ VSS VSS VDD VDD _04904_ sky130_fd_sc_hd__o21ai_0
X_19269_ net686 _10510_ net850 VSS VSS VDD VDD _04905_ sky130_fd_sc_hd__a21oi_1
X_19270_ _10510_ net680 _04904_ u_core.u_top.u_core.pend_p[1] _04905_ VSS VSS VDD VDD _1022_[1] sky130_fd_sc_hd__a221o_1
X_19271_ u_core.arr_sa_p[0] _04725_ VSS VSS VDD VDD _04906_ sky130_fd_sc_hd__nand2_1
X_19272_ u_core.arr_sa_p[0] _04722_ _04906_ VSS VSS VDD VDD _04907_ sky130_fd_sc_hd__o21ai_0
X_19273_ net686 _10516_ net850 VSS VSS VDD VDD _04908_ sky130_fd_sc_hd__a21oi_1
X_19274_ _10516_ net680 _04907_ u_core.u_top.u_core.pend_p[0] _04908_ VSS VSS VDD VDD _1022_[0] sky130_fd_sc_hd__a221o_1
X_19275_ net684 net787 VSS VSS VDD VDD _04909_ sky130_fd_sc_hd__nand2_1
X_19276_ u_core.u_top.bus_we _10195_ VSS VSS VDD VDD _04910_ sky130_fd_sc_hd__nand2_1
X_19277_ u_core.u_top.u_core.r_en _06599_ net865 VSS VSS VDD VDD _04911_ sky130_fd_sc_hd__nand3_1
X_19278_ _07278_ _04910_ _04911_ VSS VSS VDD VDD _04912_ sky130_fd_sc_hd__nor3_2
X_19279_ net972 net971 _04912_ VSS VSS VDD VDD _04913_ sky130_fd_sc_hd__and3_1
X_19280_ _10147_ _10170_ _10188_ _04913_ VSS VSS VDD VDD _04914_ sky130_fd_sc_hd__a31o_1
X_19282_ net982 _10119_ _04914_ VSS VSS VDD VDD _04916_ sky130_fd_sc_hd__mux2i_1
X_19283_ _11211_ _11212_ _11213_ _11184_ u_core.u_top.u_core.lfsr_m72[5] VSS VSS VDD VDD _04917_ sky130_fd_sc_hd__a32o_1
X_19284_ net776 _11119_ _04917_ net685 VSS VSS VDD VDD _04918_ sky130_fd_sc_hd__a22oi_1
X_19285_ _04909_ _04916_ _04918_ VSS VSS VDD VDD _1019_[5] sky130_fd_sc_hd__o21ai_1
X_19286_ net983 _10126_ _04914_ VSS VSS VDD VDD _04919_ sky130_fd_sc_hd__mux2i_1
X_19287_ _11190_ _11196_ VSS VSS VDD VDD _04920_ sky130_fd_sc_hd__nand2_1
X_19288_ _04920_ _11210_ _11212_ VSS VSS VDD VDD _04921_ sky130_fd_sc_hd__o21ai_0
X_19289_ u_core.u_top.u_core.lfsr_m72[4] _11184_ _11213_ _04921_ VSS VSS VDD VDD _04922_ sky130_fd_sc_hd__a22oi_1
X_19290_ net684 _04922_ VSS VSS VDD VDD _04923_ sky130_fd_sc_hd__nor2_1
X_19291_ net776 _11131_ _04923_ VSS VSS VDD VDD _04924_ sky130_fd_sc_hd__a21oi_1
X_19292_ _04909_ _04919_ _04924_ VSS VSS VDD VDD _1019_[4] sky130_fd_sc_hd__o21ai_1
X_19293_ net984 _10124_ _04914_ VSS VSS VDD VDD _04925_ sky130_fd_sc_hd__mux2i_1
X_19294_ net787 _11126_ _11202_ net684 VSS VSS VDD VDD _04926_ sky130_fd_sc_hd__o22a_1
X_19295_ _04909_ _04925_ _04926_ VSS VSS VDD VDD _1019_[3] sky130_fd_sc_hd__o21ai_1
X_19296_ _03283_ _03284_ u_core.u_top.u_core.r_prow[11] VSS VSS VDD VDD _04927_ sky130_fd_sc_hd__mux2i_1
X_19297_ net954 _04927_ VSS VSS VDD VDD _04928_ sky130_fd_sc_hd__nand2_1
X_19298_ _10104_ _04928_ VSS VSS VDD VDD _04929_ sky130_fd_sc_hd__xor2_1
X_19299_ net985 _04929_ _04914_ VSS VSS VDD VDD _04930_ sky130_fd_sc_hd__mux2i_1
X_19300_ net776 _10971_ _11185_ net685 VSS VSS VDD VDD _04931_ sky130_fd_sc_hd__a22oi_1
X_19301_ _04909_ _04930_ _04931_ VSS VSS VDD VDD _1019_[2] sky130_fd_sc_hd__o21ai_1
X_19302_ _0905_[1] _0907_[1] u_core.u_top.u_core.r_prow[11] VSS VSS VDD VDD _04932_ sky130_fd_sc_hd__mux2_1
X_19303_ net954 _04932_ VSS VSS VDD VDD _04933_ sky130_fd_sc_hd__nand2_1
X_19304_ net954 _02586_ _04933_ VSS VSS VDD VDD _04934_ sky130_fd_sc_hd__o21ai_0
X_19305_ net986 _04934_ _04914_ VSS VSS VDD VDD _04935_ sky130_fd_sc_hd__mux2i_1
X_19306_ u_core.u_top.u_core.r_x[66] net910 VSS VSS VDD VDD _04936_ sky130_fd_sc_hd__nor2_1
X_19307_ u_core.u_top.u_core.r_x[98] net900 VSS VSS VDD VDD _04937_ sky130_fd_sc_hd__nor2_1
X_19308_ net933 u_core.u_top.u_core.r_x[128] VSS VSS VDD VDD _04938_ sky130_fd_sc_hd__nor2_1
X_19309_ net931 net932 VSS VSS VDD VDD _04939_ sky130_fd_sc_hd__nor2_1
X_19310_ net929 net930 _11193_ _04939_ VSS VSS VDD VDD _04940_ sky130_fd_sc_hd__o31ai_1
X_19311_ _04938_ _04940_ u_core.u_top.u_core.r_x[126] u_core.u_top.u_core.r_x[124] VSS VSS VDD VDD _04941_ sky130_fd_sc_hd__a211oi_1
X_19312_ u_core.u_top.u_core.r_x[122] net935 _04941_ _11157_ VSS VSS VDD VDD _04942_ sky130_fd_sc_hd__o31ai_1
X_19313_ _11158_ _04942_ u_core.u_top.u_core.r_x[110] net940 VSS VSS VDD VDD _04943_ sky130_fd_sc_hd__a211oi_1
X_19314_ net943 net944 VSS VSS VDD VDD _04944_ sky130_fd_sc_hd__nor2_1
X_19315_ net941 net942 _04943_ _04944_ VSS VSS VDD VDD _04945_ sky130_fd_sc_hd__o31ai_1
X_19316_ _04937_ _04945_ net901 u_core.u_top.u_core.r_x[92] VSS VSS VDD VDD _04946_ sky130_fd_sc_hd__a211oi_1
X_19317_ u_core.u_top.u_core.r_x[90] net903 _04946_ _11153_ VSS VSS VDD VDD _04947_ sky130_fd_sc_hd__o31ai_1
X_19318_ _11154_ _04947_ net906 u_core.u_top.u_core.r_x[76] VSS VSS VDD VDD _04948_ sky130_fd_sc_hd__a211oi_1
X_19319_ u_core.u_top.u_core.r_x[74] net907 _04948_ _10999_ _10930_ VSS VSS VDD VDD _04949_ sky130_fd_sc_hd__o311ai_0
X_19320_ _04936_ _04949_ u_core.u_top.u_core.r_x[62] net911 VSS VSS VDD VDD _04950_ sky130_fd_sc_hd__a211oi_1
X_19321_ u_core.u_top.u_core.r_x[58] net912 _04950_ _11149_ VSS VSS VDD VDD _04951_ sky130_fd_sc_hd__o31a_1
X_19322_ _11148_ _11173_ _11150_ VSS VSS VDD VDD _04952_ sky130_fd_sc_hd__nand3_1
X_19323_ net918 net919 _11172_ _11147_ VSS VSS VDD VDD _04953_ sky130_fd_sc_hd__o31ai_1
X_19324_ _11148_ _04953_ VSS VSS VDD VDD _04954_ sky130_fd_sc_hd__nand2_1
X_19325_ _04951_ _04952_ _11176_ _04954_ VSS VSS VDD VDD _04955_ sky130_fd_sc_hd__o211ai_1
X_19326_ net685 _11187_ _11200_ VSS VSS VDD VDD _04956_ sky130_fd_sc_hd__and3_1
X_19327_ net926 net927 _11145_ _11186_ VSS VSS VDD VDD _04957_ sky130_fd_sc_hd__o31ai_1
X_19328_ u_core.u_top.u_core.r_x[2] _11181_ _11183_ VSS VSS VDD VDD _04958_ sky130_fd_sc_hd__nor3_1
X_19329_ net993 _11184_ _11187_ _04957_ _04958_ VSS VSS VDD VDD _04959_ sky130_fd_sc_hd__a221oi_1
X_19330_ net776 _11103_ VSS VSS VDD VDD _04960_ sky130_fd_sc_hd__nand2_1
X_19331_ net684 _04959_ _04960_ VSS VSS VDD VDD _04961_ sky130_fd_sc_hd__o21ai_0
X_19332_ _04955_ _04956_ _04961_ VSS VSS VDD VDD _04962_ sky130_fd_sc_hd__a21oi_1
X_19333_ _04909_ _04935_ _04962_ VSS VSS VDD VDD _1019_[1] sky130_fd_sc_hd__o21ai_1
X_19334_ _10189_ _04913_ VSS VSS VDD VDD _04963_ sky130_fd_sc_hd__nor2_1
X_19335_ _10120_ _0905_[0] VSS VSS VDD VDD _04964_ sky130_fd_sc_hd__xnor2_1
X_19336_ net972 net971 _04912_ VSS VSS VDD VDD _04965_ sky130_fd_sc_hd__nand3_1
X_19337_ net686 _04964_ VSS VSS VDD VDD _04966_ sky130_fd_sc_hd__nor2_1
X_19338_ _04965_ _04966_ net787 net987 net684 VSS VSS VDD VDD _04967_ sky130_fd_sc_hd__o2111ai_1
X_19339_ _10189_ _04967_ _11058_ net776 VSS VSS VDD VDD _04968_ sky130_fd_sc_hd__a2bb2oi_1
X_19340_ net940 VSS VSS VDD VDD _04969_ sky130_fd_sc_hd__inv_1
X_19341_ net937 VSS VSS VDD VDD _04970_ sky130_fd_sc_hd__inv_1
X_19342_ u_core.u_top.u_core.r_x[142] _06453_ net929 VSS VSS VDD VDD _04971_ sky130_fd_sc_hd__a21oi_1
X_19343_ net930 _04971_ net931 VSS VSS VDD VDD _04972_ sky130_fd_sc_hd__o21bai_1
X_19344_ _06454_ _04972_ net933 VSS VSS VDD VDD _04973_ sky130_fd_sc_hd__a21oi_1
X_19345_ u_core.u_top.u_core.r_x[128] _04973_ _10842_ VSS VSS VDD VDD _04974_ sky130_fd_sc_hd__o21ai_0
X_19346_ _06399_ _04974_ u_core.u_top.u_core.r_x[122] VSS VSS VDD VDD _04975_ sky130_fd_sc_hd__a21oi_1
X_19347_ net935 _04975_ net936 VSS VSS VDD VDD _04976_ sky130_fd_sc_hd__o21bai_1
X_19348_ _04970_ _04976_ u_core.u_top.u_core.r_x[114] VSS VSS VDD VDD _04977_ sky130_fd_sc_hd__a21oi_1
X_19349_ net938 _04977_ u_core.u_top.u_core.r_x[110] VSS VSS VDD VDD _04978_ sky130_fd_sc_hd__o21bai_1
X_19350_ _04969_ _04978_ net941 VSS VSS VDD VDD _04979_ sky130_fd_sc_hd__a21oi_1
X_19351_ net942 _04979_ VSS VSS VDD VDD _04980_ sky130_fd_sc_hd__nor2_1
X_19352_ net944 net900 u_core.u_top.u_core.r_x[92] net903 VSS VSS VDD VDD _04981_ sky130_fd_sc_hd__nor4_1
X_19353_ net943 _04980_ _04981_ VSS VSS VDD VDD _04982_ sky130_fd_sc_hd__o21ai_0
X_19354_ net900 u_core.u_top.u_core.r_x[92] net903 VSS VSS VDD VDD _04983_ sky130_fd_sc_hd__nor3_1
X_19355_ net901 _06402_ u_core.u_top.u_core.r_x[90] VSS VSS VDD VDD _04984_ sky130_fd_sc_hd__a21oi_1
X_19356_ net904 u_core.u_top.u_core.r_x[82] net906 VSS VSS VDD VDD _04985_ sky130_fd_sc_hd__nor3_1
X_19357_ net903 _04984_ _04985_ VSS VSS VDD VDD _04986_ sky130_fd_sc_hd__o21ai_0
X_19358_ u_core.u_top.u_core.r_x[98] _04983_ _04986_ VSS VSS VDD VDD _04987_ sky130_fd_sc_hd__a21oi_1
X_19359_ u_core.u_top.u_core.r_x[82] VSS VSS VDD VDD _04988_ sky130_fd_sc_hd__inv_1
X_19360_ net905 _04988_ u_core.u_top.u_core.r_x[80] VSS VSS VDD VDD _04989_ sky130_fd_sc_hd__a21oi_1
X_19361_ u_core.u_top.u_core.r_x[76] net907 net909 VSS VSS VDD VDD _04990_ sky130_fd_sc_hd__nor3_1
X_19362_ net910 _10898_ net911 VSS VSS VDD VDD _04991_ sky130_fd_sc_hd__a21oi_1
X_19363_ u_core.u_top.u_core.r_x[58] _04991_ VSS VSS VDD VDD _04992_ sky130_fd_sc_hd__nor2_1
X_19364_ net912 net913 net915 _04992_ VSS VSS VDD VDD _04993_ sky130_fd_sc_hd__nor4_1
X_19365_ net906 _04989_ _04990_ _04993_ VSS VSS VDD VDD _04994_ sky130_fd_sc_hd__o211ai_1
X_19366_ net924 _10754_ net925 VSS VSS VDD VDD _04995_ sky130_fd_sc_hd__a21oi_1
X_19367_ u_core.u_top.u_core.r_x[34] _11045_ u_core.u_top.u_core.r_x[30] VSS VSS VDD VDD _04996_ sky130_fd_sc_hd__a21oi_1
X_19368_ u_core.u_top.u_core.r_x[26] u_core.u_top.u_core.r_x[22] net926 VSS VSS VDD VDD _04997_ sky130_fd_sc_hd__nor3_1
X_19369_ net923 _04996_ _04997_ VSS VSS VDD VDD _04998_ sky130_fd_sc_hd__o21ai_0
X_19370_ net918 VSS VSS VDD VDD _04999_ sky130_fd_sc_hd__inv_1
X_19371_ net917 _04999_ net919 VSS VSS VDD VDD _05000_ sky130_fd_sc_hd__a21oi_1
X_19372_ net920 _05000_ VSS VSS VDD VDD _05001_ sky130_fd_sc_hd__nor2_1
X_19373_ net921 net922 net923 _05001_ VSS VSS VDD VDD _05002_ sky130_fd_sc_hd__nor4_1
X_19374_ net927 net934 net902 VSS VSS VDD VDD _05003_ sky130_fd_sc_hd__nor3_1
X_19375_ _11203_ u_core.u_top.u_core.r_x[2] _05003_ VSS VSS VDD VDD _05004_ sky130_fd_sc_hd__o21ai_0
X_19376_ _11181_ _05004_ VSS VSS VDD VDD _05005_ sky130_fd_sc_hd__nor2_1
X_19377_ net926 _04995_ _04998_ _05002_ _05005_ VSS VSS VDD VDD _05006_ sky130_fd_sc_hd__o221ai_1
X_19378_ _04982_ _04987_ _04994_ _05006_ VSS VSS VDD VDD _05007_ sky130_fd_sc_hd__a211oi_1
X_19379_ net907 VSS VSS VDD VDD _05008_ sky130_fd_sc_hd__inv_1
X_19380_ u_core.u_top.u_core.r_x[74] _05008_ u_core.u_top.u_core.r_x[70] VSS VSS VDD VDD _05009_ sky130_fd_sc_hd__a21oi_1
X_19381_ u_core.u_top.u_core.r_x[66] u_core.u_top.u_core.r_x[62] u_core.u_top.u_core.r_x[58] VSS VSS VDD VDD _05010_ sky130_fd_sc_hd__nor3_1
X_19382_ net909 _05009_ _05010_ VSS VSS VDD VDD _05011_ sky130_fd_sc_hd__o21ai_0
X_19383_ u_core.u_top.u_core.r_x[54] _07578_ u_core.u_top.u_core.r_x[50] VSS VSS VDD VDD _05012_ sky130_fd_sc_hd__a21oi_1
X_19384_ net916 net918 net920 VSS VSS VDD VDD _05013_ sky130_fd_sc_hd__nor3_1
X_19385_ net915 _05012_ _05013_ VSS VSS VDD VDD _05014_ sky130_fd_sc_hd__o21ai_0
X_19386_ _04993_ _05011_ _04998_ _05014_ VSS VSS VDD VDD _05015_ sky130_fd_sc_hd__a211oi_1
X_19387_ _05006_ _05015_ VSS VSS VDD VDD _05016_ sky130_fd_sc_hd__nor2_1
X_19388_ _11208_ _05007_ _05016_ net685 VSS VSS VDD VDD _05017_ sky130_fd_sc_hd__o31ai_1
X_19389_ _04909_ _04963_ _04964_ _04968_ _05017_ VSS VSS VDD VDD _1019_[0] sky130_fd_sc_hd__o311ai_1
X_19391_ net989 u_core.arr_op[1] _10235_ VSS VSS VDD VDD _05019_ sky130_fd_sc_hd__a21oi_1
X_19392_ net989 u_core.arr_op[1] VSS VSS VDD VDD _05020_ sky130_fd_sc_hd__nand2_1
X_19393_ _10224_ _05020_ _10214_ VSS VSS VDD VDD _05021_ sky130_fd_sc_hd__a21oi_1
X_19394_ _04835_ _05021_ net897 VSS VSS VDD VDD _05022_ sky130_fd_sc_hd__o21ai_0
X_19395_ net790 _05019_ _05022_ net681 VSS VSS VDD VDD _1017_[1] sky130_fd_sc_hd__o211ai_1
X_19396_ net897 net886 VSS VSS VDD VDD _05023_ sky130_fd_sc_hd__nand2_1
X_19397_ net898 net989 u_core.arr_op[0] VSS VSS VDD VDD _05024_ sky130_fd_sc_hd__nand3_1
X_19398_ _10223_ _05024_ VSS VSS VDD VDD _05025_ sky130_fd_sc_hd__nand2_1
X_19399_ net861 _05025_ VSS VSS VDD VDD _05026_ sky130_fd_sc_hd__nand2_1
X_19400_ net1000 u_core.arr_op[0] _10224_ VSS VSS VDD VDD _05027_ sky130_fd_sc_hd__o21ai_0
X_19401_ net886 _05027_ VSS VSS VDD VDD _05028_ sky130_fd_sc_hd__nand2_1
X_19402_ net1000 u_core.arr_op[0] _10244_ _05028_ VSS VSS VDD VDD _05029_ sky130_fd_sc_hd__o31ai_1
X_19403_ _10211_ _05023_ _05026_ _05029_ net897 VSS VSS VDD VDD _1017_[0] sky130_fd_sc_hd__a32oi_1
X_19404_ u_core.u_top.u_core.d_acc[130] VSS VSS VDD VDD _0294_[0] sky130_fd_sc_hd__inv_1
X_19406_ _02882_ VSS VSS VDD VDD _05030_ sky130_fd_sc_hd__inv_1
X_19407_ _02529_ VSS VSS VDD VDD _05031_ sky130_fd_sc_hd__inv_1
X_19408_ _03045_ u_core.u_top.u_core.d_acc[30] _03089_ VSS VSS VDD VDD _05032_ sky130_fd_sc_hd__a21o_1
X_19409_ _03351_ _05032_ _03350_ VSS VSS VDD VDD _05033_ sky130_fd_sc_hd__a21oi_1
X_19410_ _05031_ _05033_ _02528_ VSS VSS VDD VDD _05034_ sky130_fd_sc_hd__o21bai_1
X_19411_ _03319_ _05034_ _03318_ VSS VSS VDD VDD _05035_ sky130_fd_sc_hd__a21oi_1
X_19412_ _05030_ _05035_ _02881_ VSS VSS VDD VDD _05036_ sky130_fd_sc_hd__o21bai_1
X_19413_ _03183_ _05036_ _03182_ VSS VSS VDD VDD _05037_ sky130_fd_sc_hd__a21oi_1
X_19414_ _02545_ _05037_ VSS VSS VDD VDD _0243_[7] sky130_fd_sc_hd__xnor2_1
X_19415_ _02529_ _05033_ VSS VSS VDD VDD _0243_[3] sky130_fd_sc_hd__xnor2_1
X_19416_ _03294_ _06214_ VSS VSS VDD VDD _0327_[3] sky130_fd_sc_hd__xnor2_1
X_19417_ _02865_ VSS VSS VDD VDD _05038_ sky130_fd_sc_hd__inv_1
X_19418_ _02873_ VSS VSS VDD VDD _05039_ sky130_fd_sc_hd__inv_1
X_19419_ u_core.u_top.u_core.d_acc[40] _02658_ _02657_ VSS VSS VDD VDD _05040_ sky130_fd_sc_hd__a21o_1
X_19420_ _02549_ _05040_ _02548_ VSS VSS VDD VDD _05041_ sky130_fd_sc_hd__a21oi_1
X_19421_ _05039_ _05041_ _02872_ VSS VSS VDD VDD _05042_ sky130_fd_sc_hd__o21bai_1
X_19422_ _02869_ _05042_ _02868_ VSS VSS VDD VDD _05043_ sky130_fd_sc_hd__a21oi_1
X_19423_ _05038_ _05043_ _02864_ VSS VSS VDD VDD _05044_ sky130_fd_sc_hd__o21bai_1
X_19424_ _02553_ _05044_ _02552_ VSS VSS VDD VDD _05045_ sky130_fd_sc_hd__a21oi_1
X_19425_ _02564_ _05045_ VSS VSS VDD VDD _0249_[7] sky130_fd_sc_hd__xnor2_1
X_19426_ _02873_ _05041_ VSS VSS VDD VDD _0249_[3] sky130_fd_sc_hd__xnor2_1
X_19427_ u_core.u_top.u_core.acc[151] VSS VSS VDD VDD _02849_ sky130_fd_sc_hd__inv_1
X_19428_ _03216_ VSS VSS VDD VDD _05046_ sky130_fd_sc_hd__inv_1
X_19429_ _02504_ VSS VSS VDD VDD _05047_ sky130_fd_sc_hd__inv_1
X_19430_ _02335_ VSS VSS VDD VDD _05048_ sky130_fd_sc_hd__inv_1
X_19431_ _02779_ _05048_ _02778_ VSS VSS VDD VDD _05049_ sky130_fd_sc_hd__a21oi_1
X_19432_ _02503_ VSS VSS VDD VDD _05050_ sky130_fd_sc_hd__inv_1
X_19433_ _05047_ _05049_ _05050_ VSS VSS VDD VDD _05051_ sky130_fd_sc_hd__o21ai_0
X_19434_ _03036_ _05051_ _03035_ VSS VSS VDD VDD _05052_ sky130_fd_sc_hd__a21oi_1
X_19435_ _05046_ _05052_ _03215_ VSS VSS VDD VDD _05053_ sky130_fd_sc_hd__o21bai_1
X_19436_ _02812_ _05053_ _02811_ VSS VSS VDD VDD _05054_ sky130_fd_sc_hd__a21o_1
X_19437_ _02781_ _05054_ _02780_ VSS VSS VDD VDD _05055_ sky130_fd_sc_hd__a21oi_1
X_19438_ _03194_ _05055_ VSS VSS VDD VDD _0316_[8] sky130_fd_sc_hd__xnor2_1
X_19439_ _02812_ _05053_ VSS VSS VDD VDD _0316_[6] sky130_fd_sc_hd__xor2_1
X_19440_ _03036_ _05051_ VSS VSS VDD VDD _0316_[4] sky130_fd_sc_hd__xor2_1
X_19441_ _02779_ _02335_ VSS VSS VDD VDD _0316_[2] sky130_fd_sc_hd__xnor2_1
X_19442_ _02405_ VSS VSS VDD VDD _05056_ sky130_fd_sc_hd__inv_1
X_19443_ _05056_ _03351_ _03350_ VSS VSS VDD VDD _05057_ sky130_fd_sc_hd__a21oi_1
X_19444_ _05031_ _05057_ _02528_ VSS VSS VDD VDD _05058_ sky130_fd_sc_hd__o21bai_1
X_19445_ _03319_ _05058_ _03318_ VSS VSS VDD VDD _05059_ sky130_fd_sc_hd__a21oi_1
X_19446_ _05030_ _05059_ _02881_ VSS VSS VDD VDD _05060_ sky130_fd_sc_hd__o21bai_1
X_19447_ _03183_ _05060_ _03182_ VSS VSS VDD VDD _05061_ sky130_fd_sc_hd__a21o_1
X_19448_ _02545_ _05061_ _02544_ VSS VSS VDD VDD _05062_ sky130_fd_sc_hd__a21oi_1
X_19449_ _03113_ _05062_ VSS VSS VDD VDD _0243_[8] sky130_fd_sc_hd__xnor2_1
X_19450_ _03319_ _05058_ VSS VSS VDD VDD _0243_[4] sky130_fd_sc_hd__xor2_1
X_19451_ _03169_ VSS VSS VDD VDD _05063_ sky130_fd_sc_hd__inv_1
X_19452_ _02951_ VSS VSS VDD VDD _05064_ sky130_fd_sc_hd__inv_1
X_19453_ _02417_ VSS VSS VDD VDD _05065_ sky130_fd_sc_hd__inv_1
X_19454_ _03056_ _05065_ _03055_ VSS VSS VDD VDD _05066_ sky130_fd_sc_hd__a21oi_1
X_19455_ _02950_ VSS VSS VDD VDD _05067_ sky130_fd_sc_hd__inv_1
X_19456_ _05064_ _05066_ _05067_ VSS VSS VDD VDD _05068_ sky130_fd_sc_hd__o21ai_0
X_19457_ _02888_ _05068_ _02887_ VSS VSS VDD VDD _05069_ sky130_fd_sc_hd__a21oi_1
X_19458_ _05063_ _05069_ _03168_ VSS VSS VDD VDD _05070_ sky130_fd_sc_hd__o21bai_1
X_19459_ _02742_ _05070_ _02741_ VSS VSS VDD VDD _05071_ sky130_fd_sc_hd__a21o_1
X_19460_ _02551_ _05071_ _02550_ VSS VSS VDD VDD _05072_ sky130_fd_sc_hd__a21oi_1
X_19461_ _03222_ _05072_ VSS VSS VDD VDD _0333_[8] sky130_fd_sc_hd__xnor2_1
X_19462_ _03317_ VSS VSS VDD VDD _05073_ sky130_fd_sc_hd__inv_1
X_19463_ _03146_ VSS VSS VDD VDD _05074_ sky130_fd_sc_hd__inv_1
X_19464_ _05074_ _09519_ _03145_ VSS VSS VDD VDD _05075_ sky130_fd_sc_hd__o21bai_1
X_19465_ _03091_ _05075_ _03090_ VSS VSS VDD VDD _05076_ sky130_fd_sc_hd__a21oi_1
X_19466_ _05073_ _05076_ _03316_ VSS VSS VDD VDD _05077_ sky130_fd_sc_hd__o21bai_1
X_19467_ _03431_ _05077_ _03430_ VSS VSS VDD VDD _05078_ sky130_fd_sc_hd__a21oi_1
X_19468_ _03064_ _05078_ VSS VSS VDD VDD _0306_[7] sky130_fd_sc_hd__xnor2_1
X_19469_ _03108_ VSS VSS VDD VDD _05079_ sky130_fd_sc_hd__inv_1
X_19470_ _02614_ VSS VSS VDD VDD _05080_ sky130_fd_sc_hd__inv_1
X_19471_ u_core.u_top.u_core.d_acc[50] _02581_ _02580_ VSS VSS VDD VDD _05081_ sky130_fd_sc_hd__a21o_1
X_19472_ _02771_ _05081_ _02770_ VSS VSS VDD VDD _05082_ sky130_fd_sc_hd__a21oi_1
X_19473_ _05080_ _05082_ _02613_ VSS VSS VDD VDD _05083_ sky130_fd_sc_hd__o21bai_1
X_19474_ _03181_ _05083_ _03180_ VSS VSS VDD VDD _05084_ sky130_fd_sc_hd__a21oi_1
X_19475_ _05079_ _05084_ _03107_ VSS VSS VDD VDD _05085_ sky130_fd_sc_hd__o21bai_1
X_19476_ _02706_ _05085_ _02705_ VSS VSS VDD VDD _05086_ sky130_fd_sc_hd__a21oi_1
X_19477_ _03152_ _05086_ VSS VSS VDD VDD _0254_[7] sky130_fd_sc_hd__xnor2_1
X_19478_ _02614_ _05082_ VSS VSS VDD VDD _0254_[3] sky130_fd_sc_hd__xnor2_1
X_19479_ _02402_ VSS VSS VDD VDD _0274_[1] sky130_fd_sc_hd__inv_1
X_19480_ _02389_ VSS VSS VDD VDD _05087_ sky130_fd_sc_hd__inv_1
X_19481_ _03138_ _05087_ _03137_ VSS VSS VDD VDD _05088_ sky130_fd_sc_hd__a21oi_1
X_19482_ _05074_ _05088_ _03145_ VSS VSS VDD VDD _05089_ sky130_fd_sc_hd__o21bai_1
X_19483_ _03091_ _05089_ _03090_ VSS VSS VDD VDD _05090_ sky130_fd_sc_hd__a21oi_1
X_19484_ _05073_ _05090_ _03316_ VSS VSS VDD VDD _05091_ sky130_fd_sc_hd__o21bai_1
X_19485_ _03431_ _05091_ _03430_ VSS VSS VDD VDD _05092_ sky130_fd_sc_hd__a21o_1
X_19486_ _03064_ _05092_ _03063_ VSS VSS VDD VDD _05093_ sky130_fd_sc_hd__a21oi_1
X_19487_ _02622_ _05093_ VSS VSS VDD VDD _0306_[8] sky130_fd_sc_hd__xnor2_1
X_19488_ _02763_ VSS VSS VDD VDD _05094_ sky130_fd_sc_hd__inv_1
X_19489_ _02561_ VSS VSS VDD VDD _05095_ sky130_fd_sc_hd__inv_1
X_19490_ _02361_ VSS VSS VDD VDD _05096_ sky130_fd_sc_hd__inv_1
X_19491_ _02999_ _05096_ _02998_ VSS VSS VDD VDD _05097_ sky130_fd_sc_hd__a21oi_1
X_19492_ _02560_ VSS VSS VDD VDD _05098_ sky130_fd_sc_hd__inv_1
X_19493_ _05095_ _05097_ _05098_ VSS VSS VDD VDD _05099_ sky130_fd_sc_hd__o21ai_0
X_19494_ _02577_ _05099_ _02576_ VSS VSS VDD VDD _05100_ sky130_fd_sc_hd__a21oi_1
X_19495_ _05094_ _05100_ _02762_ VSS VSS VDD VDD _05101_ sky130_fd_sc_hd__o21bai_1
X_19496_ _02572_ _05101_ _02571_ VSS VSS VDD VDD _05102_ sky130_fd_sc_hd__a21o_1
X_19497_ _03157_ _05102_ _03156_ VSS VSS VDD VDD _05103_ sky130_fd_sc_hd__a21oi_1
X_19498_ _02783_ _05103_ VSS VSS VDD VDD _0259_[8] sky130_fd_sc_hd__xnor2_1
X_19499_ _02577_ _05099_ VSS VSS VDD VDD _0259_[4] sky130_fd_sc_hd__xor2_1
X_19500_ u_core.u_top.u_core.r_off[2] VSS VSS VDD VDD _02485_ sky130_fd_sc_hd__inv_2
X_19501_ _02409_ VSS VSS VDD VDD _05104_ sky130_fd_sc_hd__inv_1
X_19502_ _02549_ _05104_ _02548_ VSS VSS VDD VDD _05105_ sky130_fd_sc_hd__a21oi_1
X_19503_ _05039_ _05105_ _02872_ VSS VSS VDD VDD _05106_ sky130_fd_sc_hd__o21bai_1
X_19504_ _02869_ _05106_ _02868_ VSS VSS VDD VDD _05107_ sky130_fd_sc_hd__a21oi_1
X_19505_ _05038_ _05107_ _02864_ VSS VSS VDD VDD _05108_ sky130_fd_sc_hd__o21bai_1
X_19506_ _02553_ _05108_ _02552_ VSS VSS VDD VDD _05109_ sky130_fd_sc_hd__a21o_1
X_19507_ _02564_ _05109_ _02563_ VSS VSS VDD VDD _05110_ sky130_fd_sc_hd__a21oi_1
X_19508_ _02991_ _05110_ VSS VSS VDD VDD _0249_[8] sky130_fd_sc_hd__xnor2_1
X_19509_ u_core.u_top.u_core.d_acc[79] u_core.u_top.u_core.lfsr[7] VSS VSS VDD VDD _05111_ sky130_fd_sc_hd__xnor2_1
X_19510_ _03022_ VSS VSS VDD VDD _05112_ sky130_fd_sc_hd__inv_1
X_19511_ u_core.u_top.u_core.d_acc[70] _02889_ _02943_ VSS VSS VDD VDD _05113_ sky130_fd_sc_hd__a21o_1
X_19512_ _02769_ _05113_ _02768_ VSS VSS VDD VDD _05114_ sky130_fd_sc_hd__a21oi_1
X_19513_ _08100_ _05114_ _08103_ VSS VSS VDD VDD _05115_ sky130_fd_sc_hd__o21ai_0
X_19514_ _03368_ _05115_ _03367_ VSS VSS VDD VDD _05116_ sky130_fd_sc_hd__a21oi_1
X_19515_ _08099_ _05116_ _03393_ VSS VSS VDD VDD _05117_ sky130_fd_sc_hd__o21bai_1
X_19516_ _02945_ _05117_ _02944_ VSS VSS VDD VDD _05118_ sky130_fd_sc_hd__a21oi_1
X_19517_ _05112_ _05118_ _03021_ VSS VSS VDD VDD _05119_ sky130_fd_sc_hd__o21bai_1
X_19518_ _03392_ _05119_ _03391_ VSS VSS VDD VDD _05120_ sky130_fd_sc_hd__a21oi_1
X_19519_ _05111_ _05120_ VSS VSS VDD VDD _0264_[9] sky130_fd_sc_hd__xnor2_1
X_19520_ _02869_ _05106_ VSS VSS VDD VDD _0249_[4] sky130_fd_sc_hd__xor2_1
X_19521_ _03394_ _05116_ VSS VSS VDD VDD _0264_[5] sky130_fd_sc_hd__xnor2_1
X_19522_ _02590_ VSS VSS VDD VDD _05121_ sky130_fd_sc_hd__inv_1
X_19523_ _03315_ VSS VSS VDD VDD _05122_ sky130_fd_sc_hd__inv_1
X_19524_ _02420_ VSS VSS VDD VDD _05123_ sky130_fd_sc_hd__inv_1
X_19525_ _03131_ _05123_ _03130_ VSS VSS VDD VDD _05124_ sky130_fd_sc_hd__a21oi_1
X_19526_ _03314_ VSS VSS VDD VDD _05125_ sky130_fd_sc_hd__inv_1
X_19527_ _05122_ _05124_ _05125_ VSS VSS VDD VDD _05126_ sky130_fd_sc_hd__o21ai_0
X_19528_ _02667_ _05126_ _02666_ VSS VSS VDD VDD _05127_ sky130_fd_sc_hd__a21oi_1
X_19529_ _05121_ _05127_ VSS VSS VDD VDD _05128_ sky130_fd_sc_hd__nor2_1
X_19530_ _02589_ _05128_ VSS VSS VDD VDD _05129_ sky130_fd_sc_hd__nor2_1
X_19531_ _03119_ _05129_ VSS VSS VDD VDD _0269_[6] sky130_fd_sc_hd__xnor2_1
X_19532_ _03131_ _02420_ VSS VSS VDD VDD _0269_[2] sky130_fd_sc_hd__xnor2_1
X_19537_ net750 net817 VSS VSS VDD VDD _05134_ sky130_fd_sc_hd__nor2_2
X_19543_ u_core.u_top.bus_wdata[30] u_core.u_top.bus_wdata[14] net871 VSS VSS VDD VDD _05140_ sky130_fd_sc_hd__mux2i_1
X_19544_ net750 net723 _05140_ VSS VSS VDD VDD _05141_ sky130_fd_sc_hd__nor3_1
X_19545_ net723 u_core.u_top.bus_wdata[46] net725 _05141_ VSS VSS VDD VDD _05142_ sky130_fd_sc_hd__a31oi_1
X_19548_ _0356_[7] _03427_ _03111_ net819 VSS VSS VDD VDD _05145_ sky130_fd_sc_hd__nor4_1
X_19549_ _0356_[7] _03427_ _03111_ _05145_ VSS VSS VDD VDD _05146_ sky130_fd_sc_hd__a31oi_1
X_19550_ _03424_ _03425_ _05146_ VSS VSS VDD VDD _05147_ sky130_fd_sc_hd__or3_1
X_19551_ _05147_ VSS VSS VDD VDD _05148_ sky130_fd_sc_hd__inv_1
X_19552_ _0356_[7] _02476_ _05148_ VSS VSS VDD VDD _05149_ sky130_fd_sc_hd__nand3_2
X_19555_ u_core.u_top.u_core.r_x[142] net652 VSS VSS VDD VDD _05152_ sky130_fd_sc_hd__nand2_1
X_19556_ _05142_ net646 _05152_ VSS VSS VDD VDD _0359_[142] sky130_fd_sc_hd__o21ai_0
X_19560_ u_core.u_top.bus_wdata[29] u_core.u_top.bus_wdata[13] net871 VSS VSS VDD VDD _05156_ sky130_fd_sc_hd__mux2i_1
X_19561_ net750 net723 _05156_ VSS VSS VDD VDD _05157_ sky130_fd_sc_hd__nor3_1
X_19562_ net723 u_core.u_top.bus_wdata[45] net725 _05157_ VSS VSS VDD VDD _05158_ sky130_fd_sc_hd__a31oi_1
X_19563_ u_core.u_top.u_core.r_x[141] net652 VSS VSS VDD VDD _05159_ sky130_fd_sc_hd__nand2_1
X_19564_ net646 _05158_ _05159_ VSS VSS VDD VDD _0359_[141] sky130_fd_sc_hd__o21ai_0
X_19565_ u_core.u_top.bus_wdata[28] u_core.u_top.bus_wdata[12] net871 VSS VSS VDD VDD _05160_ sky130_fd_sc_hd__mux2i_1
X_19566_ net750 net723 _05160_ VSS VSS VDD VDD _05161_ sky130_fd_sc_hd__nor3_1
X_19567_ net723 u_core.u_top.bus_wdata[44] net725 _05161_ VSS VSS VDD VDD _05162_ sky130_fd_sc_hd__a31oi_1
X_19568_ _06453_ _05148_ net646 _05162_ VSS VSS VDD VDD _0359_[140] sky130_fd_sc_hd__o22ai_1
X_19569_ u_core.u_top.bus_wdata[27] u_core.u_top.bus_wdata[11] net872 VSS VSS VDD VDD _05163_ sky130_fd_sc_hd__mux2i_1
X_19570_ net750 net723 _05163_ VSS VSS VDD VDD _05164_ sky130_fd_sc_hd__nor3_1
X_19571_ net723 u_core.u_top.bus_wdata[43] net725 _05164_ VSS VSS VDD VDD _05165_ sky130_fd_sc_hd__a31oi_1
X_19572_ u_core.u_top.u_core.r_x[139] net652 VSS VSS VDD VDD _05166_ sky130_fd_sc_hd__nand2_1
X_19573_ net646 _05165_ _05166_ VSS VSS VDD VDD _0359_[139] sky130_fd_sc_hd__o21ai_0
X_19574_ u_core.u_top.bus_wdata[26] u_core.u_top.bus_wdata[10] net870 VSS VSS VDD VDD _05167_ sky130_fd_sc_hd__mux2i_1
X_19575_ net750 net724 _05167_ VSS VSS VDD VDD _05168_ sky130_fd_sc_hd__nor3_1
X_19576_ net724 net967 _05134_ _05168_ VSS VSS VDD VDD _05169_ sky130_fd_sc_hd__a31oi_1
X_19577_ net929 net652 VSS VSS VDD VDD _05170_ sky130_fd_sc_hd__nand2_1
X_19578_ net646 _05169_ _05170_ VSS VSS VDD VDD _0359_[138] sky130_fd_sc_hd__o21ai_0
X_19579_ u_core.u_top.bus_wdata[25] u_core.u_top.bus_wdata[9] net872 VSS VSS VDD VDD _05171_ sky130_fd_sc_hd__mux2i_1
X_19580_ net750 net723 _05171_ VSS VSS VDD VDD _05172_ sky130_fd_sc_hd__nor3_1
X_19581_ net723 u_core.u_top.bus_wdata[41] net725 _05172_ VSS VSS VDD VDD _05173_ sky130_fd_sc_hd__a31oi_1
X_19582_ u_core.u_top.u_core.r_x[137] net652 VSS VSS VDD VDD _05174_ sky130_fd_sc_hd__nand2_1
X_19583_ net646 _05173_ _05174_ VSS VSS VDD VDD _0359_[137] sky130_fd_sc_hd__o21ai_0
X_19584_ u_core.u_top.bus_wdata[24] u_core.u_top.bus_wdata[8] _06204_ VSS VSS VDD VDD _05175_ sky130_fd_sc_hd__mux2i_1
X_19585_ net750 net724 _05175_ VSS VSS VDD VDD _05176_ sky130_fd_sc_hd__nor3_1
X_19586_ net724 u_core.u_top.bus_wdata[40] _05134_ _05176_ VSS VSS VDD VDD _05177_ sky130_fd_sc_hd__a31oi_1
X_19587_ net930 net652 VSS VSS VDD VDD _05178_ sky130_fd_sc_hd__nand2_1
X_19588_ net646 _05177_ _05178_ VSS VSS VDD VDD _0359_[136] sky130_fd_sc_hd__o21ai_0
X_19590_ u_core.u_top.bus_wdata[23] net964 _06204_ VSS VSS VDD VDD _05180_ sky130_fd_sc_hd__mux2i_1
X_19591_ net750 net724 _05180_ VSS VSS VDD VDD _05181_ sky130_fd_sc_hd__nor3_1
X_19592_ net724 u_core.u_top.bus_wdata[39] _05134_ _05181_ VSS VSS VDD VDD _05182_ sky130_fd_sc_hd__a31oi_1
X_19593_ _06450_ _05148_ net646 _05182_ VSS VSS VDD VDD _0359_[135] sky130_fd_sc_hd__o22ai_1
X_19594_ u_core.u_top.bus_wdata[22] net965 net870 VSS VSS VDD VDD _05183_ sky130_fd_sc_hd__mux2i_1
X_19595_ net750 net724 _05183_ VSS VSS VDD VDD _05184_ sky130_fd_sc_hd__nor3_1
X_19596_ net724 u_core.u_top.bus_wdata[38] _05134_ _05184_ VSS VSS VDD VDD _05185_ sky130_fd_sc_hd__a31oi_1
X_19597_ net931 net652 VSS VSS VDD VDD _05186_ sky130_fd_sc_hd__nand2_1
X_19598_ net646 _05185_ _05186_ VSS VSS VDD VDD _0359_[134] sky130_fd_sc_hd__o21ai_0
X_19599_ u_core.u_top.bus_wdata[21] net966 net871 VSS VSS VDD VDD _05187_ sky130_fd_sc_hd__mux2i_1
X_19600_ net750 net723 _05187_ VSS VSS VDD VDD _05188_ sky130_fd_sc_hd__nor3_1
X_19601_ net723 u_core.u_top.bus_wdata[37] net725 _05188_ VSS VSS VDD VDD _05189_ sky130_fd_sc_hd__a31oi_1
X_19602_ u_core.u_top.u_core.r_x[133] net652 VSS VSS VDD VDD _05190_ sky130_fd_sc_hd__nand2_1
X_19603_ net646 _05189_ _05190_ VSS VSS VDD VDD _0359_[133] sky130_fd_sc_hd__o21ai_0
X_19604_ u_core.u_top.bus_wdata[20] u_core.u_top.bus_wdata[4] net872 VSS VSS VDD VDD _05191_ sky130_fd_sc_hd__mux2i_1
X_19605_ net750 net723 _05191_ VSS VSS VDD VDD _05192_ sky130_fd_sc_hd__nor3_1
X_19606_ net723 net969 net725 _05192_ VSS VSS VDD VDD _05193_ sky130_fd_sc_hd__a31oi_1
X_19607_ _06454_ _05148_ net646 _05193_ VSS VSS VDD VDD _0359_[132] sky130_fd_sc_hd__o22ai_1
X_19608_ _0356_[5] VSS VSS VDD VDD _05194_ sky130_fd_sc_hd__inv_1
X_19610_ u_core.u_top.bus_wdata[19] net968 _06204_ VSS VSS VDD VDD _05195_ sky130_fd_sc_hd__mux2i_1
X_19611_ net750 _05195_ VSS VSS VDD VDD _05196_ sky130_fd_sc_hd__nor2_1
X_19614_ net724 u_core.u_top.bus_wdata[35] VSS VSS VDD VDD _05199_ sky130_fd_sc_hd__nand2_1
X_19615_ net750 net817 _05199_ VSS VSS VDD VDD _05200_ sky130_fd_sc_hd__nor3_1
X_19616_ net717 _05196_ _05200_ VSS VSS VDD VDD _05201_ sky130_fd_sc_hd__a21oi_1
X_19617_ u_core.u_top.u_core.r_x[131] net652 VSS VSS VDD VDD _05202_ sky130_fd_sc_hd__nand2_1
X_19618_ net646 _05201_ _05202_ VSS VSS VDD VDD _0359_[131] sky130_fd_sc_hd__o21ai_0
X_19619_ u_core.u_top.bus_wdata[18] net970 net870 VSS VSS VDD VDD _05203_ sky130_fd_sc_hd__mux2i_1
X_19620_ net750 net724 _05203_ VSS VSS VDD VDD _05204_ sky130_fd_sc_hd__nor3_1
X_19621_ net724 u_core.u_top.bus_wdata[34] _05134_ _05204_ VSS VSS VDD VDD _05205_ sky130_fd_sc_hd__a31oi_1
X_19622_ net933 net652 VSS VSS VDD VDD _05206_ sky130_fd_sc_hd__nand2_1
X_19623_ net646 _05205_ _05206_ VSS VSS VDD VDD _0359_[130] sky130_fd_sc_hd__o21ai_0
X_19624_ u_core.u_top.bus_wdata[17] net971 net871 VSS VSS VDD VDD _05207_ sky130_fd_sc_hd__mux2i_1
X_19625_ net750 _05207_ VSS VSS VDD VDD _05208_ sky130_fd_sc_hd__nor2_1
X_19626_ net723 u_core.u_top.bus_wdata[33] VSS VSS VDD VDD _05209_ sky130_fd_sc_hd__nand2_1
X_19627_ net750 net819 _05209_ VSS VSS VDD VDD _05210_ sky130_fd_sc_hd__nor3_1
X_19628_ net717 _05208_ _05210_ VSS VSS VDD VDD _05211_ sky130_fd_sc_hd__a21oi_1
X_19629_ u_core.u_top.u_core.r_x[129] net652 VSS VSS VDD VDD _05212_ sky130_fd_sc_hd__nand2_1
X_19630_ net646 _05211_ _05212_ VSS VSS VDD VDD _0359_[129] sky130_fd_sc_hd__o21ai_0
X_19631_ u_core.u_top.bus_wdata[16] net972 net871 VSS VSS VDD VDD _05213_ sky130_fd_sc_hd__mux2i_1
X_19632_ net750 _05213_ VSS VSS VDD VDD _05214_ sky130_fd_sc_hd__nor2_1
X_19633_ net723 u_core.u_top.bus_wdata[32] VSS VSS VDD VDD _05215_ sky130_fd_sc_hd__nand2_1
X_19634_ net750 net819 _05215_ VSS VSS VDD VDD _05216_ sky130_fd_sc_hd__nor3_1
X_19635_ net717 _05214_ _05216_ VSS VSS VDD VDD _05217_ sky130_fd_sc_hd__a21oi_1
X_19636_ _06460_ _05148_ net646 _05217_ VSS VSS VDD VDD _0359_[128] sky130_fd_sc_hd__o22ai_1
X_19637_ _03424_ _03425_ _0356_[7] VSS VSS VDD VDD _05218_ sky130_fd_sc_hd__nor3b_1
X_19638_ _03111_ net819 net666 _03427_ VSS VSS VDD VDD _05219_ sky130_fd_sc_hd__o211ai_4
X_19642_ net723 u_core.u_top.bus_wdata[47] VSS VSS VDD VDD _05223_ sky130_fd_sc_hd__nand2_1
X_19644_ net717 u_core.u_top.bus_wdata[15] VSS VSS VDD VDD _05225_ sky130_fd_sc_hd__nand2_1
X_19646_ _05223_ _05225_ net872 VSS VSS VDD VDD _05227_ sky130_fd_sc_hd__a21oi_1
X_19647_ net723 u_core.u_top.bus_wdata[31] net872 _05227_ VSS VSS VDD VDD _05228_ sky130_fd_sc_hd__a31oi_1
X_19648_ net750 _05228_ VSS VSS VDD VDD _05229_ sky130_fd_sc_hd__nor2_1
X_19649_ _02476_ VSS VSS VDD VDD _05230_ sky130_fd_sc_hd__inv_1
X_19650_ _05230_ _05219_ VSS VSS VDD VDD _05231_ sky130_fd_sc_hd__nor2_4
X_19651_ u_core.u_top.u_core.r_x[127] net659 _05229_ _05231_ VSS VSS VDD VDD _0359_[127] sky130_fd_sc_hd__a22o_1
X_19654_ net723 u_core.u_top.bus_wdata[46] VSS VSS VDD VDD _05234_ sky130_fd_sc_hd__nand2_1
X_19655_ net717 u_core.u_top.bus_wdata[14] VSS VSS VDD VDD _05235_ sky130_fd_sc_hd__nand2_1
X_19656_ _05234_ _05235_ net871 VSS VSS VDD VDD _05236_ sky130_fd_sc_hd__a21oi_1
X_19657_ net723 u_core.u_top.bus_wdata[30] net871 _05236_ VSS VSS VDD VDD _05237_ sky130_fd_sc_hd__a31oi_1
X_19658_ net750 _05237_ VSS VSS VDD VDD _05238_ sky130_fd_sc_hd__nor2_1
X_19659_ u_core.u_top.u_core.r_x[126] net659 _05231_ _05238_ VSS VSS VDD VDD _0359_[126] sky130_fd_sc_hd__a22o_1
X_19660_ net723 u_core.u_top.bus_wdata[45] VSS VSS VDD VDD _05239_ sky130_fd_sc_hd__nand2_1
X_19661_ net717 u_core.u_top.bus_wdata[13] VSS VSS VDD VDD _05240_ sky130_fd_sc_hd__nand2_1
X_19662_ _05239_ _05240_ net871 VSS VSS VDD VDD _05241_ sky130_fd_sc_hd__a21oi_1
X_19663_ net723 u_core.u_top.bus_wdata[29] net871 _05241_ VSS VSS VDD VDD _05242_ sky130_fd_sc_hd__a31oi_1
X_19664_ net750 _05242_ VSS VSS VDD VDD _05243_ sky130_fd_sc_hd__nor2_1
X_19665_ u_core.u_top.u_core.r_x[125] net659 _05231_ _05243_ VSS VSS VDD VDD _0359_[125] sky130_fd_sc_hd__a22o_1
X_19666_ net723 u_core.u_top.bus_wdata[44] VSS VSS VDD VDD _05244_ sky130_fd_sc_hd__nand2_1
X_19667_ net717 u_core.u_top.bus_wdata[12] VSS VSS VDD VDD _05245_ sky130_fd_sc_hd__nand2_1
X_19668_ _05244_ _05245_ net871 VSS VSS VDD VDD _05246_ sky130_fd_sc_hd__a21oi_1
X_19669_ net723 u_core.u_top.bus_wdata[28] net871 _05246_ VSS VSS VDD VDD _05247_ sky130_fd_sc_hd__a31oi_1
X_19670_ net750 _05247_ VSS VSS VDD VDD _05248_ sky130_fd_sc_hd__nor2_1
X_19671_ u_core.u_top.u_core.r_x[124] net659 _05231_ _05248_ VSS VSS VDD VDD _0359_[124] sky130_fd_sc_hd__a22o_1
X_19672_ net723 u_core.u_top.bus_wdata[43] VSS VSS VDD VDD _05249_ sky130_fd_sc_hd__nand2_1
X_19673_ net717 u_core.u_top.bus_wdata[11] VSS VSS VDD VDD _05250_ sky130_fd_sc_hd__nand2_1
X_19675_ _05249_ _05250_ net872 VSS VSS VDD VDD _05252_ sky130_fd_sc_hd__a21oi_1
X_19676_ net723 u_core.u_top.bus_wdata[27] net872 _05252_ VSS VSS VDD VDD _05253_ sky130_fd_sc_hd__a31oi_1
X_19677_ net750 _05253_ VSS VSS VDD VDD _05254_ sky130_fd_sc_hd__nor2_1
X_19678_ u_core.u_top.u_core.r_x[123] net659 _05231_ _05254_ VSS VSS VDD VDD _0359_[123] sky130_fd_sc_hd__a22o_1
X_19679_ net724 u_core.u_top.bus_wdata[42] VSS VSS VDD VDD _05255_ sky130_fd_sc_hd__nand2_1
X_19680_ net717 u_core.u_top.bus_wdata[10] VSS VSS VDD VDD _05256_ sky130_fd_sc_hd__nand2_1
X_19681_ _05255_ _05256_ net870 VSS VSS VDD VDD _05257_ sky130_fd_sc_hd__a21oi_1
X_19682_ net724 u_core.u_top.bus_wdata[26] net870 _05257_ VSS VSS VDD VDD _05258_ sky130_fd_sc_hd__a31oi_1
X_19683_ net750 _05258_ VSS VSS VDD VDD _05259_ sky130_fd_sc_hd__nor2_1
X_19684_ u_core.u_top.u_core.r_x[122] net659 _05231_ _05259_ VSS VSS VDD VDD _0359_[122] sky130_fd_sc_hd__a22o_1
X_19685_ net723 u_core.u_top.bus_wdata[41] VSS VSS VDD VDD _05260_ sky130_fd_sc_hd__nand2_1
X_19686_ net717 u_core.u_top.bus_wdata[9] VSS VSS VDD VDD _05261_ sky130_fd_sc_hd__nand2_1
X_19687_ _05260_ _05261_ net872 VSS VSS VDD VDD _05262_ sky130_fd_sc_hd__a21oi_1
X_19688_ net723 u_core.u_top.bus_wdata[25] net872 _05262_ VSS VSS VDD VDD _05263_ sky130_fd_sc_hd__a31oi_1
X_19689_ net750 _05263_ VSS VSS VDD VDD _05264_ sky130_fd_sc_hd__nor2_1
X_19690_ u_core.u_top.u_core.r_x[121] net659 _05231_ _05264_ VSS VSS VDD VDD _0359_[121] sky130_fd_sc_hd__a22o_1
X_19691_ net724 u_core.u_top.bus_wdata[40] VSS VSS VDD VDD _05265_ sky130_fd_sc_hd__nand2_1
X_19692_ net717 u_core.u_top.bus_wdata[8] VSS VSS VDD VDD _05266_ sky130_fd_sc_hd__nand2_1
X_19693_ _05265_ _05266_ _06204_ VSS VSS VDD VDD _05267_ sky130_fd_sc_hd__a21oi_1
X_19694_ net724 u_core.u_top.bus_wdata[24] _06204_ _05267_ VSS VSS VDD VDD _05268_ sky130_fd_sc_hd__a31oi_1
X_19695_ net750 _05268_ VSS VSS VDD VDD _05269_ sky130_fd_sc_hd__nor2_1
X_19696_ net935 net659 _05231_ _05269_ VSS VSS VDD VDD _0359_[120] sky130_fd_sc_hd__a22o_1
X_19697_ net724 u_core.u_top.bus_wdata[39] VSS VSS VDD VDD _05270_ sky130_fd_sc_hd__nand2_1
X_19698_ net717 net964 VSS VSS VDD VDD _05271_ sky130_fd_sc_hd__nand2_1
X_19699_ _05270_ _05271_ _06204_ VSS VSS VDD VDD _05272_ sky130_fd_sc_hd__a21oi_1
X_19700_ net724 u_core.u_top.bus_wdata[23] _06204_ _05272_ VSS VSS VDD VDD _05273_ sky130_fd_sc_hd__a31oi_1
X_19701_ net750 _05273_ VSS VSS VDD VDD _05274_ sky130_fd_sc_hd__nor2_1
X_19702_ u_core.u_top.u_core.r_x[119] net659 _05231_ _05274_ VSS VSS VDD VDD _0359_[119] sky130_fd_sc_hd__a22o_1
X_19703_ net724 u_core.u_top.bus_wdata[38] VSS VSS VDD VDD _05275_ sky130_fd_sc_hd__nand2_1
X_19704_ net717 net965 VSS VSS VDD VDD _05276_ sky130_fd_sc_hd__nand2_1
X_19705_ _05275_ _05276_ net870 VSS VSS VDD VDD _05277_ sky130_fd_sc_hd__a21oi_1
X_19706_ u_core.u_top.bus_wdata[22] net724 net870 _05277_ VSS VSS VDD VDD _05278_ sky130_fd_sc_hd__a31oi_1
X_19707_ net750 _05278_ VSS VSS VDD VDD _05279_ sky130_fd_sc_hd__nor2_1
X_19708_ net936 net659 _05231_ _05279_ VSS VSS VDD VDD _0359_[118] sky130_fd_sc_hd__a22o_1
X_19709_ net723 u_core.u_top.bus_wdata[37] VSS VSS VDD VDD _05280_ sky130_fd_sc_hd__nand2_1
X_19710_ net717 net966 VSS VSS VDD VDD _05281_ sky130_fd_sc_hd__nand2_1
X_19711_ _05280_ _05281_ net871 VSS VSS VDD VDD _05282_ sky130_fd_sc_hd__a21oi_1
X_19712_ net723 u_core.u_top.bus_wdata[21] net871 _05282_ VSS VSS VDD VDD _05283_ sky130_fd_sc_hd__a31oi_1
X_19713_ net750 _05283_ VSS VSS VDD VDD _05284_ sky130_fd_sc_hd__nor2_1
X_19714_ u_core.u_top.u_core.r_x[117] net659 _05231_ _05284_ VSS VSS VDD VDD _0359_[117] sky130_fd_sc_hd__a22o_1
X_19715_ net723 u_core.u_top.bus_wdata[36] VSS VSS VDD VDD _05285_ sky130_fd_sc_hd__nand2_1
X_19716_ net717 u_core.u_top.bus_wdata[4] VSS VSS VDD VDD _05286_ sky130_fd_sc_hd__nand2_1
X_19717_ _05285_ _05286_ net872 VSS VSS VDD VDD _05287_ sky130_fd_sc_hd__a21oi_1
X_19718_ net723 u_core.u_top.bus_wdata[20] net872 _05287_ VSS VSS VDD VDD _05288_ sky130_fd_sc_hd__a31oi_1
X_19719_ net750 _05288_ VSS VSS VDD VDD _05289_ sky130_fd_sc_hd__nor2_1
X_19720_ net937 net659 _05231_ _05289_ VSS VSS VDD VDD _0359_[116] sky130_fd_sc_hd__a22o_1
X_19721_ net717 net968 VSS VSS VDD VDD _05290_ sky130_fd_sc_hd__nand2_1
X_19722_ _05199_ _05290_ _06204_ VSS VSS VDD VDD _05291_ sky130_fd_sc_hd__a21oi_1
X_19723_ net724 u_core.u_top.bus_wdata[19] _06204_ _05291_ VSS VSS VDD VDD _05292_ sky130_fd_sc_hd__a31oi_1
X_19724_ net750 _05292_ VSS VSS VDD VDD _05293_ sky130_fd_sc_hd__nor2_1
X_19725_ u_core.u_top.u_core.r_x[115] net659 _05231_ _05293_ VSS VSS VDD VDD _0359_[115] sky130_fd_sc_hd__a22o_1
X_19726_ net724 u_core.u_top.bus_wdata[34] VSS VSS VDD VDD _05294_ sky130_fd_sc_hd__nand2_1
X_19727_ net717 net970 VSS VSS VDD VDD _05295_ sky130_fd_sc_hd__nand2_1
X_19728_ _05294_ _05295_ net870 VSS VSS VDD VDD _05296_ sky130_fd_sc_hd__a21oi_1
X_19729_ net724 u_core.u_top.bus_wdata[18] net870 _05296_ VSS VSS VDD VDD _05297_ sky130_fd_sc_hd__a31oi_1
X_19730_ net750 _05297_ VSS VSS VDD VDD _05298_ sky130_fd_sc_hd__nor2_1
X_19731_ u_core.u_top.u_core.r_x[114] net659 _05231_ _05298_ VSS VSS VDD VDD _0359_[114] sky130_fd_sc_hd__a22o_1
X_19732_ net971 net717 VSS VSS VDD VDD _05299_ sky130_fd_sc_hd__nand2_1
X_19733_ _05209_ _05299_ net871 VSS VSS VDD VDD _05300_ sky130_fd_sc_hd__a21oi_1
X_19734_ net723 u_core.u_top.bus_wdata[17] net871 _05300_ VSS VSS VDD VDD _05301_ sky130_fd_sc_hd__a31oi_1
X_19735_ net750 _05301_ VSS VSS VDD VDD _05302_ sky130_fd_sc_hd__nor2_1
X_19736_ u_core.u_top.u_core.r_x[113] net659 _05231_ _05302_ VSS VSS VDD VDD _0359_[113] sky130_fd_sc_hd__a22o_1
X_19737_ net972 net717 VSS VSS VDD VDD _05303_ sky130_fd_sc_hd__nand2_1
X_19738_ _05215_ _05303_ net871 VSS VSS VDD VDD _05304_ sky130_fd_sc_hd__a21oi_1
X_19739_ net723 u_core.u_top.bus_wdata[16] net871 _05304_ VSS VSS VDD VDD _05305_ sky130_fd_sc_hd__a31oi_1
X_19740_ net750 _05305_ VSS VSS VDD VDD _05306_ sky130_fd_sc_hd__nor2_1
X_19741_ net938 net659 _05231_ _05306_ VSS VSS VDD VDD _0359_[112] sky130_fd_sc_hd__a22o_1
X_19742_ _03111_ net817 VSS VSS VDD VDD _05307_ sky130_fd_sc_hd__nand2_1
X_19743_ _03427_ net666 _05307_ VSS VSS VDD VDD _05308_ sky130_fd_sc_hd__and3_1
X_19746_ u_core.u_top.bus_wdata[31] u_core.u_top.bus_wdata[15] net872 VSS VSS VDD VDD _05311_ sky130_fd_sc_hd__mux2i_1
X_19747_ net750 _05311_ VSS VSS VDD VDD _05312_ sky130_fd_sc_hd__nor2_1
X_19748_ net717 _05230_ VSS VSS VDD VDD _05313_ sky130_fd_sc_hd__nor2_4
X_19750_ _03424_ net724 _02476_ VSS VSS VDD VDD _05315_ sky130_fd_sc_hd__or3_1
X_19752_ net819 _05315_ VSS VSS VDD VDD _05317_ sky130_fd_sc_hd__nor2_4
X_19754_ _05312_ _05313_ _05317_ u_core.u_top.bus_wdata[47] VSS VSS VDD VDD _05319_ sky130_fd_sc_hd__a22oi_1
X_19756_ u_core.u_top.u_core.r_x[111] net658 VSS VSS VDD VDD _05321_ sky130_fd_sc_hd__nor2_1
X_19757_ net658 _05319_ _05321_ VSS VSS VDD VDD _0359_[111] sky130_fd_sc_hd__a21oi_1
X_19758_ net750 _05140_ VSS VSS VDD VDD _05322_ sky130_fd_sc_hd__nor2_1
X_19759_ _05322_ _05313_ _05317_ u_core.u_top.bus_wdata[46] VSS VSS VDD VDD _05323_ sky130_fd_sc_hd__a22oi_1
X_19760_ u_core.u_top.u_core.r_x[110] net658 VSS VSS VDD VDD _05324_ sky130_fd_sc_hd__nor2_1
X_19761_ net658 _05323_ _05324_ VSS VSS VDD VDD _0359_[110] sky130_fd_sc_hd__a21oi_1
X_19762_ net750 _05156_ VSS VSS VDD VDD _05325_ sky130_fd_sc_hd__nor2_1
X_19763_ _05325_ _05313_ _05317_ u_core.u_top.bus_wdata[45] VSS VSS VDD VDD _05326_ sky130_fd_sc_hd__a22oi_1
X_19764_ u_core.u_top.u_core.r_x[109] net658 VSS VSS VDD VDD _05327_ sky130_fd_sc_hd__nor2_1
X_19765_ net658 _05326_ _05327_ VSS VSS VDD VDD _0359_[109] sky130_fd_sc_hd__a21oi_1
X_19766_ net750 _05160_ VSS VSS VDD VDD _05328_ sky130_fd_sc_hd__nor2_1
X_19767_ _05328_ _05313_ _05317_ u_core.u_top.bus_wdata[44] VSS VSS VDD VDD _05329_ sky130_fd_sc_hd__a22oi_1
X_19768_ net940 net658 VSS VSS VDD VDD _05330_ sky130_fd_sc_hd__nor2_1
X_19769_ net658 _05329_ _05330_ VSS VSS VDD VDD _0359_[108] sky130_fd_sc_hd__a21oi_1
X_19770_ net750 _05163_ VSS VSS VDD VDD _05331_ sky130_fd_sc_hd__nor2_1
X_19771_ _05331_ net701 _05317_ u_core.u_top.bus_wdata[43] VSS VSS VDD VDD _05332_ sky130_fd_sc_hd__a22oi_1
X_19773_ u_core.u_top.u_core.r_x[107] net658 VSS VSS VDD VDD _05334_ sky130_fd_sc_hd__nor2_1
X_19774_ net658 _05332_ _05334_ VSS VSS VDD VDD _0359_[107] sky130_fd_sc_hd__a21oi_1
X_19775_ net750 _05167_ VSS VSS VDD VDD _05335_ sky130_fd_sc_hd__nor2_1
X_19776_ _05335_ net701 _05317_ net967 VSS VSS VDD VDD _05336_ sky130_fd_sc_hd__a22oi_1
X_19777_ net941 net658 VSS VSS VDD VDD _05337_ sky130_fd_sc_hd__nor2_1
X_19778_ net658 _05336_ _05337_ VSS VSS VDD VDD _0359_[106] sky130_fd_sc_hd__a21oi_1
X_19779_ net750 _05171_ VSS VSS VDD VDD _05338_ sky130_fd_sc_hd__nor2_1
X_19780_ _05338_ _05313_ _05317_ u_core.u_top.bus_wdata[41] VSS VSS VDD VDD _05339_ sky130_fd_sc_hd__a22oi_1
X_19781_ u_core.u_top.u_core.r_x[105] _05308_ VSS VSS VDD VDD _05340_ sky130_fd_sc_hd__nor2_1
X_19782_ _05308_ _05339_ _05340_ VSS VSS VDD VDD _0359_[105] sky130_fd_sc_hd__a21oi_1
X_19783_ net750 _05175_ VSS VSS VDD VDD _05341_ sky130_fd_sc_hd__nor2_1
X_19784_ _05341_ net701 _05317_ u_core.u_top.bus_wdata[40] VSS VSS VDD VDD _05342_ sky130_fd_sc_hd__a22oi_1
X_19785_ net942 _05308_ VSS VSS VDD VDD _05343_ sky130_fd_sc_hd__nor2_1
X_19786_ _05308_ _05342_ _05343_ VSS VSS VDD VDD _0359_[104] sky130_fd_sc_hd__a21oi_1
X_19787_ net750 _05180_ VSS VSS VDD VDD _05344_ sky130_fd_sc_hd__nor2_1
X_19788_ _05344_ net701 _05317_ u_core.u_top.bus_wdata[39] VSS VSS VDD VDD _05345_ sky130_fd_sc_hd__a22oi_1
X_19789_ u_core.u_top.u_core.r_x[103] _05308_ VSS VSS VDD VDD _05346_ sky130_fd_sc_hd__nor2_1
X_19790_ _05308_ _05345_ _05346_ VSS VSS VDD VDD _0359_[103] sky130_fd_sc_hd__a21oi_1
X_19791_ net750 _05183_ VSS VSS VDD VDD _05347_ sky130_fd_sc_hd__nor2_1
X_19792_ _05347_ net701 _05317_ u_core.u_top.bus_wdata[38] VSS VSS VDD VDD _05348_ sky130_fd_sc_hd__a22oi_1
X_19793_ net943 net658 VSS VSS VDD VDD _05349_ sky130_fd_sc_hd__nor2_1
X_19794_ net658 _05348_ _05349_ VSS VSS VDD VDD _0359_[102] sky130_fd_sc_hd__a21oi_1
X_19795_ net750 _05187_ VSS VSS VDD VDD _05350_ sky130_fd_sc_hd__nor2_1
X_19796_ _05350_ _05313_ _05317_ u_core.u_top.bus_wdata[37] VSS VSS VDD VDD _05351_ sky130_fd_sc_hd__a22oi_1
X_19797_ u_core.u_top.u_core.r_x[101] net658 VSS VSS VDD VDD _05352_ sky130_fd_sc_hd__nor2_1
X_19798_ net658 _05351_ _05352_ VSS VSS VDD VDD _0359_[101] sky130_fd_sc_hd__a21oi_1
X_19799_ net750 _05191_ VSS VSS VDD VDD _05353_ sky130_fd_sc_hd__nor2_1
X_19800_ _05353_ net701 _05317_ net969 VSS VSS VDD VDD _05354_ sky130_fd_sc_hd__a22oi_1
X_19801_ net944 _05308_ VSS VSS VDD VDD _05355_ sky130_fd_sc_hd__nor2_1
X_19802_ _05308_ _05354_ _05355_ VSS VSS VDD VDD _0359_[100] sky130_fd_sc_hd__a21oi_1
X_19803_ _05196_ net701 _05317_ u_core.u_top.bus_wdata[35] VSS VSS VDD VDD _05356_ sky130_fd_sc_hd__a22oi_1
X_19804_ u_core.u_top.u_core.r_x[99] _05308_ VSS VSS VDD VDD _05357_ sky130_fd_sc_hd__nor2_1
X_19805_ _05308_ _05356_ _05357_ VSS VSS VDD VDD _0359_[99] sky130_fd_sc_hd__a21oi_1
X_19806_ net750 _05203_ VSS VSS VDD VDD _05358_ sky130_fd_sc_hd__nor2_1
X_19807_ _05358_ net701 _05317_ u_core.u_top.bus_wdata[34] VSS VSS VDD VDD _05359_ sky130_fd_sc_hd__a22oi_1
X_19808_ u_core.u_top.u_core.r_x[98] net658 VSS VSS VDD VDD _05360_ sky130_fd_sc_hd__nor2_1
X_19809_ net658 _05359_ _05360_ VSS VSS VDD VDD _0359_[98] sky130_fd_sc_hd__a21oi_1
X_19810_ _05208_ _05313_ _05317_ u_core.u_top.bus_wdata[33] VSS VSS VDD VDD _05361_ sky130_fd_sc_hd__a22oi_1
X_19811_ u_core.u_top.u_core.r_x[97] net658 VSS VSS VDD VDD _05362_ sky130_fd_sc_hd__nor2_1
X_19812_ net658 _05361_ _05362_ VSS VSS VDD VDD _0359_[97] sky130_fd_sc_hd__a21oi_1
X_19813_ _05214_ _05313_ _05317_ u_core.u_top.bus_wdata[32] VSS VSS VDD VDD _05363_ sky130_fd_sc_hd__a22oi_1
X_19814_ net900 net658 VSS VSS VDD VDD _05364_ sky130_fd_sc_hd__nor2_1
X_19815_ net658 _05363_ _05364_ VSS VSS VDD VDD _0359_[96] sky130_fd_sc_hd__a21oi_1
X_19816_ _05307_ _03111_ _03427_ VSS VSS VDD VDD _05365_ sky130_fd_sc_hd__mux2i_1
X_19817_ net666 _05365_ VSS VSS VDD VDD _05366_ sky130_fd_sc_hd__nand2_1
X_19819_ _03424_ net717 _05230_ _06204_ VSS VSS VDD VDD _05368_ sky130_fd_sc_hd__nor4_4
X_19822_ u_core.u_top.bus_wdata[47] u_core.u_top.bus_wdata[31] net872 VSS VSS VDD VDD _05371_ sky130_fd_sc_hd__mux2i_1
X_19823_ net716 _05371_ VSS VSS VDD VDD _05372_ sky130_fd_sc_hd__nor2_1
X_19824_ u_core.u_top.bus_wdata[15] net700 _05372_ VSS VSS VDD VDD _05373_ sky130_fd_sc_hd__a21oi_1
X_19826_ u_core.u_top.u_core.r_x[95] net657 VSS VSS VDD VDD _05375_ sky130_fd_sc_hd__nand2_1
X_19827_ net657 _05373_ _05375_ VSS VSS VDD VDD _0359_[95] sky130_fd_sc_hd__o21ai_0
X_19828_ u_core.u_top.bus_wdata[46] u_core.u_top.bus_wdata[30] net871 VSS VSS VDD VDD _05376_ sky130_fd_sc_hd__mux2i_1
X_19829_ net716 _05376_ VSS VSS VDD VDD _05377_ sky130_fd_sc_hd__nor2_1
X_19830_ u_core.u_top.bus_wdata[14] net700 _05377_ VSS VSS VDD VDD _05378_ sky130_fd_sc_hd__a21oi_1
X_19831_ net901 net657 VSS VSS VDD VDD _05379_ sky130_fd_sc_hd__nand2_1
X_19832_ net657 _05378_ _05379_ VSS VSS VDD VDD _0359_[94] sky130_fd_sc_hd__o21ai_0
X_19833_ u_core.u_top.bus_wdata[45] u_core.u_top.bus_wdata[29] net871 VSS VSS VDD VDD _05380_ sky130_fd_sc_hd__mux2i_1
X_19834_ net716 _05380_ VSS VSS VDD VDD _05381_ sky130_fd_sc_hd__nor2_1
X_19835_ u_core.u_top.bus_wdata[13] net700 _05381_ VSS VSS VDD VDD _05382_ sky130_fd_sc_hd__a21oi_1
X_19836_ u_core.u_top.u_core.r_x[93] net657 VSS VSS VDD VDD _05383_ sky130_fd_sc_hd__nand2_1
X_19837_ net657 _05382_ _05383_ VSS VSS VDD VDD _0359_[93] sky130_fd_sc_hd__o21ai_0
X_19838_ u_core.u_top.bus_wdata[44] u_core.u_top.bus_wdata[28] net871 VSS VSS VDD VDD _05384_ sky130_fd_sc_hd__mux2i_1
X_19839_ net716 _05384_ VSS VSS VDD VDD _05385_ sky130_fd_sc_hd__nor2_1
X_19841_ u_core.u_top.bus_wdata[12] net700 _05385_ net657 VSS VSS VDD VDD _05387_ sky130_fd_sc_hd__a211oi_1
X_19842_ _06402_ net657 _05387_ VSS VSS VDD VDD _0359_[92] sky130_fd_sc_hd__a21oi_1
X_19843_ u_core.u_top.bus_wdata[43] u_core.u_top.bus_wdata[27] net872 VSS VSS VDD VDD _05388_ sky130_fd_sc_hd__mux2i_1
X_19844_ net716 _05388_ VSS VSS VDD VDD _05389_ sky130_fd_sc_hd__nor2_1
X_19845_ u_core.u_top.bus_wdata[11] net700 _05389_ VSS VSS VDD VDD _05390_ sky130_fd_sc_hd__a21oi_1
X_19846_ u_core.u_top.u_core.r_x[91] net657 VSS VSS VDD VDD _05391_ sky130_fd_sc_hd__nand2_1
X_19847_ net657 _05390_ _05391_ VSS VSS VDD VDD _0359_[91] sky130_fd_sc_hd__o21ai_0
X_19848_ net967 u_core.u_top.bus_wdata[26] net870 VSS VSS VDD VDD _05392_ sky130_fd_sc_hd__mux2i_1
X_19849_ net716 _05392_ VSS VSS VDD VDD _05393_ sky130_fd_sc_hd__nor2_1
X_19850_ u_core.u_top.bus_wdata[10] net700 _05393_ VSS VSS VDD VDD _05394_ sky130_fd_sc_hd__a21oi_1
X_19851_ u_core.u_top.u_core.r_x[90] net656 VSS VSS VDD VDD _05395_ sky130_fd_sc_hd__nand2_1
X_19852_ net656 _05394_ _05395_ VSS VSS VDD VDD _0359_[90] sky130_fd_sc_hd__o21ai_0
X_19853_ u_core.u_top.bus_wdata[41] u_core.u_top.bus_wdata[25] net872 VSS VSS VDD VDD _05396_ sky130_fd_sc_hd__mux2i_1
X_19854_ net716 _05396_ VSS VSS VDD VDD _05397_ sky130_fd_sc_hd__nor2_1
X_19855_ u_core.u_top.bus_wdata[9] net700 _05397_ VSS VSS VDD VDD _05398_ sky130_fd_sc_hd__a21oi_1
X_19856_ u_core.u_top.u_core.r_x[89] net657 VSS VSS VDD VDD _05399_ sky130_fd_sc_hd__nand2_1
X_19857_ net657 _05398_ _05399_ VSS VSS VDD VDD _0359_[89] sky130_fd_sc_hd__o21ai_0
X_19858_ u_core.u_top.bus_wdata[40] u_core.u_top.bus_wdata[24] _06204_ VSS VSS VDD VDD _05400_ sky130_fd_sc_hd__mux2i_1
X_19859_ net716 _05400_ VSS VSS VDD VDD _05401_ sky130_fd_sc_hd__nor2_1
X_19860_ u_core.u_top.bus_wdata[8] net700 _05401_ VSS VSS VDD VDD _05402_ sky130_fd_sc_hd__a21oi_1
X_19861_ net903 net656 VSS VSS VDD VDD _05403_ sky130_fd_sc_hd__nand2_1
X_19862_ net656 _05402_ _05403_ VSS VSS VDD VDD _0359_[88] sky130_fd_sc_hd__o21ai_0
X_19863_ u_core.u_top.bus_wdata[39] u_core.u_top.bus_wdata[23] _06204_ VSS VSS VDD VDD _05404_ sky130_fd_sc_hd__mux2i_1
X_19864_ net716 _05404_ VSS VSS VDD VDD _05405_ sky130_fd_sc_hd__nor2_1
X_19865_ net964 net700 _05405_ VSS VSS VDD VDD _05406_ sky130_fd_sc_hd__a21oi_1
X_19866_ u_core.u_top.u_core.r_x[87] net656 VSS VSS VDD VDD _05407_ sky130_fd_sc_hd__nand2_1
X_19867_ net656 _05406_ _05407_ VSS VSS VDD VDD _0359_[87] sky130_fd_sc_hd__o21ai_0
X_19868_ u_core.u_top.bus_wdata[38] u_core.u_top.bus_wdata[22] net870 VSS VSS VDD VDD _05408_ sky130_fd_sc_hd__mux2i_1
X_19869_ net716 _05408_ VSS VSS VDD VDD _05409_ sky130_fd_sc_hd__nor2_1
X_19870_ net965 net700 _05409_ VSS VSS VDD VDD _05410_ sky130_fd_sc_hd__a21oi_1
X_19871_ net904 net656 VSS VSS VDD VDD _05411_ sky130_fd_sc_hd__nand2_1
X_19872_ net656 _05410_ _05411_ VSS VSS VDD VDD _0359_[86] sky130_fd_sc_hd__o21ai_0
X_19873_ u_core.u_top.bus_wdata[37] u_core.u_top.bus_wdata[21] net871 VSS VSS VDD VDD _05412_ sky130_fd_sc_hd__mux2i_1
X_19874_ net716 _05412_ VSS VSS VDD VDD _05413_ sky130_fd_sc_hd__nor2_1
X_19875_ net966 net700 _05413_ VSS VSS VDD VDD _05414_ sky130_fd_sc_hd__a21oi_1
X_19876_ u_core.u_top.u_core.r_x[85] net657 VSS VSS VDD VDD _05415_ sky130_fd_sc_hd__nand2_1
X_19877_ net657 _05414_ _05415_ VSS VSS VDD VDD _0359_[85] sky130_fd_sc_hd__o21ai_0
X_19878_ net969 u_core.u_top.bus_wdata[20] net871 VSS VSS VDD VDD _05416_ sky130_fd_sc_hd__mux2i_1
X_19879_ net716 _05416_ VSS VSS VDD VDD _05417_ sky130_fd_sc_hd__nor2_1
X_19880_ u_core.u_top.bus_wdata[4] net700 _05417_ VSS VSS VDD VDD _05418_ sky130_fd_sc_hd__a21oi_1
X_19881_ net905 net657 VSS VSS VDD VDD _05419_ sky130_fd_sc_hd__nand2_1
X_19882_ net657 _05418_ _05419_ VSS VSS VDD VDD _0359_[84] sky130_fd_sc_hd__o21ai_0
X_19883_ u_core.u_top.bus_wdata[35] u_core.u_top.bus_wdata[19] _06204_ VSS VSS VDD VDD _05420_ sky130_fd_sc_hd__mux2i_1
X_19884_ net716 _05420_ VSS VSS VDD VDD _05421_ sky130_fd_sc_hd__nor2_1
X_19885_ net968 net700 _05421_ VSS VSS VDD VDD _05422_ sky130_fd_sc_hd__a21oi_1
X_19886_ u_core.u_top.u_core.r_x[83] net656 VSS VSS VDD VDD _05423_ sky130_fd_sc_hd__nand2_1
X_19887_ net656 _05422_ _05423_ VSS VSS VDD VDD _0359_[83] sky130_fd_sc_hd__o21ai_0
X_19888_ u_core.u_top.bus_wdata[34] u_core.u_top.bus_wdata[18] net870 VSS VSS VDD VDD _05424_ sky130_fd_sc_hd__mux2i_1
X_19889_ net716 _05424_ VSS VSS VDD VDD _05425_ sky130_fd_sc_hd__nor2_1
X_19890_ net970 net700 _05425_ net656 VSS VSS VDD VDD _05426_ sky130_fd_sc_hd__a211oi_1
X_19891_ _04988_ net656 _05426_ VSS VSS VDD VDD _0359_[82] sky130_fd_sc_hd__a21oi_1
X_19892_ u_core.u_top.bus_wdata[33] u_core.u_top.bus_wdata[17] net871 VSS VSS VDD VDD _05427_ sky130_fd_sc_hd__mux2i_1
X_19893_ net716 _05427_ VSS VSS VDD VDD _05428_ sky130_fd_sc_hd__nor2_1
X_19894_ net971 net700 _05428_ VSS VSS VDD VDD _05429_ sky130_fd_sc_hd__a21oi_1
X_19895_ u_core.u_top.u_core.r_x[81] net657 VSS VSS VDD VDD _05430_ sky130_fd_sc_hd__nand2_1
X_19896_ net657 _05429_ _05430_ VSS VSS VDD VDD _0359_[81] sky130_fd_sc_hd__o21ai_0
X_19897_ u_core.u_top.bus_wdata[32] u_core.u_top.bus_wdata[16] net871 VSS VSS VDD VDD _05431_ sky130_fd_sc_hd__mux2i_1
X_19898_ net716 _05431_ VSS VSS VDD VDD _05432_ sky130_fd_sc_hd__nor2_1
X_19899_ net972 net700 _05432_ net657 VSS VSS VDD VDD _05433_ sky130_fd_sc_hd__a211oi_1
X_19900_ _06415_ net657 _05433_ VSS VSS VDD VDD _0359_[80] sky130_fd_sc_hd__a21oi_1
X_19901_ net750 net723 _05311_ VSS VSS VDD VDD _05434_ sky130_fd_sc_hd__nor3_1
X_19902_ net723 u_core.u_top.bus_wdata[47] net725 _05434_ VSS VSS VDD VDD _05435_ sky130_fd_sc_hd__a31oi_1
X_19903_ _03111_ net817 VSS VSS VDD VDD _05436_ sky130_fd_sc_hd__nor2_1
X_19904_ _03111_ _05436_ _03427_ VSS VSS VDD VDD _05437_ sky130_fd_sc_hd__mux2_1
X_19905_ _05230_ net666 _05437_ VSS VSS VDD VDD _05438_ sky130_fd_sc_hd__nand3_2
X_19907_ net666 _05437_ VSS VSS VDD VDD _05440_ sky130_fd_sc_hd__nand2_2
X_19909_ u_core.u_top.u_core.r_x[79] _05440_ VSS VSS VDD VDD _05442_ sky130_fd_sc_hd__nand2_1
X_19910_ _05435_ net655 _05442_ VSS VSS VDD VDD _0359_[79] sky130_fd_sc_hd__o21ai_0
X_19911_ net906 _05440_ VSS VSS VDD VDD _05443_ sky130_fd_sc_hd__nand2_1
X_19912_ _05142_ net655 _05443_ VSS VSS VDD VDD _0359_[78] sky130_fd_sc_hd__o21ai_0
X_19913_ u_core.u_top.u_core.r_x[77] _05440_ VSS VSS VDD VDD _05444_ sky130_fd_sc_hd__nand2_1
X_19914_ _05158_ net655 _05444_ VSS VSS VDD VDD _0359_[77] sky130_fd_sc_hd__o21ai_0
X_19915_ u_core.u_top.u_core.r_x[76] _05440_ VSS VSS VDD VDD _05445_ sky130_fd_sc_hd__nand2_1
X_19916_ _05162_ net655 _05445_ VSS VSS VDD VDD _0359_[76] sky130_fd_sc_hd__o21ai_0
X_19917_ u_core.u_top.u_core.r_x[75] _05440_ VSS VSS VDD VDD _05446_ sky130_fd_sc_hd__nand2_1
X_19918_ _05165_ net655 _05446_ VSS VSS VDD VDD _0359_[75] sky130_fd_sc_hd__o21ai_0
X_19919_ u_core.u_top.u_core.r_x[74] _05440_ VSS VSS VDD VDD _05447_ sky130_fd_sc_hd__nand2_1
X_19920_ _05169_ net655 _05447_ VSS VSS VDD VDD _0359_[74] sky130_fd_sc_hd__o21ai_0
X_19921_ u_core.u_top.u_core.r_x[73] _05440_ VSS VSS VDD VDD _05448_ sky130_fd_sc_hd__nand2_1
X_19922_ _05173_ net655 _05448_ VSS VSS VDD VDD _0359_[73] sky130_fd_sc_hd__o21ai_0
X_19923_ net907 _05440_ VSS VSS VDD VDD _05449_ sky130_fd_sc_hd__nand2_1
X_19924_ _05177_ net655 _05449_ VSS VSS VDD VDD _0359_[72] sky130_fd_sc_hd__o21ai_0
X_19925_ u_core.u_top.u_core.r_x[71] _05440_ VSS VSS VDD VDD _05450_ sky130_fd_sc_hd__nand2_1
X_19926_ _05182_ net655 _05450_ VSS VSS VDD VDD _0359_[71] sky130_fd_sc_hd__o21ai_0
X_19927_ u_core.u_top.u_core.r_x[70] _05440_ VSS VSS VDD VDD _05451_ sky130_fd_sc_hd__nand2_1
X_19928_ _05185_ net655 _05451_ VSS VSS VDD VDD _0359_[70] sky130_fd_sc_hd__o21ai_0
X_19929_ u_core.u_top.u_core.r_x[69] _05440_ VSS VSS VDD VDD _05452_ sky130_fd_sc_hd__nand2_1
X_19930_ _05189_ net655 _05452_ VSS VSS VDD VDD _0359_[69] sky130_fd_sc_hd__o21ai_0
X_19931_ net909 _05440_ VSS VSS VDD VDD _05453_ sky130_fd_sc_hd__nand2_1
X_19932_ _05193_ net655 _05453_ VSS VSS VDD VDD _0359_[68] sky130_fd_sc_hd__o21ai_0
X_19933_ u_core.u_top.u_core.r_x[67] _05440_ VSS VSS VDD VDD _05454_ sky130_fd_sc_hd__nand2_1
X_19934_ _05201_ net655 _05454_ VSS VSS VDD VDD _0359_[67] sky130_fd_sc_hd__o21ai_0
X_19935_ u_core.u_top.u_core.r_x[66] _05440_ VSS VSS VDD VDD _05455_ sky130_fd_sc_hd__nand2_1
X_19936_ _05205_ net655 _05455_ VSS VSS VDD VDD _0359_[66] sky130_fd_sc_hd__o21ai_0
X_19937_ u_core.u_top.u_core.r_x[65] _05440_ VSS VSS VDD VDD _05456_ sky130_fd_sc_hd__nand2_1
X_19938_ _05211_ net655 _05456_ VSS VSS VDD VDD _0359_[65] sky130_fd_sc_hd__o21ai_0
X_19939_ net910 _05440_ VSS VSS VDD VDD _05457_ sky130_fd_sc_hd__nand2_1
X_19940_ _05217_ net655 _05457_ VSS VSS VDD VDD _0359_[64] sky130_fd_sc_hd__o21ai_0
X_19941_ _03427_ net666 VSS VSS VDD VDD _05458_ sky130_fd_sc_hd__nor2b_1
X_19942_ _03111_ net817 _05458_ VSS VSS VDD VDD _05459_ sky130_fd_sc_hd__o21ai_4
X_19944_ _02476_ _05459_ VSS VSS VDD VDD _05461_ sky130_fd_sc_hd__nor2_4
X_19946_ u_core.u_top.u_core.r_x[63] _05459_ _05461_ _05229_ VSS VSS VDD VDD _0359_[63] sky130_fd_sc_hd__a22o_1
X_19947_ u_core.u_top.u_core.r_x[62] _05459_ _05461_ _05238_ VSS VSS VDD VDD _0359_[62] sky130_fd_sc_hd__a22o_1
X_19948_ u_core.u_top.u_core.r_x[61] _05459_ _05461_ _05243_ VSS VSS VDD VDD _0359_[61] sky130_fd_sc_hd__a22o_1
X_19949_ net911 _05459_ _05461_ _05248_ VSS VSS VDD VDD _0359_[60] sky130_fd_sc_hd__a22o_1
X_19950_ u_core.u_top.u_core.r_x[59] _05459_ _05461_ _05254_ VSS VSS VDD VDD _0359_[59] sky130_fd_sc_hd__a22o_1
X_19951_ u_core.u_top.u_core.r_x[58] _05459_ _05461_ _05259_ VSS VSS VDD VDD _0359_[58] sky130_fd_sc_hd__a22o_1
X_19952_ u_core.u_top.u_core.r_x[57] _05459_ _05461_ _05264_ VSS VSS VDD VDD _0359_[57] sky130_fd_sc_hd__a22o_1
X_19953_ net912 _05459_ _05461_ _05269_ VSS VSS VDD VDD _0359_[56] sky130_fd_sc_hd__a22o_1
X_19954_ u_core.u_top.u_core.r_x[55] _05459_ _05461_ _05274_ VSS VSS VDD VDD _0359_[55] sky130_fd_sc_hd__a22o_1
X_19955_ u_core.u_top.u_core.r_x[54] _05459_ _05461_ _05279_ VSS VSS VDD VDD _0359_[54] sky130_fd_sc_hd__a22o_1
X_19956_ u_core.u_top.u_core.r_x[53] _05459_ _05461_ _05284_ VSS VSS VDD VDD _0359_[53] sky130_fd_sc_hd__a22o_1
X_19957_ net913 _05459_ _05461_ _05289_ VSS VSS VDD VDD _0359_[52] sky130_fd_sc_hd__a22o_1
X_19958_ u_core.u_top.u_core.r_x[51] _05459_ _05461_ _05293_ VSS VSS VDD VDD _0359_[51] sky130_fd_sc_hd__a22o_1
X_19959_ u_core.u_top.u_core.r_x[50] _05459_ _05461_ _05298_ VSS VSS VDD VDD _0359_[50] sky130_fd_sc_hd__a22o_1
X_19960_ u_core.u_top.u_core.r_x[49] _05459_ _05461_ _05302_ VSS VSS VDD VDD _0359_[49] sky130_fd_sc_hd__a22o_1
X_19961_ net915 _05459_ _05461_ _05306_ VSS VSS VDD VDD _0359_[48] sky130_fd_sc_hd__a22o_1
X_19962_ _0356_[7] _02476_ _03424_ VSS VSS VDD VDD _05463_ sky130_fd_sc_hd__nand3b_1
X_19963_ _05463_ net717 VSS VSS VDD VDD _05464_ sky130_fd_sc_hd__nand2b_2
X_19965_ net819 _05464_ VSS VSS VDD VDD _05466_ sky130_fd_sc_hd__nor2_4
X_19966_ _03426_ _05466_ _05458_ VSS VSS VDD VDD _05467_ sky130_fd_sc_hd__a21oi_1
X_19967_ _03111_ net817 _05467_ VSS VSS VDD VDD _05468_ sky130_fd_sc_hd__a21oi_4
X_19970_ net724 _0356_[7] VSS VSS VDD VDD _05471_ sky130_fd_sc_hd__nand2_1
X_19971_ _03424_ _02476_ _05471_ VSS VSS VDD VDD _05472_ sky130_fd_sc_hd__nor3_2
X_19973_ u_core.u_top.bus_wdata[47] net651 net654 _05312_ VSS VSS VDD VDD _05474_ sky130_fd_sc_hd__a22oi_1
X_19975_ u_core.u_top.u_core.r_x[47] net645 VSS VSS VDD VDD _05476_ sky130_fd_sc_hd__nor2_1
X_19976_ net645 _05474_ _05476_ VSS VSS VDD VDD _0359_[47] sky130_fd_sc_hd__a21oi_1
X_19977_ u_core.u_top.bus_wdata[46] net651 net654 _05322_ VSS VSS VDD VDD _05477_ sky130_fd_sc_hd__a22oi_1
X_19978_ net916 net645 VSS VSS VDD VDD _05478_ sky130_fd_sc_hd__nor2_1
X_19979_ net645 _05477_ _05478_ VSS VSS VDD VDD _0359_[46] sky130_fd_sc_hd__a21oi_1
X_19980_ u_core.u_top.bus_wdata[45] net651 net654 _05325_ VSS VSS VDD VDD _05479_ sky130_fd_sc_hd__a22oi_1
X_19981_ u_core.u_top.u_core.r_x[45] net645 VSS VSS VDD VDD _05480_ sky130_fd_sc_hd__nor2_1
X_19982_ net645 _05479_ _05480_ VSS VSS VDD VDD _0359_[45] sky130_fd_sc_hd__a21oi_1
X_19983_ u_core.u_top.bus_wdata[44] net651 net654 _05328_ VSS VSS VDD VDD _05481_ sky130_fd_sc_hd__a22oi_1
X_19984_ net917 net645 VSS VSS VDD VDD _05482_ sky130_fd_sc_hd__nor2_1
X_19985_ net645 _05481_ _05482_ VSS VSS VDD VDD _0359_[44] sky130_fd_sc_hd__a21oi_1
X_19986_ u_core.u_top.bus_wdata[43] net651 net654 _05331_ VSS VSS VDD VDD _05483_ sky130_fd_sc_hd__a22oi_1
X_19988_ u_core.u_top.u_core.r_x[43] net645 VSS VSS VDD VDD _05485_ sky130_fd_sc_hd__nor2_1
X_19989_ net645 _05483_ _05485_ VSS VSS VDD VDD _0359_[43] sky130_fd_sc_hd__a21oi_1
X_19990_ net967 net651 net654 _05335_ VSS VSS VDD VDD _05486_ sky130_fd_sc_hd__a22oi_1
X_19991_ net918 _05468_ VSS VSS VDD VDD _05487_ sky130_fd_sc_hd__nor2_1
X_19992_ _05468_ _05486_ _05487_ VSS VSS VDD VDD _0359_[42] sky130_fd_sc_hd__a21oi_1
X_19993_ u_core.u_top.bus_wdata[41] net651 net654 _05338_ VSS VSS VDD VDD _05488_ sky130_fd_sc_hd__a22oi_1
X_19994_ u_core.u_top.u_core.r_x[41] net645 VSS VSS VDD VDD _05489_ sky130_fd_sc_hd__nor2_1
X_19995_ net645 _05488_ _05489_ VSS VSS VDD VDD _0359_[41] sky130_fd_sc_hd__a21oi_1
X_19996_ u_core.u_top.bus_wdata[40] net651 net654 _05341_ VSS VSS VDD VDD _05490_ sky130_fd_sc_hd__a22oi_1
X_19997_ net919 net645 VSS VSS VDD VDD _05491_ sky130_fd_sc_hd__nor2_1
X_19998_ net645 _05490_ _05491_ VSS VSS VDD VDD _0359_[40] sky130_fd_sc_hd__a21oi_1
X_19999_ u_core.u_top.bus_wdata[39] net651 net654 _05344_ VSS VSS VDD VDD _05492_ sky130_fd_sc_hd__a22oi_1
X_20000_ u_core.u_top.u_core.r_x[39] _05468_ VSS VSS VDD VDD _05493_ sky130_fd_sc_hd__nor2_1
X_20001_ _05468_ _05492_ _05493_ VSS VSS VDD VDD _0359_[39] sky130_fd_sc_hd__a21oi_1
X_20002_ u_core.u_top.bus_wdata[38] net651 net654 _05347_ VSS VSS VDD VDD _05494_ sky130_fd_sc_hd__a22oi_1
X_20003_ net920 _05468_ VSS VSS VDD VDD _05495_ sky130_fd_sc_hd__nor2_1
X_20004_ _05468_ _05494_ _05495_ VSS VSS VDD VDD _0359_[38] sky130_fd_sc_hd__a21oi_1
X_20005_ u_core.u_top.bus_wdata[37] net651 net654 _05350_ VSS VSS VDD VDD _05496_ sky130_fd_sc_hd__a22oi_1
X_20006_ u_core.u_top.u_core.r_x[37] net645 VSS VSS VDD VDD _05497_ sky130_fd_sc_hd__nor2_1
X_20007_ net645 _05496_ _05497_ VSS VSS VDD VDD _0359_[37] sky130_fd_sc_hd__a21oi_1
X_20008_ net969 net651 net654 _05353_ VSS VSS VDD VDD _05498_ sky130_fd_sc_hd__a22oi_1
X_20009_ net921 net645 VSS VSS VDD VDD _05499_ sky130_fd_sc_hd__nor2_1
X_20010_ net645 _05498_ _05499_ VSS VSS VDD VDD _0359_[36] sky130_fd_sc_hd__a21oi_1
X_20011_ u_core.u_top.bus_wdata[35] net651 net654 _05196_ VSS VSS VDD VDD _05500_ sky130_fd_sc_hd__a22oi_1
X_20012_ u_core.u_top.u_core.r_x[35] _05468_ VSS VSS VDD VDD _05501_ sky130_fd_sc_hd__nor2_1
X_20013_ _05468_ _05500_ _05501_ VSS VSS VDD VDD _0359_[35] sky130_fd_sc_hd__a21oi_1
X_20014_ u_core.u_top.bus_wdata[34] net651 net654 _05358_ VSS VSS VDD VDD _05502_ sky130_fd_sc_hd__a22oi_1
X_20015_ u_core.u_top.u_core.r_x[34] _05468_ VSS VSS VDD VDD _05503_ sky130_fd_sc_hd__nor2_1
X_20016_ _05468_ _05502_ _05503_ VSS VSS VDD VDD _0359_[34] sky130_fd_sc_hd__a21oi_1
X_20017_ u_core.u_top.bus_wdata[33] net651 net654 _05208_ VSS VSS VDD VDD _05504_ sky130_fd_sc_hd__a22oi_1
X_20018_ u_core.u_top.u_core.r_x[33] net645 VSS VSS VDD VDD _05505_ sky130_fd_sc_hd__nor2_1
X_20019_ net645 _05504_ _05505_ VSS VSS VDD VDD _0359_[33] sky130_fd_sc_hd__a21oi_1
X_20020_ u_core.u_top.bus_wdata[32] net651 net654 _05214_ VSS VSS VDD VDD _05506_ sky130_fd_sc_hd__a22oi_1
X_20021_ net922 net645 VSS VSS VDD VDD _05507_ sky130_fd_sc_hd__nor2_1
X_20022_ net645 _05506_ _05507_ VSS VSS VDD VDD _0359_[32] sky130_fd_sc_hd__a21oi_1
X_20023_ _03426_ VSS VSS VDD VDD _05508_ sky130_fd_sc_hd__inv_1
X_20024_ _03111_ _05458_ VSS VSS VDD VDD _05509_ sky130_fd_sc_hd__nand2b_1
X_20025_ _05508_ _05464_ _05509_ VSS VSS VDD VDD _05510_ sky130_fd_sc_hd__o21ai_4
X_20027_ _03424_ _02476_ net870 _05471_ VSS VSS VDD VDD _05512_ sky130_fd_sc_hd__nor4_4
X_20030_ _05371_ _05464_ VSS VSS VDD VDD _05515_ sky130_fd_sc_hd__nor2_1
X_20031_ u_core.u_top.bus_wdata[15] net653 _05515_ VSS VSS VDD VDD _05516_ sky130_fd_sc_hd__a21oi_1
X_20033_ u_core.u_top.u_core.r_x[31] net649 VSS VSS VDD VDD _05518_ sky130_fd_sc_hd__nor2_1
X_20034_ net649 _05516_ _05518_ VSS VSS VDD VDD _0359_[31] sky130_fd_sc_hd__a21oi_1
X_20035_ _05376_ _05464_ VSS VSS VDD VDD _05519_ sky130_fd_sc_hd__nor2_1
X_20036_ u_core.u_top.bus_wdata[14] net653 _05519_ VSS VSS VDD VDD _05520_ sky130_fd_sc_hd__a21oi_1
X_20037_ u_core.u_top.u_core.r_x[30] net649 VSS VSS VDD VDD _05521_ sky130_fd_sc_hd__nor2_1
X_20038_ net649 _05520_ _05521_ VSS VSS VDD VDD _0359_[30] sky130_fd_sc_hd__a21oi_1
X_20039_ _05380_ _05464_ VSS VSS VDD VDD _05522_ sky130_fd_sc_hd__nor2_1
X_20040_ u_core.u_top.bus_wdata[13] net653 _05522_ VSS VSS VDD VDD _05523_ sky130_fd_sc_hd__a21oi_1
X_20041_ u_core.u_top.u_core.r_x[29] net649 VSS VSS VDD VDD _05524_ sky130_fd_sc_hd__nor2_1
X_20042_ net649 _05523_ _05524_ VSS VSS VDD VDD _0359_[29] sky130_fd_sc_hd__a21oi_1
X_20043_ _05384_ _05464_ VSS VSS VDD VDD _05525_ sky130_fd_sc_hd__nor2_1
X_20044_ u_core.u_top.bus_wdata[12] net653 _05525_ VSS VSS VDD VDD _05526_ sky130_fd_sc_hd__a21oi_1
X_20046_ net923 net649 VSS VSS VDD VDD _05528_ sky130_fd_sc_hd__nor2_1
X_20047_ net649 _05526_ _05528_ VSS VSS VDD VDD _0359_[28] sky130_fd_sc_hd__a21oi_1
X_20048_ _05388_ _05464_ VSS VSS VDD VDD _05529_ sky130_fd_sc_hd__nor2_1
X_20049_ u_core.u_top.bus_wdata[11] net653 _05529_ VSS VSS VDD VDD _05530_ sky130_fd_sc_hd__a21oi_1
X_20050_ u_core.u_top.u_core.r_x[27] net649 VSS VSS VDD VDD _05531_ sky130_fd_sc_hd__nor2_1
X_20051_ net649 _05530_ _05531_ VSS VSS VDD VDD _0359_[27] sky130_fd_sc_hd__a21oi_1
X_20052_ _05392_ _05464_ VSS VSS VDD VDD _05532_ sky130_fd_sc_hd__nor2_1
X_20053_ u_core.u_top.bus_wdata[10] _05512_ _05532_ VSS VSS VDD VDD _05533_ sky130_fd_sc_hd__a21oi_1
X_20054_ u_core.u_top.u_core.r_x[26] _05510_ VSS VSS VDD VDD _05534_ sky130_fd_sc_hd__nor2_1
X_20055_ _05510_ _05533_ _05534_ VSS VSS VDD VDD _0359_[26] sky130_fd_sc_hd__a21oi_1
X_20056_ _05396_ _05464_ VSS VSS VDD VDD _05535_ sky130_fd_sc_hd__nor2_1
X_20057_ u_core.u_top.bus_wdata[9] net653 _05535_ VSS VSS VDD VDD _05536_ sky130_fd_sc_hd__a21oi_1
X_20058_ u_core.u_top.u_core.r_x[25] net649 VSS VSS VDD VDD _05537_ sky130_fd_sc_hd__nor2_1
X_20059_ net649 _05536_ _05537_ VSS VSS VDD VDD _0359_[25] sky130_fd_sc_hd__a21oi_1
X_20060_ _05400_ _05464_ VSS VSS VDD VDD _05538_ sky130_fd_sc_hd__nor2_1
X_20061_ u_core.u_top.bus_wdata[8] _05512_ _05538_ VSS VSS VDD VDD _05539_ sky130_fd_sc_hd__a21oi_1
X_20062_ net924 _05510_ VSS VSS VDD VDD _05540_ sky130_fd_sc_hd__nor2_1
X_20063_ _05510_ _05539_ _05540_ VSS VSS VDD VDD _0359_[24] sky130_fd_sc_hd__a21oi_1
X_20064_ _05404_ _05464_ VSS VSS VDD VDD _05541_ sky130_fd_sc_hd__nor2_1
X_20065_ net964 _05512_ _05541_ VSS VSS VDD VDD _05542_ sky130_fd_sc_hd__a21oi_1
X_20066_ u_core.u_top.u_core.r_x[23] _05510_ VSS VSS VDD VDD _05543_ sky130_fd_sc_hd__nor2_1
X_20067_ _05510_ _05542_ _05543_ VSS VSS VDD VDD _0359_[23] sky130_fd_sc_hd__a21oi_1
X_20068_ net965 _05512_ VSS VSS VDD VDD _05544_ sky130_fd_sc_hd__nand2_1
X_20069_ _05408_ _05464_ _05544_ VSS VSS VDD VDD _05545_ sky130_fd_sc_hd__o21ai_0
X_20070_ _05510_ _05545_ VSS VSS VDD VDD _05546_ sky130_fd_sc_hd__nand2_1
X_20071_ _10754_ _05510_ _05546_ VSS VSS VDD VDD _0359_[22] sky130_fd_sc_hd__o21ai_0
X_20072_ _05412_ _05464_ VSS VSS VDD VDD _05547_ sky130_fd_sc_hd__nor2_1
X_20073_ net966 net653 _05547_ VSS VSS VDD VDD _05548_ sky130_fd_sc_hd__a21oi_1
X_20074_ u_core.u_top.u_core.r_x[21] net649 VSS VSS VDD VDD _05549_ sky130_fd_sc_hd__nor2_1
X_20075_ net649 _05548_ _05549_ VSS VSS VDD VDD _0359_[21] sky130_fd_sc_hd__a21oi_1
X_20076_ _05416_ _05464_ VSS VSS VDD VDD _05550_ sky130_fd_sc_hd__nor2_1
X_20077_ u_core.u_top.bus_wdata[4] net653 _05550_ VSS VSS VDD VDD _05551_ sky130_fd_sc_hd__a21oi_1
X_20078_ net925 net649 VSS VSS VDD VDD _05552_ sky130_fd_sc_hd__nor2_1
X_20079_ net649 _05551_ _05552_ VSS VSS VDD VDD _0359_[20] sky130_fd_sc_hd__a21oi_1
X_20080_ _05420_ _05464_ VSS VSS VDD VDD _05553_ sky130_fd_sc_hd__nor2_1
X_20081_ net968 _05512_ _05553_ VSS VSS VDD VDD _05554_ sky130_fd_sc_hd__a21oi_1
X_20082_ u_core.u_top.u_core.r_x[19] _05510_ VSS VSS VDD VDD _05555_ sky130_fd_sc_hd__nor2_1
X_20083_ _05510_ _05554_ _05555_ VSS VSS VDD VDD _0359_[19] sky130_fd_sc_hd__a21oi_1
X_20084_ _05424_ _05464_ VSS VSS VDD VDD _05556_ sky130_fd_sc_hd__nor2_1
X_20085_ net970 _05512_ _05556_ VSS VSS VDD VDD _05557_ sky130_fd_sc_hd__a21oi_1
X_20086_ net926 _05510_ VSS VSS VDD VDD _05558_ sky130_fd_sc_hd__nor2_1
X_20087_ _05510_ _05557_ _05558_ VSS VSS VDD VDD _0359_[18] sky130_fd_sc_hd__a21oi_1
X_20088_ _05427_ _05464_ VSS VSS VDD VDD _05559_ sky130_fd_sc_hd__nor2_1
X_20089_ net971 net653 _05559_ VSS VSS VDD VDD _05560_ sky130_fd_sc_hd__a21oi_1
X_20090_ u_core.u_top.u_core.r_x[17] net649 VSS VSS VDD VDD _05561_ sky130_fd_sc_hd__nor2_1
X_20091_ net649 _05560_ _05561_ VSS VSS VDD VDD _0359_[17] sky130_fd_sc_hd__a21oi_1
X_20092_ _05431_ _05464_ VSS VSS VDD VDD _05562_ sky130_fd_sc_hd__nor2_1
X_20093_ net972 net653 _05562_ VSS VSS VDD VDD _05563_ sky130_fd_sc_hd__a21oi_1
X_20094_ net927 net649 VSS VSS VDD VDD _05564_ sky130_fd_sc_hd__nor2_1
X_20095_ net649 _05563_ _05564_ VSS VSS VDD VDD _0359_[16] sky130_fd_sc_hd__a21oi_1
X_20096_ _05508_ _05463_ _05509_ net817 VSS VSS VDD VDD _05565_ sky130_fd_sc_hd__o22ai_1
X_20097_ net717 net870 _05565_ VSS VSS VDD VDD _05566_ sky130_fd_sc_hd__o21ai_4
X_20099_ _05463_ _05566_ VSS VSS VDD VDD _05568_ sky130_fd_sc_hd__nor2_4
X_20101_ net818 _05223_ _05311_ net723 VSS VSS VDD VDD _05570_ sky130_fd_sc_hd__o22ai_1
X_20102_ u_core.u_top.u_core.r_x[15] _05566_ _05568_ _05570_ VSS VSS VDD VDD _0359_[15] sky130_fd_sc_hd__a22o_1
X_20103_ net723 _05140_ _05234_ net819 VSS VSS VDD VDD _05571_ sky130_fd_sc_hd__o22ai_1
X_20104_ u_core.u_top.u_core.r_x[14] _05566_ _05568_ _05571_ VSS VSS VDD VDD _0359_[14] sky130_fd_sc_hd__a22o_1
X_20105_ net723 _05156_ _05239_ net819 VSS VSS VDD VDD _05572_ sky130_fd_sc_hd__o22ai_1
X_20106_ u_core.u_top.u_core.r_x[13] _05566_ _05568_ _05572_ VSS VSS VDD VDD _0359_[13] sky130_fd_sc_hd__a22o_1
X_20107_ net723 _05160_ _05244_ net819 VSS VSS VDD VDD _05573_ sky130_fd_sc_hd__o22ai_1
X_20108_ net934 _05566_ _05568_ _05573_ VSS VSS VDD VDD _0359_[12] sky130_fd_sc_hd__a22o_1
X_20109_ net723 _05163_ _05249_ net818 VSS VSS VDD VDD _05574_ sky130_fd_sc_hd__o22ai_1
X_20110_ u_core.u_top.u_core.r_x[11] _05566_ _05568_ _05574_ VSS VSS VDD VDD _0359_[11] sky130_fd_sc_hd__a22o_1
X_20111_ net724 _05167_ _05255_ net817 VSS VSS VDD VDD _05575_ sky130_fd_sc_hd__o22ai_1
X_20112_ net939 _05566_ _05568_ _05575_ VSS VSS VDD VDD _0359_[10] sky130_fd_sc_hd__a22o_1
X_20113_ net723 _05171_ _05260_ net819 VSS VSS VDD VDD _05576_ sky130_fd_sc_hd__o22ai_1
X_20114_ u_core.u_top.u_core.r_x[9] _05566_ _05568_ _05576_ VSS VSS VDD VDD _0359_[9] sky130_fd_sc_hd__a22o_1
X_20115_ net724 _05175_ _05265_ net817 VSS VSS VDD VDD _05577_ sky130_fd_sc_hd__o22ai_1
X_20116_ net902 _05566_ _05568_ _05577_ VSS VSS VDD VDD _0359_[8] sky130_fd_sc_hd__a22o_1
X_20117_ net724 _05180_ _05270_ net817 VSS VSS VDD VDD _05578_ sky130_fd_sc_hd__o22ai_1
X_20118_ u_core.u_top.u_core.r_x[7] _05566_ _05568_ _05578_ VSS VSS VDD VDD _0359_[7] sky130_fd_sc_hd__a22o_1
X_20119_ net724 _05183_ _05275_ net817 VSS VSS VDD VDD _05579_ sky130_fd_sc_hd__o22ai_1
X_20120_ net908 _05566_ _05568_ _05579_ VSS VSS VDD VDD _0359_[6] sky130_fd_sc_hd__a22o_1
X_20121_ net723 _05187_ _05280_ net819 VSS VSS VDD VDD _05580_ sky130_fd_sc_hd__o22ai_1
X_20122_ u_core.u_top.u_core.r_x[5] _05566_ _05568_ _05580_ VSS VSS VDD VDD _0359_[5] sky130_fd_sc_hd__a22o_1
X_20123_ net723 _05191_ _05285_ net819 VSS VSS VDD VDD _05581_ sky130_fd_sc_hd__o22ai_1
X_20124_ net914 _05566_ _05568_ _05581_ VSS VSS VDD VDD _0359_[4] sky130_fd_sc_hd__a22o_1
X_20125_ net724 _05195_ _05199_ net817 VSS VSS VDD VDD _05582_ sky130_fd_sc_hd__o22ai_1
X_20126_ u_core.u_top.u_core.r_x[3] _05566_ _05568_ _05582_ VSS VSS VDD VDD _0359_[3] sky130_fd_sc_hd__a22o_1
X_20127_ net724 _05203_ _05294_ net817 VSS VSS VDD VDD _05583_ sky130_fd_sc_hd__o22ai_1
X_20128_ u_core.u_top.u_core.r_x[2] _05566_ _05568_ _05583_ VSS VSS VDD VDD _0359_[2] sky130_fd_sc_hd__a22o_1
X_20129_ net723 _05207_ _05209_ net819 VSS VSS VDD VDD _05584_ sky130_fd_sc_hd__o22ai_1
X_20130_ u_core.u_top.u_core.r_x[1] _05566_ _05568_ _05584_ VSS VSS VDD VDD _0359_[1] sky130_fd_sc_hd__a22o_1
X_20131_ net723 _05213_ _05215_ net819 VSS VSS VDD VDD _05585_ sky130_fd_sc_hd__o22ai_1
X_20132_ net945 _05566_ _05568_ _05585_ VSS VSS VDD VDD _0359_[0] sky130_fd_sc_hd__a22o_1
X_20133_ _02894_ VSS VSS VDD VDD _05586_ sky130_fd_sc_hd__inv_1
X_20134_ _03386_ VSS VSS VDD VDD _05587_ sky130_fd_sc_hd__inv_1
X_20135_ _02365_ VSS VSS VDD VDD _05588_ sky130_fd_sc_hd__inv_1
X_20136_ _03420_ _05588_ _03419_ VSS VSS VDD VDD _05589_ sky130_fd_sc_hd__a21oi_1
X_20137_ _03385_ VSS VSS VDD VDD _05590_ sky130_fd_sc_hd__inv_1
X_20138_ _05587_ _05589_ _05590_ VSS VSS VDD VDD _05591_ sky130_fd_sc_hd__o21ai_0
X_20139_ _03012_ _05591_ _03011_ VSS VSS VDD VDD _05592_ sky130_fd_sc_hd__a21oi_1
X_20140_ _05586_ _05592_ _02893_ VSS VSS VDD VDD _05593_ sky130_fd_sc_hd__o21bai_1
X_20141_ _02953_ _05593_ _02952_ VSS VSS VDD VDD _05594_ sky130_fd_sc_hd__a21o_1
X_20142_ _02983_ _05594_ _02982_ VSS VSS VDD VDD _05595_ sky130_fd_sc_hd__a21oi_1
X_20143_ _03445_ _05595_ VSS VSS VDD VDD _0279_[8] sky130_fd_sc_hd__xnor2_1
X_20144_ _03416_ _06522_ VSS VSS VDD VDD _0226_[7] sky130_fd_sc_hd__xnor2_1
X_20145_ _03470_ _06518_ VSS VSS VDD VDD _0226_[3] sky130_fd_sc_hd__xnor2_1
X_20146_ _03244_ VSS VSS VDD VDD _05596_ sky130_fd_sc_hd__inv_1
X_20147_ _02656_ VSS VSS VDD VDD _05597_ sky130_fd_sc_hd__inv_1
X_20148_ u_core.u_top.u_core.d_acc[210] _02748_ _02747_ VSS VSS VDD VDD _05598_ sky130_fd_sc_hd__a21o_1
X_20149_ _03167_ _05598_ _03166_ VSS VSS VDD VDD _05599_ sky130_fd_sc_hd__a21oi_1
X_20150_ _05597_ _05599_ _02655_ VSS VSS VDD VDD _05600_ sky130_fd_sc_hd__o21bai_1
X_20151_ _03465_ _05600_ _03464_ VSS VSS VDD VDD _05601_ sky130_fd_sc_hd__a21oi_1
X_20152_ _05596_ _05601_ _03243_ VSS VSS VDD VDD _05602_ sky130_fd_sc_hd__o21bai_1
X_20153_ _02648_ _05602_ _02647_ VSS VSS VDD VDD _05603_ sky130_fd_sc_hd__a21oi_1
X_20154_ _03238_ _05603_ VSS VSS VDD VDD _0338_[7] sky130_fd_sc_hd__xnor2_1
X_20155_ _02723_ VSS VSS VDD VDD _05604_ sky130_fd_sc_hd__inv_1
X_20156_ _02579_ VSS VSS VDD VDD _05605_ sky130_fd_sc_hd__inv_1
X_20157_ u_core.u_top.u_core.d_acc[90] _02941_ _02940_ VSS VSS VDD VDD _05606_ sky130_fd_sc_hd__a21o_1
X_20158_ _02937_ _05606_ _02936_ VSS VSS VDD VDD _05607_ sky130_fd_sc_hd__a21oi_1
X_20159_ _05605_ _05607_ _02578_ VSS VSS VDD VDD _05608_ sky130_fd_sc_hd__o21bai_1
X_20160_ _03363_ _05608_ _03362_ VSS VSS VDD VDD _05609_ sky130_fd_sc_hd__a21oi_1
X_20161_ _05604_ _05609_ _02722_ VSS VSS VDD VDD _05610_ sky130_fd_sc_hd__o21bai_1
X_20162_ _02791_ _05610_ _02790_ VSS VSS VDD VDD _05611_ sky130_fd_sc_hd__a21oi_1
X_20163_ _02592_ _05611_ VSS VSS VDD VDD _0274_[7] sky130_fd_sc_hd__xnor2_1
X_20164_ _02579_ _05607_ VSS VSS VDD VDD _0274_[3] sky130_fd_sc_hd__xnor2_1
X_20165_ _02818_ _09516_ _03241_ VSS VSS VDD VDD _05612_ sky130_fd_sc_hd__o21ai_0
X_20166_ _03240_ _05612_ VSS VSS VDD VDD _05613_ sky130_fd_sc_hd__nand2b_1
X_20167_ _03296_ _05613_ _03295_ VSS VSS VDD VDD _05614_ sky130_fd_sc_hd__a21oi_1
X_20168_ _02833_ _05614_ VSS VSS VDD VDD _0238_[8] sky130_fd_sc_hd__xnor2_1
X_20169_ _02806_ _09514_ VSS VSS VDD VDD _0238_[4] sky130_fd_sc_hd__xor2_1
X_20170_ _02410_ VSS VSS VDD VDD _0249_[1] sky130_fd_sc_hd__inv_1
X_20171_ u_core.u_top.u_core.d_acc[90] VSS VSS VDD VDD _0274_[0] sky130_fd_sc_hd__inv_1
X_20172_ u_core.u_top.u_core.d_acc[80] _02583_ _02582_ VSS VSS VDD VDD _05615_ sky130_fd_sc_hd__a21o_1
X_20173_ _03131_ _05615_ _03130_ VSS VSS VDD VDD _05616_ sky130_fd_sc_hd__a21oi_1
X_20174_ _05122_ _05616_ _05125_ VSS VSS VDD VDD _05617_ sky130_fd_sc_hd__o21ai_0
X_20175_ _02667_ _05617_ _02666_ VSS VSS VDD VDD _05618_ sky130_fd_sc_hd__a21oi_1
X_20176_ _02590_ _05618_ VSS VSS VDD VDD _0269_[5] sky130_fd_sc_hd__xnor2_1
X_20177_ net994 u_core.u_top.u_core.d_acc[179] VSS VSS VDD VDD _05619_ sky130_fd_sc_hd__xnor2_1
X_20178_ _02781_ VSS VSS VDD VDD _05620_ sky130_fd_sc_hd__inv_1
X_20179_ u_core.u_top.u_core.d_acc[170] _02651_ _02931_ VSS VSS VDD VDD _05621_ sky130_fd_sc_hd__a21o_1
X_20180_ _02779_ _05621_ _02778_ VSS VSS VDD VDD _05622_ sky130_fd_sc_hd__a21oi_1
X_20181_ _05047_ _05622_ _05050_ VSS VSS VDD VDD _05623_ sky130_fd_sc_hd__o21ai_0
X_20182_ _03036_ _05623_ _03035_ VSS VSS VDD VDD _05624_ sky130_fd_sc_hd__a21oi_1
X_20183_ _05046_ _05624_ _03215_ VSS VSS VDD VDD _05625_ sky130_fd_sc_hd__o21bai_1
X_20184_ _02812_ _05625_ _02811_ VSS VSS VDD VDD _05626_ sky130_fd_sc_hd__a21oi_1
X_20185_ _05620_ _05626_ _02780_ VSS VSS VDD VDD _05627_ sky130_fd_sc_hd__o21bai_1
X_20186_ _03194_ _05627_ _03193_ VSS VSS VDD VDD _05628_ sky130_fd_sc_hd__a21oi_1
X_20187_ _05619_ _05628_ VSS VSS VDD VDD _0316_[9] sky130_fd_sc_hd__xnor2_1
X_20188_ _02397_ VSS VSS VDD VDD _05629_ sky130_fd_sc_hd__inv_1
X_20189_ _02771_ _05629_ _02770_ VSS VSS VDD VDD _05630_ sky130_fd_sc_hd__a21oi_1
X_20190_ _05080_ _05630_ _02613_ VSS VSS VDD VDD _05631_ sky130_fd_sc_hd__o21bai_1
X_20191_ _03181_ _05631_ _03180_ VSS VSS VDD VDD _05632_ sky130_fd_sc_hd__a21oi_1
X_20192_ _05079_ _05632_ _03107_ VSS VSS VDD VDD _05633_ sky130_fd_sc_hd__o21bai_1
X_20193_ _02706_ _05633_ _02705_ VSS VSS VDD VDD _05634_ sky130_fd_sc_hd__a21o_1
X_20194_ _03152_ _05634_ _03151_ VSS VSS VDD VDD _05635_ sky130_fd_sc_hd__a21oi_1
X_20195_ _03478_ _05635_ VSS VSS VDD VDD _0254_[8] sky130_fd_sc_hd__xnor2_1
X_20196_ _03181_ _05631_ VSS VSS VDD VDD _0254_[4] sky130_fd_sc_hd__xor2_1
X_20197_ _02504_ _05622_ VSS VSS VDD VDD _0316_[3] sky130_fd_sc_hd__xnor2_1
X_20198_ u_core.u_top.u_core.lfsr[6] u_core.u_top.u_core.d_acc[69] VSS VSS VDD VDD _05636_ sky130_fd_sc_hd__xnor2_1
X_20199_ _03157_ VSS VSS VDD VDD _05637_ sky130_fd_sc_hd__inv_1
X_20200_ _02911_ u_core.u_top.u_core.d_acc[60] _03443_ VSS VSS VDD VDD _05638_ sky130_fd_sc_hd__a21o_1
X_20201_ _02999_ _05638_ _02998_ VSS VSS VDD VDD _05639_ sky130_fd_sc_hd__a21oi_1
X_20202_ _05095_ _05639_ _05098_ VSS VSS VDD VDD _05640_ sky130_fd_sc_hd__o21ai_0
X_20203_ _02577_ _05640_ _02576_ VSS VSS VDD VDD _05641_ sky130_fd_sc_hd__a21oi_1
X_20204_ _05094_ _05641_ _02762_ VSS VSS VDD VDD _05642_ sky130_fd_sc_hd__o21bai_1
X_20205_ _02572_ _05642_ _02571_ VSS VSS VDD VDD _05643_ sky130_fd_sc_hd__a21oi_1
X_20206_ _05637_ _05643_ _03156_ VSS VSS VDD VDD _05644_ sky130_fd_sc_hd__o21bai_1
X_20207_ _02783_ _05644_ _02782_ VSS VSS VDD VDD _05645_ sky130_fd_sc_hd__a21oi_1
X_20208_ _05636_ _05645_ VSS VSS VDD VDD _0259_[9] sky130_fd_sc_hd__xnor2_1
X_20209_ _02763_ _05641_ VSS VSS VDD VDD _0259_[5] sky130_fd_sc_hd__xnor2_1
X_20210_ _02706_ _05633_ VSS VSS VDD VDD _0254_[6] sky130_fd_sc_hd__xor2_1
X_20211_ u_core.u_top.u_core.acc[171] VSS VSS VDD VDD _03005_ sky130_fd_sc_hd__inv_1
X_20212_ u_core.u_top.u_core.r_off[1] VSS VSS VDD VDD _02310_ sky130_fd_sc_hd__inv_2
X_20213_ _03244_ _05601_ VSS VSS VDD VDD _0338_[5] sky130_fd_sc_hd__xnor2_1
X_20214_ u_core.u_top.u_core.lfsr[10] u_core.u_top.u_core.d_acc[109] VSS VSS VDD VDD _05646_ sky130_fd_sc_hd__xnor2_1
X_20215_ _02983_ VSS VSS VDD VDD _05647_ sky130_fd_sc_hd__inv_1
X_20216_ u_core.u_top.u_core.d_acc[100] _02808_ _02807_ VSS VSS VDD VDD _05648_ sky130_fd_sc_hd__a21o_1
X_20217_ _03420_ _05648_ _03419_ VSS VSS VDD VDD _05649_ sky130_fd_sc_hd__a21oi_1
X_20218_ _05587_ _05649_ _05590_ VSS VSS VDD VDD _05650_ sky130_fd_sc_hd__o21ai_0
X_20219_ _03012_ _05650_ _03011_ VSS VSS VDD VDD _05651_ sky130_fd_sc_hd__a21oi_1
X_20220_ _05586_ _05651_ _02893_ VSS VSS VDD VDD _05652_ sky130_fd_sc_hd__o21bai_1
X_20221_ _02953_ _05652_ _02952_ VSS VSS VDD VDD _05653_ sky130_fd_sc_hd__a21oi_1
X_20222_ _05647_ _05653_ _02982_ VSS VSS VDD VDD _05654_ sky130_fd_sc_hd__o21bai_1
X_20223_ _03445_ _05654_ _03444_ VSS VSS VDD VDD _05655_ sky130_fd_sc_hd__a21oi_1
X_20224_ _05646_ _05655_ VSS VSS VDD VDD _0279_[9] sky130_fd_sc_hd__xnor2_1
X_20225_ _02894_ _05651_ VSS VSS VDD VDD _0279_[5] sky130_fd_sc_hd__xnor2_1
X_20226_ _02945_ _08106_ VSS VSS VDD VDD _0264_[6] sky130_fd_sc_hd__xor2_1
X_20227_ _02769_ _02354_ VSS VSS VDD VDD _0264_[2] sky130_fd_sc_hd__xnor2_1
X_20228_ _03192_ VSS VSS VDD VDD _05656_ sky130_fd_sc_hd__inv_1
X_20229_ _02855_ VSS VSS VDD VDD _05657_ sky130_fd_sc_hd__inv_1
X_20230_ _03270_ u_core.u_top.u_core.d_acc[230] _03269_ VSS VSS VDD VDD _05658_ sky130_fd_sc_hd__a21o_1
X_20231_ _02569_ _05658_ _02568_ VSS VSS VDD VDD _05659_ sky130_fd_sc_hd__a21oi_1
X_20232_ _05657_ _05659_ _02854_ VSS VSS VDD VDD _05660_ sky130_fd_sc_hd__o21bai_1
X_20233_ _03376_ _05660_ _03375_ VSS VSS VDD VDD _05661_ sky130_fd_sc_hd__a21oi_1
X_20234_ _05656_ _05661_ _03191_ VSS VSS VDD VDD _05662_ sky130_fd_sc_hd__o21bai_1
X_20235_ _03474_ _05662_ _03473_ VSS VSS VDD VDD _05663_ sky130_fd_sc_hd__a21oi_1
X_20236_ _03272_ _05663_ VSS VSS VDD VDD _0349_[7] sky130_fd_sc_hd__xnor2_1
X_20237_ _03378_ VSS VSS VDD VDD _05664_ sky130_fd_sc_hd__inv_1
X_20238_ _02451_ VSS VSS VDD VDD _05665_ sky130_fd_sc_hd__inv_1
X_20239_ _03374_ _05665_ _03373_ VSS VSS VDD VDD _05666_ sky130_fd_sc_hd__a21oi_1
X_20240_ _03377_ VSS VSS VDD VDD _05667_ sky130_fd_sc_hd__inv_1
X_20241_ _05664_ _05666_ _05667_ VSS VSS VDD VDD _05668_ sky130_fd_sc_hd__o21ai_0
X_20242_ _03068_ _05668_ VSS VSS VDD VDD _0344_[4] sky130_fd_sc_hd__xor2_1
X_20243_ _03106_ VSS VSS VDD VDD _05669_ sky130_fd_sc_hd__inv_1
X_20244_ u_core.u_top.u_core.d_acc[110] _02912_ _02972_ VSS VSS VDD VDD _05670_ sky130_fd_sc_hd__a21o_1
X_20245_ _03226_ _05670_ _03225_ VSS VSS VDD VDD _05671_ sky130_fd_sc_hd__a21oi_1
X_20246_ _05669_ _05671_ _03105_ VSS VSS VDD VDD _05672_ sky130_fd_sc_hd__o21bai_1
X_20247_ _03228_ _05672_ _03227_ VSS VSS VDD VDD _05673_ sky130_fd_sc_hd__a21oi_1
X_20248_ _03224_ _05673_ VSS VSS VDD VDD _0284_[5] sky130_fd_sc_hd__xnor2_1
X_20249_ _02656_ _05599_ VSS VSS VDD VDD _0338_[3] sky130_fd_sc_hd__xnor2_1
X_20250_ net992 u_core.u_top.u_core.d_acc[189] VSS VSS VDD VDD _05674_ sky130_fd_sc_hd__xnor2_1
X_20251_ _02967_ VSS VSS VDD VDD _05675_ sky130_fd_sc_hd__inv_1
X_20252_ _02599_ VSS VSS VDD VDD _05676_ sky130_fd_sc_hd__inv_1
X_20253_ _05676_ _09524_ _02598_ VSS VSS VDD VDD _05677_ sky130_fd_sc_hd__o21bai_1
X_20254_ _03150_ _05677_ _03149_ VSS VSS VDD VDD _05678_ sky130_fd_sc_hd__a21oi_1
X_20255_ _05675_ _05678_ _02966_ VSS VSS VDD VDD _05679_ sky130_fd_sc_hd__o21bai_1
X_20256_ _03177_ _05679_ _03176_ VSS VSS VDD VDD _05680_ sky130_fd_sc_hd__a21oi_1
X_20257_ _05674_ _05680_ VSS VSS VDD VDD _0322_[9] sky130_fd_sc_hd__xnor2_1
X_20258_ _02358_ VSS VSS VDD VDD _05681_ sky130_fd_sc_hd__inv_1
X_20259_ _03095_ _05681_ _03094_ VSS VSS VDD VDD _05682_ sky130_fd_sc_hd__a21oi_1
X_20260_ _09520_ _05682_ _03162_ VSS VSS VDD VDD _05683_ sky130_fd_sc_hd__o21bai_1
X_20261_ _03014_ _05683_ _03013_ VSS VSS VDD VDD _05684_ sky130_fd_sc_hd__a21oi_1
X_20262_ _05676_ _05684_ VSS VSS VDD VDD _05685_ sky130_fd_sc_hd__nor2_1
X_20263_ _02598_ _05685_ VSS VSS VDD VDD _05686_ sky130_fd_sc_hd__nor2_1
X_20264_ _03150_ _05686_ VSS VSS VDD VDD _0322_[6] sky130_fd_sc_hd__xnor2_1
X_20265_ _05121_ _05618_ _02589_ VSS VSS VDD VDD _05687_ sky130_fd_sc_hd__o21bai_1
X_20266_ _03119_ _05687_ _03118_ VSS VSS VDD VDD _05688_ sky130_fd_sc_hd__a21oi_1
X_20267_ _02829_ _05688_ VSS VSS VDD VDD _0269_[7] sky130_fd_sc_hd__xnor2_1
X_20268_ _03315_ _05616_ VSS VSS VDD VDD _0269_[3] sky130_fd_sc_hd__xnor2_1
X_20269_ _03163_ _09522_ VSS VSS VDD VDD _0322_[3] sky130_fd_sc_hd__xnor2_1
X_20270_ _03192_ _05661_ VSS VSS VDD VDD _0349_[5] sky130_fd_sc_hd__xnor2_1
X_20271_ u_core.u_top.u_core.acc_upd[51] VSS VSS VDD VDD _02349_ sky130_fd_sc_hd__inv_1
X_20272_ u_core.u_top.u_core.lfsr_m72[4] _03026_ _03025_ VSS VSS VDD VDD _05689_ sky130_fd_sc_hd__or3_1
X_20274_ u_core.u_top.u_core.lfsr_m72[6] u_core.u_top.u_core.lfsr_m72[5] _05689_ VSS VSS VDD VDD _05691_ sky130_fd_sc_hd__nor3_1
X_20275_ _03026_ _03025_ u_core.u_top.u_core.lfsr_m72[4] VSS VSS VDD VDD _05692_ sky130_fd_sc_hd__o21ai_0
X_20276_ u_core.u_top.u_core.lfsr[10] u_core.u_top.u_core.lfsr[15] VSS VSS VDD VDD _05693_ sky130_fd_sc_hd__xor2_1
X_20277_ u_core.u_top.u_core.lfsr[13] u_core.u_top.u_core.lfsr[12] VSS VSS VDD VDD _05694_ sky130_fd_sc_hd__xnor2_1
X_20278_ _05693_ _05694_ VSS VSS VDD VDD _0725_[0] sky130_fd_sc_hd__xnor2_2
X_20279_ net992 _03026_ VSS VSS VDD VDD _05695_ sky130_fd_sc_hd__nand2_1
X_20280_ net993 net995 net878 _05695_ _02874_ VSS VSS VDD VDD _05696_ sky130_fd_sc_hd__o41ai_1
X_20281_ _05689_ _05696_ VSS VSS VDD VDD _05697_ sky130_fd_sc_hd__nand2_1
X_20282_ _05692_ _05697_ VSS VSS VDD VDD _05698_ sky130_fd_sc_hd__nand2_1
X_20283_ u_core.u_top.u_core.lfsr_m72[5] _05689_ VSS VSS VDD VDD _05699_ sky130_fd_sc_hd__nor2_1
X_20284_ u_core.u_top.u_core.lfsr_m72[5] _05698_ _05699_ u_core.u_top.u_core.lfsr_m72[6] VSS VSS VDD VDD _05700_ sky130_fd_sc_hd__a211oi_1
X_20285_ _05691_ _05700_ _02874_ VSS VSS VDD VDD _05701_ sky130_fd_sc_hd__nor3b_1
X_20286_ _02875_ _05691_ _05701_ VSS VSS VDD VDD _05702_ sky130_fd_sc_hd__a21oi_1
X_20287_ _05689_ _05692_ VSS VSS VDD VDD _05703_ sky130_fd_sc_hd__nand2_1
X_20288_ _05702_ _05703_ VSS VSS VDD VDD u_core.u_top.u_core.m72_next[5] sky130_fd_sc_hd__xnor2_1
X_20289_ _05691_ _05700_ _0727_[4] VSS VSS VDD VDD _05704_ sky130_fd_sc_hd__nor3b_1
X_20290_ _0725_[4] _05691_ _05700_ u_core.u_top.u_core.m72_t[4] _05704_ VSS VSS VDD VDD u_core.u_top.u_core.m72_next[4] sky130_fd_sc_hd__a221o_1
X_20291_ net992 _05700_ VSS VSS VDD VDD u_core.u_top.u_core.m72_next[3] sky130_fd_sc_hd__xnor2_1
X_20292_ u_core.u_top.u_core.d_acc[110] VSS VSS VDD VDD _0284_[0] sky130_fd_sc_hd__inv_1
X_20293_ net992 VSS VSS VDD VDD _02305_ sky130_fd_sc_hd__inv_1
X_20294_ u_core.u_top.u_core.lfsr[6] VSS VSS VDD VDD _02363_ sky130_fd_sc_hd__inv_1
X_20295_ _03374_ _02451_ VSS VSS VDD VDD _0344_[2] sky130_fd_sc_hd__xnor2_1
X_20296_ u_core.u_top.u_core.d_acc[141] VSS VSS VDD VDD _02442_ sky130_fd_sc_hd__inv_1
X_20297_ u_core.u_actl.cnt[1] VSS VSS VDD VDD _02926_ sky130_fd_sc_hd__inv_1
X_20298_ net994 VSS VSS VDD VDD _02337_ sky130_fd_sc_hd__inv_1
X_20299_ _03078_ VSS VSS VDD VDD _05705_ sky130_fd_sc_hd__inv_1
X_20300_ _05705_ _06513_ _03077_ VSS VSS VDD VDD _05706_ sky130_fd_sc_hd__o21bai_1
X_20301_ _03280_ _05706_ _03279_ VSS VSS VDD VDD _05707_ sky130_fd_sc_hd__a21oi_1
X_20302_ _03276_ _05707_ VSS VSS VDD VDD _0289_[7] sky130_fd_sc_hd__xnor2_1
X_20303_ _02840_ _02465_ VSS VSS VDD VDD _0289_[2] sky130_fd_sc_hd__xnor2_1
X_20304_ u_core.u_top.u_core.r_off[5] VSS VSS VDD VDD _02515_ sky130_fd_sc_hd__inv_2
X_20305_ u_core.u_top.u_core.d_acc[0] VSS VSS VDD VDD _0226_[0] sky130_fd_sc_hd__inv_1
X_20306_ u_core.u_top.u_core.d_acc[1] VSS VSS VDD VDD _02327_ sky130_fd_sc_hd__inv_1
X_20307_ _02329_ VSS VSS VDD VDD _0226_[1] sky130_fd_sc_hd__inv_1
X_20308_ u_core.u_top.u_core.d_acc[181] VSS VSS VDD VDD _02357_ sky130_fd_sc_hd__inv_1
X_20309_ _03014_ _05683_ VSS VSS VDD VDD _0322_[4] sky130_fd_sc_hd__xor2_1
X_20310_ _02401_ VSS VSS VDD VDD _05708_ sky130_fd_sc_hd__inv_1
X_20311_ _02937_ _05708_ _02936_ VSS VSS VDD VDD _05709_ sky130_fd_sc_hd__a21oi_1
X_20312_ _05605_ _05709_ _02578_ VSS VSS VDD VDD _05710_ sky130_fd_sc_hd__o21bai_1
X_20313_ _03363_ _05710_ _03362_ VSS VSS VDD VDD _05711_ sky130_fd_sc_hd__a21oi_1
X_20314_ _05604_ _05711_ _02722_ VSS VSS VDD VDD _05712_ sky130_fd_sc_hd__o21bai_1
X_20315_ _02791_ _05712_ _02790_ VSS VSS VDD VDD _05713_ sky130_fd_sc_hd__a21o_1
X_20316_ _02592_ _05713_ _02591_ VSS VSS VDD VDD _05714_ sky130_fd_sc_hd__a21oi_1
X_20317_ _02787_ _05714_ VSS VSS VDD VDD _0274_[8] sky130_fd_sc_hd__xnor2_1
X_20318_ _03363_ _05710_ VSS VSS VDD VDD _0274_[4] sky130_fd_sc_hd__xor2_1
X_20319_ _02369_ VSS VSS VDD VDD _05715_ sky130_fd_sc_hd__inv_1
X_20320_ _05715_ _03226_ _03225_ VSS VSS VDD VDD _05716_ sky130_fd_sc_hd__a21oi_1
X_20321_ _05669_ _05716_ _03105_ VSS VSS VDD VDD _05717_ sky130_fd_sc_hd__o21bai_1
X_20322_ _03228_ _05717_ VSS VSS VDD VDD _0284_[4] sky130_fd_sc_hd__xor2_1
X_20323_ u_core.u_top.u_core.d_acc[191] VSS VSS VDD VDD _02457_ sky130_fd_sc_hd__inv_1
X_20324_ _02983_ _05653_ VSS VSS VDD VDD _0279_[7] sky130_fd_sc_hd__xnor2_1
X_20325_ _03386_ _05649_ VSS VSS VDD VDD _0279_[3] sky130_fd_sc_hd__xnor2_1
X_20326_ _02855_ _05659_ VSS VSS VDD VDD _0349_[3] sky130_fd_sc_hd__xnor2_1
X_20327_ _03224_ VSS VSS VDD VDD _05718_ sky130_fd_sc_hd__inv_1
X_20328_ _05718_ _05673_ _03223_ VSS VSS VDD VDD _05719_ sky130_fd_sc_hd__o21bai_1
X_20329_ _03390_ _05719_ _03389_ VSS VSS VDD VDD _05720_ sky130_fd_sc_hd__a21oi_1
X_20330_ _02704_ _05720_ VSS VSS VDD VDD _0284_[7] sky130_fd_sc_hd__xnor2_1
X_20331_ _03106_ _05671_ VSS VSS VDD VDD _0284_[3] sky130_fd_sc_hd__xnor2_1
X_20332_ _03030_ VSS VSS VDD VDD _05721_ sky130_fd_sc_hd__inv_1
X_20333_ _03034_ VSS VSS VDD VDD _05722_ sky130_fd_sc_hd__inv_1
X_20334_ _02443_ VSS VSS VDD VDD _05723_ sky130_fd_sc_hd__inv_1
X_20335_ _05723_ _02620_ _02619_ VSS VSS VDD VDD _05724_ sky130_fd_sc_hd__a21oi_1
X_20336_ _03033_ VSS VSS VDD VDD _05725_ sky130_fd_sc_hd__inv_1
X_20337_ _05722_ _05724_ _05725_ VSS VSS VDD VDD _05726_ sky130_fd_sc_hd__o21ai_0
X_20338_ _03196_ _05726_ _03195_ VSS VSS VDD VDD _05727_ sky130_fd_sc_hd__a21oi_1
X_20339_ _05721_ _05727_ VSS VSS VDD VDD _05728_ sky130_fd_sc_hd__nor2_1
X_20340_ _03029_ _05728_ VSS VSS VDD VDD _05729_ sky130_fd_sc_hd__nor2_1
X_20341_ _02759_ _05729_ VSS VSS VDD VDD _0300_[6] sky130_fd_sc_hd__xnor2_1
X_20342_ net992 u_core.u_top.u_core.d_acc[29] VSS VSS VDD VDD _05730_ sky130_fd_sc_hd__xnor2_1
X_20343_ _03296_ VSS VSS VDD VDD _05731_ sky130_fd_sc_hd__inv_1
X_20344_ _05731_ _08098_ _03295_ VSS VSS VDD VDD _05732_ sky130_fd_sc_hd__o21bai_1
X_20345_ _02833_ _05732_ _02832_ VSS VSS VDD VDD _05733_ sky130_fd_sc_hd__a21oi_1
X_20346_ _05730_ _05733_ VSS VSS VDD VDD _0238_[9] sky130_fd_sc_hd__xnor2_1
X_20347_ _02888_ _05068_ VSS VSS VDD VDD _0333_[4] sky130_fd_sc_hd__xor2_1
X_20348_ u_core.u_top.u_core.lfsr[14] VSS VSS VDD VDD _02445_ sky130_fd_sc_hd__inv_1
X_20349_ _02393_ VSS VSS VDD VDD _05734_ sky130_fd_sc_hd__inv_1
X_20350_ _03412_ _05734_ _03411_ VSS VSS VDD VDD _05735_ sky130_fd_sc_hd__a21oi_1
X_20351_ _06226_ _05735_ _03273_ VSS VSS VDD VDD _05736_ sky130_fd_sc_hd__o21bai_1
X_20352_ _03468_ _05736_ _03467_ VSS VSS VDD VDD _05737_ sky130_fd_sc_hd__a21oi_1
X_20353_ _09525_ _05737_ _02749_ VSS VSS VDD VDD _05738_ sky130_fd_sc_hd__o21bai_1
X_20354_ _03102_ _05738_ _03101_ VSS VSS VDD VDD _05739_ sky130_fd_sc_hd__a21o_1
X_20355_ _02831_ _05739_ _02830_ VSS VSS VDD VDD _05740_ sky130_fd_sc_hd__a21oi_1
X_20356_ _03104_ _05740_ VSS VSS VDD VDD _0294_[8] sky130_fd_sc_hd__xnor2_1
X_20357_ _03274_ _06228_ VSS VSS VDD VDD _0294_[3] sky130_fd_sc_hd__xnor2_1
X_20358_ _02953_ _05593_ VSS VSS VDD VDD _0279_[6] sky130_fd_sc_hd__xor2_1
X_20359_ _03420_ _02365_ VSS VSS VDD VDD _0279_[2] sky130_fd_sc_hd__xnor2_1
X_20360_ u_core.u_top.u_core.lfsr[5] VSS VSS VDD VDD _02399_ sky130_fd_sc_hd__inv_1
X_20361_ u_core.u_top.u_core.r_off[4] VSS VSS VDD VDD _02490_ sky130_fd_sc_hd__inv_2
X_20362_ u_core.u_top.u_core.lfsr[14] u_core.u_top.u_core.d_acc[149] VSS VSS VDD VDD _05741_ sky130_fd_sc_hd__xnor2_1
X_20363_ _02612_ VSS VSS VDD VDD _05742_ sky130_fd_sc_hd__inv_1
X_20364_ u_core.u_top.u_core.d_acc[140] _03231_ _03242_ VSS VSS VDD VDD _05743_ sky130_fd_sc_hd__a21o_1
X_20365_ _02620_ _05743_ _02619_ VSS VSS VDD VDD _05744_ sky130_fd_sc_hd__a21oi_1
X_20366_ _05722_ _05744_ _05725_ VSS VSS VDD VDD _05745_ sky130_fd_sc_hd__o21ai_0
X_20367_ _03196_ _05745_ _03195_ VSS VSS VDD VDD _05746_ sky130_fd_sc_hd__a21oi_1
X_20368_ _05721_ _05746_ _03029_ VSS VSS VDD VDD _05747_ sky130_fd_sc_hd__o21bai_1
X_20369_ _02759_ _05747_ _02758_ VSS VSS VDD VDD _05748_ sky130_fd_sc_hd__a21oi_1
X_20370_ _05742_ _05748_ _02611_ VSS VSS VDD VDD _05749_ sky130_fd_sc_hd__o21bai_1
X_20371_ _03230_ _05749_ _03229_ VSS VSS VDD VDD _05750_ sky130_fd_sc_hd__a21oi_1
X_20372_ _05741_ _05750_ VSS VSS VDD VDD _0300_[9] sky130_fd_sc_hd__xnor2_1
X_20373_ _03175_ _06558_ VSS VSS VDD VDD _0327_[7] sky130_fd_sc_hd__xnor2_1
X_20374_ _02458_ VSS VSS VDD VDD _05751_ sky130_fd_sc_hd__inv_1
X_20375_ _03366_ _05751_ _03365_ VSS VSS VDD VDD _05752_ sky130_fd_sc_hd__a21oi_1
X_20376_ _06212_ _05752_ _03293_ VSS VSS VDD VDD _05753_ sky130_fd_sc_hd__o21bai_1
X_20377_ _03456_ _05753_ VSS VSS VDD VDD _0327_[4] sky130_fd_sc_hd__xor2_1
X_20378_ _03196_ _05726_ VSS VSS VDD VDD _0300_[4] sky130_fd_sc_hd__xor2_1
X_20379_ u_core.u_top.u_core.d_acc[30] VSS VSS VDD VDD _0243_[0] sky130_fd_sc_hd__inv_1
X_20380_ _03228_ _05717_ _03227_ VSS VSS VDD VDD _05754_ sky130_fd_sc_hd__a21oi_1
X_20381_ _05718_ _05754_ VSS VSS VDD VDD _05755_ sky130_fd_sc_hd__nor2_1
X_20382_ _03223_ _05755_ VSS VSS VDD VDD _05756_ sky130_fd_sc_hd__nor2_1
X_20383_ _03390_ _05756_ VSS VSS VDD VDD _0284_[6] sky130_fd_sc_hd__xnor2_1
X_20384_ _02369_ _03226_ VSS VSS VDD VDD _0284_[2] sky130_fd_sc_hd__xnor2_1
X_20385_ u_core.u_top.u_core.d_acc[180] VSS VSS VDD VDD _0322_[0] sky130_fd_sc_hd__inv_1
X_20386_ u_core.u_top.u_core.acc[131] VSS VSS VDD VDD _02801_ sky130_fd_sc_hd__inv_1
X_20387_ _03317_ _05076_ VSS VSS VDD VDD _0306_[5] sky130_fd_sc_hd__xnor2_1
X_20388_ u_core.u_top.u_core.d_acc[190] VSS VSS VDD VDD _0327_[0] sky130_fd_sc_hd__inv_1
X_20389_ _03179_ _06546_ VSS VSS VDD VDD _0311_[7] sky130_fd_sc_hd__xnor2_1
X_20390_ _02817_ _02299_ VSS VSS VDD VDD _0311_[2] sky130_fd_sc_hd__xnor2_1
X_20391_ _03431_ _05091_ VSS VSS VDD VDD _0306_[6] sky130_fd_sc_hd__xor2_1
X_20392_ _03456_ _05753_ _03455_ VSS VSS VDD VDD _05757_ sky130_fd_sc_hd__a21oi_1
X_20393_ _06556_ _05757_ _03172_ VSS VSS VDD VDD _05758_ sky130_fd_sc_hd__o21bai_1
X_20394_ _03205_ _05758_ _03204_ VSS VSS VDD VDD _05759_ sky130_fd_sc_hd__a21o_1
X_20395_ _03175_ _05759_ _03174_ VSS VSS VDD VDD _05760_ sky130_fd_sc_hd__a21oi_1
X_20396_ _03171_ _05760_ VSS VSS VDD VDD _0327_[8] sky130_fd_sc_hd__xnor2_1
X_20397_ _02511_ _06540_ _02863_ VSS VSS VDD VDD _05761_ sky130_fd_sc_hd__o21ai_0
X_20398_ _02862_ _05761_ VSS VSS VDD VDD _05762_ sky130_fd_sc_hd__nand2b_1
X_20399_ _03159_ _05762_ _03158_ VSS VSS VDD VDD _05763_ sky130_fd_sc_hd__a21oi_1
X_20400_ _03020_ _05763_ VSS VSS VDD VDD _0232_[8] sky130_fd_sc_hd__xnor2_1
X_20401_ _03056_ _02417_ VSS VSS VDD VDD _0333_[2] sky130_fd_sc_hd__xnor2_1
X_20402_ u_core.u_top.u_core.d_acc[140] VSS VSS VDD VDD _0300_[0] sky130_fd_sc_hd__inv_1
X_20403_ _03018_ _06532_ _03017_ VSS VSS VDD VDD _05764_ sky130_fd_sc_hd__a21oi_1
X_20404_ _06544_ _05764_ _03291_ VSS VSS VDD VDD _05765_ sky130_fd_sc_hd__o21bai_1
X_20405_ _02775_ _05765_ _02774_ VSS VSS VDD VDD _05766_ sky130_fd_sc_hd__a21o_1
X_20406_ _03179_ _05766_ _03178_ VSS VSS VDD VDD _05767_ sky130_fd_sc_hd__a21oi_1
X_20407_ _03148_ _05767_ VSS VSS VDD VDD _0311_[8] sky130_fd_sc_hd__xnor2_1
X_20408_ _02985_ _06527_ VSS VSS VDD VDD _0311_[3] sky130_fd_sc_hd__xnor2_1
X_20409_ _03102_ _05738_ VSS VSS VDD VDD _0294_[6] sky130_fd_sc_hd__xor2_1
X_20410_ _03034_ _05744_ VSS VSS VDD VDD _0300_[3] sky130_fd_sc_hd__xnor2_1
X_20411_ _02398_ VSS VSS VDD VDD _0254_[1] sky130_fd_sc_hd__inv_1
X_20412_ _02598_ _05685_ _03150_ VSS VSS VDD VDD _05768_ sky130_fd_sc_hd__o21ai_0
X_20413_ _03149_ _05768_ VSS VSS VDD VDD _05769_ sky130_fd_sc_hd__nand2b_1
X_20414_ _02967_ _05769_ _02966_ VSS VSS VDD VDD _05770_ sky130_fd_sc_hd__a21oi_1
X_20415_ _03177_ _05770_ VSS VSS VDD VDD _0322_[8] sky130_fd_sc_hd__xnor2_1
X_20416_ u_core.u_top.u_core.d_acc[59] u_core.u_top.u_core.lfsr[5] VSS VSS VDD VDD _05771_ sky130_fd_sc_hd__xnor2_1
X_20417_ _03152_ VSS VSS VDD VDD _05772_ sky130_fd_sc_hd__inv_1
X_20418_ _05772_ _05086_ _03151_ VSS VSS VDD VDD _05773_ sky130_fd_sc_hd__o21bai_1
X_20419_ _03478_ _05773_ _03477_ VSS VSS VDD VDD _05774_ sky130_fd_sc_hd__a21oi_1
X_20420_ _05771_ _05774_ VSS VSS VDD VDD _0254_[9] sky130_fd_sc_hd__xnor2_1
X_20421_ _03108_ _05084_ VSS VSS VDD VDD _0254_[5] sky130_fd_sc_hd__xnor2_1
X_20422_ u_core.u_top.u_core.lfsr[9] VSS VSS VDD VDD _02403_ sky130_fd_sc_hd__inv_1
X_20423_ _03216_ _05624_ VSS VSS VDD VDD _0316_[5] sky130_fd_sc_hd__xnor2_1
X_20424_ _02572_ _05101_ VSS VSS VDD VDD _0259_[6] sky130_fd_sc_hd__xor2_1
X_20425_ _02999_ _02361_ VSS VSS VDD VDD _0259_[2] sky130_fd_sc_hd__xnor2_1
X_20426_ u_core.u_top.u_core.d_acc[219] u_core.u_top.u_core.lfsr[5] VSS VSS VDD VDD _05775_ sky130_fd_sc_hd__xnor2_1
X_20427_ _03238_ VSS VSS VDD VDD _05776_ sky130_fd_sc_hd__inv_1
X_20428_ _05776_ _05603_ _03237_ VSS VSS VDD VDD _05777_ sky130_fd_sc_hd__o21bai_1
X_20429_ _03254_ _05777_ _03253_ VSS VSS VDD VDD _05778_ sky130_fd_sc_hd__a21oi_1
X_20430_ _05775_ _05778_ VSS VSS VDD VDD _0338_[9] sky130_fd_sc_hd__xnor2_1
X_20431_ _03022_ _05118_ VSS VSS VDD VDD _0264_[7] sky130_fd_sc_hd__xnor2_1
X_20432_ _03066_ _05114_ VSS VSS VDD VDD _0264_[3] sky130_fd_sc_hd__xnor2_1
X_20433_ _02589_ _05128_ _03119_ VSS VSS VDD VDD _05779_ sky130_fd_sc_hd__o21ai_0
X_20434_ _03118_ _05779_ VSS VSS VDD VDD _05780_ sky130_fd_sc_hd__nand2b_1
X_20435_ _02829_ _05780_ _02828_ VSS VSS VDD VDD _05781_ sky130_fd_sc_hd__a21oi_1
X_20436_ _02773_ _05781_ VSS VSS VDD VDD _0269_[8] sky130_fd_sc_hd__xnor2_1
X_20437_ _02667_ _05126_ VSS VSS VDD VDD _0269_[4] sky130_fd_sc_hd__xor2_1
X_20438_ _02967_ _05678_ VSS VSS VDD VDD _0322_[7] sky130_fd_sc_hd__xnor2_1
X_20439_ net991 u_core.u_top.u_core.d_acc[99] VSS VSS VDD VDD _05782_ sky130_fd_sc_hd__xnor2_1
X_20440_ _02592_ VSS VSS VDD VDD _05783_ sky130_fd_sc_hd__inv_1
X_20441_ _05783_ _05611_ _02591_ VSS VSS VDD VDD _05784_ sky130_fd_sc_hd__o21bai_1
X_20442_ _02787_ _05784_ _02786_ VSS VSS VDD VDD _05785_ sky130_fd_sc_hd__a21oi_1
X_20443_ _05782_ _05785_ VSS VSS VDD VDD _0274_[9] sky130_fd_sc_hd__xnor2_1
X_20444_ _02723_ _05609_ VSS VSS VDD VDD _0274_[5] sky130_fd_sc_hd__xnor2_1
X_20445_ _02444_ VSS VSS VDD VDD _0300_[1] sky130_fd_sc_hd__inv_1
X_20446_ _06609_ VSS VSS VDD VDD u_core.u_top.u_core.x_idx[1] sky130_fd_sc_hd__inv_1
X_20447_ u_core.u_top.u_core.d_acc[170] VSS VSS VDD VDD _0316_[0] sky130_fd_sc_hd__inv_1
X_20448_ u_core.u_top.u_core.d_acc[39] u_core.u_top.u_core.lfsr[3] VSS VSS VDD VDD _05786_ sky130_fd_sc_hd__xnor2_1
X_20449_ _02545_ VSS VSS VDD VDD _05787_ sky130_fd_sc_hd__inv_1
X_20450_ _05787_ _05037_ _02544_ VSS VSS VDD VDD _05788_ sky130_fd_sc_hd__o21bai_1
X_20451_ _03113_ _05788_ _03112_ VSS VSS VDD VDD _05789_ sky130_fd_sc_hd__a21oi_1
X_20452_ _05786_ _05789_ VSS VSS VDD VDD _0243_[9] sky130_fd_sc_hd__xnor2_1
X_20453_ _02882_ _05035_ VSS VSS VDD VDD _0243_[5] sky130_fd_sc_hd__xnor2_1
X_20454_ _03205_ _05758_ VSS VSS VDD VDD _0327_[6] sky130_fd_sc_hd__xor2_1
X_20455_ _02465_ VSS VSS VDD VDD _05790_ sky130_fd_sc_hd__inv_1
X_20456_ _02840_ _05790_ _02839_ VSS VSS VDD VDD _05791_ sky130_fd_sc_hd__a21oi_1
X_20457_ _06509_ _05791_ _02556_ VSS VSS VDD VDD _05792_ sky130_fd_sc_hd__o21bai_1
X_20458_ _03278_ _05792_ _03277_ VSS VSS VDD VDD _05793_ sky130_fd_sc_hd__a21oi_1
X_20459_ _05705_ _05793_ VSS VSS VDD VDD _05794_ sky130_fd_sc_hd__nor2_1
X_20460_ _03077_ _05794_ VSS VSS VDD VDD _05795_ sky130_fd_sc_hd__nor2_1
X_20461_ _03280_ _05795_ VSS VSS VDD VDD _0289_[6] sky130_fd_sc_hd__xnor2_1
X_20462_ u_core.u_top.u_core.d_acc[49] u_core.u_top.u_core.lfsr[4] VSS VSS VDD VDD _05796_ sky130_fd_sc_hd__xnor2_1
X_20463_ _02564_ VSS VSS VDD VDD _05797_ sky130_fd_sc_hd__inv_1
X_20464_ _05797_ _05045_ _02563_ VSS VSS VDD VDD _05798_ sky130_fd_sc_hd__o21bai_1
X_20465_ _02991_ _05798_ _02990_ VSS VSS VDD VDD _05799_ sky130_fd_sc_hd__a21oi_1
X_20466_ _05796_ _05799_ VSS VSS VDD VDD _0249_[9] sky130_fd_sc_hd__xnor2_1
X_20467_ _02865_ _05043_ VSS VSS VDD VDD _0249_[5] sky130_fd_sc_hd__xnor2_1
X_20468_ u_core.u_top.u_core.d_acc[171] VSS VSS VDD VDD _02334_ sky130_fd_sc_hd__inv_1
X_20469_ _02753_ VSS VSS VDD VDD _03466_ sky130_fd_sc_hd__inv_1
X_20470_ u_core.u_top.u_core.d_acc[61] VSS VSS VDD VDD _02360_ sky130_fd_sc_hd__inv_1
X_20471_ u_core.u_top.u_core.d_acc[230] VSS VSS VDD VDD _0349_[0] sky130_fd_sc_hd__inv_1
X_20472_ _02336_ VSS VSS VDD VDD _0316_[1] sky130_fd_sc_hd__inv_1
X_20473_ _02791_ _05712_ VSS VSS VDD VDD _0274_[6] sky130_fd_sc_hd__xor2_1
X_20474_ _02937_ _02401_ VSS VSS VDD VDD _0274_[2] sky130_fd_sc_hd__xnor2_1
X_20475_ _03012_ _05591_ VSS VSS VDD VDD _0279_[4] sky130_fd_sc_hd__xor2_1
X_20476_ _02304_ VSS VSS VDD VDD _0238_[1] sky130_fd_sc_hd__inv_1
X_20477_ u_core.u_top.u_core.d_acc[209] u_core.u_top.u_core.lfsr[4] VSS VSS VDD VDD _05800_ sky130_fd_sc_hd__xnor2_1
X_20478_ _02551_ VSS VSS VDD VDD _05801_ sky130_fd_sc_hd__inv_1
X_20479_ u_core.u_top.u_core.d_acc[200] _03096_ _03232_ VSS VSS VDD VDD _05802_ sky130_fd_sc_hd__a21o_1
X_20480_ _03056_ _05802_ _03055_ VSS VSS VDD VDD _05803_ sky130_fd_sc_hd__a21oi_1
X_20481_ _05064_ _05803_ _05067_ VSS VSS VDD VDD _05804_ sky130_fd_sc_hd__o21ai_0
X_20482_ _02888_ _05804_ _02887_ VSS VSS VDD VDD _05805_ sky130_fd_sc_hd__a21oi_1
X_20483_ _05063_ _05805_ _03168_ VSS VSS VDD VDD _05806_ sky130_fd_sc_hd__o21bai_1
X_20484_ _02742_ _05806_ _02741_ VSS VSS VDD VDD _05807_ sky130_fd_sc_hd__a21oi_1
X_20485_ _05801_ _05807_ _02550_ VSS VSS VDD VDD _05808_ sky130_fd_sc_hd__o21bai_1
X_20486_ _03222_ _05808_ _03221_ VSS VSS VDD VDD _05809_ sky130_fd_sc_hd__a21oi_1
X_20487_ _05800_ _05809_ VSS VSS VDD VDD _0333_[9] sky130_fd_sc_hd__xnor2_1
X_20488_ _03169_ _05805_ VSS VSS VDD VDD _0333_[5] sky130_fd_sc_hd__xnor2_1
X_20489_ u_core.u_top.u_core.lfsr[8] u_core.u_top.u_core.d_acc[89] VSS VSS VDD VDD _05810_ sky130_fd_sc_hd__xnor2_1
X_20490_ _02829_ VSS VSS VDD VDD _05811_ sky130_fd_sc_hd__inv_1
X_20491_ _05811_ _05688_ _02828_ VSS VSS VDD VDD _05812_ sky130_fd_sc_hd__o21bai_1
X_20492_ _02773_ _05812_ _02772_ VSS VSS VDD VDD _05813_ sky130_fd_sc_hd__a21oi_1
X_20493_ _05810_ _05813_ VSS VSS VDD VDD _0269_[9] sky130_fd_sc_hd__xnor2_1
X_20494_ _03157_ _05643_ VSS VSS VDD VDD _0259_[7] sky130_fd_sc_hd__xnor2_1
X_20495_ _03091_ _05089_ VSS VSS VDD VDD _0306_[4] sky130_fd_sc_hd__xor2_1
X_20496_ net995 VSS VSS VDD VDD _02301_ sky130_fd_sc_hd__inv_1
X_20497_ _02630_ VSS VSS VDD VDD _02632_ sky130_fd_sc_hd__inv_1
X_20498_ _02553_ _05108_ VSS VSS VDD VDD _0249_[6] sky130_fd_sc_hd__xor2_1
X_20499_ _02394_ VSS VSS VDD VDD _0294_[1] sky130_fd_sc_hd__inv_1
X_20500_ u_core.u_top.u_core.lfsr[4] VSS VSS VDD VDD _02411_ sky130_fd_sc_hd__inv_1
X_20501_ _03029_ _05728_ _02759_ VSS VSS VDD VDD _05814_ sky130_fd_sc_hd__o21ai_0
X_20502_ _02758_ _05814_ VSS VSS VDD VDD _05815_ sky130_fd_sc_hd__nand2b_1
X_20503_ _02612_ _05815_ _02611_ VSS VSS VDD VDD _05816_ sky130_fd_sc_hd__a21oi_1
X_20504_ _03230_ _05816_ VSS VSS VDD VDD _0300_[8] sky130_fd_sc_hd__xnor2_1
X_20505_ _02428_ VSS VSS VDD VDD _05817_ sky130_fd_sc_hd__inv_1
X_20506_ _03167_ _05817_ _03166_ VSS VSS VDD VDD _05818_ sky130_fd_sc_hd__a21oi_1
X_20507_ _05597_ _05818_ _02655_ VSS VSS VDD VDD _05819_ sky130_fd_sc_hd__o21bai_1
X_20508_ _03465_ _05819_ _03464_ VSS VSS VDD VDD _05820_ sky130_fd_sc_hd__a21oi_1
X_20509_ _05596_ _05820_ VSS VSS VDD VDD _05821_ sky130_fd_sc_hd__nor2_1
X_20510_ _03243_ _05821_ VSS VSS VDD VDD _05822_ sky130_fd_sc_hd__nor2_1
X_20511_ _02648_ _05822_ VSS VSS VDD VDD _0338_[6] sky130_fd_sc_hd__xnor2_1
X_20512_ _03167_ _02428_ VSS VSS VDD VDD _0338_[2] sky130_fd_sc_hd__xnor2_1
X_20513_ u_core.u_top.u_core.d_acc[201] VSS VSS VDD VDD _02416_ sky130_fd_sc_hd__inv_1
X_20514_ _03366_ _02458_ VSS VSS VDD VDD _0327_[2] sky130_fd_sc_hd__xnor2_1
X_20515_ _02366_ VSS VSS VDD VDD _0279_[1] sky130_fd_sc_hd__inv_1
X_20516_ u_core.u_top.u_core.lfsr[3] VSS VSS VDD VDD _02407_ sky130_fd_sc_hd__inv_1
X_20517_ u_core.u_top.u_core.d_acc[231] VSS VSS VDD VDD _02472_ sky130_fd_sc_hd__inv_1
X_20518_ _02370_ VSS VSS VDD VDD _0284_[1] sky130_fd_sc_hd__inv_1
X_20519_ _02429_ VSS VSS VDD VDD _0338_[1] sky130_fd_sc_hd__inv_1
X_20520_ u_core.u_top.u_core.acc_upd[141] VSS VSS VDD VDD _02338_ sky130_fd_sc_hd__inv_1
X_20521_ _02561_ _05639_ VSS VSS VDD VDD _0259_[3] sky130_fd_sc_hd__xnor2_1
X_20522_ _02551_ _05807_ VSS VSS VDD VDD _0333_[7] sky130_fd_sc_hd__xnor2_1
X_20523_ _02951_ _05803_ VSS VSS VDD VDD _0333_[3] sky130_fd_sc_hd__xnor2_1
X_20524_ _03077_ _05794_ _03280_ VSS VSS VDD VDD _05823_ sky130_fd_sc_hd__o21ai_0
X_20525_ _03279_ _05823_ VSS VSS VDD VDD _05824_ sky130_fd_sc_hd__nand2b_1
X_20526_ _03276_ _05824_ _03275_ VSS VSS VDD VDD _05825_ sky130_fd_sc_hd__a21oi_1
X_20527_ _03304_ _05825_ VSS VSS VDD VDD _0289_[8] sky130_fd_sc_hd__xnor2_1
X_20528_ _02557_ _06511_ VSS VSS VDD VDD _0289_[3] sky130_fd_sc_hd__xnor2_1
X_20529_ _03278_ _05792_ VSS VSS VDD VDD _0289_[4] sky130_fd_sc_hd__xor2_1
X_20530_ _03257_ VSS VSS VDD VDD _05826_ sky130_fd_sc_hd__inv_1
X_20531_ u_core.u_top.u_core.d_acc[220] _03190_ _03189_ VSS VSS VDD VDD _05827_ sky130_fd_sc_hd__a21o_1
X_20532_ _03374_ _05827_ _03373_ VSS VSS VDD VDD _05828_ sky130_fd_sc_hd__a21oi_1
X_20533_ _05664_ _05828_ _05667_ VSS VSS VDD VDD _05829_ sky130_fd_sc_hd__o21ai_0
X_20534_ _03068_ _05829_ _03067_ VSS VSS VDD VDD _05830_ sky130_fd_sc_hd__a21oi_1
X_20535_ _05826_ _05830_ _03256_ VSS VSS VDD VDD _05831_ sky130_fd_sc_hd__o21bai_1
X_20536_ _03234_ _05831_ _03233_ VSS VSS VDD VDD _05832_ sky130_fd_sc_hd__a21oi_1
X_20537_ _03463_ _05832_ VSS VSS VDD VDD _0344_[7] sky130_fd_sc_hd__xnor2_1
X_20538_ _03378_ _05828_ VSS VSS VDD VDD _0344_[3] sky130_fd_sc_hd__xnor2_1
X_20539_ _03068_ _05668_ _03067_ VSS VSS VDD VDD _05833_ sky130_fd_sc_hd__a21oi_1
X_20540_ _05826_ _05833_ _03256_ VSS VSS VDD VDD _05834_ sky130_fd_sc_hd__o21bai_1
X_20541_ _03234_ _05834_ _03233_ VSS VSS VDD VDD _05835_ sky130_fd_sc_hd__a21o_1
X_20542_ _03463_ _05835_ _03462_ VSS VSS VDD VDD _05836_ sky130_fd_sc_hd__a21oi_1
X_20543_ _02664_ _05836_ VSS VSS VDD VDD _0344_[8] sky130_fd_sc_hd__xnor2_1
X_20544_ _03243_ _05821_ _02648_ VSS VSS VDD VDD _05837_ sky130_fd_sc_hd__o21ai_0
X_20545_ _02647_ _05837_ VSS VSS VDD VDD _05838_ sky130_fd_sc_hd__nand2b_1
X_20546_ _03238_ _05838_ _03237_ VSS VSS VDD VDD _05839_ sky130_fd_sc_hd__a21oi_1
X_20547_ _03254_ _05839_ VSS VSS VDD VDD _0338_[8] sky130_fd_sc_hd__xnor2_1
X_20548_ _03465_ _05819_ VSS VSS VDD VDD _0338_[4] sky130_fd_sc_hd__xor2_1
X_20549_ u_core.u_top.u_core.acc_upd[21] VSS VSS VDD VDD _02372_ sky130_fd_sc_hd__inv_1
X_20550_ _0355_[7] VSS VSS VDD VDD _03423_ sky130_fd_sc_hd__inv_1
X_20551_ u_core.u_top.u_core.d_acc[221] VSS VSS VDD VDD _02450_ sky130_fd_sc_hd__inv_1
X_20552_ _02359_ VSS VSS VDD VDD _0322_[1] sky130_fd_sc_hd__inv_1
X_20553_ u_core.u_top.u_core.d_acc[31] VSS VSS VDD VDD _02404_ sky130_fd_sc_hd__inv_1
X_20554_ _02406_ VSS VSS VDD VDD _0243_[1] sky130_fd_sc_hd__inv_1
X_20555_ u_core.u_top.u_core.acc_upd[41] VSS VSS VDD VDD _02468_ sky130_fd_sc_hd__inv_1
X_20556_ u_core.u_top.u_core.d_acc[70] VSS VSS VDD VDD _0264_[0] sky130_fd_sc_hd__inv_1
X_20557_ _02418_ VSS VSS VDD VDD _0333_[1] sky130_fd_sc_hd__inv_1
X_20558_ u_core.u_top.u_core.lfsr[6] u_core.u_top.u_core.d_acc[229] VSS VSS VDD VDD _05840_ sky130_fd_sc_hd__xnor2_1
X_20559_ _03463_ VSS VSS VDD VDD _05841_ sky130_fd_sc_hd__inv_1
X_20560_ _05841_ _05832_ _03462_ VSS VSS VDD VDD _05842_ sky130_fd_sc_hd__o21bai_1
X_20561_ _02664_ _05842_ _02663_ VSS VSS VDD VDD _05843_ sky130_fd_sc_hd__a21oi_1
X_20562_ _05840_ _05843_ VSS VSS VDD VDD _0344_[9] sky130_fd_sc_hd__xnor2_1
X_20563_ _03257_ _05830_ VSS VSS VDD VDD _0344_[5] sky130_fd_sc_hd__xnor2_1
X_20564_ u_core.u_top.u_core.r_off[6] VSS VSS VDD VDD _02625_ sky130_fd_sc_hd__inv_2
X_20565_ u_core.u_top.u_core.lfsr[7] VSS VSS VDD VDD _02356_ sky130_fd_sc_hd__inv_1
X_20566_ u_core.u_top.u_core.d_acc[150] VSS VSS VDD VDD _0306_[0] sky130_fd_sc_hd__inv_1
X_20567_ _02825_ _06538_ VSS VSS VDD VDD _0232_[4] sky130_fd_sc_hd__xor2_1
X_20568_ _02775_ _05765_ VSS VSS VDD VDD _0311_[6] sky130_fd_sc_hd__xor2_1
X_20569_ u_core.u_top.u_core.lfsr[12] VSS VSS VDD VDD _02467_ sky130_fd_sc_hd__inv_1
X_20570_ u_core.u_top.u_core.lfsr[10] VSS VSS VDD VDD _02367_ sky130_fd_sc_hd__inv_1
X_20571_ u_core.u_top.u_core.lfsr[12] u_core.u_top.u_core.d_acc[129] VSS VSS VDD VDD _05844_ sky130_fd_sc_hd__xnor2_1
X_20572_ _03276_ VSS VSS VDD VDD _05845_ sky130_fd_sc_hd__inv_1
X_20573_ _05845_ _05707_ _03275_ VSS VSS VDD VDD _05846_ sky130_fd_sc_hd__o21bai_1
X_20574_ _03304_ _05846_ _03303_ VSS VSS VDD VDD _05847_ sky130_fd_sc_hd__a21oi_1
X_20575_ _05844_ _05847_ VSS VSS VDD VDD _0289_[9] sky130_fd_sc_hd__xnor2_1
X_20576_ u_core.u_top.u_core.d_acc[91] VSS VSS VDD VDD _02400_ sky130_fd_sc_hd__inv_1
X_20577_ u_core.u_top.u_core.d_acc[81] VSS VSS VDD VDD _02419_ sky130_fd_sc_hd__inv_1
X_20578_ u_core.u_top.u_core.d_acc[40] VSS VSS VDD VDD _0249_[0] sky130_fd_sc_hd__inv_1
X_20579_ _03183_ _05060_ VSS VSS VDD VDD _0243_[6] sky130_fd_sc_hd__xor2_1
X_20580_ _02473_ VSS VSS VDD VDD _05848_ sky130_fd_sc_hd__inv_1
X_20581_ _02569_ _05848_ _02568_ VSS VSS VDD VDD _05849_ sky130_fd_sc_hd__a21oi_1
X_20582_ _05657_ _05849_ _02854_ VSS VSS VDD VDD _05850_ sky130_fd_sc_hd__o21bai_1
X_20583_ _03376_ _05850_ _03375_ VSS VSS VDD VDD _05851_ sky130_fd_sc_hd__a21oi_1
X_20584_ _05656_ _05851_ _03191_ VSS VSS VDD VDD _05852_ sky130_fd_sc_hd__o21bai_1
X_20585_ _03474_ _05852_ _03473_ VSS VSS VDD VDD _05853_ sky130_fd_sc_hd__a21o_1
X_20586_ _03272_ _05853_ _03271_ VSS VSS VDD VDD _05854_ sky130_fd_sc_hd__a21oi_1
X_20587_ _03410_ _05854_ VSS VSS VDD VDD _0349_[8] sky130_fd_sc_hd__xnor2_1
X_20588_ _03376_ _05850_ VSS VSS VDD VDD _0349_[4] sky130_fd_sc_hd__xor2_1
X_20589_ u_core.u_top.u_core.d_acc[41] VSS VSS VDD VDD _02408_ sky130_fd_sc_hd__inv_1
X_20590_ u_core.u_top.u_core.d_acc[71] VSS VSS VDD VDD _02353_ sky130_fd_sc_hd__inv_1
X_20591_ u_core.u_top.u_core.lfsr[13] u_core.u_top.u_core.d_acc[139] VSS VSS VDD VDD _05855_ sky130_fd_sc_hd__xnor2_1
X_20592_ _02831_ VSS VSS VDD VDD _05856_ sky130_fd_sc_hd__inv_1
X_20593_ _05856_ _09527_ _02830_ VSS VSS VDD VDD _05857_ sky130_fd_sc_hd__o21bai_1
X_20594_ _03104_ _05857_ _03103_ VSS VSS VDD VDD _05858_ sky130_fd_sc_hd__a21oi_1
X_20595_ _05855_ _05858_ VSS VSS VDD VDD _0294_[9] sky130_fd_sc_hd__xnor2_1
X_20596_ u_core.u_top.u_core.lfsr[11] u_core.u_top.u_core.d_acc[119] VSS VSS VDD VDD _05859_ sky130_fd_sc_hd__xnor2_1
X_20597_ _02704_ VSS VSS VDD VDD _05860_ sky130_fd_sc_hd__inv_1
X_20598_ _05860_ _05720_ _02703_ VSS VSS VDD VDD _05861_ sky130_fd_sc_hd__o21bai_1
X_20599_ _02637_ _05861_ _02636_ VSS VSS VDD VDD _05862_ sky130_fd_sc_hd__a21oi_1
X_20600_ _05859_ _05862_ VSS VSS VDD VDD _0284_[9] sky130_fd_sc_hd__xnor2_1
X_20601_ u_core.u_top.u_core.d_acc[50] VSS VSS VDD VDD _0254_[0] sky130_fd_sc_hd__inv_1
X_20602_ u_core.u_top.u_core.d_acc[80] VSS VSS VDD VDD _0269_[0] sky130_fd_sc_hd__inv_1
X_20603_ _03468_ _05736_ VSS VSS VDD VDD _0294_[4] sky130_fd_sc_hd__xor2_1
X_20604_ u_core.u_top.u_core.d_acc[200] VSS VSS VDD VDD _0333_[0] sky130_fd_sc_hd__inv_1
X_20605_ u_core.u_top.u_core.d_acc[51] VSS VSS VDD VDD _02396_ sky130_fd_sc_hd__inv_1
X_20606_ u_core.u_top.u_spi.bitcnt[1] VSS VSS VDD VDD _03079_ sky130_fd_sc_hd__inv_1
X_20607_ _09485_ _09489_ _09497_ VSS VSS VDD VDD _03210_ sky130_fd_sc_hd__nand3_1
X_20608_ _02819_ _08096_ VSS VSS VDD VDD _0238_[5] sky130_fd_sc_hd__xnor2_1
X_20609_ _03474_ _05852_ VSS VSS VDD VDD _0349_[6] sky130_fd_sc_hd__xor2_1
X_20610_ _02569_ _02473_ VSS VSS VDD VDD _0349_[2] sky130_fd_sc_hd__xnor2_1
X_20611_ u_core.u_actl.st[8] u_core.u_actl.st[4] VSS VSS VDD VDD _1263_ sky130_fd_sc_hd__or2_2
X_20612_ u_core.u_actl.st[5] u_core.u_actl.st[10] _1263_ VSS VSS VDD VDD _05863_ sky130_fd_sc_hd__or3_1
X_20613_ u_core.u_actl.st[3] _09476_ VSS VSS VDD VDD _05864_ sky130_fd_sc_hd__nor2_1
X_20614_ u_core.arr_req u_core.u_actl.st[6] VSS VSS VDD VDD _05865_ sky130_fd_sc_hd__nor2_1
X_20615_ u_core.u_actl.st[0] _05864_ _05865_ _09532_ VSS VSS VDD VDD _05866_ sky130_fd_sc_hd__a31oi_1
X_20616_ _05863_ _05866_ VSS VSS VDD VDD _05867_ sky130_fd_sc_hd__nor2_1
X_20617_ u_core.u_actl.st[1] u_core.u_actl.st[7] VSS VSS VDD VDD _05868_ sky130_fd_sc_hd__nor2_1
X_20618_ u_core.u_actl.st[0] _05867_ VSS VSS VDD VDD _05869_ sky130_fd_sc_hd__nand2_1
X_20619_ _05867_ _05868_ _05869_ VSS VSS VDD VDD _03507_ sky130_fd_sc_hd__o21ai_0
X_20620_ u_core.u_actl.st[1] _05867_ u_core.u_actl.st[10] VSS VSS VDD VDD _03509_ sky130_fd_sc_hd__a21o_1
X_20621_ net998 VSS VSS VDD VDD _05870_ sky130_fd_sc_hd__inv_1
X_20622_ u_core.u_actl.st[9] _09531_ VSS VSS VDD VDD _05871_ sky130_fd_sc_hd__nand2_1
X_20623_ _05870_ _09531_ _05863_ _05871_ VSS VSS VDD VDD _03510_ sky130_fd_sc_hd__o31ai_1
X_20624_ u_core.u_actl.st[6] u_core.u_actl.st[3] _05867_ VSS VSS VDD VDD _03511_ sky130_fd_sc_hd__mux2_1
X_20625_ u_core.arr_op[1] u_core.arr_op[0] u_core.arr_op[2] VSS VSS VDD VDD _05872_ sky130_fd_sc_hd__o21ai_0
X_20626_ u_core.u_actl.st[0] u_core.arr_req VSS VSS VDD VDD _05873_ sky130_fd_sc_hd__nand2_1
X_20627_ net891 _05872_ _05873_ _05867_ VSS VSS VDD VDD _03512_ sky130_fd_sc_hd__a211oi_1
X_20629_ _05873_ VSS VSS VDD VDD _1359_ sky130_fd_sc_hd__inv_1
X_20630_ net891 _1359_ _05872_ VSS VSS VDD VDD _05874_ sky130_fd_sc_hd__and3_1
X_20631_ _05874_ u_core.u_actl.st[6] _05867_ VSS VSS VDD VDD _03514_ sky130_fd_sc_hd__mux2_1
X_20632_ u_core.u_actl.st[7] _05867_ u_core.u_actl.st[4] VSS VSS VDD VDD _03515_ sky130_fd_sc_hd__a21o_1
X_20633_ net998 _09531_ VSS VSS VDD VDD _03516_ sky130_fd_sc_hd__and2_1
X_20634_ u_core.u_actl.st[3] u_core.u_actl.st[9] _05867_ VSS VSS VDD VDD _03517_ sky130_fd_sc_hd__mux2_1
X_20636_ net968 u_core.u_top.bus_wdata[2] VSS VSS VDD VDD _05875_ sky130_fd_sc_hd__nand2b_1
X_20637_ _05875_ VSS VSS VDD VDD _0352_ sky130_fd_sc_hd__inv_1
X_20638_ u_core.arr_op[1] u_core.arr_op[0] u_core.arr_op[2] VSS VSS VDD VDD _0670_ sky130_fd_sc_hd__nor3b_2
X_20639_ u_core.u_top.u_core.d_acc[10] VSS VSS VDD VDD _0232_[0] sky130_fd_sc_hd__inv_1
X_20640_ u_core.u_top.u_core.d_acc[11] VSS VSS VDD VDD _02342_ sky130_fd_sc_hd__inv_1
X_20641_ u_core.u_top.u_core.r_x[143] net652 VSS VSS VDD VDD _05876_ sky130_fd_sc_hd__nand2_1
X_20642_ net646 _05435_ _05876_ VSS VSS VDD VDD _0359_[143] sky130_fd_sc_hd__o21ai_0
X_20643_ u_core.u_top.u_spi.sck_s[1] _06570_ VSS VSS VDD VDD _05877_ sky130_fd_sc_hd__nand2_1
X_20644_ u_core.u_top.u_spi.cs_s[1] u_core.u_top.u_spi.bitcnt[6] u_core.u_top.u_spi.bitcnt[3] _05877_ VSS VSS VDD VDD _05878_ sky130_fd_sc_hd__or4_1
X_20645_ u_core.u_top.u_spi.bitcnt[5] u_core.u_top.u_spi.bitcnt[4] _05878_ VSS VSS VDD VDD _1307_ sky130_fd_sc_hd__nor3_1
X_20646_ u_core.u_top.u_spi.bitcnt[2] _03083_ _1307_ VSS VSS VDD VDD _1304_ sky130_fd_sc_hd__and3_1
X_20647_ u_core.u_top.u_spi.bitcnt[5] u_core.u_top.u_spi.bitcnt[4] VSS VSS VDD VDD _05879_ sky130_fd_sc_hd__nand2_1
X_20648_ u_core.u_top.u_spi.bitcnt[2] _03083_ u_core.u_top.u_spi.cmd[7] VSS VSS VDD VDD _05880_ sky130_fd_sc_hd__nand3_1
X_20649_ _05879_ _05878_ _05880_ VSS VSS VDD VDD _1305_ sky130_fd_sc_hd__nor3_1
X_20650_ u_core.u_top.u_spi.bitcnt[6] _05877_ _0982_ VSS VSS VDD VDD _1306_ sky130_fd_sc_hd__o21ai_0
X_20651_ u_core.u_top.u_spi.cs_s[1] _06573_ _05877_ VSS VSS VDD VDD _1308_ sky130_fd_sc_hd__nor3_1
X_20652_ u_core.u_top.bus_re u_core.u_top.bus_we VSS VSS VDD VDD _05881_ sky130_fd_sc_hd__nor2_1
X_20653_ u_core.u_top.u_spi.cs_s[1] _05881_ VSS VSS VDD VDD _1309_ sky130_fd_sc_hd__nor2_1
X_20654_ _10249_ _05023_ VSS VSS VDD VDD _05882_ sky130_fd_sc_hd__nand2_1
X_20655_ net722 _10258_ VSS VSS VDD VDD _05883_ sky130_fd_sc_hd__and2_1
X_20656_ net792 _05883_ VSS VSS VDD VDD _05884_ sky130_fd_sc_hd__nor2_1
X_20657_ _10258_ _04725_ VSS VSS VDD VDD _05885_ sky130_fd_sc_hd__nor2_1
X_20658_ net1000 net774 _05884_ _05885_ VSS VSS VDD VDD _05886_ sky130_fd_sc_hd__o22ai_1
X_20659_ _2033_[1] net684 _11217_ VSS VSS VDD VDD _05887_ sky130_fd_sc_hd__or3_1
X_20660_ net971 _05875_ VSS VSS VDD VDD _05888_ sky130_fd_sc_hd__nor2_1
X_20661_ net972 _05888_ net704 VSS VSS VDD VDD _05889_ sky130_fd_sc_hd__o21ai_0
X_20662_ _10231_ _05889_ VSS VSS VDD VDD _05890_ sky130_fd_sc_hd__nand2_1
X_20663_ _05887_ net665 _05882_ VSS VSS VDD VDD _05891_ sky130_fd_sc_hd__a21oi_1
X_20664_ _05886_ _05891_ VSS VSS VDD VDD _05892_ sky130_fd_sc_hd__nor2_1
X_20665_ _10230_ _05882_ _05892_ VSS VSS VDD VDD _1310_ sky130_fd_sc_hd__o21a_1
X_20666_ net972 net971 net704 VSS VSS VDD VDD _05893_ sky130_fd_sc_hd__nand3_1
X_20667_ _10589_ _10189_ _05893_ VSS VSS VDD VDD _05894_ sky130_fd_sc_hd__a21oi_1
X_20668_ net685 _11218_ VSS VSS VDD VDD _05895_ sky130_fd_sc_hd__nand2_1
X_20669_ net989 _10573_ VSS VSS VDD VDD _05896_ sky130_fd_sc_hd__nor2_4
X_20670_ net665 _05895_ net753 VSS VSS VDD VDD _05897_ sky130_fd_sc_hd__a21oi_1
X_20671_ _04697_ _05894_ _05897_ VSS VSS VDD VDD _1311_ sky130_fd_sc_hd__nor3_1
X_20672_ _10258_ _04725_ net792 VSS VSS VDD VDD _05898_ sky130_fd_sc_hd__o21ai_0
X_20673_ net989 net774 _05883_ _05898_ VSS VSS VDD VDD _05899_ sky130_fd_sc_hd__nor4b_1
X_20674_ _10230_ net665 _05895_ _05899_ VSS VSS VDD VDD _1312_ sky130_fd_sc_hd__a31o_1
X_20675_ _02344_ VSS VSS VDD VDD _0232_[1] sky130_fd_sc_hd__inv_1
X_20676_ net895 net897 VSS VSS VDD VDD _05900_ sky130_fd_sc_hd__nand2_1
X_20677_ net896 _05900_ net886 VSS VSS VDD VDD _05901_ sky130_fd_sc_hd__a21oi_1
X_20678_ net898 _05901_ _10573_ VSS VSS VDD VDD _05902_ sky130_fd_sc_hd__o21ai_0
X_20679_ net1000 _05902_ net665 VSS VSS VDD VDD _05903_ sky130_fd_sc_hd__a21oi_1
X_20680_ _10565_ _10567_ _10569_ _10571_ VSS VSS VDD VDD _05904_ sky130_fd_sc_hd__nand4_1
X_20681_ _10549_ _10557_ _10559_ _10563_ VSS VSS VDD VDD _05905_ sky130_fd_sc_hd__nand4_1
X_20682_ _10551_ _10553_ _10555_ VSS VSS VDD VDD _05906_ sky130_fd_sc_hd__nand3_1
X_20683_ _05904_ _05905_ _05906_ VSS VSS VDD VDD _05907_ sky130_fd_sc_hd__nor3_1
X_20684_ _10541_ _10544_ VSS VSS VDD VDD _05908_ sky130_fd_sc_hd__nand2_1
X_20685_ _10533_ _10535_ _10537_ _10539_ VSS VSS VDD VDD _05909_ sky130_fd_sc_hd__nand4_1
X_20686_ _10527_ _10529_ _10531_ _10547_ VSS VSS VDD VDD _05910_ sky130_fd_sc_hd__nand4_1
X_20687_ u_core.u_top.u_core.pend_p[23] VSS VSS VDD VDD _05911_ sky130_fd_sc_hd__inv_1
X_20688_ u_core.u_top.u_core.pend_n[23] VSS VSS VDD VDD _05912_ sky130_fd_sc_hd__inv_1
X_20689_ u_core.arr_sa_p[23] _05911_ _05912_ u_core.arr_sa_n[23] u_core.u_top.u_core.m_fail[23] VSS VSS VDD VDD _05913_ sky130_fd_sc_hd__a221oi_1
X_20690_ net857 _10525_ _10561_ _05913_ VSS VSS VDD VDD _05914_ sky130_fd_sc_hd__nand4b_1
X_20691_ _05908_ _05909_ _05910_ _05914_ VSS VSS VDD VDD _05915_ sky130_fd_sc_hd__nor4_2
X_20692_ _05907_ _05915_ _05883_ VSS VSS VDD VDD _05916_ sky130_fd_sc_hd__a21oi_1
X_20693_ net721 _10253_ _05916_ VSS VSS VDD VDD _05917_ sky130_fd_sc_hd__o21ai_0
X_20694_ _05903_ _05917_ VSS VSS VDD VDD _1315_ sky130_fd_sc_hd__nor2_1
X_20695_ net989 _03728_ VSS VSS VDD VDD _05918_ sky130_fd_sc_hd__nor2_4
X_20696_ _05890_ _05918_ VSS VSS VDD VDD _1316_ sky130_fd_sc_hd__or2_2
X_20697_ u_core.u_top.bus_addr[0] _06589_ _10207_ VSS VSS VDD VDD _1317_ sky130_fd_sc_hd__nor3_1
X_20698_ _06635_ _10207_ VSS VSS VDD VDD _1318_ sky130_fd_sc_hd__nor2_1
X_20699_ _07252_ _10207_ VSS VSS VDD VDD _1320_ sky130_fd_sc_hd__nor2_1
X_20700_ net964 net965 VSS VSS VDD VDD _05919_ sky130_fd_sc_hd__nand2b_1
X_20701_ _07277_ _06589_ _10207_ VSS VSS VDD VDD _05920_ sky130_fd_sc_hd__or3_1
X_20702_ net958 _05919_ _05920_ VSS VSS VDD VDD _1322_ sky130_fd_sc_hd__a21oi_1
X_20703_ _05919_ _05920_ VSS VSS VDD VDD _1323_ sky130_fd_sc_hd__nor2_1
X_20704_ net684 _11218_ VSS VSS VDD VDD _1324_ sky130_fd_sc_hd__nor2_1
X_20705_ net989 _10573_ net684 VSS VSS VDD VDD _1325_ sky130_fd_sc_hd__o21ai_0
X_20706_ net972 net971 _05875_ VSS VSS VDD VDD _05921_ sky130_fd_sc_hd__nor3_1
X_20707_ net862 net857 net989 VSS VSS VDD VDD _05922_ sky130_fd_sc_hd__a21oi_1
X_20708_ net704 _05921_ _05922_ VSS VSS VDD VDD _1326_ sky130_fd_sc_hd__a21o_1
X_20711_ _03483_ net669 net753 VSS VSS VDD VDD _1327_ sky130_fd_sc_hd__o21a_1
X_20712_ _03484_ net669 net753 VSS VSS VDD VDD _1328_ sky130_fd_sc_hd__o21a_1
X_20713_ _03485_ net669 net753 VSS VSS VDD VDD _1329_ sky130_fd_sc_hd__o21a_1
X_20714_ _03486_ net669 net753 VSS VSS VDD VDD _1330_ sky130_fd_sc_hd__o21a_1
X_20715_ _03487_ net669 net753 VSS VSS VDD VDD _1331_ sky130_fd_sc_hd__o21a_1
X_20716_ _03488_ net669 net753 VSS VSS VDD VDD _1332_ sky130_fd_sc_hd__o21a_1
X_20717_ _03489_ net669 net753 VSS VSS VDD VDD _1333_ sky130_fd_sc_hd__o21a_1
X_20718_ _03490_ net669 net753 VSS VSS VDD VDD _1334_ sky130_fd_sc_hd__o21a_1
X_20719_ _03491_ net669 net753 VSS VSS VDD VDD _1335_ sky130_fd_sc_hd__o21a_1
X_20720_ _03492_ net669 net753 VSS VSS VDD VDD _1336_ sky130_fd_sc_hd__o21a_1
X_20723_ _03493_ net669 net753 VSS VSS VDD VDD _1337_ sky130_fd_sc_hd__o21a_1
X_20724_ _03494_ net669 net753 VSS VSS VDD VDD _1338_ sky130_fd_sc_hd__o21a_1
X_20725_ _03495_ net669 net753 VSS VSS VDD VDD _1339_ sky130_fd_sc_hd__o21a_1
X_20726_ _03496_ net669 net753 VSS VSS VDD VDD _1340_ sky130_fd_sc_hd__o21a_1
X_20727_ _03497_ net669 net753 VSS VSS VDD VDD _1341_ sky130_fd_sc_hd__o21a_1
X_20728_ _03498_ net669 net753 VSS VSS VDD VDD _1342_ sky130_fd_sc_hd__o21a_1
X_20729_ _03499_ net669 net753 VSS VSS VDD VDD _1343_ sky130_fd_sc_hd__o21a_1
X_20730_ _03500_ net669 net753 VSS VSS VDD VDD _1344_ sky130_fd_sc_hd__o21a_1
X_20731_ _03501_ net669 net753 VSS VSS VDD VDD _1345_ sky130_fd_sc_hd__o21a_1
X_20732_ _03502_ net669 net753 VSS VSS VDD VDD _1346_ sky130_fd_sc_hd__o21a_1
X_20733_ _03503_ net669 net753 VSS VSS VDD VDD _1347_ sky130_fd_sc_hd__o21a_1
X_20734_ _03504_ net669 net753 VSS VSS VDD VDD _1348_ sky130_fd_sc_hd__o21a_1
X_20735_ _03505_ net669 net753 VSS VSS VDD VDD _1349_ sky130_fd_sc_hd__o21a_1
X_20736_ _03506_ net669 net753 VSS VSS VDD VDD _1350_ sky130_fd_sc_hd__o21a_1
X_20737_ net895 net898 net897 net665 VSS VSS VDD VDD _05927_ sky130_fd_sc_hd__nor4_1
X_20738_ net895 net897 net989 _05927_ VSS VSS VDD VDD _05928_ sky130_fd_sc_hd__a31oi_1
X_20739_ net1000 _10249_ _05928_ net896 VSS VSS VDD VDD _05929_ sky130_fd_sc_hd__o22ai_1
X_20740_ net1000 net644 net787 VSS VSS VDD VDD _05930_ sky130_fd_sc_hd__a21oi_1
X_20741_ net897 net989 VSS VSS VDD VDD _05931_ sky130_fd_sc_hd__nand2_1
X_20742_ net898 _08079_ _05931_ VSS VSS VDD VDD _05932_ sky130_fd_sc_hd__nor3_1
X_20743_ _05929_ _05930_ _05932_ VSS VSS VDD VDD _1351_ sky130_fd_sc_hd__nor3_1
X_20744_ _10217_ net850 net1000 VSS VSS VDD VDD _05933_ sky130_fd_sc_hd__o21ai_0
X_20745_ _10202_ _05933_ VSS VSS VDD VDD _1352_ sky130_fd_sc_hd__nand2_1
X_20746_ net1000 _10239_ net895 VSS VSS VDD VDD _05934_ sky130_fd_sc_hd__a21oi_1
X_20747_ net898 _05934_ net896 VSS VSS VDD VDD _05935_ sky130_fd_sc_hd__o21ai_0
X_20748_ _05900_ _05935_ VSS VSS VDD VDD _05936_ sky130_fd_sc_hd__nand2_1
X_20749_ _05930_ _05932_ _05936_ VSS VSS VDD VDD _1354_ sky130_fd_sc_hd__nor3_1
X_20750_ _09476_ _09531_ VSS VSS VDD VDD _1355_ sky130_fd_sc_hd__and2_1
X_20751_ u_core.u_actl.st[8] u_core.u_actl.st[3] u_core.u_actl.st[10] _05874_ VSS VSS VDD VDD _1356_ sky130_fd_sc_hd__or4_1
X_20752_ u_core.arr_op[1] u_core.arr_op[0] u_core.arr_op[2] VSS VSS VDD VDD _05937_ sky130_fd_sc_hd__a21oi_1
X_20753_ _05937_ _05874_ VSS VSS VDD VDD _1357_ sky130_fd_sc_hd__nor2b_1
X_20754_ _05864_ _03516_ VSS VSS VDD VDD _1360_ sky130_fd_sc_hd__nor2_1
X_20755_ net998 _09479_ _09531_ VSS VSS VDD VDD _1361_ sky130_fd_sc_hd__and3_1
X_20757_ u_core.u_top.u_core.acc[2] u_core.u_top.u_core.acc[3] u_core.u_top.u_core.acc[4] VSS VSS VDD VDD _05939_ sky130_fd_sc_hd__o21ai_0
X_20758_ _09437_ _05939_ VSS VSS VDD VDD _05940_ sky130_fd_sc_hd__nand2_1
X_20759_ u_core.u_top.u_core.acc[7] _05940_ u_core.u_top.u_core.acc[8] VSS VSS VDD VDD _05941_ sky130_fd_sc_hd__a21oi_1
X_20760_ u_core.u_top.u_core.acc[9] _05941_ _04687_ VSS VSS VDD VDD _05942_ sky130_fd_sc_hd__a21oi_1
X_20761_ net989 net885 VSS VSS VDD VDD _05943_ sky130_fd_sc_hd__nor2_1
X_20762_ net685 _05943_ net883 VSS VSS VDD VDD _05944_ sky130_fd_sc_hd__o21ai_4
X_20764_ net773 _05942_ net664 VSS VSS VDD VDD _1362_ sky130_fd_sc_hd__a21oi_1
X_20765_ _04637_ VSS VSS VDD VDD _05946_ sky130_fd_sc_hd__inv_1
X_20766_ _10236_ net989 _08079_ VSS VSS VDD VDD _05947_ sky130_fd_sc_hd__nor3_4
X_20768_ _09365_ u_core.u_top.u_core.acc[14] VSS VSS VDD VDD _05949_ sky130_fd_sc_hd__nor2b_1
X_20769_ u_core.u_top.u_core.acc[15] u_core.u_top.u_core.acc[16] _05949_ u_core.u_top.u_core.acc[17] VSS VSS VDD VDD _05950_ sky130_fd_sc_hd__o31ai_1
X_20770_ u_core.u_top.u_core.acc[18] u_core.u_top.u_core.acc[19] _05950_ VSS VSS VDD VDD _05951_ sky130_fd_sc_hd__nand3b_1
X_20771_ _05946_ net849 _05951_ net664 VSS VSS VDD VDD _1363_ sky130_fd_sc_hd__a31oi_1
X_20772_ _09303_ u_core.u_top.u_core.acc[24] VSS VSS VDD VDD _05952_ sky130_fd_sc_hd__nor2b_1
X_20773_ u_core.u_top.u_core.acc[26] u_core.u_top.u_core.acc[25] _05952_ u_core.u_top.u_core.acc[27] VSS VSS VDD VDD _05953_ sky130_fd_sc_hd__o31ai_1
X_20774_ u_core.u_top.u_core.acc[29] _09301_ _05953_ VSS VSS VDD VDD _05954_ sky130_fd_sc_hd__nand3_1
X_20776_ _04584_ net849 _05954_ net664 VSS VSS VDD VDD _1364_ sky130_fd_sc_hd__a31oi_1
X_20777_ _09244_ _09249_ _09252_ VSS VSS VDD VDD _05956_ sky130_fd_sc_hd__o21ai_0
X_20778_ u_core.u_top.u_core.acc[37] _05956_ u_core.u_top.u_core.acc[38] VSS VSS VDD VDD _05957_ sky130_fd_sc_hd__a21oi_1
X_20779_ u_core.u_top.u_core.acc[39] _05957_ _04542_ VSS VSS VDD VDD _05958_ sky130_fd_sc_hd__a21oi_1
X_20780_ net773 _05958_ net664 VSS VSS VDD VDD _1365_ sky130_fd_sc_hd__a21oi_1
X_20781_ _04478_ VSS VSS VDD VDD _05959_ sky130_fd_sc_hd__inv_1
X_20782_ _09180_ _09185_ _09187_ VSS VSS VDD VDD _05960_ sky130_fd_sc_hd__o21ai_0
X_20783_ u_core.u_top.u_core.acc[47] _05960_ VSS VSS VDD VDD _05961_ sky130_fd_sc_hd__nand2_1
X_20784_ u_core.u_top.u_core.acc[48] u_core.u_top.u_core.acc[49] _05961_ VSS VSS VDD VDD _05962_ sky130_fd_sc_hd__nand3b_1
X_20785_ _05959_ net849 _05962_ net664 VSS VSS VDD VDD _1366_ sky130_fd_sc_hd__a31oi_1
X_20786_ _09123_ u_core.u_top.u_core.acc[54] VSS VSS VDD VDD _05963_ sky130_fd_sc_hd__nor2b_1
X_20787_ u_core.u_top.u_core.acc[56] u_core.u_top.u_core.acc[55] _05963_ u_core.u_top.u_core.acc[57] VSS VSS VDD VDD _05964_ sky130_fd_sc_hd__o31ai_1
X_20788_ u_core.u_top.u_core.acc[58] u_core.u_top.u_core.acc[59] _05964_ VSS VSS VDD VDD _05965_ sky130_fd_sc_hd__nand3b_1
X_20789_ _04421_ net849 _05965_ net664 VSS VSS VDD VDD _1367_ sky130_fd_sc_hd__a31oi_1
X_20790_ _04365_ VSS VSS VDD VDD _05966_ sky130_fd_sc_hd__inv_1
X_20791_ u_core.u_top.u_core.acc[62] net961 net960 VSS VSS VDD VDD _05967_ sky130_fd_sc_hd__o21ai_0
X_20792_ _09090_ _05967_ VSS VSS VDD VDD _05968_ sky130_fd_sc_hd__nand2_1
X_20793_ net959 _05968_ VSS VSS VDD VDD _05969_ sky130_fd_sc_hd__nand2_1
X_20794_ u_core.u_top.u_core.acc[68] u_core.u_top.u_core.acc[69] _05969_ VSS VSS VDD VDD _05970_ sky130_fd_sc_hd__nand3b_1
X_20795_ _05966_ net849 _05970_ net664 VSS VSS VDD VDD _1368_ sky130_fd_sc_hd__a31oi_1
X_20796_ _09016_ _09018_ VSS VSS VDD VDD _05971_ sky130_fd_sc_hd__nor2_1
X_20797_ u_core.u_top.u_core.acc[75] u_core.u_top.u_core.acc[76] _05971_ u_core.u_top.u_core.acc[77] VSS VSS VDD VDD _05972_ sky130_fd_sc_hd__o31ai_1
X_20798_ _09011_ u_core.u_top.u_core.acc[79] _05972_ _04310_ VSS VSS VDD VDD _05973_ sky130_fd_sc_hd__a31oi_1
X_20799_ net773 _05973_ net664 VSS VSS VDD VDD _1369_ sky130_fd_sc_hd__a21oi_1
X_20800_ _04256_ VSS VSS VDD VDD _05974_ sky130_fd_sc_hd__inv_1
X_20801_ u_core.u_top.u_core.acc[82] u_core.u_top.u_core.acc[83] u_core.u_top.u_core.acc[84] VSS VSS VDD VDD _05975_ sky130_fd_sc_hd__o21ai_0
X_20802_ _08980_ _05975_ VSS VSS VDD VDD _05976_ sky130_fd_sc_hd__nand2_1
X_20803_ u_core.u_top.u_core.acc[87] _05976_ VSS VSS VDD VDD _05977_ sky130_fd_sc_hd__nand2_1
X_20804_ u_core.u_top.u_core.acc[88] u_core.u_top.u_core.acc[89] _05977_ VSS VSS VDD VDD _05978_ sky130_fd_sc_hd__nand3b_1
X_20805_ _05974_ _05947_ _05978_ net664 VSS VSS VDD VDD _1370_ sky130_fd_sc_hd__a31oi_1
X_20806_ _08905_ _08935_ VSS VSS VDD VDD _05979_ sky130_fd_sc_hd__nor2_1
X_20807_ u_core.u_top.u_core.acc[96] u_core.u_top.u_core.acc[95] _05979_ u_core.u_top.u_core.acc[97] VSS VSS VDD VDD _05980_ sky130_fd_sc_hd__o31ai_1
X_20808_ u_core.u_top.u_core.acc[99] _08897_ _05980_ _04188_ VSS VSS VDD VDD _05981_ sky130_fd_sc_hd__a31oi_1
X_20809_ net773 _05981_ net664 VSS VSS VDD VDD _1371_ sky130_fd_sc_hd__a21oi_1
X_20810_ _08847_ _08851_ _08865_ VSS VSS VDD VDD _05982_ sky130_fd_sc_hd__o21ai_0
X_20811_ u_core.u_top.u_core.acc[107] _05982_ VSS VSS VDD VDD _05983_ sky130_fd_sc_hd__nand2_1
X_20812_ u_core.u_top.u_core.acc[108] u_core.u_top.u_core.acc[109] _05983_ VSS VSS VDD VDD _05984_ sky130_fd_sc_hd__nand3b_1
X_20813_ _04151_ net773 _05984_ net664 VSS VSS VDD VDD _1372_ sky130_fd_sc_hd__a31oi_1
X_20814_ _08796_ u_core.u_top.u_core.acc[114] VSS VSS VDD VDD _05985_ sky130_fd_sc_hd__nor2b_1
X_20815_ u_core.u_top.u_core.acc[116] u_core.u_top.u_core.acc[115] _05985_ u_core.u_top.u_core.acc[117] VSS VSS VDD VDD _05986_ sky130_fd_sc_hd__o31ai_1
X_20816_ u_core.u_top.u_core.acc[118] u_core.u_top.u_core.acc[119] _05986_ VSS VSS VDD VDD _05987_ sky130_fd_sc_hd__nand3b_1
X_20817_ _04093_ net773 _05987_ net664 VSS VSS VDD VDD _1373_ sky130_fd_sc_hd__a31oi_1
X_20818_ _04038_ VSS VSS VDD VDD _05988_ sky130_fd_sc_hd__inv_1
X_20819_ u_core.u_top.u_core.acc[122] u_core.u_top.u_core.acc[123] u_core.u_top.u_core.acc[124] VSS VSS VDD VDD _05989_ sky130_fd_sc_hd__o21ai_0
X_20820_ _08744_ _05989_ VSS VSS VDD VDD _05990_ sky130_fd_sc_hd__nand2_1
X_20821_ u_core.u_top.u_core.acc[127] _05990_ VSS VSS VDD VDD _05991_ sky130_fd_sc_hd__nand2_1
X_20822_ _08739_ u_core.u_top.u_core.acc[129] _05991_ VSS VSS VDD VDD _05992_ sky130_fd_sc_hd__nand3_1
X_20823_ _05988_ net849 _05992_ net664 VSS VSS VDD VDD _1374_ sky130_fd_sc_hd__a31oi_1
X_20824_ _08684_ u_core.u_top.u_core.acc[134] VSS VSS VDD VDD _05993_ sky130_fd_sc_hd__nor2b_1
X_20825_ u_core.u_top.u_core.acc[136] u_core.u_top.u_core.acc[135] _05993_ u_core.u_top.u_core.acc[137] VSS VSS VDD VDD _05994_ sky130_fd_sc_hd__o31ai_1
X_20826_ u_core.u_top.u_core.acc[138] u_core.u_top.u_core.acc[139] _05994_ VSS VSS VDD VDD _05995_ sky130_fd_sc_hd__nand3b_1
X_20827_ _03974_ net773 _05995_ net664 VSS VSS VDD VDD _1375_ sky130_fd_sc_hd__a31oi_1
X_20828_ u_core.u_top.u_core.acc[144] _08638_ u_core.u_top.u_core.acc[146] u_core.u_top.u_core.acc[145] VSS VSS VDD VDD _05996_ sky130_fd_sc_hd__a211o_1
X_20829_ u_core.u_top.u_core.acc[147] _05996_ VSS VSS VDD VDD _05997_ sky130_fd_sc_hd__nand2_1
X_20830_ _08626_ u_core.u_top.u_core.acc[149] _05997_ _03913_ VSS VSS VDD VDD _05998_ sky130_fd_sc_hd__a31oi_1
X_20831_ net773 _05998_ net664 VSS VSS VDD VDD _1376_ sky130_fd_sc_hd__a21oi_1
X_20832_ _03855_ VSS VSS VDD VDD _05999_ sky130_fd_sc_hd__inv_1
X_20833_ _08566_ u_core.u_top.u_core.acc[154] VSS VSS VDD VDD _06000_ sky130_fd_sc_hd__nor2b_1
X_20834_ u_core.u_top.u_core.acc[155] u_core.u_top.u_core.acc[156] _06000_ u_core.u_top.u_core.acc[157] VSS VSS VDD VDD _06001_ sky130_fd_sc_hd__o31ai_1
X_20835_ u_core.u_top.u_core.acc[158] u_core.u_top.u_core.acc[159] _06001_ VSS VSS VDD VDD _06002_ sky130_fd_sc_hd__nand3b_1
X_20836_ _05999_ net849 _06002_ net664 VSS VSS VDD VDD _1377_ sky130_fd_sc_hd__a31oi_1
X_20837_ _03791_ VSS VSS VDD VDD _06003_ sky130_fd_sc_hd__inv_1
X_20838_ _08521_ _08510_ _08523_ VSS VSS VDD VDD _06004_ sky130_fd_sc_hd__o21ai_0
X_20839_ u_core.u_top.u_core.acc[167] _06004_ VSS VSS VDD VDD _06005_ sky130_fd_sc_hd__nand2_1
X_20840_ u_core.u_top.u_core.acc[168] u_core.u_top.u_core.acc[169] _06005_ VSS VSS VDD VDD _06006_ sky130_fd_sc_hd__nand3b_1
X_20841_ _06003_ net849 _06006_ net664 VSS VSS VDD VDD _1378_ sky130_fd_sc_hd__a31oi_1
X_20842_ _08446_ u_core.u_top.u_core.acc[174] VSS VSS VDD VDD _06007_ sky130_fd_sc_hd__nor2b_1
X_20843_ net963 u_core.u_top.u_core.acc[176] _06007_ u_core.u_top.u_core.acc[177] VSS VSS VDD VDD _06008_ sky130_fd_sc_hd__o31ai_1
X_20844_ net962 u_core.u_top.u_core.acc[179] _06008_ VSS VSS VDD VDD _06009_ sky130_fd_sc_hd__nand3b_1
X_20845_ _03732_ net849 _06009_ net664 VSS VSS VDD VDD _1379_ sky130_fd_sc_hd__a31oi_1
X_20846_ _08394_ u_core.u_top.u_core.acc[184] VSS VSS VDD VDD _06010_ sky130_fd_sc_hd__nor2b_1
X_20847_ u_core.u_top.u_core.acc[186] u_core.u_top.u_core.acc[185] _06010_ u_core.u_top.u_core.acc[187] VSS VSS VDD VDD _06011_ sky130_fd_sc_hd__o31ai_1
X_20848_ _08386_ u_core.u_top.u_core.acc[189] _06011_ _03680_ VSS VSS VDD VDD _06012_ sky130_fd_sc_hd__a31oi_1
X_20849_ net773 _06012_ net664 VSS VSS VDD VDD _1380_ sky130_fd_sc_hd__a21oi_1
X_20850_ _08339_ u_core.u_top.u_core.acc[194] VSS VSS VDD VDD _06013_ sky130_fd_sc_hd__nor2b_1
X_20851_ u_core.u_top.u_core.acc[196] u_core.u_top.u_core.acc[195] _06013_ u_core.u_top.u_core.acc[197] VSS VSS VDD VDD _06014_ sky130_fd_sc_hd__o31ai_1
X_20852_ _08331_ u_core.u_top.u_core.acc[199] _06014_ _03630_ VSS VSS VDD VDD _06015_ sky130_fd_sc_hd__a31oi_1
X_20853_ net773 _06015_ net664 VSS VSS VDD VDD _1381_ sky130_fd_sc_hd__a21oi_1
X_20854_ u_core.u_top.u_core.acc[202] u_core.u_top.u_core.acc[203] u_core.u_top.u_core.acc[204] VSS VSS VDD VDD _06016_ sky130_fd_sc_hd__o21ai_0
X_20855_ _08302_ _06016_ VSS VSS VDD VDD _06017_ sky130_fd_sc_hd__nand2_1
X_20856_ u_core.u_top.u_core.acc[207] _06017_ u_core.u_top.u_core.acc[208] VSS VSS VDD VDD _06018_ sky130_fd_sc_hd__a21oi_1
X_20857_ u_core.u_top.u_core.acc[209] _06018_ _03578_ VSS VSS VDD VDD _06019_ sky130_fd_sc_hd__a21oi_1
X_20858_ net773 _06019_ net664 VSS VSS VDD VDD _1382_ sky130_fd_sc_hd__a21oi_1
X_20859_ _08248_ u_core.u_top.u_core.acc[214] VSS VSS VDD VDD _06020_ sky130_fd_sc_hd__nor2b_1
X_20860_ u_core.u_top.u_core.acc[216] u_core.u_top.u_core.acc[215] _06020_ u_core.u_top.u_core.acc[217] VSS VSS VDD VDD _06021_ sky130_fd_sc_hd__o31ai_1
X_20861_ _08240_ u_core.u_top.u_core.acc[219] _06021_ _03527_ VSS VSS VDD VDD _06022_ sky130_fd_sc_hd__a31oi_1
X_20862_ net773 _06022_ net664 VSS VSS VDD VDD _1383_ sky130_fd_sc_hd__a21oi_1
X_20863_ _11296_ VSS VSS VDD VDD _06023_ sky130_fd_sc_hd__inv_1
X_20864_ _08181_ _08187_ _08189_ VSS VSS VDD VDD _06024_ sky130_fd_sc_hd__o21ai_0
X_20865_ u_core.u_top.u_core.acc[227] _06024_ _11286_ u_core.u_top.u_core.acc[228] VSS VSS VDD VDD _06025_ sky130_fd_sc_hd__a211o_1
X_20866_ _06023_ net849 _06025_ net664 VSS VSS VDD VDD _1384_ sky130_fd_sc_hd__a31oi_1
X_20867_ _11233_ VSS VSS VDD VDD _06026_ sky130_fd_sc_hd__inv_1
X_20868_ u_core.u_top.u_core.acc[232] u_core.u_top.u_core.acc[233] u_core.u_top.u_core.acc[234] VSS VSS VDD VDD _06027_ sky130_fd_sc_hd__o21ai_0
X_20869_ _08123_ _06027_ VSS VSS VDD VDD _06028_ sky130_fd_sc_hd__nand2_1
X_20870_ u_core.u_top.u_core.acc[237] _06028_ VSS VSS VDD VDD _06029_ sky130_fd_sc_hd__nand2_1
X_20871_ u_core.u_top.u_core.acc[238] u_core.u_top.u_core.acc[239] _06029_ VSS VSS VDD VDD _06030_ sky130_fd_sc_hd__nand3b_1
X_20872_ _06026_ net849 _06030_ net664 VSS VSS VDD VDD _1385_ sky130_fd_sc_hd__a31oi_1
X_20873_ u_core.arr_mask_n[21] u_core.arr_mask_n[18] u_core.arr_mask_n[16] u_core.arr_mask_n[13] VSS VSS VDD VDD _06031_ sky130_fd_sc_hd__nor4_1
X_20874_ u_core.arr_mask_n[17] u_core.arr_mask_n[14] u_core.arr_mask_n[15] u_core.arr_mask_n[12] VSS VSS VDD VDD _06032_ sky130_fd_sc_hd__nor4_1
X_20875_ u_core.arr_mask_n[5] u_core.arr_mask_n[2] u_core.arr_mask_n[3] u_core.arr_mask_n[0] VSS VSS VDD VDD _06033_ sky130_fd_sc_hd__nor4_1
X_20876_ u_core.arr_mask_n[22] u_core.arr_mask_n[23] u_core.arr_mask_n[20] u_core.arr_mask_n[19] VSS VSS VDD VDD _06034_ sky130_fd_sc_hd__nor4_1
X_20877_ _06031_ _06032_ net874 _06034_ VSS VSS VDD VDD _06035_ sky130_fd_sc_hd__nand4_1
X_20878_ u_core.arr_mask_p[5] u_core.arr_mask_p[2] u_core.arr_mask_p[3] u_core.arr_mask_p[0] VSS VSS VDD VDD _06036_ sky130_fd_sc_hd__nor4_1
X_20879_ u_core.arr_mask_p[22] u_core.arr_mask_p[23] u_core.arr_mask_p[18] u_core.arr_mask_p[1] VSS VSS VDD VDD _06037_ sky130_fd_sc_hd__nor4_1
X_20880_ u_core.arr_mask_p[10] u_core.arr_mask_p[11] u_core.arr_mask_p[8] u_core.arr_mask_p[7] VSS VSS VDD VDD _06038_ sky130_fd_sc_hd__nor4_1
X_20881_ u_core.arr_mask_p[13] u_core.arr_mask_p[9] u_core.arr_mask_p[6] u_core.arr_mask_p[4] VSS VSS VDD VDD _06039_ sky130_fd_sc_hd__nor4_1
X_20882_ _06036_ _06037_ _06038_ _06039_ VSS VSS VDD VDD _06040_ sky130_fd_sc_hd__nand4_1
X_20883_ u_core.arr_mask_n[11] u_core.arr_mask_n[8] u_core.arr_mask_n[7] u_core.arr_mask_n[1] VSS VSS VDD VDD _06041_ sky130_fd_sc_hd__nor4_1
X_20884_ u_core.arr_mask_n[10] u_core.arr_mask_n[9] u_core.arr_mask_n[6] u_core.arr_mask_n[4] VSS VSS VDD VDD _06042_ sky130_fd_sc_hd__nor4_1
X_20885_ u_core.arr_mask_p[20] u_core.arr_mask_p[21] u_core.arr_mask_p[19] u_core.arr_mask_p[12] VSS VSS VDD VDD _06043_ sky130_fd_sc_hd__nor4_1
X_20886_ u_core.arr_mask_p[16] u_core.arr_mask_p[17] u_core.arr_mask_p[14] u_core.arr_mask_p[15] VSS VSS VDD VDD _06044_ sky130_fd_sc_hd__nor4_1
X_20887_ _06041_ _06042_ _06043_ _06044_ VSS VSS VDD VDD _06045_ sky130_fd_sc_hd__nand4_1
X_20888_ _06035_ _06040_ _06045_ VSS VSS VDD VDD _0390_ sky130_fd_sc_hd__or3_1
X_20889_ u_core.u_top.u_spi.sck_s[1] _06570_ _0982_ VSS VSS VDD VDD _1124_ sky130_fd_sc_hd__o21ai_0
X_20890_ u_core.u_actl.st[5] u_core.u_actl.st[6] VSS VSS VDD VDD _1267_ sky130_fd_sc_hd__or2_2
X_20891_ u_core.u_top.u_core.lfsr_m72[4] net992 VSS VSS VDD VDD _06046_ sky130_fd_sc_hd__nor2_1
X_20892_ _03026_ _06046_ _05700_ _05691_ VSS VSS VDD VDD _06047_ sky130_fd_sc_hd__a211oi_1
X_20893_ _0725_[3] _05691_ _06047_ VSS VSS VDD VDD _06048_ sky130_fd_sc_hd__a21oi_1
X_20894_ u_core.u_top.u_core.lfsr_m72[5] _05689_ VSS VSS VDD VDD _06049_ sky130_fd_sc_hd__xnor2_1
X_20895_ _06048_ _06049_ VSS VSS VDD VDD u_core.u_top.u_core.m72_next[6] sky130_fd_sc_hd__xnor2_1
X_20896_ _02452_ VSS VSS VDD VDD _0344_[1] sky130_fd_sc_hd__inv_1
X_20897_ _03030_ _05746_ VSS VSS VDD VDD _0300_[5] sky130_fd_sc_hd__xnor2_1
X_20898_ u_core.u_top.u_core.d_acc[111] VSS VSS VDD VDD _02368_ sky130_fd_sc_hd__inv_1
X_20899_ _03223_ _05755_ _03390_ VSS VSS VDD VDD _06050_ sky130_fd_sc_hd__o21ai_0
X_20900_ _03389_ _06050_ VSS VSS VDD VDD _06051_ sky130_fd_sc_hd__nand2b_1
X_20901_ _02704_ _06051_ _02703_ VSS VSS VDD VDD _06052_ sky130_fd_sc_hd__a21oi_1
X_20902_ _02637_ _06052_ VSS VSS VDD VDD _0284_[8] sky130_fd_sc_hd__xnor2_1
X_20903_ _10195_ _05881_ VSS VSS VDD VDD _2241_ sky130_fd_sc_hd__nor2_1
X_20904_ _02612_ _05748_ VSS VSS VDD VDD _0300_[7] sky130_fd_sc_hd__xnor2_1
X_20905_ _02355_ VSS VSS VDD VDD _0264_[1] sky130_fd_sc_hd__inv_1
X_20906_ u_core.u_top.u_core.d_acc[239] u_core.u_top.u_core.lfsr[7] VSS VSS VDD VDD _06053_ sky130_fd_sc_hd__xnor2_1
X_20907_ _03272_ VSS VSS VDD VDD _06054_ sky130_fd_sc_hd__inv_1
X_20908_ _06054_ _05663_ _03271_ VSS VSS VDD VDD _06055_ sky130_fd_sc_hd__o21bai_1
X_20909_ _03410_ _06055_ _03409_ VSS VSS VDD VDD _06056_ sky130_fd_sc_hd__a21oi_1
X_20910_ _06053_ _06056_ VSS VSS VDD VDD _0349_[9] sky130_fd_sc_hd__xnor2_1
X_20911_ u_core.u_top.u_core.d_acc[101] VSS VSS VDD VDD _02364_ sky130_fd_sc_hd__inv_1
X_20912_ _02742_ _05070_ VSS VSS VDD VDD _0333_[6] sky130_fd_sc_hd__xor2_1
X_20913_ _02781_ _05626_ VSS VSS VDD VDD _0316_[7] sky130_fd_sc_hd__xnor2_1
X_20914_ u_core.u_top.u_core.r_ie u_core.u_top.u_core.s_done VSS VSS VDD VDD _06057_ sky130_fd_sc_hd__nand2_1
X_20915_ _06057_ VSS VSS VDD VDD net146 sky130_fd_sc_hd__inv_1
X_20916_ net790 _05023_ VSS VSS VDD VDD _06058_ sky130_fd_sc_hd__nand2_1
X_20917_ net989 u_core.arr_op[2] _06058_ _04725_ VSS VSS VDD VDD _06059_ sky130_fd_sc_hd__a31oi_1
X_20918_ _10211_ _06059_ VSS VSS VDD VDD _1017_[2] sky130_fd_sc_hd__nand2_1
X_20919_ u_core.u_top.u_core.lfsr_m72[6] _11184_ _11215_ VSS VSS VDD VDD _06060_ sky130_fd_sc_hd__a21oi_1
X_20920_ net981 _10111_ _04914_ VSS VSS VDD VDD _06061_ sky130_fd_sc_hd__mux2i_1
X_20921_ _11118_ VSS VSS VDD VDD _06062_ sky130_fd_sc_hd__inv_1
X_20922_ _11110_ _06062_ _11113_ VSS VSS VDD VDD _06063_ sky130_fd_sc_hd__o21ai_0
X_20923_ net776 _06063_ VSS VSS VDD VDD _06064_ sky130_fd_sc_hd__nand2_1
X_20924_ net684 _06060_ _06061_ _04909_ _06064_ VSS VSS VDD VDD _1019_[6] sky130_fd_sc_hd__o221ai_1
X_20925_ u_core.u_top.u_core.r_pdata[47] u_core.u_top.u_core.r_pdata[46] VSS VSS VDD VDD _06065_ sky130_fd_sc_hd__nor2b_1
X_20926_ net702 _06065_ VSS VSS VDD VDD _06066_ sky130_fd_sc_hd__nand2_1
X_20927_ _09910_ net702 _06066_ VSS VSS VDD VDD _06067_ sky130_fd_sc_hd__o21ai_0
X_20928_ u_core.arr_sa_p[23] _05911_ _04722_ VSS VSS VDD VDD _06068_ sky130_fd_sc_hd__nor3_1
X_20929_ _10236_ _06067_ _06068_ net774 VSS VSS VDD VDD _06069_ sky130_fd_sc_hd__a211oi_1
X_20930_ net686 _06065_ _06069_ VSS VSS VDD VDD _1022_[23] sky130_fd_sc_hd__a21oi_1
X_20931_ u_core.u_top.u_core.r_pdata[46] u_core.u_top.u_core.r_pdata[47] VSS VSS VDD VDD _06070_ sky130_fd_sc_hd__nand2_1
X_20932_ net702 _06070_ VSS VSS VDD VDD _06071_ sky130_fd_sc_hd__nand2_1
X_20933_ _09909_ _09957_ net897 VSS VSS VDD VDD _06072_ sky130_fd_sc_hd__a21oi_1
X_20934_ u_core.arr_sa_n[23] _05912_ _04722_ VSS VSS VDD VDD _06073_ sky130_fd_sc_hd__nor3_1
X_20935_ _06071_ _06072_ _06073_ net774 VSS VSS VDD VDD _06074_ sky130_fd_sc_hd__a211oi_1
X_20936_ u_core.u_top.u_core.r_pdata[46] u_core.u_top.u_core.r_pdata[47] net686 _06074_ VSS VSS VDD VDD _1025_[23] sky130_fd_sc_hd__a31oi_1
X_20937_ net990 _06587_ u_core.u_top.u_core.s_done VSS VSS VDD VDD _06075_ sky130_fd_sc_hd__o21ai_0
X_20938_ _10214_ _11258_ _05890_ _06075_ VSS VSS VDD VDD _1029_ sky130_fd_sc_hd__o22ai_1
X_20939_ _0374_[18] _0374_[19] _0374_[16] _0374_[17] VSS VSS VDD VDD _06076_ sky130_fd_sc_hd__or4_1
X_20940_ _0374_[23] _0374_[20] _0374_[21] _0374_[12] VSS VSS VDD VDD _06077_ sky130_fd_sc_hd__nor4_1
X_20941_ net899 _0374_[22] _0374_[7] _0374_[1] VSS VSS VDD VDD _06078_ sky130_fd_sc_hd__nor4_1
X_20942_ _06077_ net848 VSS VSS VDD VDD _06079_ sky130_fd_sc_hd__nand2_1
X_20943_ _0374_[14] _0374_[15] _06076_ _06079_ VSS VSS VDD VDD _06080_ sky130_fd_sc_hd__nor4_1
X_20944_ _0374_[5] _0374_[2] _0374_[3] _0374_[0] VSS VSS VDD VDD _06081_ sky130_fd_sc_hd__nor4_1
X_20945_ _0374_[13] _0374_[9] _0374_[6] _0374_[4] VSS VSS VDD VDD _06082_ sky130_fd_sc_hd__nor4_1
X_20946_ _0374_[10] _0374_[11] _0374_[8] VSS VSS VDD VDD _06083_ sky130_fd_sc_hd__nor3_1
X_20947_ net751 _06081_ _06082_ _06083_ VSS VSS VDD VDD _06084_ sky130_fd_sc_hd__nand4_1
X_20948_ net899 net895 net792 _05900_ net896 VSS VSS VDD VDD _06085_ sky130_fd_sc_hd__o311a_1
X_20949_ _10213_ net895 _06084_ _06085_ VSS VSS VDD VDD _06086_ sky130_fd_sc_hd__a31oi_1
X_20950_ _11259_ _06084_ VSS VSS VDD VDD _06087_ sky130_fd_sc_hd__nand2_1
X_20951_ _10230_ _05902_ _06086_ net898 _06087_ VSS VSS VDD VDD _1036_ sky130_fd_sc_hd__o221ai_1
X_20952_ _05973_ _06012_ _06015_ VSS VSS VDD VDD _06088_ sky130_fd_sc_hd__and3_1
X_20953_ _05965_ _05970_ _05978_ _05992_ VSS VSS VDD VDD _06089_ sky130_fd_sc_hd__nand4_1
X_20954_ _06006_ _06009_ _06025_ _06030_ VSS VSS VDD VDD _06090_ sky130_fd_sc_hd__nand4_1
X_20955_ _06089_ _06090_ VSS VSS VDD VDD _06091_ sky130_fd_sc_hd__nor2_1
X_20956_ _05951_ _05954_ _05962_ _06002_ VSS VSS VDD VDD _06092_ sky130_fd_sc_hd__nand4_1
X_20957_ _04037_ net726 _06092_ VSS VSS VDD VDD _06093_ sky130_fd_sc_hd__nor3_1
X_20958_ _11142_ _11294_ net729 _03854_ VSS VSS VDD VDD _06094_ sky130_fd_sc_hd__nor4_1
X_20959_ _04255_ net727 _04477_ _04636_ VSS VSS VDD VDD _06095_ sky130_fd_sc_hd__nor4_1
X_20960_ _06091_ _06093_ _06094_ _06095_ VSS VSS VDD VDD _06096_ sky130_fd_sc_hd__nand4_1
X_20961_ _05981_ _05998_ VSS VSS VDD VDD _06097_ sky130_fd_sc_hd__nand2_1
X_20962_ net728 _04420_ _06096_ _06097_ VSS VSS VDD VDD _06098_ sky130_fd_sc_hd__nor4_1
X_20963_ _04093_ _05987_ VSS VSS VDD VDD _06099_ sky130_fd_sc_hd__nand2_1
X_20964_ _03974_ _05995_ VSS VSS VDD VDD _06100_ sky130_fd_sc_hd__nand2_1
X_20965_ _04151_ _05942_ _05984_ VSS VSS VDD VDD _06101_ sky130_fd_sc_hd__nand3_1
X_20966_ _05958_ _06019_ _06022_ VSS VSS VDD VDD _06102_ sky130_fd_sc_hd__nand3_1
X_20967_ _06099_ _06100_ _06101_ _06102_ VSS VSS VDD VDD _06103_ sky130_fd_sc_hd__nor4_1
X_20968_ _06088_ _06098_ _06103_ net851 VSS VSS VDD VDD _1038_ sky130_fd_sc_hd__a31oi_1
X_20969_ _02721_ _11230_ _02720_ VSS VSS VDD VDD _06104_ sky130_fd_sc_hd__a21o_1
X_20970_ _02884_ _06104_ _02883_ VSS VSS VDD VDD _06105_ sky130_fd_sc_hd__a21oi_1
X_20971_ delaynet_18_clk _1316_ VSS VSS VDD VDD _11345_ sky130_fd_sc_hd__dlclkp_1
X_20972_ delaynet_13_clk _1314_ VSS VSS VDD VDD _11346_ sky130_fd_sc_hd__dlclkp_1
X_20973_ delaynet_7_clk _1315_ VSS VSS VDD VDD _11347_ sky130_fd_sc_hd__dlclkp_1
X_20974_ clknet_leaf_10_clk _0296_ VSS VSS VDD VDD _11348_ sky130_fd_sc_hd__dlclkp_1
X_20975_ delaynet_16_clk _1124_ VSS VSS VDD VDD _11349_ sky130_fd_sc_hd__dlclkp_1
X_20976_ delaynet_13_clk _1323_ VSS VSS VDD VDD _11350_ sky130_fd_sc_hd__dlclkp_1
X_20977_ delaynet_9_clk _1356_ VSS VSS VDD VDD _11351_ sky130_fd_sc_hd__dlclkp_1
X_20978_ delaynet_4_clk _1322_ VSS VSS VDD VDD _11352_ sky130_fd_sc_hd__dlclkp_1
X_20979_ delaynet_7_clk _1354_ VSS VSS VDD VDD _11353_ sky130_fd_sc_hd__dlclkp_1
X_20980_ delaynet_2_clk _1309_ VSS VSS VDD VDD _11354_ sky130_fd_sc_hd__dlclkp_1
X_20981_ clknet_leaf_17_clk _03520_ VSS VSS VDD VDD _11355_ sky130_fd_sc_hd__dlclkp_1
X_20982_ clknet_leaf_17_clk _03519_ VSS VSS VDD VDD _11356_ sky130_fd_sc_hd__dlclkp_1
X_20983_ delaynet_5_clk _03518_ VSS VSS VDD VDD _11357_ sky130_fd_sc_hd__dlclkp_1
X_20984_ clknet_leaf_21_clk _1385_ VSS VSS VDD VDD _11358_ sky130_fd_sc_hd__dlclkp_1
X_20985_ clknet_leaf_6_clk _1334_ VSS VSS VDD VDD _11359_ sky130_fd_sc_hd__dlclkp_1
X_20986_ clknet_leaf_18_clk _1306_ VSS VSS VDD VDD _11360_ sky130_fd_sc_hd__dlclkp_1
X_20987_ clknet_leaf_15_clk _1308_ VSS VSS VDD VDD _11361_ sky130_fd_sc_hd__dlclkp_1
X_20988_ clknet_leaf_7_clk _1347_ VSS VSS VDD VDD _11362_ sky130_fd_sc_hd__dlclkp_1
X_20989_ clknet_leaf_2_clk _1342_ VSS VSS VDD VDD _11363_ sky130_fd_sc_hd__dlclkp_1
X_20990_ delaynet_5_clk _1325_ VSS VSS VDD VDD _11364_ sky130_fd_sc_hd__dlclkp_1
X_20991_ clknet_leaf_6_clk _1333_ VSS VSS VDD VDD _11365_ sky130_fd_sc_hd__dlclkp_1
X_20992_ clknet_leaf_13_clk _1360_ VSS VSS VDD VDD _11366_ sky130_fd_sc_hd__dlclkp_1
X_20993_ clknet_leaf_3_clk _1371_ VSS VSS VDD VDD _11367_ sky130_fd_sc_hd__dlclkp_1
X_20994_ clknet_leaf_5_clk _1337_ VSS VSS VDD VDD _11368_ sky130_fd_sc_hd__dlclkp_1
X_20995_ clknet_leaf_19_clk _1362_ VSS VSS VDD VDD _11369_ sky130_fd_sc_hd__dlclkp_1
X_20996_ clknet_leaf_5_clk _1349_ VSS VSS VDD VDD _11370_ sky130_fd_sc_hd__dlclkp_1
X_20997_ clknet_leaf_4_clk _1348_ VSS VSS VDD VDD _11371_ sky130_fd_sc_hd__dlclkp_1
X_20998_ clknet_leaf_20_clk _1381_ VSS VSS VDD VDD _11372_ sky130_fd_sc_hd__dlclkp_1
X_20999_ clknet_leaf_8_clk _1344_ VSS VSS VDD VDD _11373_ sky130_fd_sc_hd__dlclkp_1
X_21000_ clknet_leaf_8_clk _1343_ VSS VSS VDD VDD _11374_ sky130_fd_sc_hd__dlclkp_1
X_21001_ clknet_leaf_7_clk _1330_ VSS VSS VDD VDD _11375_ sky130_fd_sc_hd__dlclkp_1
X_21002_ clknet_leaf_3_clk _1339_ VSS VSS VDD VDD _11376_ sky130_fd_sc_hd__dlclkp_1
X_21003_ clknet_leaf_5_clk _1338_ VSS VSS VDD VDD _11377_ sky130_fd_sc_hd__dlclkp_1
X_21004_ clknet_leaf_10_clk _1326_ VSS VSS VDD VDD _11378_ sky130_fd_sc_hd__dlclkp_1
X_21005_ clknet_leaf_20_clk _1369_ VSS VSS VDD VDD _11379_ sky130_fd_sc_hd__dlclkp_1
X_21006_ clknet_leaf_13_clk _1351_ VSS VSS VDD VDD _11380_ sky130_fd_sc_hd__dlclkp_1
X_21007_ clknet_leaf_0_clk _1374_ VSS VSS VDD VDD _11381_ sky130_fd_sc_hd__dlclkp_1
X_21008_ clknet_leaf_6_clk _1350_ VSS VSS VDD VDD _11382_ sky130_fd_sc_hd__dlclkp_1
X_21009_ delaynet_3_clk _1311_ VSS VSS VDD VDD _11383_ sky130_fd_sc_hd__dlclkp_1
X_21010_ clknet_leaf_2_clk _1373_ VSS VSS VDD VDD _11384_ sky130_fd_sc_hd__dlclkp_1
X_21011_ clknet_leaf_8_clk _1346_ VSS VSS VDD VDD _11385_ sky130_fd_sc_hd__dlclkp_1
X_21012_ clknet_leaf_9_clk _1327_ VSS VSS VDD VDD _11386_ sky130_fd_sc_hd__dlclkp_1
X_21013_ clknet_leaf_8_clk _1345_ VSS VSS VDD VDD _11387_ sky130_fd_sc_hd__dlclkp_1
X_21014_ clknet_leaf_2_clk _1372_ VSS VSS VDD VDD _11388_ sky130_fd_sc_hd__dlclkp_1
X_21015_ clknet_leaf_18_clk _1307_ VSS VSS VDD VDD _11389_ sky130_fd_sc_hd__dlclkp_1
X_21016_ clknet_leaf_0_clk _1366_ VSS VSS VDD VDD _11390_ sky130_fd_sc_hd__dlclkp_1
X_21017_ clknet_leaf_4_clk _1341_ VSS VSS VDD VDD _11391_ sky130_fd_sc_hd__dlclkp_1
X_21018_ clknet_leaf_21_clk _1384_ VSS VSS VDD VDD _11392_ sky130_fd_sc_hd__dlclkp_1
X_21019_ clknet_leaf_4_clk _1340_ VSS VSS VDD VDD _11393_ sky130_fd_sc_hd__dlclkp_1
X_21020_ clknet_leaf_2_clk _1370_ VSS VSS VDD VDD _11394_ sky130_fd_sc_hd__dlclkp_1
X_21021_ clknet_leaf_5_clk _1336_ VSS VSS VDD VDD _11395_ sky130_fd_sc_hd__dlclkp_1
X_21022_ clknet_leaf_6_clk _1335_ VSS VSS VDD VDD _11396_ sky130_fd_sc_hd__dlclkp_1
X_21023_ clknet_leaf_19_clk _1367_ VSS VSS VDD VDD _11397_ sky130_fd_sc_hd__dlclkp_1
X_21024_ clknet_leaf_11_clk _1361_ VSS VSS VDD VDD _11398_ sky130_fd_sc_hd__dlclkp_1
X_21025_ clknet_leaf_3_clk _1377_ VSS VSS VDD VDD _11399_ sky130_fd_sc_hd__dlclkp_1
X_21026_ clknet_leaf_17_clk net752 VSS VSS VDD VDD _11400_ sky130_fd_sc_hd__dlclkp_1
X_21027_ delaynet_10_clk _1310_ VSS VSS VDD VDD _11401_ sky130_fd_sc_hd__dlclkp_1
X_21028_ clknet_leaf_1_clk _1363_ VSS VSS VDD VDD _11402_ sky130_fd_sc_hd__dlclkp_1
X_21029_ clknet_leaf_9_clk _1328_ VSS VSS VDD VDD _11403_ sky130_fd_sc_hd__dlclkp_1
X_21030_ clknet_leaf_21_clk _1382_ VSS VSS VDD VDD _11404_ sky130_fd_sc_hd__dlclkp_1
X_21031_ clknet_leaf_19_clk _1379_ VSS VSS VDD VDD _11405_ sky130_fd_sc_hd__dlclkp_1
X_21032_ clknet_leaf_7_clk _1331_ VSS VSS VDD VDD _11406_ sky130_fd_sc_hd__dlclkp_1
X_21033_ clknet_leaf_12_clk _1355_ VSS VSS VDD VDD _11407_ sky130_fd_sc_hd__dlclkp_1
X_21034_ clknet_leaf_0_clk _1376_ VSS VSS VDD VDD _11408_ sky130_fd_sc_hd__dlclkp_1
X_21035_ clknet_leaf_7_clk _1332_ VSS VSS VDD VDD _11409_ sky130_fd_sc_hd__dlclkp_1
X_21036_ delaynet_4_clk _1317_ VSS VSS VDD VDD _11410_ sky130_fd_sc_hd__dlclkp_1
X_21037_ clknet_leaf_1_clk _1365_ VSS VSS VDD VDD _11411_ sky130_fd_sc_hd__dlclkp_1
X_21038_ clknet_leaf_20_clk _1380_ VSS VSS VDD VDD _11412_ sky130_fd_sc_hd__dlclkp_1
X_21039_ clknet_leaf_1_clk _1364_ VSS VSS VDD VDD _11413_ sky130_fd_sc_hd__dlclkp_1
X_21040_ clknet_leaf_0_clk _1368_ VSS VSS VDD VDD _11414_ sky130_fd_sc_hd__dlclkp_1
X_21041_ clknet_leaf_15_clk net1039 VSS VSS VDD VDD _11415_ sky130_fd_sc_hd__dlclkp_1
X_21042_ clknet_leaf_9_clk _1329_ VSS VSS VDD VDD _11416_ sky130_fd_sc_hd__dlclkp_1
X_21043_ clknet_leaf_20_clk _1378_ VSS VSS VDD VDD _11417_ sky130_fd_sc_hd__dlclkp_1
X_21044_ clknet_leaf_4_clk _1324_ VSS VSS VDD VDD _11418_ sky130_fd_sc_hd__dlclkp_1
X_21045_ clknet_leaf_14_clk _0982_ VSS VSS VDD VDD _11419_ sky130_fd_sc_hd__dlclkp_1
X_21046_ delaynet_3_clk _1320_ VSS VSS VDD VDD _11420_ sky130_fd_sc_hd__dlclkp_1
X_21047_ clknet_leaf_11_clk _1267_ VSS VSS VDD VDD _11421_ sky130_fd_sc_hd__dlclkp_1
X_21048_ clknet_leaf_12_clk _1312_ VSS VSS VDD VDD _11422_ sky130_fd_sc_hd__dlclkp_1
X_21049_ clknet_leaf_16_clk _1318_ VSS VSS VDD VDD _11423_ sky130_fd_sc_hd__dlclkp_1
X_21050_ clknet_leaf_21_clk _1383_ VSS VSS VDD VDD _11424_ sky130_fd_sc_hd__dlclkp_1
X_21051_ clknet_leaf_11_clk _1263_ VSS VSS VDD VDD _11425_ sky130_fd_sc_hd__dlclkp_1
X_21052_ clknet_leaf_18_clk _1304_ VSS VSS VDD VDD _11426_ sky130_fd_sc_hd__dlclkp_1
X_21053_ clknet_leaf_3_clk _1375_ VSS VSS VDD VDD _11427_ sky130_fd_sc_hd__dlclkp_1
X_21054_ clknet_leaf_11_clk _1352_ VSS VSS VDD VDD _11428_ sky130_fd_sc_hd__dlclkp_1
X_21055_ clknet_leaf_14_clk _1359_ VSS VSS VDD VDD _11429_ sky130_fd_sc_hd__dlclkp_1
X_21056_ net995 _0311_[0] _02298_ VSS VSS VDD VDD _02299_ _02300_ sky130_fd_sc_hd__fa_1
X_21057_ _0238_[0] _02302_ net992 VSS VSS VDD VDD _02303_ _02304_ sky130_fd_sc_hd__fa_1
X_21058_ _02306_ net956 _02307_ VSS VSS VDD VDD _02308_ _02309_ sky130_fd_sc_hd__fa_1
X_21059_ _02311_ u_core.u_top.u_core.r_off[1] _02312_ VSS VSS VDD VDD _02313_ _02314_ sky130_fd_sc_hd__fa_1
X_21060_ _02315_ u_core.u_top.u_core.r_off[1] _02316_ VSS VSS VDD VDD _02317_ _02318_ sky130_fd_sc_hd__fa_1
X_21061_ _02319_ net956 _02320_ VSS VSS VDD VDD _02321_ _02322_ sky130_fd_sc_hd__fa_1
X_21062_ _02323_ u_core.u_top.u_core.r_off[1] _02324_ VSS VSS VDD VDD _02325_ _02326_ sky130_fd_sc_hd__fa_1
X_21063_ net995 _0226_[0] _02327_ VSS VSS VDD VDD _02328_ _02329_ sky130_fd_sc_hd__fa_1
X_21064_ _02330_ net956 _02331_ VSS VSS VDD VDD _02332_ _02333_ sky130_fd_sc_hd__fa_1
X_21065_ net994 _0316_[0] _02334_ VSS VSS VDD VDD _02335_ _02336_ sky130_fd_sc_hd__fa_1
X_21066_ _02338_ u_core.u_top.u_core.r_off[1] _02339_ VSS VSS VDD VDD _02340_ _02341_ sky130_fd_sc_hd__fa_1
X_21067_ net994 _0232_[0] _02342_ VSS VSS VDD VDD _02343_ _02344_ sky130_fd_sc_hd__fa_1
X_21068_ _02345_ u_core.u_top.u_core.r_off[1] _02346_ VSS VSS VDD VDD _02347_ _02348_ sky130_fd_sc_hd__fa_1
X_21069_ _02349_ net956 _02350_ VSS VSS VDD VDD _02351_ _02352_ sky130_fd_sc_hd__fa_1
X_21070_ _0264_[0] _02353_ u_core.u_top.u_core.lfsr[7] VSS VSS VDD VDD _02354_ _02355_ sky130_fd_sc_hd__fa_1
X_21071_ _0322_[0] _02357_ net992 VSS VSS VDD VDD _02358_ _02359_ sky130_fd_sc_hd__fa_1
X_21072_ _0259_[0] _02360_ u_core.u_top.u_core.lfsr[6] VSS VSS VDD VDD _02361_ _02362_ sky130_fd_sc_hd__fa_1
X_21073_ _0279_[0] _02364_ u_core.u_top.u_core.lfsr[10] VSS VSS VDD VDD _02365_ _02366_ sky130_fd_sc_hd__fa_1
X_21074_ _0284_[0] _02368_ u_core.u_top.u_core.lfsr[11] VSS VSS VDD VDD _02369_ _02370_ sky130_fd_sc_hd__fa_1
X_21075_ _02372_ net956 _02373_ VSS VSS VDD VDD _02374_ _02375_ sky130_fd_sc_hd__fa_1
X_21076_ _02376_ u_core.u_top.u_core.r_off[1] _02377_ VSS VSS VDD VDD _02378_ _02379_ sky130_fd_sc_hd__fa_1
X_21077_ _02380_ net956 _02381_ VSS VSS VDD VDD _02382_ _02383_ sky130_fd_sc_hd__fa_1
X_21078_ _02384_ u_core.u_top.u_core.r_off[1] _02385_ VSS VSS VDD VDD _02386_ _02387_ sky130_fd_sc_hd__fa_1
X_21079_ _0306_[0] _02388_ u_core.u_top.u_core.lfsr[15] VSS VSS VDD VDD _02389_ _02390_ sky130_fd_sc_hd__fa_1
X_21080_ _0294_[0] _02392_ u_core.u_top.u_core.lfsr[13] VSS VSS VDD VDD _02393_ _02394_ sky130_fd_sc_hd__fa_1
X_21081_ _0254_[0] _02396_ u_core.u_top.u_core.lfsr[5] VSS VSS VDD VDD _02397_ _02398_ sky130_fd_sc_hd__fa_1
X_21082_ _0274_[0] _02400_ net991 VSS VSS VDD VDD _02401_ _02402_ sky130_fd_sc_hd__fa_1
X_21083_ _0243_[0] _02404_ u_core.u_top.u_core.lfsr[3] VSS VSS VDD VDD _02405_ _02406_ sky130_fd_sc_hd__fa_1
X_21084_ _0249_[0] _02408_ u_core.u_top.u_core.lfsr[4] VSS VSS VDD VDD _02409_ _02410_ sky130_fd_sc_hd__fa_1
X_21085_ _02412_ u_core.u_top.u_core.r_off[1] _02413_ VSS VSS VDD VDD _02414_ _02415_ sky130_fd_sc_hd__fa_1
X_21086_ _0333_[0] _02416_ u_core.u_top.u_core.lfsr[4] VSS VSS VDD VDD _02417_ _02418_ sky130_fd_sc_hd__fa_1
X_21087_ _0269_[0] _02419_ u_core.u_top.u_core.lfsr[8] VSS VSS VDD VDD _02420_ _02421_ sky130_fd_sc_hd__fa_1
X_21088_ _02423_ net956 _02424_ VSS VSS VDD VDD _02425_ _02426_ sky130_fd_sc_hd__fa_1
X_21089_ _0338_[0] _02427_ u_core.u_top.u_core.lfsr[5] VSS VSS VDD VDD _02428_ _02429_ sky130_fd_sc_hd__fa_1
X_21090_ _02430_ u_core.u_top.u_core.r_off[1] _02431_ VSS VSS VDD VDD _02432_ _02433_ sky130_fd_sc_hd__fa_1
X_21091_ _02434_ u_core.u_top.u_core.r_off[1] _02435_ VSS VSS VDD VDD _02436_ _02437_ sky130_fd_sc_hd__fa_1
X_21092_ _02438_ u_core.u_top.u_core.r_off[1] _02439_ VSS VSS VDD VDD _02440_ _02441_ sky130_fd_sc_hd__fa_1
X_21093_ _0300_[0] _02442_ u_core.u_top.u_core.lfsr[14] VSS VSS VDD VDD _02443_ _02444_ sky130_fd_sc_hd__fa_1
X_21094_ _02446_ net956 _02447_ VSS VSS VDD VDD _02448_ _02449_ sky130_fd_sc_hd__fa_1
X_21095_ _0344_[0] _02450_ u_core.u_top.u_core.lfsr[6] VSS VSS VDD VDD _02451_ _02452_ sky130_fd_sc_hd__fa_1
X_21096_ _02453_ net956 _02454_ VSS VSS VDD VDD _02455_ _02456_ sky130_fd_sc_hd__fa_1
X_21097_ _0327_[0] _02457_ u_core.u_top.u_core.lfsr[3] VSS VSS VDD VDD _02458_ _02459_ sky130_fd_sc_hd__fa_1
X_21098_ _02460_ net956 _02461_ VSS VSS VDD VDD _02462_ _02463_ sky130_fd_sc_hd__fa_1
X_21099_ _0289_[0] _02464_ u_core.u_top.u_core.lfsr[12] VSS VSS VDD VDD _02465_ _02466_ sky130_fd_sc_hd__fa_1
X_21100_ _02468_ u_core.u_top.u_core.r_off[1] _02469_ VSS VSS VDD VDD _02470_ _02471_ sky130_fd_sc_hd__fa_1
X_21101_ _0349_[0] _02472_ u_core.u_top.u_core.lfsr[7] VSS VSS VDD VDD _02473_ _02474_ sky130_fd_sc_hd__fa_1
X_21102_ net872 u_core.u_top.u_core.x_idx[1] net872 VSS VSS VDD VDD _02476_ _0356_[5] sky130_fd_sc_hd__fa_1
X_21103_ _02477_ u_core.u_top.u_core.r_off[1] _02478_ VSS VSS VDD VDD _02479_ _02480_ sky130_fd_sc_hd__fa_1
X_21104_ _02481_ net956 _02482_ VSS VSS VDD VDD _02483_ _02484_ sky130_fd_sc_hd__fa_1
X_21105_ u_core.u_top.u_core.acc_upd[62] _02485_ VSS VSS VDD VDD _02486_ _02487_ sky130_fd_sc_hd__ha_1
X_21106_ u_core.u_top.u_core.acc_upd[192] _02485_ VSS VSS VDD VDD _02488_ _02489_ sky130_fd_sc_hd__ha_1
X_21107_ u_core.u_top.u_core.acc_upd[204] _02490_ VSS VSS VDD VDD _02491_ _02492_ sky130_fd_sc_hd__ha_1
X_21108_ _02493_ u_core.u_top.u_core.r_off[0] VSS VSS VDD VDD _02424_ _02494_ sky130_fd_sc_hd__ha_1
X_21109_ u_core.u_top.u_core.acc_upd[203] _02495_ VSS VSS VDD VDD _02496_ _02497_ sky130_fd_sc_hd__ha_1
X_21110_ _02498_ u_core.u_top.u_core.r_off[0] VSS VSS VDD VDD _02385_ _02499_ sky130_fd_sc_hd__ha_1
X_21111_ u_core.u_top.u_core.acc_upd[11] net879 VSS VSS VDD VDD _02500_ _02501_ sky130_fd_sc_hd__ha_1
X_21112_ _02337_ u_core.u_top.u_core.d_acc[173] VSS VSS VDD VDD _02503_ _02504_ sky130_fd_sc_hd__ha_1
X_21113_ _02337_ u_core.u_top.u_core.d_acc[13] VSS VSS VDD VDD _02505_ _02506_ sky130_fd_sc_hd__ha_1
X_21114_ _02301_ u_core.u_top.u_core.d_acc[8] VSS VSS VDD VDD _02507_ _02508_ sky130_fd_sc_hd__ha_1
X_21115_ u_core.u_top.u_core.acc_upd[31] net879 VSS VSS VDD VDD _02509_ _02510_ sky130_fd_sc_hd__ha_1
X_21116_ _02337_ u_core.u_top.u_core.d_acc[15] VSS VSS VDD VDD _02511_ _02512_ sky130_fd_sc_hd__ha_1
X_21117_ u_core.u_top.u_core.acc_upd[34] net876 VSS VSS VDD VDD _02513_ _02514_ sky130_fd_sc_hd__ha_1
X_21118_ u_core.u_top.u_core.acc_upd[205] _02515_ VSS VSS VDD VDD _02516_ _02517_ sky130_fd_sc_hd__ha_1
X_21119_ u_core.u_top.u_core.acc_upd[234] net876 VSS VSS VDD VDD _02518_ _02519_ sky130_fd_sc_hd__ha_1
X_21120_ _02301_ u_core.u_top.u_core.d_acc[5] VSS VSS VDD VDD _02520_ _02521_ sky130_fd_sc_hd__ha_1
X_21121_ u_core.u_top.u_core.acc_upd[223] _02495_ VSS VSS VDD VDD _02522_ _02523_ sky130_fd_sc_hd__ha_1
X_21122_ u_core.u_top.u_core.acc_upd[85] net877 VSS VSS VDD VDD _02524_ _02525_ sky130_fd_sc_hd__ha_1
X_21123_ u_core.u_top.u_core.acc_upd[145] _02515_ VSS VSS VDD VDD _02526_ _02527_ sky130_fd_sc_hd__ha_1
X_21124_ u_core.u_top.u_core.d_acc[33] _02407_ VSS VSS VDD VDD _02528_ _02529_ sky130_fd_sc_hd__ha_1
X_21125_ u_core.u_top.u_core.acc_upd[102] _02485_ VSS VSS VDD VDD _02530_ _02531_ sky130_fd_sc_hd__ha_1
X_21126_ u_core.u_top.u_core.acc_upd[138] net881 VSS VSS VDD VDD _02533_ _02534_ sky130_fd_sc_hd__ha_1
X_21127_ _02535_ net957 VSS VSS VDD VDD _02431_ _02536_ sky130_fd_sc_hd__ha_1
X_21128_ _02537_ _0152_[0] VSS VSS VDD VDD _02538_ _02539_ sky130_fd_sc_hd__ha_1
X_21129_ u_core.u_top.u_core.acc_upd[111] _02310_ VSS VSS VDD VDD _02540_ _02541_ sky130_fd_sc_hd__ha_1
X_21130_ _0152_[0] _02537_ VSS VSS VDD VDD _02542_ _0152_[1] sky130_fd_sc_hd__ha_1
X_21131_ u_core.u_top.u_core.acc[180] u_core.u_top.u_core.acc[181] VSS VSS VDD VDD _02543_ _11430_ sky130_fd_sc_hd__ha_1
X_21132_ u_core.u_top.u_core.d_acc[37] _02407_ VSS VSS VDD VDD _02544_ _02545_ sky130_fd_sc_hd__ha_1
X_21133_ _02546_ net957 VSS VSS VDD VDD _02454_ _02547_ sky130_fd_sc_hd__ha_1
X_21134_ u_core.u_top.u_core.d_acc[42] _02411_ VSS VSS VDD VDD _02548_ _02549_ sky130_fd_sc_hd__ha_1
X_21135_ u_core.u_top.u_core.d_acc[207] _02411_ VSS VSS VDD VDD _02550_ _02551_ sky130_fd_sc_hd__ha_1
X_21136_ u_core.u_top.u_core.d_acc[46] _02411_ VSS VSS VDD VDD _02552_ _02553_ sky130_fd_sc_hd__ha_1
X_21137_ u_core.u_top.u_core.acc_upd[162] net880 VSS VSS VDD VDD _02554_ _02555_ sky130_fd_sc_hd__ha_1
X_21138_ u_core.u_top.u_core.d_acc[123] _02467_ VSS VSS VDD VDD _02556_ _02557_ sky130_fd_sc_hd__ha_1
X_21139_ u_core.u_top.u_core.acc_upd[174] net876 VSS VSS VDD VDD _02558_ _02559_ sky130_fd_sc_hd__ha_1
X_21140_ u_core.u_top.u_core.d_acc[63] _02363_ VSS VSS VDD VDD _02560_ _02561_ sky130_fd_sc_hd__ha_1
X_21141_ u_core.u_top.u_core.d_acc[47] _02411_ VSS VSS VDD VDD _02563_ _02564_ sky130_fd_sc_hd__ha_1
X_21142_ _02565_ _0164_[0] VSS VSS VDD VDD _02566_ _02567_ sky130_fd_sc_hd__ha_1
X_21143_ u_core.u_top.u_core.d_acc[232] _02356_ VSS VSS VDD VDD _02568_ _02569_ sky130_fd_sc_hd__ha_1
X_21144_ u_core.u_top.u_core.d_acc[66] _02363_ VSS VSS VDD VDD _02571_ _02572_ sky130_fd_sc_hd__ha_1
X_21145_ u_core.u_top.u_core.acc_upd[153] _02495_ VSS VSS VDD VDD _02574_ _02575_ sky130_fd_sc_hd__ha_1
X_21146_ u_core.u_top.u_core.d_acc[64] _02363_ VSS VSS VDD VDD _02576_ _02577_ sky130_fd_sc_hd__ha_1
X_21147_ u_core.u_top.u_core.d_acc[93] _02403_ VSS VSS VDD VDD _02578_ _02579_ sky130_fd_sc_hd__ha_1
X_21148_ u_core.u_top.u_core.d_acc[51] _02399_ VSS VSS VDD VDD _02580_ _02581_ sky130_fd_sc_hd__ha_1
X_21149_ u_core.u_top.u_core.d_acc[81] _02422_ VSS VSS VDD VDD _02582_ _02583_ sky130_fd_sc_hd__ha_1
X_21150_ u_core.u_top.u_core.acc_upd[122] _02485_ VSS VSS VDD VDD _02584_ _02585_ sky130_fd_sc_hd__ha_1
X_21151_ _0009_[0] _02586_ VSS VSS VDD VDD _11431_ _0905_[1] sky130_fd_sc_hd__ha_1
X_21152_ _0164_[0] _02565_ VSS VSS VDD VDD _02587_ _0164_[1] sky130_fd_sc_hd__ha_1
X_21153_ u_core.u_top.u_core.acc[190] u_core.u_top.u_core.acc[191] VSS VSS VDD VDD _02588_ _11432_ sky130_fd_sc_hd__ha_1
X_21154_ u_core.u_top.u_core.d_acc[85] _02422_ VSS VSS VDD VDD _02589_ _02590_ sky130_fd_sc_hd__ha_1
X_21155_ u_core.u_top.u_core.d_acc[97] _02403_ VSS VSS VDD VDD _02591_ _02592_ sky130_fd_sc_hd__ha_1
X_21156_ u_core.u_top.u_core.acc_upd[171] net879 VSS VSS VDD VDD _02593_ _02594_ sky130_fd_sc_hd__ha_1
X_21157_ _0055_[0] _02595_ VSS VSS VDD VDD _02596_ _02597_ sky130_fd_sc_hd__ha_1
X_21158_ u_core.u_top.u_core.d_acc[185] _02305_ VSS VSS VDD VDD _02598_ _02599_ sky130_fd_sc_hd__ha_1
X_21159_ _02601_ _0176_[0] VSS VSS VDD VDD _02602_ _02603_ sky130_fd_sc_hd__ha_1
X_21160_ net992 _03026_ VSS VSS VDD VDD _11433_ _0727_[4] sky130_fd_sc_hd__ha_1
X_21161_ _0088_[0] _02606_ VSS VSS VDD VDD _02607_ _02608_ sky130_fd_sc_hd__ha_1
X_21162_ u_core.u_top.u_core.d_acc[131] _02395_ VSS VSS VDD VDD _02609_ _02610_ sky130_fd_sc_hd__ha_1
X_21163_ u_core.u_top.u_core.d_acc[147] _02445_ VSS VSS VDD VDD _02611_ _02612_ sky130_fd_sc_hd__ha_1
X_21164_ u_core.u_top.u_core.d_acc[53] _02399_ VSS VSS VDD VDD _02613_ _02614_ sky130_fd_sc_hd__ha_1
X_21165_ _0176_[0] _02601_ VSS VSS VDD VDD _02615_ _0176_[1] sky130_fd_sc_hd__ha_1
X_21166_ u_core.u_top.u_core.acc[200] u_core.u_top.u_core.acc[201] VSS VSS VDD VDD _02616_ _11434_ sky130_fd_sc_hd__ha_1
X_21167_ _02617_ net957 VSS VSS VDD VDD _02320_ _02618_ sky130_fd_sc_hd__ha_1
X_21168_ u_core.u_top.u_core.d_acc[142] _02445_ VSS VSS VDD VDD _02619_ _02620_ sky130_fd_sc_hd__ha_1
X_21169_ u_core.u_top.u_core.d_acc[158] net988 VSS VSS VDD VDD _02621_ _02622_ sky130_fd_sc_hd__ha_1
X_21170_ u_core.u_top.u_core.acc_upd[185] net877 VSS VSS VDD VDD _02623_ _02624_ sky130_fd_sc_hd__ha_1
X_21171_ u_core.u_top.u_core.acc_upd[186] net875 VSS VSS VDD VDD _02626_ _02627_ sky130_fd_sc_hd__ha_1
X_21172_ _0005_[0] _02628_ VSS VSS VDD VDD _11435_ _0896_[1] sky130_fd_sc_hd__ha_1
X_21173_ _02629_ _02630_ VSS VSS VDD VDD _11436_ _02631_ sky130_fd_sc_hd__ha_1
X_21174_ _02629_ _02632_ VSS VSS VDD VDD _02633_ _11437_ sky130_fd_sc_hd__ha_1
X_21175_ u_core.u_top.u_core.acc_upd[193] net894 VSS VSS VDD VDD _02634_ _02635_ sky130_fd_sc_hd__ha_1
X_21176_ u_core.u_top.u_core.d_acc[118] _02371_ VSS VSS VDD VDD _02636_ _02637_ sky130_fd_sc_hd__ha_1
X_21177_ u_core.u_top.u_core.acc_upd[56] net875 VSS VSS VDD VDD _02638_ _02639_ sky130_fd_sc_hd__ha_1
X_21178_ _02641_ u_core.u_top.u_core.r_off[0] VSS VSS VDD VDD _02339_ _02642_ sky130_fd_sc_hd__ha_1
X_21179_ _02644_ _0188_[0] VSS VSS VDD VDD _02645_ _02646_ sky130_fd_sc_hd__ha_1
X_21180_ u_core.u_top.u_core.d_acc[216] _02399_ VSS VSS VDD VDD _02647_ _02648_ sky130_fd_sc_hd__ha_1
X_21181_ _02337_ u_core.u_top.u_core.d_acc[12] VSS VSS VDD VDD _02649_ _02650_ sky130_fd_sc_hd__ha_1
X_21182_ _0900_[0] _02652_ VSS VSS VDD VDD _02653_ _0900_[1] sky130_fd_sc_hd__ha_1
X_21183_ _0007_[0] _0007_[1] VSS VSS VDD VDD _02654_ _11438_ sky130_fd_sc_hd__ha_1
X_21184_ u_core.u_top.u_core.d_acc[213] _02399_ VSS VSS VDD VDD _02655_ _02656_ sky130_fd_sc_hd__ha_1
X_21185_ u_core.u_top.u_core.d_acc[41] _02411_ VSS VSS VDD VDD _02657_ _02658_ sky130_fd_sc_hd__ha_1
X_21186_ _0188_[0] _02644_ VSS VSS VDD VDD _02659_ _0188_[1] sky130_fd_sc_hd__ha_1
X_21187_ u_core.u_top.u_core.acc[210] u_core.u_top.u_core.acc[211] VSS VSS VDD VDD _02660_ _11439_ sky130_fd_sc_hd__ha_1
X_21188_ u_core.u_top.u_core.acc_upd[191] net879 VSS VSS VDD VDD _02661_ _02662_ sky130_fd_sc_hd__ha_1
X_21189_ u_core.u_top.u_core.d_acc[228] _02363_ VSS VSS VDD VDD _02663_ _02664_ sky130_fd_sc_hd__ha_1
X_21190_ u_core.u_top.u_core.d_acc[84] _02422_ VSS VSS VDD VDD _02666_ _02667_ sky130_fd_sc_hd__ha_1
X_21191_ u_core.u_top.u_core.acc_upd[151] net879 VSS VSS VDD VDD _02668_ _02669_ sky130_fd_sc_hd__ha_1
X_21192_ _02670_ u_core.u_top.u_core.r_off[0] VSS VSS VDD VDD _02413_ _02671_ sky130_fd_sc_hd__ha_1
X_21193_ _02672_ _0200_[0] VSS VSS VDD VDD _02673_ _02674_ sky130_fd_sc_hd__ha_1
X_21194_ _0200_[0] _02672_ VSS VSS VDD VDD _02675_ _0200_[1] sky130_fd_sc_hd__ha_1
X_21195_ u_core.u_top.u_core.acc[220] u_core.u_top.u_core.acc[221] VSS VSS VDD VDD _02676_ _11440_ sky130_fd_sc_hd__ha_1
X_21196_ u_core.u_top.u_core.acc_upd[188] net882 VSS VSS VDD VDD _02677_ _02678_ sky130_fd_sc_hd__ha_1
X_21197_ u_core.u_top.u_core.acc_upd[207] net881 VSS VSS VDD VDD _02679_ _02680_ sky130_fd_sc_hd__ha_1
X_21198_ u_core.u_top.u_core.acc_upd[181] net879 VSS VSS VDD VDD _02681_ _02682_ sky130_fd_sc_hd__ha_1
X_21199_ u_core.u_top.u_core.acc_upd[187] net882 VSS VSS VDD VDD _02683_ _02684_ sky130_fd_sc_hd__ha_1
X_21200_ u_core.u_top.u_core.acc_upd[195] net877 VSS VSS VDD VDD _02685_ _02686_ sky130_fd_sc_hd__ha_1
X_21201_ u_core.u_top.u_core.acc_upd[183] net894 VSS VSS VDD VDD _02687_ _02688_ sky130_fd_sc_hd__ha_1
X_21202_ _0912_[0] _02689_ VSS VSS VDD VDD _02690_ _02691_ sky130_fd_sc_hd__ha_1
X_21203_ _02692_ _0211_[0] VSS VSS VDD VDD _02693_ _02694_ sky130_fd_sc_hd__ha_1
X_21204_ u_core.u_top.u_core.acc_upd[165] net877 VSS VSS VDD VDD _02695_ _02696_ sky130_fd_sc_hd__ha_1
X_21205_ u_core.u_top.u_core.amp[0] _02697_ VSS VSS VDD VDD _02698_ _02699_ sky130_fd_sc_hd__ha_1
X_21206_ u_core.u_top.u_core.amp[0] u_core.u_top.u_core.amp[1] VSS VSS VDD VDD _02700_ _11441_ sky130_fd_sc_hd__ha_1
X_21207_ _0055_[0] _02595_ VSS VSS VDD VDD _02701_ _0055_[1] sky130_fd_sc_hd__ha_1
X_21208_ u_core.u_top.u_core.acc[90] u_core.u_top.u_core.acc[91] VSS VSS VDD VDD _02702_ _11442_ sky130_fd_sc_hd__ha_1
X_21209_ u_core.u_top.u_core.d_acc[117] _02371_ VSS VSS VDD VDD _02703_ _02704_ sky130_fd_sc_hd__ha_1
X_21210_ u_core.u_top.u_core.d_acc[56] _02399_ VSS VSS VDD VDD _02705_ _02706_ sky130_fd_sc_hd__ha_1
X_21211_ _02707_ _0021_[0] VSS VSS VDD VDD _02708_ _02709_ sky130_fd_sc_hd__ha_1
X_21212_ u_core.u_top.u_core.acc_upd[121] net879 VSS VSS VDD VDD _02710_ _02711_ sky130_fd_sc_hd__ha_1
X_21213_ u_core.u_top.u_core.acc_upd[87] _11271_ VSS VSS VDD VDD _02712_ _02713_ sky130_fd_sc_hd__ha_1
X_21214_ u_core.u_top.u_core.acc_upd[217] net881 VSS VSS VDD VDD _02714_ _02715_ sky130_fd_sc_hd__ha_1
X_21215_ u_core.u_top.u_core.acc_upd[132] _02485_ VSS VSS VDD VDD _02716_ _02717_ sky130_fd_sc_hd__ha_1
X_21216_ u_core.u_top.u_core.acc_upd[143] _02495_ VSS VSS VDD VDD _02718_ _02719_ sky130_fd_sc_hd__ha_1
X_21217_ u_core.u_top.u_core.acc_upd[237] net882 VSS VSS VDD VDD _02720_ _02721_ sky130_fd_sc_hd__ha_1
X_21218_ u_core.u_top.u_core.d_acc[95] _02403_ VSS VSS VDD VDD _02722_ _02723_ sky130_fd_sc_hd__ha_1
X_21219_ _02301_ u_core.u_top.u_core.d_acc[4] VSS VSS VDD VDD _02724_ _02725_ sky130_fd_sc_hd__ha_1
X_21220_ u_core.u_top.u_core.acc_upd[147] net881 VSS VSS VDD VDD _02726_ _02727_ sky130_fd_sc_hd__ha_1
X_21221_ _02728_ u_core.u_top.u_core.r_off[0] VSS VSS VDD VDD _02377_ _02729_ sky130_fd_sc_hd__ha_1
X_21222_ u_core.u_top.u_core.acc_upd[158] net881 VSS VSS VDD VDD _02730_ _02731_ sky130_fd_sc_hd__ha_1
X_21223_ u_core.u_top.u_core.acc_upd[227] net881 VSS VSS VDD VDD _02732_ _02733_ sky130_fd_sc_hd__ha_1
X_21224_ u_core.u_top.u_core.acc_upd[141] net879 VSS VSS VDD VDD _02734_ _02665_ sky130_fd_sc_hd__ha_1
X_21225_ u_core.u_top.u_core.acc_upd[127] net881 VSS VSS VDD VDD _02735_ _02736_ sky130_fd_sc_hd__ha_1
X_21226_ u_core.u_top.u_core.acc_upd[54] net876 VSS VSS VDD VDD _02737_ _02738_ sky130_fd_sc_hd__ha_1
X_21227_ u_core.u_top.u_core.acc_upd[232] _02485_ VSS VSS VDD VDD _02739_ _02740_ sky130_fd_sc_hd__ha_1
X_21228_ u_core.u_top.u_core.d_acc[206] _02411_ VSS VSS VDD VDD _02741_ _02742_ sky130_fd_sc_hd__ha_1
X_21229_ _02301_ u_core.u_top.u_core.d_acc[1] VSS VSS VDD VDD _02743_ _02640_ sky130_fd_sc_hd__ha_1
X_21230_ u_core.u_top.u_core.acc_upd[214] _02490_ VSS VSS VDD VDD _02744_ _02745_ sky130_fd_sc_hd__ha_1
X_21231_ u_core.u_top.u_core.d_acc[211] _02399_ VSS VSS VDD VDD _02747_ _02748_ sky130_fd_sc_hd__ha_1
X_21232_ u_core.u_top.u_core.d_acc[135] _02395_ VSS VSS VDD VDD _02749_ _02750_ sky130_fd_sc_hd__ha_1
X_21233_ net955 _02629_ VSS VSS VDD VDD _11443_ _0888_[1] sky130_fd_sc_hd__ha_1
X_21234_ _0001_[1] _11444_ VSS VSS VDD VDD _0888_[4] _02751_ sky130_fd_sc_hd__ha_1
X_21235_ _0888_[0] _02629_ VSS VSS VDD VDD _11444_ _0890_[1] sky130_fd_sc_hd__ha_1
X_21236_ _0888_[0] _0001_[1] VSS VSS VDD VDD _02752_ _11445_ sky130_fd_sc_hd__ha_1
X_21237_ net955 _0001_[1] VSS VSS VDD VDD _02753_ _11446_ sky130_fd_sc_hd__ha_1
X_21238_ u_core.u_top.u_core.acc_upd[176] net875 VSS VSS VDD VDD _02754_ _02755_ sky130_fd_sc_hd__ha_1
X_21239_ u_core.u_top.u_core.acc_upd[114] net876 VSS VSS VDD VDD _02756_ _02757_ sky130_fd_sc_hd__ha_1
X_21240_ u_core.u_top.u_core.d_acc[146] _02445_ VSS VSS VDD VDD _02758_ _02759_ sky130_fd_sc_hd__ha_1
X_21241_ u_core.u_top.u_core.acc_upd[228] net881 VSS VSS VDD VDD _02760_ _02761_ sky130_fd_sc_hd__ha_1
X_21242_ u_core.u_top.u_core.d_acc[65] _02363_ VSS VSS VDD VDD _02762_ _02763_ sky130_fd_sc_hd__ha_1
X_21243_ u_core.u_top.u_core.acc_upd[76] net875 VSS VSS VDD VDD _02764_ _02765_ sky130_fd_sc_hd__ha_1
X_21244_ u_core.u_top.u_core.acc_upd[91] net879 VSS VSS VDD VDD _02766_ _02767_ sky130_fd_sc_hd__ha_1
X_21245_ u_core.u_top.u_core.d_acc[72] _02356_ VSS VSS VDD VDD _02768_ _02769_ sky130_fd_sc_hd__ha_1
X_21246_ u_core.u_top.u_core.d_acc[52] _02399_ VSS VSS VDD VDD _02770_ _02771_ sky130_fd_sc_hd__ha_1
X_21247_ u_core.u_top.u_core.d_acc[88] _02422_ VSS VSS VDD VDD _02772_ _02773_ sky130_fd_sc_hd__ha_1
X_21248_ _02301_ u_core.u_top.u_core.d_acc[166] VSS VSS VDD VDD _02774_ _02775_ sky130_fd_sc_hd__ha_1
X_21249_ u_core.u_top.u_core.acc_upd[92] net880 VSS VSS VDD VDD _02776_ _02777_ sky130_fd_sc_hd__ha_1
X_21250_ _02337_ u_core.u_top.u_core.d_acc[172] VSS VSS VDD VDD _02778_ _02779_ sky130_fd_sc_hd__ha_1
X_21251_ _02337_ u_core.u_top.u_core.d_acc[177] VSS VSS VDD VDD _02780_ _02781_ sky130_fd_sc_hd__ha_1
X_21252_ u_core.u_top.u_core.d_acc[68] _02363_ VSS VSS VDD VDD _02782_ _02783_ sky130_fd_sc_hd__ha_1
X_21253_ u_core.u_top.u_core.acc_upd[222] _02485_ VSS VSS VDD VDD _02784_ _02785_ sky130_fd_sc_hd__ha_1
X_21254_ u_core.u_top.u_core.d_acc[98] _02403_ VSS VSS VDD VDD _02786_ _02787_ sky130_fd_sc_hd__ha_1
X_21255_ u_core.u_top.u_core.acc_upd[66] net875 VSS VSS VDD VDD _02788_ _02789_ sky130_fd_sc_hd__ha_1
X_21256_ u_core.u_top.u_core.d_acc[96] _02403_ VSS VSS VDD VDD _02790_ _02791_ sky130_fd_sc_hd__ha_1
X_21257_ u_core.u_top.u_core.acc_upd[61] net879 VSS VSS VDD VDD _02792_ _02793_ sky130_fd_sc_hd__ha_1
X_21258_ u_core.u_top.u_core.acc_upd[201] net879 VSS VSS VDD VDD _02794_ _02600_ sky130_fd_sc_hd__ha_1
X_21259_ _0731_[0] _02795_ VSS VSS VDD VDD _02796_ _0731_[1] sky130_fd_sc_hd__ha_1
X_21260_ _0731_[0] net986 VSS VSS VDD VDD _02797_ _11447_ sky130_fd_sc_hd__ha_1
X_21261_ net987 _02795_ VSS VSS VDD VDD _02798_ _11448_ sky130_fd_sc_hd__ha_1
X_21262_ net987 net986 VSS VSS VDD VDD _02799_ _11449_ sky130_fd_sc_hd__ha_1
X_21263_ net987 net986 VSS VSS VDD VDD _02800_ _11450_ sky130_fd_sc_hd__ha_1
X_21264_ _0098_[0] _02801_ VSS VSS VDD VDD _02802_ _02803_ sky130_fd_sc_hd__ha_1
X_21265_ _02337_ u_core.u_top.u_core.d_acc[11] VSS VSS VDD VDD _02804_ _02746_ sky130_fd_sc_hd__ha_1
X_21266_ u_core.u_top.u_core.d_acc[24] _02305_ VSS VSS VDD VDD _02805_ _02806_ sky130_fd_sc_hd__ha_1
X_21267_ u_core.u_top.u_core.d_acc[101] _02367_ VSS VSS VDD VDD _02807_ _02808_ sky130_fd_sc_hd__ha_1
X_21268_ u_core.u_top.u_core.acc_upd[211] net879 VSS VSS VDD VDD _02809_ _02810_ sky130_fd_sc_hd__ha_1
X_21269_ _02337_ u_core.u_top.u_core.d_acc[176] VSS VSS VDD VDD _02811_ _02812_ sky130_fd_sc_hd__ha_1
X_21270_ _0066_[0] _02813_ VSS VSS VDD VDD _02814_ _02815_ sky130_fd_sc_hd__ha_1
X_21271_ _02301_ u_core.u_top.u_core.d_acc[162] VSS VSS VDD VDD _02816_ _02817_ sky130_fd_sc_hd__ha_1
X_21272_ u_core.u_top.u_core.d_acc[25] _02305_ VSS VSS VDD VDD _02818_ _02819_ sky130_fd_sc_hd__ha_1
X_21273_ _0098_[0] _02801_ VSS VSS VDD VDD _02820_ _0098_[1] sky130_fd_sc_hd__ha_1
X_21274_ u_core.u_top.u_core.acc[130] u_core.u_top.u_core.acc[131] VSS VSS VDD VDD _02821_ _11451_ sky130_fd_sc_hd__ha_1
X_21275_ u_core.u_top.u_core.acc_upd[38] _11271_ VSS VSS VDD VDD _02822_ _02823_ sky130_fd_sc_hd__ha_1
X_21276_ _02337_ u_core.u_top.u_core.d_acc[14] VSS VSS VDD VDD _02824_ _02825_ sky130_fd_sc_hd__ha_1
X_21277_ u_core.u_top.u_core.acc_upd[226] net875 VSS VSS VDD VDD _02826_ _02827_ sky130_fd_sc_hd__ha_1
X_21278_ u_core.u_top.u_core.d_acc[87] _02422_ VSS VSS VDD VDD _02828_ _02829_ sky130_fd_sc_hd__ha_1
X_21279_ u_core.u_top.u_core.d_acc[137] _02395_ VSS VSS VDD VDD _02830_ _02831_ sky130_fd_sc_hd__ha_1
X_21280_ u_core.u_top.u_core.d_acc[28] _02305_ VSS VSS VDD VDD _02832_ _02833_ sky130_fd_sc_hd__ha_1
X_21281_ u_core.u_top.u_core.acc_upd[96] net875 VSS VSS VDD VDD _02835_ _02836_ sky130_fd_sc_hd__ha_1
X_21282_ u_core.u_top.u_core.acc_upd[18] net881 VSS VSS VDD VDD _02837_ _02838_ sky130_fd_sc_hd__ha_1
X_21283_ u_core.u_top.u_core.d_acc[122] _02467_ VSS VSS VDD VDD _02839_ _02840_ sky130_fd_sc_hd__ha_1
X_21284_ _02301_ u_core.u_top.u_core.d_acc[2] VSS VSS VDD VDD _02841_ _02842_ sky130_fd_sc_hd__ha_1
X_21285_ _0066_[0] _02813_ VSS VSS VDD VDD _02843_ _0066_[1] sky130_fd_sc_hd__ha_1
X_21286_ u_core.u_top.u_core.acc[100] u_core.u_top.u_core.acc[101] VSS VSS VDD VDD _02844_ _11452_ sky130_fd_sc_hd__ha_1
X_21287_ _0013_[0] _02845_ VSS VSS VDD VDD _02846_ _0014_[1] sky130_fd_sc_hd__ha_1
X_21288_ _0013_[0] _02845_ VSS VSS VDD VDD _02847_ _11453_ sky130_fd_sc_hd__ha_1
X_21289_ u_core.u_top.u_core.acc[50] u_core.u_top.u_core.acc[51] VSS VSS VDD VDD _02848_ _11454_ sky130_fd_sc_hd__ha_1
X_21290_ _0119_[0] _02849_ VSS VSS VDD VDD _02850_ _02851_ sky130_fd_sc_hd__ha_1
X_21291_ u_core.u_top.u_core.acc_upd[112] net880 VSS VSS VDD VDD _02852_ _02853_ sky130_fd_sc_hd__ha_1
X_21292_ u_core.u_top.u_core.d_acc[233] _02356_ VSS VSS VDD VDD _02854_ _02855_ sky130_fd_sc_hd__ha_1
X_21293_ u_core.u_top.u_core.acc_upd[148] net881 VSS VSS VDD VDD _02856_ _02857_ sky130_fd_sc_hd__ha_1
X_21294_ u_core.u_top.u_core.acc_upd[5] net877 VSS VSS VDD VDD _02858_ _02859_ sky130_fd_sc_hd__ha_1
X_21295_ _0912_[0] _02689_ VSS VSS VDD VDD _02860_ _0912_[1] sky130_fd_sc_hd__ha_1
X_21296_ u_core.u_top.u_core.acc[0] u_core.u_top.u_core.acc[1] VSS VSS VDD VDD _02861_ _11455_ sky130_fd_sc_hd__ha_1
X_21297_ _02337_ u_core.u_top.u_core.d_acc[16] VSS VSS VDD VDD _02862_ _02863_ sky130_fd_sc_hd__ha_1
X_21298_ u_core.u_top.u_core.d_acc[45] _02411_ VSS VSS VDD VDD _02864_ _02865_ sky130_fd_sc_hd__ha_1
X_21299_ u_core.u_top.u_core.acc_upd[105] _02515_ VSS VSS VDD VDD _02866_ _02867_ sky130_fd_sc_hd__ha_1
X_21300_ u_core.u_top.u_core.d_acc[44] _02411_ VSS VSS VDD VDD _02868_ _02869_ sky130_fd_sc_hd__ha_1
X_21301_ u_core.u_top.u_core.acc_upd[196] net875 VSS VSS VDD VDD _02870_ _02871_ sky130_fd_sc_hd__ha_1
X_21302_ u_core.u_top.u_core.d_acc[43] _02411_ VSS VSS VDD VDD _02872_ _02873_ sky130_fd_sc_hd__ha_1
X_21303_ _0725_[3] _03026_ VSS VSS VDD VDD _02874_ _0725_[4] sky130_fd_sc_hd__ha_1
X_21304_ net992 u_core.u_top.u_core.m72_t[4] VSS VSS VDD VDD _02875_ _11456_ sky130_fd_sc_hd__ha_1
X_21305_ u_core.u_top.u_core.acc_upd[28] net882 VSS VSS VDD VDD _02876_ _02877_ sky130_fd_sc_hd__ha_1
X_21306_ _0032_[0] _02878_ VSS VSS VDD VDD _02879_ _02880_ sky130_fd_sc_hd__ha_1
X_21307_ u_core.u_top.u_core.d_acc[35] _02407_ VSS VSS VDD VDD _02881_ _02882_ sky130_fd_sc_hd__ha_1
X_21308_ u_core.u_top.u_core.acc_upd[238] net882 VSS VSS VDD VDD _02883_ _02884_ sky130_fd_sc_hd__ha_1
X_21309_ u_core.u_top.u_core.acc_upd[42] _02485_ VSS VSS VDD VDD _02885_ _02886_ sky130_fd_sc_hd__ha_1
X_21310_ u_core.u_top.u_core.d_acc[204] _02411_ VSS VSS VDD VDD _02887_ _02888_ sky130_fd_sc_hd__ha_1
X_21311_ _0130_[0] _02890_ VSS VSS VDD VDD _02891_ _02892_ sky130_fd_sc_hd__ha_1
X_21312_ u_core.u_top.u_core.d_acc[105] _02367_ VSS VSS VDD VDD _02893_ _02894_ sky130_fd_sc_hd__ha_1
X_21313_ u_core.u_top.u_core.acc_upd[2] net880 VSS VSS VDD VDD _02896_ _02897_ sky130_fd_sc_hd__ha_1
X_21314_ _0032_[0] _02878_ VSS VSS VDD VDD _02898_ _0032_[1] sky130_fd_sc_hd__ha_1
X_21315_ u_core.u_top.u_core.acc[70] u_core.u_top.u_core.acc[71] VSS VSS VDD VDD _02899_ _11457_ sky130_fd_sc_hd__ha_1
X_21316_ u_core.u_top.u_core.r_cnt[0] u_core.u_top.u_core.r_cnt[1] VSS VSS VDD VDD _02900_ _0373_[1] sky130_fd_sc_hd__ha_1
X_21317_ u_core.u_top.u_core.r_cnt[0] u_core.u_top.u_core.r_cnt[1] VSS VSS VDD VDD _02901_ _11458_ sky130_fd_sc_hd__ha_1
X_21318_ _02902_ net957 VSS VSS VDD VDD _02482_ _02903_ sky130_fd_sc_hd__ha_1
X_21319_ u_core.u_top.u_core.acc_upd[23] net894 VSS VSS VDD VDD _02904_ _02905_ sky130_fd_sc_hd__ha_1
X_21320_ u_core.u_top.u_core.acc_upd[231] net879 VSS VSS VDD VDD _02906_ _02570_ sky130_fd_sc_hd__ha_1
X_21321_ u_core.u_top.u_core.acc_upd[17] net881 VSS VSS VDD VDD _02907_ _02908_ sky130_fd_sc_hd__ha_1
X_21322_ u_core.u_top.u_core.acc_upd[194] net876 VSS VSS VDD VDD _02909_ _02910_ sky130_fd_sc_hd__ha_1
X_21323_ _0109_[0] _02913_ VSS VSS VDD VDD _02914_ _0109_[1] sky130_fd_sc_hd__ha_1
X_21324_ _0109_[0] _02913_ VSS VSS VDD VDD _02915_ _11459_ sky130_fd_sc_hd__ha_1
X_21325_ u_core.u_top.u_core.acc[140] u_core.u_top.u_core.acc[141] VSS VSS VDD VDD _02916_ _11460_ sky130_fd_sc_hd__ha_1
X_21326_ u_core.u_top.u_core.acc_upd[24] net876 VSS VSS VDD VDD _02917_ _02918_ sky130_fd_sc_hd__ha_1
X_21327_ u_core.u_top.u_core.acc_upd[44] _02490_ VSS VSS VDD VDD _02919_ _02920_ sky130_fd_sc_hd__ha_1
X_21328_ u_core.u_top.u_core.acc_upd[118] _11271_ VSS VSS VDD VDD _02921_ _02922_ sky130_fd_sc_hd__ha_1
X_21329_ _0077_[0] _02923_ VSS VSS VDD VDD _02924_ _02925_ sky130_fd_sc_hd__ha_1
X_21330_ _0699_[0] _02926_ VSS VSS VDD VDD _02927_ _02928_ sky130_fd_sc_hd__ha_1
X_21331_ u_core.u_top.u_core.acc_upd[156] net875 VSS VSS VDD VDD _02929_ _02930_ sky130_fd_sc_hd__ha_1
X_21332_ _02337_ u_core.u_top.u_core.d_acc[171] VSS VSS VDD VDD _02931_ _02651_ sky130_fd_sc_hd__ha_1
X_21333_ u_core.u_top.u_core.acc_upd[43] _02495_ VSS VSS VDD VDD _02932_ _02933_ sky130_fd_sc_hd__ha_1
X_21334_ u_core.u_top.u_core.acc_upd[157] net881 VSS VSS VDD VDD _02934_ _02935_ sky130_fd_sc_hd__ha_1
X_21335_ u_core.u_top.u_core.d_acc[92] _02403_ VSS VSS VDD VDD _02936_ _02937_ sky130_fd_sc_hd__ha_1
X_21336_ u_core.u_top.u_core.acc_upd[212] _02485_ VSS VSS VDD VDD _02938_ _02939_ sky130_fd_sc_hd__ha_1
X_21337_ u_core.u_top.u_core.d_acc[91] _02403_ VSS VSS VDD VDD _02940_ _02941_ sky130_fd_sc_hd__ha_1
X_21338_ u_core.u_top.u_core.d_acc[71] _02356_ VSS VSS VDD VDD _02943_ _02889_ sky130_fd_sc_hd__ha_1
X_21339_ u_core.u_top.u_core.d_acc[76] _02356_ VSS VSS VDD VDD _02944_ _02945_ sky130_fd_sc_hd__ha_1
X_21340_ u_core.u_top.u_core.acc_upd[164] net876 VSS VSS VDD VDD _02946_ _02947_ sky130_fd_sc_hd__ha_1
X_21341_ u_core.u_top.u_core.acc_upd[206] net875 VSS VSS VDD VDD _02948_ _02949_ sky130_fd_sc_hd__ha_1
X_21342_ u_core.u_top.u_core.d_acc[203] _02411_ VSS VSS VDD VDD _02950_ _02951_ sky130_fd_sc_hd__ha_1
X_21343_ u_core.u_top.u_core.d_acc[106] _02367_ VSS VSS VDD VDD _02952_ _02953_ sky130_fd_sc_hd__ha_1
X_21344_ u_core.u_top.u_core.acc_upd[197] net882 VSS VSS VDD VDD _02954_ _02955_ sky130_fd_sc_hd__ha_1
X_21345_ _0119_[0] _02849_ VSS VSS VDD VDD _02956_ _0119_[1] sky130_fd_sc_hd__ha_1
X_21346_ u_core.u_top.u_core.acc[150] u_core.u_top.u_core.acc[151] VSS VSS VDD VDD _02957_ _11461_ sky130_fd_sc_hd__ha_1
X_21347_ u_core.u_top.u_core.acc_upd[4] net876 VSS VSS VDD VDD _02958_ _02959_ sky130_fd_sc_hd__ha_1
X_21348_ u_core.u_top.u_core.acc_upd[146] net875 VSS VSS VDD VDD _02960_ _02961_ sky130_fd_sc_hd__ha_1
X_21349_ u_core.u_top.u_core.acc_upd[168] net882 VSS VSS VDD VDD _02962_ _02963_ sky130_fd_sc_hd__ha_1
X_21350_ u_core.u_top.u_core.acc_upd[175] net877 VSS VSS VDD VDD _02964_ _02965_ sky130_fd_sc_hd__ha_1
X_21351_ u_core.u_top.u_core.d_acc[187] _02305_ VSS VSS VDD VDD _02966_ _02967_ sky130_fd_sc_hd__ha_1
X_21352_ _02969_ _0932_[0] VSS VSS VDD VDD _02970_ _02971_ sky130_fd_sc_hd__ha_1
X_21353_ u_core.u_top.u_core.d_acc[111] _02371_ VSS VSS VDD VDD _02972_ _02912_ sky130_fd_sc_hd__ha_1
X_21354_ _0077_[0] _02923_ VSS VSS VDD VDD _02973_ _0077_[1] sky130_fd_sc_hd__ha_1
X_21355_ u_core.u_top.u_core.acc[110] u_core.u_top.u_core.acc[111] VSS VSS VDD VDD _02974_ _11462_ sky130_fd_sc_hd__ha_1
X_21356_ u_core.u_top.u_core.acc_upd[101] _02310_ VSS VSS VDD VDD _02975_ _02573_ sky130_fd_sc_hd__ha_1
X_21357_ u_core.u_top.u_core.acc_upd[12] net880 VSS VSS VDD VDD _02976_ _02977_ sky130_fd_sc_hd__ha_1
X_21358_ u_core.u_top.u_core.acc_upd[177] net882 VSS VSS VDD VDD _02978_ _02979_ sky130_fd_sc_hd__ha_1
X_21359_ u_core.u_top.u_core.acc_upd[104] net876 VSS VSS VDD VDD _02980_ _02981_ sky130_fd_sc_hd__ha_1
X_21360_ u_core.u_top.u_core.d_acc[107] _02367_ VSS VSS VDD VDD _02982_ _02983_ sky130_fd_sc_hd__ha_1
X_21361_ _02301_ u_core.u_top.u_core.d_acc[163] VSS VSS VDD VDD _02984_ _02985_ sky130_fd_sc_hd__ha_1
X_21362_ u_core.u_top.u_core.acc_upd[7] net882 VSS VSS VDD VDD _02986_ _02987_ sky130_fd_sc_hd__ha_1
X_21363_ u_core.u_top.u_core.acc_upd[13] net894 VSS VSS VDD VDD _02988_ _02989_ sky130_fd_sc_hd__ha_1
X_21364_ u_core.u_top.u_core.d_acc[48] _02411_ VSS VSS VDD VDD _02990_ _02991_ sky130_fd_sc_hd__ha_1
X_21365_ u_core.u_top.u_core.acc_upd[27] net882 VSS VSS VDD VDD _02992_ _02993_ sky130_fd_sc_hd__ha_1
X_21366_ _0088_[0] _02606_ VSS VSS VDD VDD _02994_ _0088_[1] sky130_fd_sc_hd__ha_1
X_21367_ u_core.u_top.u_core.acc[120] u_core.u_top.u_core.acc[121] VSS VSS VDD VDD _02995_ _11463_ sky130_fd_sc_hd__ha_1
X_21368_ u_core.u_top.u_core.acc_upd[32] net880 VSS VSS VDD VDD _02996_ _02997_ sky130_fd_sc_hd__ha_1
X_21369_ u_core.u_top.u_core.d_acc[62] _02363_ VSS VSS VDD VDD _02998_ _02999_ sky130_fd_sc_hd__ha_1
X_21370_ _03000_ net957 VSS VSS VDD VDD _02461_ _03001_ sky130_fd_sc_hd__ha_1
X_21371_ u_core.u_top.u_core.acc_upd[25] net877 VSS VSS VDD VDD _03002_ _03003_ sky130_fd_sc_hd__ha_1
X_21372_ _0141_[0] _03005_ VSS VSS VDD VDD _03006_ _0141_[1] sky130_fd_sc_hd__ha_1
X_21373_ _0141_[0] _03005_ VSS VSS VDD VDD _03007_ _11464_ sky130_fd_sc_hd__ha_1
X_21374_ u_core.u_top.u_core.acc[170] u_core.u_top.u_core.acc[171] VSS VSS VDD VDD _03008_ _11465_ sky130_fd_sc_hd__ha_1
X_21375_ _03009_ u_core.u_top.u_core.r_off[0] VSS VSS VDD VDD _02435_ _03010_ sky130_fd_sc_hd__ha_1
X_21376_ u_core.u_top.u_core.d_acc[104] _02367_ VSS VSS VDD VDD _03011_ _03012_ sky130_fd_sc_hd__ha_1
X_21377_ u_core.u_top.u_core.d_acc[184] _02305_ VSS VSS VDD VDD _03013_ _03014_ sky130_fd_sc_hd__ha_1
X_21378_ u_core.u_top.u_core.acc_upd[3] net894 VSS VSS VDD VDD _03015_ _03016_ sky130_fd_sc_hd__ha_1
X_21379_ _02301_ u_core.u_top.u_core.d_acc[164] VSS VSS VDD VDD _03017_ _03018_ sky130_fd_sc_hd__ha_1
X_21380_ _02337_ u_core.u_top.u_core.d_acc[18] VSS VSS VDD VDD _03019_ _03020_ sky130_fd_sc_hd__ha_1
X_21381_ u_core.u_top.u_core.d_acc[77] _02356_ VSS VSS VDD VDD _03021_ _03022_ sky130_fd_sc_hd__ha_1
X_21382_ _0969_[1070] _03023_ VSS VSS VDD VDD _03024_ _0391_[1] sky130_fd_sc_hd__ha_1
X_21383_ net988 u_core.u_top.u_core.lfsr_m72[3] VSS VSS VDD VDD _03025_ _03026_ sky130_fd_sc_hd__ha_1
X_21384_ u_core.u_top.u_core.acc_upd[154] _02490_ VSS VSS VDD VDD _03027_ _03028_ sky130_fd_sc_hd__ha_1
X_21385_ u_core.u_top.u_core.d_acc[145] _02445_ VSS VSS VDD VDD _03029_ _03030_ sky130_fd_sc_hd__ha_1
X_21386_ u_core.u_top.u_core.acc_upd[53] net894 VSS VSS VDD VDD _03031_ _03032_ sky130_fd_sc_hd__ha_1
X_21387_ u_core.u_top.u_core.d_acc[143] _02445_ VSS VSS VDD VDD _03033_ _03034_ sky130_fd_sc_hd__ha_1
X_21388_ _02337_ u_core.u_top.u_core.d_acc[174] VSS VSS VDD VDD _03035_ _03036_ sky130_fd_sc_hd__ha_1
X_21389_ _03037_ u_core.u_top.u_core.r_off[0] VSS VSS VDD VDD _02469_ _03038_ sky130_fd_sc_hd__ha_1
X_21390_ u_core.u_top.u_core.acc_upd[84] net876 VSS VSS VDD VDD _03039_ _03040_ sky130_fd_sc_hd__ha_1
X_21391_ _0926_[0] _03041_ VSS VSS VDD VDD _03042_ _0926_[1] sky130_fd_sc_hd__ha_1
X_21392_ _0926_[0] _03041_ VSS VSS VDD VDD _03043_ _11466_ sky130_fd_sc_hd__ha_1
X_21393_ u_core.u_top.u_core.acc[20] u_core.u_top.u_core.acc[21] VSS VSS VDD VDD _03044_ _11467_ sky130_fd_sc_hd__ha_1
X_21394_ u_core.u_top.u_core.acc_upd[233] net894 VSS VSS VDD VDD _03046_ _03047_ sky130_fd_sc_hd__ha_1
X_21395_ u_core.u_top.u_core.acc_upd[93] net894 VSS VSS VDD VDD _03048_ _03049_ sky130_fd_sc_hd__ha_1
X_21396_ u_core.u_top.u_core.acc_upd[33] net894 VSS VSS VDD VDD _03050_ _03051_ sky130_fd_sc_hd__ha_1
X_21397_ u_core.u_top.u_core.acc_upd[155] _02515_ VSS VSS VDD VDD _03052_ _03053_ sky130_fd_sc_hd__ha_1
X_21398_ net41 net42 VSS VSS VDD VDD _03054_ _0684_[1] sky130_fd_sc_hd__ha_1
X_21399_ u_core.u_top.u_core.d_acc[202] _02411_ VSS VSS VDD VDD _03055_ _03056_ sky130_fd_sc_hd__ha_1
X_21400_ u_core.u_top.u_core.d_acc[191] _02407_ VSS VSS VDD VDD _03057_ _03058_ sky130_fd_sc_hd__ha_1
X_21401_ u_core.u_top.u_core.acc_upd[72] _02485_ VSS VSS VDD VDD _03059_ _03060_ sky130_fd_sc_hd__ha_1
X_21402_ u_core.u_top.u_core.acc_upd[73] net894 VSS VSS VDD VDD _03061_ _03062_ sky130_fd_sc_hd__ha_1
X_21403_ u_core.u_top.u_core.d_acc[157] net988 VSS VSS VDD VDD _03063_ _03064_ sky130_fd_sc_hd__ha_1
X_21404_ net37 net38 VSS VSS VDD VDD _0694_[3] _0694_[2] sky130_fd_sc_hd__ha_1
X_21405_ u_core.u_top.u_core.d_acc[73] _02356_ VSS VSS VDD VDD _03065_ _03066_ sky130_fd_sc_hd__ha_1
X_21406_ u_core.u_top.u_core.d_acc[224] _02363_ VSS VSS VDD VDD _03067_ _03068_ sky130_fd_sc_hd__ha_1
X_21407_ u_core.u_top.u_core.acc_upd[97] net881 VSS VSS VDD VDD _03070_ _03071_ sky130_fd_sc_hd__ha_1
X_21408_ _0892_[0] _03072_ VSS VSS VDD VDD _03073_ _0892_[1] sky130_fd_sc_hd__ha_1
X_21409_ _0003_[0] _0003_[1] VSS VSS VDD VDD _03074_ _11468_ sky130_fd_sc_hd__ha_1
X_21410_ u_core.u_top.u_core.acc_upd[142] _02485_ VSS VSS VDD VDD _03075_ _03076_ sky130_fd_sc_hd__ha_1
X_21411_ u_core.u_top.u_core.d_acc[125] _02467_ VSS VSS VDD VDD _03077_ _03078_ sky130_fd_sc_hd__ha_1
X_21412_ _0717_[0] _03079_ VSS VSS VDD VDD _03080_ _0717_[1] sky130_fd_sc_hd__ha_1
X_21413_ _0717_[0] u_core.u_top.u_spi.bitcnt[1] VSS VSS VDD VDD _03081_ _11469_ sky130_fd_sc_hd__ha_1
X_21414_ u_core.u_top.u_spi.bitcnt[0] _03079_ VSS VSS VDD VDD _03082_ _11470_ sky130_fd_sc_hd__ha_1
X_21415_ u_core.u_top.u_spi.bitcnt[0] u_core.u_top.u_spi.bitcnt[1] VSS VSS VDD VDD _03083_ _11471_ sky130_fd_sc_hd__ha_1
X_21416_ u_core.u_top.u_spi.bitcnt[0] u_core.u_top.u_spi.bitcnt[1] VSS VSS VDD VDD _03084_ _11472_ sky130_fd_sc_hd__ha_1
X_21417_ u_core.u_top.u_core.acc_upd[115] net877 VSS VSS VDD VDD _03085_ _03086_ sky130_fd_sc_hd__ha_1
X_21418_ u_core.u_top.u_core.acc_upd[125] _02515_ VSS VSS VDD VDD _03087_ _03088_ sky130_fd_sc_hd__ha_1
X_21419_ u_core.u_top.u_core.d_acc[31] _02407_ VSS VSS VDD VDD _03089_ _03045_ sky130_fd_sc_hd__ha_1
X_21420_ u_core.u_top.u_core.d_acc[154] net988 VSS VSS VDD VDD _03090_ _03091_ sky130_fd_sc_hd__ha_1
X_21421_ _0130_[0] _02890_ VSS VSS VDD VDD _03092_ _0130_[1] sky130_fd_sc_hd__ha_1
X_21422_ u_core.u_top.u_core.acc[160] u_core.u_top.u_core.acc[161] VSS VSS VDD VDD _03093_ _11473_ sky130_fd_sc_hd__ha_1
X_21423_ u_core.u_top.u_core.d_acc[182] _02305_ VSS VSS VDD VDD _03094_ _03095_ sky130_fd_sc_hd__ha_1
X_21424_ _03097_ net957 VSS VSS VDD VDD _02439_ _03098_ sky130_fd_sc_hd__ha_1
X_21425_ u_core.u_top.u_core.acc_upd[124] net876 VSS VSS VDD VDD _03099_ _03100_ sky130_fd_sc_hd__ha_1
X_21426_ u_core.u_top.u_core.d_acc[136] _02395_ VSS VSS VDD VDD _03101_ _03102_ sky130_fd_sc_hd__ha_1
X_21427_ u_core.u_top.u_core.d_acc[138] _02395_ VSS VSS VDD VDD _03103_ _03104_ sky130_fd_sc_hd__ha_1
X_21428_ u_core.u_top.u_core.d_acc[113] _02371_ VSS VSS VDD VDD _03105_ _03106_ sky130_fd_sc_hd__ha_1
X_21429_ u_core.u_top.u_core.d_acc[55] _02399_ VSS VSS VDD VDD _03107_ _03108_ sky130_fd_sc_hd__ha_1
X_21430_ net872 _05194_ VSS VSS VDD VDD _03110_ _03111_ sky130_fd_sc_hd__ha_1
X_21431_ u_core.u_top.u_core.d_acc[38] _02407_ VSS VSS VDD VDD _03112_ _03113_ sky130_fd_sc_hd__ha_1
X_21432_ u_core.u_top.u_core.acc_upd[45] _02515_ VSS VSS VDD VDD _03114_ _03115_ sky130_fd_sc_hd__ha_1
X_21433_ u_core.u_top.u_core.acc_upd[94] net876 VSS VSS VDD VDD _03116_ _03117_ sky130_fd_sc_hd__ha_1
X_21434_ u_core.u_top.u_core.d_acc[86] _02422_ VSS VSS VDD VDD _03118_ _03119_ sky130_fd_sc_hd__ha_1
X_21435_ u_core.u_top.u_core.acc_upd[235] net877 VSS VSS VDD VDD _03120_ _03121_ sky130_fd_sc_hd__ha_1
X_21436_ u_core.u_top.u_core.acc_upd[236] net875 VSS VSS VDD VDD _03122_ _03123_ sky130_fd_sc_hd__ha_1
X_21437_ _03124_ u_core.u_top.u_core.r_off[0] VSS VSS VDD VDD _02316_ _03125_ sky130_fd_sc_hd__ha_1
X_21438_ _0044_[0] _03126_ VSS VSS VDD VDD _03127_ _0044_[1] sky130_fd_sc_hd__ha_1
X_21439_ _0044_[0] _03126_ VSS VSS VDD VDD _03128_ _11474_ sky130_fd_sc_hd__ha_1
X_21440_ u_core.u_top.u_core.acc[80] u_core.u_top.u_core.acc[81] VSS VSS VDD VDD _03129_ _11475_ sky130_fd_sc_hd__ha_1
X_21441_ u_core.u_top.u_core.d_acc[82] _02422_ VSS VSS VDD VDD _03130_ _03131_ sky130_fd_sc_hd__ha_1
X_21442_ u_core.u_top.u_core.acc_upd[74] net876 VSS VSS VDD VDD _03132_ _03133_ sky130_fd_sc_hd__ha_1
X_21443_ u_core.u_top.u_core.acc_upd[77] net882 VSS VSS VDD VDD _03134_ _03135_ sky130_fd_sc_hd__ha_1
X_21444_ u_core.u_top.u_core.d_acc[151] _02391_ VSS VSS VDD VDD _03136_ _03004_ sky130_fd_sc_hd__ha_1
X_21445_ u_core.u_top.u_core.d_acc[152] _02391_ VSS VSS VDD VDD _03137_ _03138_ sky130_fd_sc_hd__ha_1
X_21446_ u_core.u_top.u_core.acc_upd[1] net879 VSS VSS VDD VDD _03139_ _03140_ sky130_fd_sc_hd__ha_1
X_21447_ u_core.u_top.u_core.acc_upd[75] net877 VSS VSS VDD VDD _03141_ _03142_ sky130_fd_sc_hd__ha_1
X_21448_ u_core.u_top.u_core.acc_upd[136] net875 VSS VSS VDD VDD _03143_ _03144_ sky130_fd_sc_hd__ha_1
X_21449_ u_core.u_top.u_core.d_acc[153] _02391_ VSS VSS VDD VDD _03145_ _03146_ sky130_fd_sc_hd__ha_1
X_21450_ _02301_ u_core.u_top.u_core.d_acc[168] VSS VSS VDD VDD _03147_ _03148_ sky130_fd_sc_hd__ha_1
X_21451_ u_core.u_top.u_core.d_acc[186] _02305_ VSS VSS VDD VDD _03149_ _03150_ sky130_fd_sc_hd__ha_1
X_21452_ u_core.u_top.u_core.d_acc[57] _02399_ VSS VSS VDD VDD _03151_ _03152_ sky130_fd_sc_hd__ha_1
X_21453_ _0021_[0] _02707_ VSS VSS VDD VDD _03153_ _0021_[1] sky130_fd_sc_hd__ha_1
X_21454_ u_core.u_top.u_core.acc[60] u_core.u_top.u_core.acc[61] VSS VSS VDD VDD _03154_ _11476_ sky130_fd_sc_hd__ha_1
X_21455_ _02301_ u_core.u_top.u_core.d_acc[161] VSS VSS VDD VDD _03155_ _02502_ sky130_fd_sc_hd__ha_1
X_21456_ u_core.u_top.u_core.d_acc[67] _02363_ VSS VSS VDD VDD _03156_ _03157_ sky130_fd_sc_hd__ha_1
X_21457_ _02337_ u_core.u_top.u_core.d_acc[17] VSS VSS VDD VDD _03158_ _03159_ sky130_fd_sc_hd__ha_1
X_21458_ _03160_ net957 VSS VSS VDD VDD _02346_ _03161_ sky130_fd_sc_hd__ha_1
X_21459_ u_core.u_top.u_core.d_acc[183] _02305_ VSS VSS VDD VDD _03162_ _03163_ sky130_fd_sc_hd__ha_1
X_21460_ u_core.u_top.u_core.acc_upd[117] _11271_ VSS VSS VDD VDD _03164_ _03165_ sky130_fd_sc_hd__ha_1
X_21461_ u_core.u_top.u_core.d_acc[212] _02399_ VSS VSS VDD VDD _03166_ _03167_ sky130_fd_sc_hd__ha_1
X_21462_ u_core.u_top.u_core.d_acc[205] _02411_ VSS VSS VDD VDD _03168_ _03169_ sky130_fd_sc_hd__ha_1
X_21463_ u_core.u_top.u_core.d_acc[198] _02407_ VSS VSS VDD VDD _03170_ _03171_ sky130_fd_sc_hd__ha_1
X_21464_ u_core.u_top.u_core.d_acc[195] _02407_ VSS VSS VDD VDD _03172_ _03173_ sky130_fd_sc_hd__ha_1
X_21465_ u_core.u_top.u_core.d_acc[197] _02407_ VSS VSS VDD VDD _03174_ _03175_ sky130_fd_sc_hd__ha_1
X_21466_ u_core.u_top.u_core.d_acc[188] _02305_ VSS VSS VDD VDD _03176_ _03177_ sky130_fd_sc_hd__ha_1
X_21467_ _02301_ u_core.u_top.u_core.d_acc[167] VSS VSS VDD VDD _03178_ _03179_ sky130_fd_sc_hd__ha_1
X_21468_ u_core.u_top.u_core.d_acc[54] _02399_ VSS VSS VDD VDD _03180_ _03181_ sky130_fd_sc_hd__ha_1
X_21469_ u_core.u_top.u_core.d_acc[36] _02407_ VSS VSS VDD VDD _03182_ _03183_ sky130_fd_sc_hd__ha_1
X_21470_ u_core.u_top.u_core.acc_upd[51] net879 VSS VSS VDD VDD _03184_ _02834_ sky130_fd_sc_hd__ha_1
X_21471_ u_core.u_top.u_core.acc_upd[86] net875 VSS VSS VDD VDD _03185_ _03186_ sky130_fd_sc_hd__ha_1
X_21472_ u_core.u_top.u_core.acc_upd[37] net882 VSS VSS VDD VDD _03187_ _03188_ sky130_fd_sc_hd__ha_1
X_21473_ u_core.u_top.u_core.d_acc[221] _02363_ VSS VSS VDD VDD _03189_ _03190_ sky130_fd_sc_hd__ha_1
X_21474_ u_core.u_top.u_core.d_acc[235] _02356_ VSS VSS VDD VDD _03191_ _03192_ sky130_fd_sc_hd__ha_1
X_21475_ _02337_ u_core.u_top.u_core.d_acc[178] VSS VSS VDD VDD _03193_ _03194_ sky130_fd_sc_hd__ha_1
X_21476_ u_core.u_top.u_core.d_acc[144] _02445_ VSS VSS VDD VDD _03195_ _03196_ sky130_fd_sc_hd__ha_1
X_21477_ u_core.u_top.u_core.acc_upd[68] net881 VSS VSS VDD VDD _03197_ _03198_ sky130_fd_sc_hd__ha_1
X_21478_ u_core.u_top.u_core.acc_upd[135] _02515_ VSS VSS VDD VDD _03200_ _03201_ sky130_fd_sc_hd__ha_1
X_21479_ u_core.u_top.u_core.acc_upd[123] _02495_ VSS VSS VDD VDD _03202_ _03203_ sky130_fd_sc_hd__ha_1
X_21480_ u_core.u_top.u_core.d_acc[196] _02407_ VSS VSS VDD VDD _03204_ _03205_ sky130_fd_sc_hd__ha_1
X_21481_ _03206_ net957 VSS VSS VDD VDD _02447_ _03207_ sky130_fd_sc_hd__ha_1
X_21482_ u_core.u_top.u_core.acc_upd[36] net875 VSS VSS VDD VDD _03208_ _03209_ sky130_fd_sc_hd__ha_1
X_21483_ _0687_[0] _03210_ VSS VSS VDD VDD _03211_ _03212_ sky130_fd_sc_hd__ha_1
X_21484_ u_core.u_top.u_core.acc_upd[163] net894 VSS VSS VDD VDD _03213_ _03214_ sky130_fd_sc_hd__ha_1
X_21485_ _02337_ u_core.u_top.u_core.d_acc[175] VSS VSS VDD VDD _03215_ _03216_ sky130_fd_sc_hd__ha_1
X_21486_ u_core.u_top.u_core.acc_upd[98] net881 VSS VSS VDD VDD _03217_ _03218_ sky130_fd_sc_hd__ha_1
X_21487_ u_core.u_top.u_core.acc_upd[95] net877 VSS VSS VDD VDD _03219_ _03220_ sky130_fd_sc_hd__ha_1
X_21488_ u_core.u_top.u_core.d_acc[208] _02411_ VSS VSS VDD VDD _03221_ _03222_ sky130_fd_sc_hd__ha_1
X_21489_ u_core.u_top.u_core.d_acc[115] _02371_ VSS VSS VDD VDD _03223_ _03224_ sky130_fd_sc_hd__ha_1
X_21490_ u_core.u_top.u_core.d_acc[112] _02371_ VSS VSS VDD VDD _03225_ _03226_ sky130_fd_sc_hd__ha_1
X_21491_ u_core.u_top.u_core.d_acc[114] _02371_ VSS VSS VDD VDD _03227_ _03228_ sky130_fd_sc_hd__ha_1
X_21492_ u_core.u_top.u_core.d_acc[148] _02445_ VSS VSS VDD VDD _03229_ _03230_ sky130_fd_sc_hd__ha_1
X_21493_ u_core.u_top.u_core.d_acc[201] _02411_ VSS VSS VDD VDD _03232_ _03096_ sky130_fd_sc_hd__ha_1
X_21494_ u_core.u_top.u_core.d_acc[226] _02363_ VSS VSS VDD VDD _03233_ _03234_ sky130_fd_sc_hd__ha_1
X_21495_ u_core.u_top.u_core.acc_upd[26] net875 VSS VSS VDD VDD _03235_ _03236_ sky130_fd_sc_hd__ha_1
X_21496_ u_core.u_top.u_core.d_acc[217] _02399_ VSS VSS VDD VDD _03237_ _03238_ sky130_fd_sc_hd__ha_1
X_21497_ u_core.u_top.u_core.d_acc[21] _02305_ VSS VSS VDD VDD _03239_ _02562_ sky130_fd_sc_hd__ha_1
X_21498_ u_core.u_top.u_core.d_acc[26] _02305_ VSS VSS VDD VDD _03240_ _03241_ sky130_fd_sc_hd__ha_1
X_21499_ u_core.u_top.u_core.d_acc[141] _02445_ VSS VSS VDD VDD _03242_ _03231_ sky130_fd_sc_hd__ha_1
X_21500_ u_core.u_top.u_core.d_acc[215] _02399_ VSS VSS VDD VDD _03243_ _03244_ sky130_fd_sc_hd__ha_1
X_21501_ u_core.u_top.u_core.acc_upd[198] net882 VSS VSS VDD VDD _03245_ _03246_ sky130_fd_sc_hd__ha_1
X_21502_ u_core.u_top.u_core.acc_upd[167] net882 VSS VSS VDD VDD _03247_ _03248_ sky130_fd_sc_hd__ha_1
X_21503_ _03249_ net957 VSS VSS VDD VDD _02331_ _03250_ sky130_fd_sc_hd__ha_1
X_21504_ u_core.u_top.u_core.acc_upd[166] net875 VSS VSS VDD VDD _03251_ _03252_ sky130_fd_sc_hd__ha_1
X_21505_ u_core.u_top.u_core.d_acc[218] _02399_ VSS VSS VDD VDD _03253_ _03254_ sky130_fd_sc_hd__ha_1
X_21506_ u_core.u_top.u_core.acc_upd[131] net879 VSS VSS VDD VDD _03255_ _02604_ sky130_fd_sc_hd__ha_1
X_21507_ u_core.u_top.u_core.d_acc[225] _02363_ VSS VSS VDD VDD _03256_ _03257_ sky130_fd_sc_hd__ha_1
X_21508_ u_core.u_top.u_core.acc_upd[82] net880 VSS VSS VDD VDD _03258_ _03259_ sky130_fd_sc_hd__ha_1
X_21509_ u_core.u_top.u_core.d_acc[121] _02467_ VSS VSS VDD VDD _03260_ _03261_ sky130_fd_sc_hd__ha_1
X_21510_ u_core.u_top.u_core.acc_upd[81] _02310_ VSS VSS VDD VDD _03262_ _03199_ sky130_fd_sc_hd__ha_1
X_21511_ u_core.u_top.u_core.acc_upd[88] _11271_ VSS VSS VDD VDD _03263_ _03264_ sky130_fd_sc_hd__ha_1
X_21512_ u_core.u_top.u_core.acc_upd[41] net879 VSS VSS VDD VDD _03265_ _03266_ sky130_fd_sc_hd__ha_1
X_21513_ _03267_ net957 VSS VSS VDD VDD _02373_ _03268_ sky130_fd_sc_hd__ha_1
X_21514_ u_core.u_top.u_core.d_acc[231] _02356_ VSS VSS VDD VDD _03269_ _03270_ sky130_fd_sc_hd__ha_1
X_21515_ u_core.u_top.u_core.d_acc[237] _02356_ VSS VSS VDD VDD _03271_ _03272_ sky130_fd_sc_hd__ha_1
X_21516_ u_core.u_top.u_core.d_acc[133] _02395_ VSS VSS VDD VDD _03273_ _03274_ sky130_fd_sc_hd__ha_1
X_21517_ u_core.u_top.u_core.d_acc[127] _02467_ VSS VSS VDD VDD _03275_ _03276_ sky130_fd_sc_hd__ha_1
X_21518_ u_core.u_top.u_core.d_acc[124] _02467_ VSS VSS VDD VDD _03277_ _03278_ sky130_fd_sc_hd__ha_1
X_21519_ u_core.u_top.u_core.d_acc[126] _02467_ VSS VSS VDD VDD _03279_ _03280_ sky130_fd_sc_hd__ha_1
X_21520_ _0896_[0] _02628_ VSS VSS VDD VDD _03281_ _0898_[1] sky130_fd_sc_hd__ha_1
X_21521_ _0005_[0] _0005_[1] VSS VSS VDD VDD _03282_ _11477_ sky130_fd_sc_hd__ha_1
X_21522_ _0905_[0] _02586_ VSS VSS VDD VDD _03283_ _0907_[1] sky130_fd_sc_hd__ha_1
X_21523_ _0009_[0] _0009_[1] VSS VSS VDD VDD _03284_ _11478_ sky130_fd_sc_hd__ha_1
X_21524_ _03285_ u_core.u_top.u_core.r_off[0] VSS VSS VDD VDD _02324_ _03286_ sky130_fd_sc_hd__ha_1
X_21525_ u_core.u_top.u_core.acc_upd[182] net880 VSS VSS VDD VDD _03287_ _03288_ sky130_fd_sc_hd__ha_1
X_21526_ u_core.u_top.u_core.acc_upd[48] net881 VSS VSS VDD VDD _03289_ _03290_ sky130_fd_sc_hd__ha_1
X_21527_ _02301_ u_core.u_top.u_core.d_acc[165] VSS VSS VDD VDD _03291_ _03292_ sky130_fd_sc_hd__ha_1
X_21528_ u_core.u_top.u_core.d_acc[193] _02407_ VSS VSS VDD VDD _03293_ _03294_ sky130_fd_sc_hd__ha_1
X_21529_ u_core.u_top.u_core.d_acc[27] _02305_ VSS VSS VDD VDD _03295_ _03296_ sky130_fd_sc_hd__ha_1
X_21530_ u_core.u_top.u_core.d_acc[23] _02305_ VSS VSS VDD VDD _03297_ _03298_ sky130_fd_sc_hd__ha_1
X_21531_ u_core.u_top.u_core.acc_upd[126] net875 VSS VSS VDD VDD _03299_ _03300_ sky130_fd_sc_hd__ha_1
X_21532_ u_core.u_top.u_core.acc_upd[184] net876 VSS VSS VDD VDD _03301_ _03302_ sky130_fd_sc_hd__ha_1
X_21533_ u_core.u_top.u_core.d_acc[128] _02467_ VSS VSS VDD VDD _03303_ _03304_ sky130_fd_sc_hd__ha_1
X_21534_ u_core.u_top.u_core.acc_upd[35] net877 VSS VSS VDD VDD _03305_ _03306_ sky130_fd_sc_hd__ha_1
X_21535_ u_core.u_top.u_core.acc_upd[178] net882 VSS VSS VDD VDD _03307_ _03308_ sky130_fd_sc_hd__ha_1
X_21536_ u_core.u_top.u_core.acc_upd[64] _02490_ VSS VSS VDD VDD _03309_ _03310_ sky130_fd_sc_hd__ha_1
X_21537_ u_core.u_top.u_core.acc_upd[67] net881 VSS VSS VDD VDD _03311_ _03312_ sky130_fd_sc_hd__ha_1
X_21538_ u_core.u_top.u_core.acc_upd[71] net879 VSS VSS VDD VDD _03313_ _02968_ sky130_fd_sc_hd__ha_1
X_21539_ u_core.u_top.u_core.d_acc[83] _02422_ VSS VSS VDD VDD _03314_ _03315_ sky130_fd_sc_hd__ha_1
X_21540_ u_core.u_top.u_core.d_acc[155] net988 VSS VSS VDD VDD _03316_ _03317_ sky130_fd_sc_hd__ha_1
X_21541_ u_core.u_top.u_core.d_acc[34] _02407_ VSS VSS VDD VDD _03318_ _03319_ sky130_fd_sc_hd__ha_1
X_21542_ u_core.u_top.u_core.acc_upd[208] net881 VSS VSS VDD VDD _03320_ _03321_ sky130_fd_sc_hd__ha_1
X_21543_ _0211_[0] _02692_ VSS VSS VDD VDD _03322_ _0211_[1] sky130_fd_sc_hd__ha_1
X_21544_ u_core.u_top.u_core.acc[230] u_core.u_top.u_core.acc[231] VSS VSS VDD VDD _03323_ _11479_ sky130_fd_sc_hd__ha_1
X_21545_ _02301_ u_core.u_top.u_core.d_acc[6] VSS VSS VDD VDD _03324_ _03325_ sky130_fd_sc_hd__ha_1
X_21546_ u_core.u_top.u_core.acc_upd[57] net882 VSS VSS VDD VDD _03326_ _03327_ sky130_fd_sc_hd__ha_1
X_21547_ u_core.u_top.u_core.acc_upd[78] net882 VSS VSS VDD VDD _03328_ _03329_ sky130_fd_sc_hd__ha_1
X_21548_ _03330_ u_core.u_top.u_core.r_off[0] VSS VSS VDD VDD _02381_ _03331_ sky130_fd_sc_hd__ha_1
X_21549_ u_core.u_top.u_core.acc_upd[21] net879 VSS VSS VDD VDD _03332_ _02942_ sky130_fd_sc_hd__ha_1
X_21550_ u_core.u_top.u_core.acc_upd[22] net880 VSS VSS VDD VDD _03333_ _03334_ sky130_fd_sc_hd__ha_1
X_21551_ u_core.u_top.u_core.acc_upd[58] net882 VSS VSS VDD VDD _03335_ _03336_ sky130_fd_sc_hd__ha_1
X_21552_ _03337_ u_core.u_top.u_core.r_off[0] VSS VSS VDD VDD _02312_ _03338_ sky130_fd_sc_hd__ha_1
X_21553_ u_core.u_top.u_core.acc_upd[221] net879 VSS VSS VDD VDD _03339_ _03069_ sky130_fd_sc_hd__ha_1
X_21554_ u_core.u_top.u_core.acc_upd[218] net881 VSS VSS VDD VDD _03340_ _03341_ sky130_fd_sc_hd__ha_1
X_21555_ u_core.u_top.u_core.acc_upd[128] net881 VSS VSS VDD VDD _03342_ _03343_ sky130_fd_sc_hd__ha_1
X_21556_ _0932_[0] _02969_ VSS VSS VDD VDD _03344_ _0932_[1] sky130_fd_sc_hd__ha_1
X_21557_ u_core.u_top.u_core.acc[30] u_core.u_top.u_core.acc[31] VSS VSS VDD VDD _03345_ _11480_ sky130_fd_sc_hd__ha_1
X_21558_ u_core.u_top.u_core.acc_upd[107] net881 VSS VSS VDD VDD _03346_ _03347_ sky130_fd_sc_hd__ha_1
X_21559_ u_core.u_top.u_core.acc_upd[134] _02490_ VSS VSS VDD VDD _03348_ _03349_ sky130_fd_sc_hd__ha_1
X_21560_ u_core.u_top.u_core.d_acc[32] _02407_ VSS VSS VDD VDD _03350_ _03351_ sky130_fd_sc_hd__ha_1
X_21561_ u_core.u_top.u_core.acc_upd[65] _02515_ VSS VSS VDD VDD _03352_ _03353_ sky130_fd_sc_hd__ha_1
X_21562_ u_core.u_top.u_core.acc_upd[108] net881 VSS VSS VDD VDD _03354_ _03355_ sky130_fd_sc_hd__ha_1
X_21563_ _03356_ u_core.u_top.u_core.r_off[0] VSS VSS VDD VDD _02478_ _03357_ sky130_fd_sc_hd__ha_1
X_21564_ u_core.u_top.u_core.acc_upd[103] _02495_ VSS VSS VDD VDD _03358_ _03359_ sky130_fd_sc_hd__ha_1
X_21565_ u_core.u_top.u_core.acc_upd[52] net880 VSS VSS VDD VDD _03360_ _03361_ sky130_fd_sc_hd__ha_1
X_21566_ u_core.u_top.u_core.d_acc[94] _02403_ VSS VSS VDD VDD _03362_ _03363_ sky130_fd_sc_hd__ha_1
X_21567_ u_core.u_top.u_core.x_idx[1] _11481_ VSS VSS VDD VDD _0355_[7] _11482_ sky130_fd_sc_hd__ha_1
X_21568_ u_core.u_top.u_core.d_acc[192] _02407_ VSS VSS VDD VDD _03365_ _03366_ sky130_fd_sc_hd__ha_1
X_21569_ u_core.u_top.u_core.d_acc[74] _02356_ VSS VSS VDD VDD _03367_ _03368_ sky130_fd_sc_hd__ha_1
X_21570_ u_core.u_top.u_core.acc_upd[173] net894 VSS VSS VDD VDD _03369_ _03370_ sky130_fd_sc_hd__ha_1
X_21571_ u_core.u_top.u_core.acc_upd[116] net875 VSS VSS VDD VDD _03371_ _03372_ sky130_fd_sc_hd__ha_1
X_21572_ u_core.u_top.u_core.d_acc[222] _02363_ VSS VSS VDD VDD _03373_ _03374_ sky130_fd_sc_hd__ha_1
X_21573_ u_core.u_top.u_core.d_acc[234] _02356_ VSS VSS VDD VDD _03375_ _03376_ sky130_fd_sc_hd__ha_1
X_21574_ u_core.u_top.u_core.d_acc[223] _02363_ VSS VSS VDD VDD _03377_ _03378_ sky130_fd_sc_hd__ha_1
X_21575_ _0390_ u_core.u_top.u_core.r_piter[0] VSS VSS VDD VDD _03023_ _0391_[0] sky130_fd_sc_hd__ha_1
X_21576_ u_core.u_top.u_core.acc_upd[225] _02515_ VSS VSS VDD VDD _03379_ _03380_ sky130_fd_sc_hd__ha_1
X_21577_ u_core.u_top.u_core.acc_upd[137] net881 VSS VSS VDD VDD _03381_ _03382_ sky130_fd_sc_hd__ha_1
X_21578_ u_core.u_top.u_core.acc_upd[63] _02495_ VSS VSS VDD VDD _03383_ _03384_ sky130_fd_sc_hd__ha_1
X_21579_ u_core.u_top.u_core.d_acc[103] _02367_ VSS VSS VDD VDD _03385_ _03386_ sky130_fd_sc_hd__ha_1
X_21580_ u_core.u_top.u_core.acc_upd[106] net875 VSS VSS VDD VDD _03387_ _03388_ sky130_fd_sc_hd__ha_1
X_21581_ u_core.u_top.u_core.d_acc[116] _02371_ VSS VSS VDD VDD _03389_ _03390_ sky130_fd_sc_hd__ha_1
X_21582_ u_core.u_top.u_core.d_acc[78] _02356_ VSS VSS VDD VDD _03391_ _03392_ sky130_fd_sc_hd__ha_1
X_21583_ u_core.u_top.u_core.d_acc[75] _02356_ VSS VSS VDD VDD _03393_ _03394_ sky130_fd_sc_hd__ha_1
X_21584_ u_core.u_top.u_core.acc_upd[216] net875 VSS VSS VDD VDD _03395_ _03396_ sky130_fd_sc_hd__ha_1
X_21585_ u_core.u_top.u_core.acc_upd[213] _02495_ VSS VSS VDD VDD _03397_ _03398_ sky130_fd_sc_hd__ha_1
X_21586_ u_core.u_top.u_core.acc_upd[215] _02515_ VSS VSS VDD VDD _03399_ _03400_ sky130_fd_sc_hd__ha_1
X_21587_ u_core.u_top.u_core.acc_upd[224] _02490_ VSS VSS VDD VDD _03401_ _03402_ sky130_fd_sc_hd__ha_1
X_21588_ u_core.u_top.u_core.acc_upd[55] net877 VSS VSS VDD VDD _03403_ _03404_ sky130_fd_sc_hd__ha_1
X_21589_ u_core.u_top.u_core.acc_upd[6] net875 VSS VSS VDD VDD _03405_ _03406_ sky130_fd_sc_hd__ha_1
X_21590_ u_core.u_top.u_core.acc_upd[8] net882 VSS VSS VDD VDD _03407_ _03408_ sky130_fd_sc_hd__ha_1
X_21591_ u_core.u_top.u_core.d_acc[238] _02356_ VSS VSS VDD VDD _03409_ _03410_ sky130_fd_sc_hd__ha_1
X_21592_ u_core.u_top.u_core.d_acc[132] _02395_ VSS VSS VDD VDD _03411_ _03412_ sky130_fd_sc_hd__ha_1
X_21593_ u_core.u_top.u_core.acc_upd[14] net876 VSS VSS VDD VDD _03413_ _03414_ sky130_fd_sc_hd__ha_1
X_21594_ _02301_ u_core.u_top.u_core.d_acc[7] VSS VSS VDD VDD _03415_ _03416_ sky130_fd_sc_hd__ha_1
X_21595_ u_core.u_top.u_core.acc_upd[16] net875 VSS VSS VDD VDD _03417_ _03418_ sky130_fd_sc_hd__ha_1
X_21596_ u_core.u_top.u_core.d_acc[102] _02367_ VSS VSS VDD VDD _03419_ _03420_ sky130_fd_sc_hd__ha_1
X_21597_ u_core.u_top.u_core.acc_upd[144] _02490_ VSS VSS VDD VDD _03421_ _03422_ sky130_fd_sc_hd__ha_1
X_21598_ _03423_ _03424_ VSS VSS VDD VDD _03425_ _0356_[7] sky130_fd_sc_hd__ha_1
X_21599_ net870 net808 VSS VSS VDD VDD _03426_ _0355_[5] sky130_fd_sc_hd__ha_1
X_21600_ net870 net810 VSS VSS VDD VDD _03424_ _11483_ sky130_fd_sc_hd__ha_1
X_21601_ net872 u_core.u_top.u_core.x_idx[1] VSS VSS VDD VDD _03427_ _11484_ sky130_fd_sc_hd__ha_1
X_21602_ net819 u_core.u_top.u_core.x_idx[1] VSS VSS VDD VDD _11481_ _11485_ sky130_fd_sc_hd__ha_1
X_21603_ u_core.u_top.u_core.acc_upd[172] net880 VSS VSS VDD VDD _03428_ _03429_ sky130_fd_sc_hd__ha_1
X_21604_ u_core.u_top.u_core.d_acc[156] net988 VSS VSS VDD VDD _03430_ _03431_ sky130_fd_sc_hd__ha_1
X_21605_ u_core.u_top.u_core.acc_upd[152] _02485_ VSS VSS VDD VDD _03432_ _03433_ sky130_fd_sc_hd__ha_1
X_21606_ u_core.u_top.u_core.d_acc[181] _02305_ VSS VSS VDD VDD _03434_ _02895_ sky130_fd_sc_hd__ha_1
X_21607_ u_core.u_top.u_core.d_acc[22] _02305_ VSS VSS VDD VDD _03435_ _03436_ sky130_fd_sc_hd__ha_1
X_21608_ _03437_ net957 VSS VSS VDD VDD _02350_ _03438_ sky130_fd_sc_hd__ha_1
X_21609_ _0938_[0] _03439_ VSS VSS VDD VDD _03440_ _0938_[1] sky130_fd_sc_hd__ha_1
X_21610_ _0938_[0] _03439_ VSS VSS VDD VDD _03441_ _11486_ sky130_fd_sc_hd__ha_1
X_21611_ u_core.u_top.u_core.acc[40] u_core.u_top.u_core.acc[41] VSS VSS VDD VDD _03442_ _11487_ sky130_fd_sc_hd__ha_1
X_21612_ u_core.u_top.u_core.d_acc[61] _02363_ VSS VSS VDD VDD _03443_ _02911_ sky130_fd_sc_hd__ha_1
X_21613_ u_core.u_top.u_core.d_acc[108] _02367_ VSS VSS VDD VDD _03444_ _03445_ sky130_fd_sc_hd__ha_1
X_21614_ u_core.u_top.u_core.acc_upd[202] _02485_ VSS VSS VDD VDD _03446_ _03447_ sky130_fd_sc_hd__ha_1
X_21615_ u_core.u_top.u_core.acc_upd[47] net881 VSS VSS VDD VDD _03448_ _03449_ sky130_fd_sc_hd__ha_1
X_21616_ u_core.u_top.u_core.acc_upd[46] net875 VSS VSS VDD VDD _03450_ _03451_ sky130_fd_sc_hd__ha_1
X_21617_ u_core.u_top.u_core.acc_upd[161] net879 VSS VSS VDD VDD _03452_ _02643_ sky130_fd_sc_hd__ha_1
X_21618_ u_core.u_top.u_core.acc_upd[83] _02495_ VSS VSS VDD VDD _03453_ _03454_ sky130_fd_sc_hd__ha_1
X_21619_ u_core.u_top.u_core.d_acc[194] _02407_ VSS VSS VDD VDD _03455_ _03456_ sky130_fd_sc_hd__ha_1
X_21620_ u_core.u_top.u_core.acc_upd[133] _02495_ VSS VSS VDD VDD _03457_ _03458_ sky130_fd_sc_hd__ha_1
X_21621_ _0919_[0] _03459_ VSS VSS VDD VDD _03460_ _03461_ sky130_fd_sc_hd__ha_1
X_21622_ u_core.u_top.u_core.d_acc[227] _02363_ VSS VSS VDD VDD _03462_ _03463_ sky130_fd_sc_hd__ha_1
X_21623_ u_core.u_top.u_core.d_acc[214] _02399_ VSS VSS VDD VDD _03464_ _03465_ sky130_fd_sc_hd__ha_1
X_21624_ _02629_ _03466_ VSS VSS VDD VDD _02630_ _11488_ sky130_fd_sc_hd__ha_1
X_21625_ u_core.u_top.u_core.d_acc[134] _02395_ VSS VSS VDD VDD _03467_ _03468_ sky130_fd_sc_hd__ha_1
X_21626_ _02301_ u_core.u_top.u_core.d_acc[3] VSS VSS VDD VDD _03469_ _03470_ sky130_fd_sc_hd__ha_1
X_21627_ u_core.u_top.u_core.acc_upd[113] _02495_ VSS VSS VDD VDD _03471_ _03472_ sky130_fd_sc_hd__ha_1
X_21628_ u_core.u_top.u_core.d_acc[236] _02356_ VSS VSS VDD VDD _03473_ _03474_ sky130_fd_sc_hd__ha_1
X_21629_ _0919_[0] _03459_ VSS VSS VDD VDD _03475_ _0919_[1] sky130_fd_sc_hd__ha_1
X_21630_ u_core.u_top.u_core.acc[10] u_core.u_top.u_core.acc[11] VSS VSS VDD VDD _03476_ _11489_ sky130_fd_sc_hd__ha_1
X_21631_ u_core.u_top.u_core.d_acc[58] _02399_ VSS VSS VDD VDD _03477_ _03478_ sky130_fd_sc_hd__ha_1
X_21632_ _03479_ u_core.u_top.u_core.r_off[0] VSS VSS VDD VDD _02307_ _03480_ sky130_fd_sc_hd__ha_1
X_21633_ u_core.u_top.u_core.acc_upd[15] net877 VSS VSS VDD VDD _03481_ _03482_ sky130_fd_sc_hd__ha_1
X_21634_ _0484_ u_core.arr_sa_p[0] VSS VSS VDD VDD _0404_ _03483_ sky130_fd_sc_hd__ha_1
X_21635_ u_core.arr_sa_n[0] _0486_ VSS VSS VDD VDD _0406_ _11490_ sky130_fd_sc_hd__ha_1
X_21636_ u_core.arr_sa_n[0] u_core.arr_sa_p[0] VSS VSS VDD VDD _0374_[0] _11491_ sky130_fd_sc_hd__ha_1
X_21637_ _0490_ u_core.arr_sa_p[1] VSS VSS VDD VDD _0410_ _03484_ sky130_fd_sc_hd__ha_1
X_21638_ u_core.arr_sa_n[1] _0492_ VSS VSS VDD VDD _0412_ _11492_ sky130_fd_sc_hd__ha_1
X_21639_ u_core.arr_sa_n[1] u_core.arr_sa_p[1] VSS VSS VDD VDD _0374_[1] _11493_ sky130_fd_sc_hd__ha_1
X_21640_ _0496_ u_core.arr_sa_p[2] VSS VSS VDD VDD _0416_ _03485_ sky130_fd_sc_hd__ha_1
X_21641_ u_core.arr_sa_n[2] _0498_ VSS VSS VDD VDD _0418_ _11494_ sky130_fd_sc_hd__ha_1
X_21642_ u_core.arr_sa_n[2] u_core.arr_sa_p[2] VSS VSS VDD VDD _0374_[2] _11495_ sky130_fd_sc_hd__ha_1
X_21643_ _0502_ net978 VSS VSS VDD VDD _0422_ _03486_ sky130_fd_sc_hd__ha_1
X_21644_ net979 _0505_ VSS VSS VDD VDD _0424_ _11496_ sky130_fd_sc_hd__ha_1
X_21645_ net979 net978 VSS VSS VDD VDD _0374_[3] _11497_ sky130_fd_sc_hd__ha_1
X_21646_ _0509_ u_core.arr_sa_p[4] VSS VSS VDD VDD _0428_ _03487_ sky130_fd_sc_hd__ha_1
X_21647_ u_core.arr_sa_n[4] _0511_ VSS VSS VDD VDD _0430_ _11498_ sky130_fd_sc_hd__ha_1
X_21648_ u_core.arr_sa_n[4] u_core.arr_sa_p[4] VSS VSS VDD VDD _0374_[4] _11499_ sky130_fd_sc_hd__ha_1
X_21649_ _0516_ u_core.arr_sa_p[5] VSS VSS VDD VDD _0434_ _03488_ sky130_fd_sc_hd__ha_2
X_21650_ u_core.arr_sa_n[5] _0518_ VSS VSS VDD VDD _0012_ _11500_ sky130_fd_sc_hd__ha_1
X_21651_ u_core.arr_sa_n[5] u_core.arr_sa_p[5] VSS VSS VDD VDD _0374_[5] _11501_ sky130_fd_sc_hd__ha_1
X_21652_ _0522_ u_core.arr_sa_p[6] VSS VSS VDD VDD _0020_ _03489_ sky130_fd_sc_hd__ha_2
X_21653_ u_core.arr_sa_n[6] _0524_ VSS VSS VDD VDD _0025_ _11502_ sky130_fd_sc_hd__ha_1
X_21654_ u_core.arr_sa_n[6] u_core.arr_sa_p[6] VSS VSS VDD VDD _0374_[6] _11503_ sky130_fd_sc_hd__ha_1
X_21655_ _0529_ u_core.arr_sa_p[7] VSS VSS VDD VDD _0031_ _03490_ sky130_fd_sc_hd__ha_2
X_21656_ u_core.arr_sa_n[7] _0531_ VSS VSS VDD VDD _0036_ _11504_ sky130_fd_sc_hd__ha_1
X_21657_ u_core.arr_sa_n[7] u_core.arr_sa_p[7] VSS VSS VDD VDD _0374_[7] _11505_ sky130_fd_sc_hd__ha_1
X_21658_ _0535_ u_core.arr_sa_p[8] VSS VSS VDD VDD _0043_ _03491_ sky130_fd_sc_hd__ha_1
X_21659_ u_core.arr_sa_n[8] _0538_ VSS VSS VDD VDD _0048_ _11506_ sky130_fd_sc_hd__ha_1
X_21660_ u_core.arr_sa_n[8] u_core.arr_sa_p[8] VSS VSS VDD VDD _0374_[8] _11507_ sky130_fd_sc_hd__ha_1
X_21661_ _0542_ u_core.arr_sa_p[9] VSS VSS VDD VDD _0054_ _03492_ sky130_fd_sc_hd__ha_1
X_21662_ u_core.arr_sa_n[9] _0544_ VSS VSS VDD VDD _0059_ _11508_ sky130_fd_sc_hd__ha_1
X_21663_ u_core.arr_sa_n[9] u_core.arr_sa_p[9] VSS VSS VDD VDD _0374_[9] _11509_ sky130_fd_sc_hd__ha_1
X_21664_ _0549_ u_core.arr_sa_p[10] VSS VSS VDD VDD _0065_ _03493_ sky130_fd_sc_hd__ha_1
X_21665_ u_core.arr_sa_n[10] _0551_ VSS VSS VDD VDD _0070_ _11510_ sky130_fd_sc_hd__ha_1
X_21666_ u_core.arr_sa_n[10] u_core.arr_sa_p[10] VSS VSS VDD VDD _0374_[10] _11511_ sky130_fd_sc_hd__ha_1
X_21667_ _0555_ u_core.arr_sa_p[11] VSS VSS VDD VDD _0076_ _03494_ sky130_fd_sc_hd__ha_1
X_21668_ u_core.arr_sa_n[11] _0557_ VSS VSS VDD VDD _0081_ _11512_ sky130_fd_sc_hd__ha_1
X_21669_ u_core.arr_sa_n[11] u_core.arr_sa_p[11] VSS VSS VDD VDD _0374_[11] _11513_ sky130_fd_sc_hd__ha_1
X_21670_ _0562_ u_core.arr_sa_p[12] VSS VSS VDD VDD _0086_ _03495_ sky130_fd_sc_hd__ha_1
X_21671_ u_core.arr_sa_n[12] _0564_ VSS VSS VDD VDD _0092_ _11514_ sky130_fd_sc_hd__ha_1
X_21672_ u_core.arr_sa_n[12] u_core.arr_sa_p[12] VSS VSS VDD VDD _0374_[12] _11515_ sky130_fd_sc_hd__ha_1
X_21673_ _0568_ u_core.arr_sa_p[13] VSS VSS VDD VDD _0097_ _03496_ sky130_fd_sc_hd__ha_1
X_21674_ u_core.arr_sa_n[13] _0571_ VSS VSS VDD VDD _0102_ _11516_ sky130_fd_sc_hd__ha_1
X_21675_ u_core.arr_sa_n[13] u_core.arr_sa_p[13] VSS VSS VDD VDD _0374_[13] _11517_ sky130_fd_sc_hd__ha_1
X_21676_ _0575_ u_core.arr_sa_p[14] VSS VSS VDD VDD _0108_ _03497_ sky130_fd_sc_hd__ha_1
X_21677_ u_core.arr_sa_n[14] _0577_ VSS VSS VDD VDD _0113_ _11518_ sky130_fd_sc_hd__ha_1
X_21678_ u_core.arr_sa_n[14] u_core.arr_sa_p[14] VSS VSS VDD VDD _0374_[14] _11519_ sky130_fd_sc_hd__ha_1
X_21679_ _0582_ u_core.arr_sa_p[15] VSS VSS VDD VDD _0118_ _03498_ sky130_fd_sc_hd__ha_1
X_21680_ u_core.arr_sa_n[15] _0584_ VSS VSS VDD VDD _0124_ _11520_ sky130_fd_sc_hd__ha_1
X_21681_ u_core.arr_sa_n[15] u_core.arr_sa_p[15] VSS VSS VDD VDD _0374_[15] _11521_ sky130_fd_sc_hd__ha_1
X_21682_ _0588_ u_core.arr_sa_p[16] VSS VSS VDD VDD _0129_ _03499_ sky130_fd_sc_hd__ha_1
X_21683_ u_core.arr_sa_n[16] _0590_ VSS VSS VDD VDD _0134_ _11522_ sky130_fd_sc_hd__ha_1
X_21684_ u_core.arr_sa_n[16] u_core.arr_sa_p[16] VSS VSS VDD VDD _0374_[16] _11523_ sky130_fd_sc_hd__ha_1
X_21685_ _0595_ u_core.arr_sa_p[17] VSS VSS VDD VDD _0140_ _03500_ sky130_fd_sc_hd__ha_1
X_21686_ u_core.arr_sa_n[17] _0597_ VSS VSS VDD VDD _0145_ _11524_ sky130_fd_sc_hd__ha_1
X_21687_ u_core.arr_sa_n[17] u_core.arr_sa_p[17] VSS VSS VDD VDD _0374_[17] _11525_ sky130_fd_sc_hd__ha_1
X_21688_ _0601_ u_core.arr_sa_p[18] VSS VSS VDD VDD _0151_ _03501_ sky130_fd_sc_hd__ha_1
X_21689_ u_core.arr_sa_n[18] _0604_ VSS VSS VDD VDD _0156_ _11526_ sky130_fd_sc_hd__ha_1
X_21690_ u_core.arr_sa_n[18] u_core.arr_sa_p[18] VSS VSS VDD VDD _0374_[18] _11527_ sky130_fd_sc_hd__ha_1
X_21691_ _0608_ u_core.arr_sa_p[19] VSS VSS VDD VDD _0163_ _03502_ sky130_fd_sc_hd__ha_1
X_21692_ u_core.arr_sa_n[19] _0610_ VSS VSS VDD VDD _0168_ _11528_ sky130_fd_sc_hd__ha_1
X_21693_ u_core.arr_sa_n[19] u_core.arr_sa_p[19] VSS VSS VDD VDD _0374_[19] _11529_ sky130_fd_sc_hd__ha_1
X_21694_ _0615_ u_core.arr_sa_p[20] VSS VSS VDD VDD _0175_ _03503_ sky130_fd_sc_hd__ha_1
X_21695_ u_core.arr_sa_n[20] _0617_ VSS VSS VDD VDD _0180_ _11530_ sky130_fd_sc_hd__ha_1
X_21696_ u_core.arr_sa_n[20] u_core.arr_sa_p[20] VSS VSS VDD VDD _0374_[20] _11531_ sky130_fd_sc_hd__ha_1
X_21697_ _0621_ u_core.arr_sa_p[21] VSS VSS VDD VDD _0187_ _03504_ sky130_fd_sc_hd__ha_1
X_21698_ u_core.arr_sa_n[21] _0623_ VSS VSS VDD VDD _0192_ _11532_ sky130_fd_sc_hd__ha_1
X_21699_ u_core.arr_sa_n[21] u_core.arr_sa_p[21] VSS VSS VDD VDD _0374_[21] _11533_ sky130_fd_sc_hd__ha_1
X_21700_ _0628_ u_core.arr_sa_p[22] VSS VSS VDD VDD _0198_ _03505_ sky130_fd_sc_hd__ha_1
X_21701_ net980 _0630_ VSS VSS VDD VDD _0204_ _11534_ sky130_fd_sc_hd__ha_1
X_21702_ net980 u_core.arr_sa_p[22] VSS VSS VDD VDD _0374_[22] _11535_ sky130_fd_sc_hd__ha_1
X_21703_ _0634_ u_core.arr_sa_p[23] VSS VSS VDD VDD _0210_ _03506_ sky130_fd_sc_hd__ha_1
X_21704_ u_core.arr_sa_n[23] _0637_ VSS VSS VDD VDD _0215_ _11536_ sky130_fd_sc_hd__ha_1
X_21705_ u_core.arr_sa_n[23] u_core.arr_sa_p[23] VSS VSS VDD VDD _0374_[23] _11537_ sky130_fd_sc_hd__ha_1
X_21708__23 VSS VSS VDD VDD tie_hi[0] nc__21708__23_LO sky130_fd_sc_hd__conb_1
X_21709__24 VSS VSS VDD VDD tie_hi[1] nc__21709__24_LO sky130_fd_sc_hd__conb_1
X_21710__25 VSS VSS VDD VDD tie_hi[2] nc__21710__25_LO sky130_fd_sc_hd__conb_1
X_21711__26 VSS VSS VDD VDD tie_hi[3] nc__21711__26_LO sky130_fd_sc_hd__conb_1
X_21712__27 VSS VSS VDD VDD tie_hi[4] nc__21712__27_LO sky130_fd_sc_hd__conb_1
X_21713__28 VSS VSS VDD VDD tie_hi[5] nc__21713__28_LO sky130_fd_sc_hd__conb_1
X_21714__29 VSS VSS VDD VDD tie_hi[6] nc__21714__29_LO sky130_fd_sc_hd__conb_1
X_21715__30 VSS VSS VDD VDD tie_hi[7] nc__21715__30_LO sky130_fd_sc_hd__conb_1
X_21716__31 VSS VSS VDD VDD tie_hi[8] nc__21716__31_LO sky130_fd_sc_hd__conb_1
X_21717__32 VSS VSS VDD VDD tie_hi[9] nc__21717__32_LO sky130_fd_sc_hd__conb_1
X_21718__33 VSS VSS VDD VDD tie_hi[10] nc__21718__33_LO sky130_fd_sc_hd__conb_1
X_21719__34 VSS VSS VDD VDD tie_hi[11] nc__21719__34_LO sky130_fd_sc_hd__conb_1
X_21720__35 VSS VSS VDD VDD tie_hi[12] nc__21720__35_LO sky130_fd_sc_hd__conb_1
X_21721__1 VSS VSS VDD VDD nc__21721__1_HI tie_lo[0] sky130_fd_sc_hd__conb_1
X_21722__2 VSS VSS VDD VDD nc__21722__2_HI tie_lo[1] sky130_fd_sc_hd__conb_1
X_21723__3 VSS VSS VDD VDD nc__21723__3_HI tie_lo[2] sky130_fd_sc_hd__conb_1
X_21724__4 VSS VSS VDD VDD nc__21724__4_HI tie_lo[3] sky130_fd_sc_hd__conb_1
X_21725__5 VSS VSS VDD VDD nc__21725__5_HI tie_lo[4] sky130_fd_sc_hd__conb_1
X_21726__6 VSS VSS VDD VDD nc__21726__6_HI tie_lo[5] sky130_fd_sc_hd__conb_1
X_21727__7 VSS VSS VDD VDD nc__21727__7_HI tie_lo[6] sky130_fd_sc_hd__conb_1
X_21728__8 VSS VSS VDD VDD nc__21728__8_HI tie_lo[7] sky130_fd_sc_hd__conb_1
X_21729__9 VSS VSS VDD VDD nc__21729__9_HI tie_lo[8] sky130_fd_sc_hd__conb_1
X_21730__10 VSS VSS VDD VDD nc__21730__10_HI tie_lo[9] sky130_fd_sc_hd__conb_1
X_21731__11 VSS VSS VDD VDD nc__21731__11_HI tie_lo[10] sky130_fd_sc_hd__conb_1
X_21732__12 VSS VSS VDD VDD nc__21732__12_HI tie_lo[11] sky130_fd_sc_hd__conb_1
X_21733__13 VSS VSS VDD VDD nc__21733__13_HI tie_lo[12] sky130_fd_sc_hd__conb_1
X_21734__14 VSS VSS VDD VDD nc__21734__14_HI tie_lo[13] sky130_fd_sc_hd__conb_1
X_21735__15 VSS VSS VDD VDD nc__21735__15_HI tie_lo[14] sky130_fd_sc_hd__conb_1
X_21736__16 VSS VSS VDD VDD nc__21736__16_HI tie_lo[15] sky130_fd_sc_hd__conb_1
X_21737__17 VSS VSS VDD VDD nc__21737__17_HI tie_lo[16] sky130_fd_sc_hd__conb_1
X_21738__18 VSS VSS VDD VDD nc__21738__18_HI tie_lo[17] sky130_fd_sc_hd__conb_1
X_21739__19 VSS VSS VDD VDD nc__21739__19_HI tie_lo[18] sky130_fd_sc_hd__conb_1
X_21740__20 VSS VSS VDD VDD nc__21740__20_HI tie_lo[19] sky130_fd_sc_hd__conb_1
X_21741__21 VSS VSS VDD VDD nc__21741__21_HI tie_lo[20] sky130_fd_sc_hd__conb_1
X_21742__22 VSS VSS VDD VDD nc__21742__22_HI tie_lo[21] sky130_fd_sc_hd__conb_1
Xbl_sen$_DFFE_PN0P_ clknet_2_2__leaf__11421_ _1101_ net1016 VSS VSS VDD VDD net96 sky130_fd_sc_hd__dfrtp_1
Xbln_prg[0]$_DFFE_PN0P_ clknet_2_3__leaf__11421_ _1099_[0] net1006 VSS VSS VDD VDD net97 sky130_fd_sc_hd__dfrtp_1
Xbln_prg[10]$_DFFE_PN0P_ clknet_2_0__leaf__11421_ _1099_[10] net1007 VSS VSS VDD VDD net98 sky130_fd_sc_hd__dfrtp_1
Xbln_prg[11]$_DFFE_PN0P_ clknet_2_0__leaf__11421_ _1099_[11] net1007 VSS VSS VDD VDD net99 sky130_fd_sc_hd__dfrtp_1
Xbln_prg[12]$_DFFE_PN0P_ clknet_2_0__leaf__11421_ _1099_[12] net1007 VSS VSS VDD VDD net100 sky130_fd_sc_hd__dfrtp_1
Xbln_prg[13]$_DFFE_PN0P_ clknet_2_0__leaf__11421_ _1099_[13] net1007 VSS VSS VDD VDD net101 sky130_fd_sc_hd__dfrtp_1
Xbln_prg[14]$_DFFE_PN0P_ clknet_2_0__leaf__11421_ _1099_[14] net1007 VSS VSS VDD VDD net102 sky130_fd_sc_hd__dfrtp_1
Xbln_prg[15]$_DFFE_PN0P_ clknet_2_0__leaf__11421_ _1099_[15] net1007 VSS VSS VDD VDD net103 sky130_fd_sc_hd__dfrtp_1
Xbln_prg[16]$_DFFE_PN0P_ clknet_2_0__leaf__11421_ _1099_[16] net1008 VSS VSS VDD VDD net104 sky130_fd_sc_hd__dfrtp_1
Xbln_prg[17]$_DFFE_PN0P_ clknet_2_0__leaf__11421_ _1099_[17] net1008 VSS VSS VDD VDD net105 sky130_fd_sc_hd__dfrtp_1
Xbln_prg[18]$_DFFE_PN0P_ clknet_2_0__leaf__11421_ _1099_[18] net1008 VSS VSS VDD VDD net106 sky130_fd_sc_hd__dfrtp_1
Xbln_prg[19]$_DFFE_PN0P_ clknet_2_0__leaf__11421_ _1099_[19] net1008 VSS VSS VDD VDD net107 sky130_fd_sc_hd__dfrtp_1
Xbln_prg[1]$_DFFE_PN0P_ clknet_2_1__leaf__11421_ _1099_[1] net1006 VSS VSS VDD VDD net108 sky130_fd_sc_hd__dfrtp_1
Xbln_prg[20]$_DFFE_PN0P_ clknet_2_0__leaf__11421_ _1099_[20] net1008 VSS VSS VDD VDD net109 sky130_fd_sc_hd__dfrtp_1
Xbln_prg[21]$_DFFE_PN0P_ clknet_2_0__leaf__11421_ _1099_[21] net1008 VSS VSS VDD VDD net110 sky130_fd_sc_hd__dfrtp_1
Xbln_prg[22]$_DFFE_PN0P_ clknet_2_0__leaf__11421_ _1099_[22] net1007 VSS VSS VDD VDD net111 sky130_fd_sc_hd__dfrtp_1
Xbln_prg[23]$_DFFE_PN0P_ clknet_2_3__leaf__11421_ _1099_[23] net1006 VSS VSS VDD VDD net112 sky130_fd_sc_hd__dfrtp_1
Xbln_prg[2]$_DFFE_PN0P_ clknet_2_3__leaf__11421_ _1099_[2] net1006 VSS VSS VDD VDD net113 sky130_fd_sc_hd__dfrtp_1
Xbln_prg[3]$_DFFE_PN0P_ clknet_2_1__leaf__11421_ _1099_[3] net1006 VSS VSS VDD VDD net114 sky130_fd_sc_hd__dfrtp_1
Xbln_prg[4]$_DFFE_PN0P_ clknet_2_0__leaf__11421_ _1099_[4] net1007 VSS VSS VDD VDD net115 sky130_fd_sc_hd__dfrtp_1
Xbln_prg[5]$_DFFE_PN0P_ clknet_2_1__leaf__11421_ _1099_[5] net1007 VSS VSS VDD VDD net116 sky130_fd_sc_hd__dfrtp_1
Xbln_prg[6]$_DFFE_PN0P_ clknet_2_0__leaf__11421_ _1099_[6] net1007 VSS VSS VDD VDD net117 sky130_fd_sc_hd__dfrtp_1
Xbln_prg[7]$_DFFE_PN0P_ clknet_2_1__leaf__11421_ _1099_[7] net1006 VSS VSS VDD VDD net118 sky130_fd_sc_hd__dfrtp_1
Xbln_prg[8]$_DFFE_PN0P_ clknet_2_1__leaf__11421_ _1099_[8] net1007 VSS VSS VDD VDD net119 sky130_fd_sc_hd__dfrtp_1
Xbln_prg[9]$_DFFE_PN0P_ clknet_2_0__leaf__11421_ _1099_[9] net1007 VSS VSS VDD VDD net120 sky130_fd_sc_hd__dfrtp_1
Xblp_prg[0]$_DFFE_PN0P_ clknet_2_2__leaf__11421_ _1097_[0] net1023 VSS VSS VDD VDD net121 sky130_fd_sc_hd__dfrtp_1
Xblp_prg[10]$_DFFE_PN0P_ clknet_2_3__leaf__11421_ _1097_[10] net1006 VSS VSS VDD VDD net122 sky130_fd_sc_hd__dfrtp_1
Xblp_prg[11]$_DFFE_PN0P_ clknet_2_1__leaf__11421_ _1097_[11] net1006 VSS VSS VDD VDD net123 sky130_fd_sc_hd__dfrtp_1
Xblp_prg[12]$_DFFE_PN0P_ clknet_2_0__leaf__11421_ _1097_[12] net1007 VSS VSS VDD VDD net124 sky130_fd_sc_hd__dfrtp_1
Xblp_prg[13]$_DFFE_PN0P_ clknet_2_3__leaf__11421_ _1097_[13] net1006 VSS VSS VDD VDD net125 sky130_fd_sc_hd__dfrtp_1
Xblp_prg[14]$_DFFE_PN0P_ clknet_2_1__leaf__11421_ _1097_[14] net1006 VSS VSS VDD VDD net126 sky130_fd_sc_hd__dfrtp_1
Xblp_prg[15]$_DFFE_PN0P_ clknet_2_1__leaf__11421_ _1097_[15] net1006 VSS VSS VDD VDD net127 sky130_fd_sc_hd__dfrtp_1
Xblp_prg[16]$_DFFE_PN0P_ clknet_2_1__leaf__11421_ _1097_[16] net1006 VSS VSS VDD VDD net128 sky130_fd_sc_hd__dfrtp_1
Xblp_prg[17]$_DFFE_PN0P_ clknet_2_1__leaf__11421_ _1097_[17] net1006 VSS VSS VDD VDD net129 sky130_fd_sc_hd__dfrtp_1
Xblp_prg[18]$_DFFE_PN0P_ clknet_2_1__leaf__11421_ _1097_[18] net1006 VSS VSS VDD VDD net130 sky130_fd_sc_hd__dfrtp_1
Xblp_prg[19]$_DFFE_PN0P_ clknet_2_0__leaf__11421_ _1097_[19] net1007 VSS VSS VDD VDD net131 sky130_fd_sc_hd__dfrtp_1
Xblp_prg[1]$_DFFE_PN0P_ clknet_2_3__leaf__11421_ _1097_[1] net1006 VSS VSS VDD VDD net132 sky130_fd_sc_hd__dfrtp_1
Xblp_prg[20]$_DFFE_PN0P_ clknet_2_1__leaf__11421_ _1097_[20] net1007 VSS VSS VDD VDD net133 sky130_fd_sc_hd__dfrtp_1
Xblp_prg[21]$_DFFE_PN0P_ clknet_2_0__leaf__11421_ _1097_[21] net1007 VSS VSS VDD VDD net134 sky130_fd_sc_hd__dfrtp_1
Xblp_prg[22]$_DFFE_PN0P_ clknet_2_1__leaf__11421_ _1097_[22] net1006 VSS VSS VDD VDD net135 sky130_fd_sc_hd__dfrtp_1
Xblp_prg[23]$_DFFE_PN0P_ clknet_2_3__leaf__11421_ _1097_[23] net1006 VSS VSS VDD VDD net136 sky130_fd_sc_hd__dfrtp_1
Xblp_prg[2]$_DFFE_PN0P_ clknet_2_2__leaf__11421_ _1097_[2] net1006 VSS VSS VDD VDD net137 sky130_fd_sc_hd__dfrtp_1
Xblp_prg[3]$_DFFE_PN0P_ clknet_2_2__leaf__11421_ _1097_[3] net1006 VSS VSS VDD VDD net138 sky130_fd_sc_hd__dfrtp_1
Xblp_prg[4]$_DFFE_PN0P_ clknet_2_3__leaf__11421_ _1097_[4] net1006 VSS VSS VDD VDD net139 sky130_fd_sc_hd__dfrtp_1
Xblp_prg[5]$_DFFE_PN0P_ clknet_2_2__leaf__11421_ _1097_[5] net1006 VSS VSS VDD VDD net140 sky130_fd_sc_hd__dfrtp_1
Xblp_prg[6]$_DFFE_PN0P_ clknet_2_3__leaf__11421_ _1097_[6] net1006 VSS VSS VDD VDD net141 sky130_fd_sc_hd__dfrtp_1
Xblp_prg[7]$_DFFE_PN0P_ clknet_2_3__leaf__11421_ _1097_[7] net1006 VSS VSS VDD VDD net142 sky130_fd_sc_hd__dfrtp_1
Xblp_prg[8]$_DFFE_PN0P_ clknet_2_3__leaf__11421_ _1097_[8] net1006 VSS VSS VDD VDD net143 sky130_fd_sc_hd__dfrtp_1
Xblp_prg[9]$_DFFE_PN0P_ clknet_2_3__leaf__11421_ _1097_[9] net1006 VSS VSS VDD VDD net144 sky130_fd_sc_hd__dfrtp_1
Xclkbuf_0__11348_ _11348_ VSS VSS VDD VDD clknet_0__11348_ sky130_fd_sc_hd__clkbuf_16
Xclkbuf_0__11352_ _11352_ VSS VSS VDD VDD clknet_0__11352_ sky130_fd_sc_hd__clkbuf_16
Xclkbuf_0__11355_ _11355_ VSS VSS VDD VDD clknet_0__11355_ sky130_fd_sc_hd__clkbuf_16
Xclkbuf_0__11356_ _11356_ VSS VSS VDD VDD clknet_0__11356_ sky130_fd_sc_hd__clkbuf_16
Xclkbuf_0__11357_ _11357_ VSS VSS VDD VDD clknet_0__11357_ sky130_fd_sc_hd__clkbuf_16
Xclkbuf_0__11358_ _11358_ VSS VSS VDD VDD clknet_0__11358_ sky130_fd_sc_hd__clkbuf_16
Xclkbuf_0__11359_ _11359_ VSS VSS VDD VDD clknet_0__11359_ sky130_fd_sc_hd__clkbuf_16
Xclkbuf_0__11360_ _11360_ VSS VSS VDD VDD clknet_0__11360_ sky130_fd_sc_hd__clkbuf_16
Xclkbuf_0__11361_ _11361_ VSS VSS VDD VDD clknet_0__11361_ sky130_fd_sc_hd__clkbuf_16
Xclkbuf_0__11362_ _11362_ VSS VSS VDD VDD clknet_0__11362_ sky130_fd_sc_hd__clkbuf_16
Xclkbuf_0__11363_ _11363_ VSS VSS VDD VDD clknet_0__11363_ sky130_fd_sc_hd__clkbuf_16
Xclkbuf_0__11364_ _11364_ VSS VSS VDD VDD clknet_0__11364_ sky130_fd_sc_hd__clkbuf_16
Xclkbuf_0__11365_ _11365_ VSS VSS VDD VDD clknet_0__11365_ sky130_fd_sc_hd__clkbuf_16
Xclkbuf_0__11366_ _11366_ VSS VSS VDD VDD clknet_0__11366_ sky130_fd_sc_hd__clkbuf_16
Xclkbuf_0__11367_ _11367_ VSS VSS VDD VDD clknet_0__11367_ sky130_fd_sc_hd__clkbuf_16
Xclkbuf_0__11368_ _11368_ VSS VSS VDD VDD clknet_0__11368_ sky130_fd_sc_hd__clkbuf_16
Xclkbuf_0__11369_ _11369_ VSS VSS VDD VDD clknet_0__11369_ sky130_fd_sc_hd__clkbuf_16
Xclkbuf_0__11370_ _11370_ VSS VSS VDD VDD clknet_0__11370_ sky130_fd_sc_hd__clkbuf_16
Xclkbuf_0__11371_ _11371_ VSS VSS VDD VDD clknet_0__11371_ sky130_fd_sc_hd__clkbuf_16
Xclkbuf_0__11372_ _11372_ VSS VSS VDD VDD clknet_0__11372_ sky130_fd_sc_hd__clkbuf_16
Xclkbuf_0__11373_ _11373_ VSS VSS VDD VDD clknet_0__11373_ sky130_fd_sc_hd__clkbuf_16
Xclkbuf_0__11374_ _11374_ VSS VSS VDD VDD clknet_0__11374_ sky130_fd_sc_hd__clkbuf_16
Xclkbuf_0__11375_ _11375_ VSS VSS VDD VDD clknet_0__11375_ sky130_fd_sc_hd__clkbuf_16
Xclkbuf_0__11376_ _11376_ VSS VSS VDD VDD clknet_0__11376_ sky130_fd_sc_hd__clkbuf_16
Xclkbuf_0__11377_ _11377_ VSS VSS VDD VDD clknet_0__11377_ sky130_fd_sc_hd__clkbuf_16
Xclkbuf_0__11378_ _11378_ VSS VSS VDD VDD clknet_0__11378_ sky130_fd_sc_hd__clkbuf_16
Xclkbuf_0__11379_ _11379_ VSS VSS VDD VDD clknet_0__11379_ sky130_fd_sc_hd__clkbuf_16
Xclkbuf_0__11380_ _11380_ VSS VSS VDD VDD clknet_0__11380_ sky130_fd_sc_hd__clkbuf_16
Xclkbuf_0__11381_ _11381_ VSS VSS VDD VDD clknet_0__11381_ sky130_fd_sc_hd__clkbuf_16
Xclkbuf_0__11382_ _11382_ VSS VSS VDD VDD clknet_0__11382_ sky130_fd_sc_hd__clkbuf_16
Xclkbuf_0__11383_ _11383_ VSS VSS VDD VDD clknet_0__11383_ sky130_fd_sc_hd__clkbuf_16
Xclkbuf_0__11384_ _11384_ VSS VSS VDD VDD clknet_0__11384_ sky130_fd_sc_hd__clkbuf_16
Xclkbuf_0__11385_ _11385_ VSS VSS VDD VDD clknet_0__11385_ sky130_fd_sc_hd__clkbuf_16
Xclkbuf_0__11386_ _11386_ VSS VSS VDD VDD clknet_0__11386_ sky130_fd_sc_hd__clkbuf_16
Xclkbuf_0__11387_ _11387_ VSS VSS VDD VDD clknet_0__11387_ sky130_fd_sc_hd__clkbuf_16
Xclkbuf_0__11388_ _11388_ VSS VSS VDD VDD clknet_0__11388_ sky130_fd_sc_hd__clkbuf_16
Xclkbuf_0__11389_ _11389_ VSS VSS VDD VDD clknet_0__11389_ sky130_fd_sc_hd__clkbuf_16
Xclkbuf_0__11390_ _11390_ VSS VSS VDD VDD clknet_0__11390_ sky130_fd_sc_hd__clkbuf_16
Xclkbuf_0__11391_ _11391_ VSS VSS VDD VDD clknet_0__11391_ sky130_fd_sc_hd__clkbuf_16
Xclkbuf_0__11392_ _11392_ VSS VSS VDD VDD clknet_0__11392_ sky130_fd_sc_hd__clkbuf_16
Xclkbuf_0__11393_ _11393_ VSS VSS VDD VDD clknet_0__11393_ sky130_fd_sc_hd__clkbuf_16
Xclkbuf_0__11394_ _11394_ VSS VSS VDD VDD clknet_0__11394_ sky130_fd_sc_hd__clkbuf_16
Xclkbuf_0__11395_ _11395_ VSS VSS VDD VDD clknet_0__11395_ sky130_fd_sc_hd__clkbuf_16
Xclkbuf_0__11396_ _11396_ VSS VSS VDD VDD clknet_0__11396_ sky130_fd_sc_hd__clkbuf_16
Xclkbuf_0__11397_ _11397_ VSS VSS VDD VDD clknet_0__11397_ sky130_fd_sc_hd__clkbuf_16
Xclkbuf_0__11398_ _11398_ VSS VSS VDD VDD clknet_0__11398_ sky130_fd_sc_hd__clkbuf_16
Xclkbuf_0__11399_ _11399_ VSS VSS VDD VDD clknet_0__11399_ sky130_fd_sc_hd__clkbuf_16
Xclkbuf_0__11400_ _11400_ VSS VSS VDD VDD clknet_0__11400_ sky130_fd_sc_hd__clkbuf_16
Xclkbuf_0__11401_ _11401_ VSS VSS VDD VDD clknet_0__11401_ sky130_fd_sc_hd__clkbuf_16
Xclkbuf_0__11402_ _11402_ VSS VSS VDD VDD clknet_0__11402_ sky130_fd_sc_hd__clkbuf_16
Xclkbuf_0__11403_ _11403_ VSS VSS VDD VDD clknet_0__11403_ sky130_fd_sc_hd__clkbuf_16
Xclkbuf_0__11404_ _11404_ VSS VSS VDD VDD clknet_0__11404_ sky130_fd_sc_hd__clkbuf_16
Xclkbuf_0__11405_ _11405_ VSS VSS VDD VDD clknet_0__11405_ sky130_fd_sc_hd__clkbuf_16
Xclkbuf_0__11406_ _11406_ VSS VSS VDD VDD clknet_0__11406_ sky130_fd_sc_hd__clkbuf_16
Xclkbuf_0__11407_ _11407_ VSS VSS VDD VDD clknet_0__11407_ sky130_fd_sc_hd__clkbuf_16
Xclkbuf_0__11408_ _11408_ VSS VSS VDD VDD clknet_0__11408_ sky130_fd_sc_hd__clkbuf_16
Xclkbuf_0__11409_ _11409_ VSS VSS VDD VDD clknet_0__11409_ sky130_fd_sc_hd__clkbuf_16
Xclkbuf_0__11410_ _11410_ VSS VSS VDD VDD clknet_0__11410_ sky130_fd_sc_hd__clkbuf_16
Xclkbuf_0__11411_ _11411_ VSS VSS VDD VDD clknet_0__11411_ sky130_fd_sc_hd__clkbuf_16
Xclkbuf_0__11412_ _11412_ VSS VSS VDD VDD clknet_0__11412_ sky130_fd_sc_hd__clkbuf_16
Xclkbuf_0__11413_ _11413_ VSS VSS VDD VDD clknet_0__11413_ sky130_fd_sc_hd__clkbuf_16
Xclkbuf_0__11414_ _11414_ VSS VSS VDD VDD clknet_0__11414_ sky130_fd_sc_hd__clkbuf_16
Xclkbuf_0__11415_ _11415_ VSS VSS VDD VDD clknet_0__11415_ sky130_fd_sc_hd__clkbuf_16
Xclkbuf_0__11416_ _11416_ VSS VSS VDD VDD clknet_0__11416_ sky130_fd_sc_hd__clkbuf_16
Xclkbuf_0__11417_ _11417_ VSS VSS VDD VDD clknet_0__11417_ sky130_fd_sc_hd__clkbuf_16
Xclkbuf_0__11418_ _11418_ VSS VSS VDD VDD clknet_0__11418_ sky130_fd_sc_hd__clkbuf_16
Xclkbuf_0__11419_ _11419_ VSS VSS VDD VDD clknet_0__11419_ sky130_fd_sc_hd__clkbuf_16
Xclkbuf_0__11420_ _11420_ VSS VSS VDD VDD clknet_0__11420_ sky130_fd_sc_hd__clkbuf_16
Xclkbuf_0__11421_ _11421_ VSS VSS VDD VDD clknet_0__11421_ sky130_fd_sc_hd__clkbuf_16
Xclkbuf_0__11422_ _11422_ VSS VSS VDD VDD clknet_0__11422_ sky130_fd_sc_hd__clkbuf_16
Xclkbuf_0__11423_ _11423_ VSS VSS VDD VDD clknet_0__11423_ sky130_fd_sc_hd__clkbuf_16
Xclkbuf_0__11424_ _11424_ VSS VSS VDD VDD clknet_0__11424_ sky130_fd_sc_hd__clkbuf_16
Xclkbuf_0__11425_ _11425_ VSS VSS VDD VDD clknet_0__11425_ sky130_fd_sc_hd__clkbuf_16
Xclkbuf_0__11426_ _11426_ VSS VSS VDD VDD clknet_0__11426_ sky130_fd_sc_hd__clkbuf_16
Xclkbuf_0__11427_ _11427_ VSS VSS VDD VDD clknet_0__11427_ sky130_fd_sc_hd__clkbuf_16
Xclkbuf_0__11428_ _11428_ VSS VSS VDD VDD clknet_0__11428_ sky130_fd_sc_hd__clkbuf_16
Xclkbuf_0__11429_ _11429_ VSS VSS VDD VDD clknet_0__11429_ sky130_fd_sc_hd__clkbuf_16
Xclkbuf_0_clk clk VSS VSS VDD VDD clknet_0_clk sky130_fd_sc_hd__clkbuf_16
Xclkbuf_0_clk_regs clk_regs VSS VSS VDD VDD clknet_0_clk_regs sky130_fd_sc_hd__clkbuf_16
Xclkbuf_1_0__f__11348_ clknet_0__11348_ VSS VSS VDD VDD clknet_1_0__leaf__11348_ sky130_fd_sc_hd__clkbuf_16
Xclkbuf_1_0__f__11352_ clknet_0__11352_ VSS VSS VDD VDD clknet_1_0__leaf__11352_ sky130_fd_sc_hd__clkbuf_16
Xclkbuf_1_0__f__11355_ clknet_0__11355_ VSS VSS VDD VDD clknet_1_0__leaf__11355_ sky130_fd_sc_hd__clkbuf_16
Xclkbuf_1_0__f__11356_ clknet_0__11356_ VSS VSS VDD VDD clknet_1_0__leaf__11356_ sky130_fd_sc_hd__clkbuf_16
Xclkbuf_1_0__f__11357_ clknet_0__11357_ VSS VSS VDD VDD clknet_1_0__leaf__11357_ sky130_fd_sc_hd__clkbuf_16
Xclkbuf_1_0__f__11358_ clknet_0__11358_ VSS VSS VDD VDD clknet_1_0__leaf__11358_ sky130_fd_sc_hd__clkbuf_16
Xclkbuf_1_0__f__11359_ clknet_0__11359_ VSS VSS VDD VDD clknet_1_0__leaf__11359_ sky130_fd_sc_hd__clkbuf_16
Xclkbuf_1_0__f__11360_ clknet_0__11360_ VSS VSS VDD VDD clknet_1_0__leaf__11360_ sky130_fd_sc_hd__clkbuf_16
Xclkbuf_1_0__f__11362_ clknet_0__11362_ VSS VSS VDD VDD clknet_1_0__leaf__11362_ sky130_fd_sc_hd__clkbuf_16
Xclkbuf_1_0__f__11363_ clknet_0__11363_ VSS VSS VDD VDD clknet_1_0__leaf__11363_ sky130_fd_sc_hd__clkbuf_16
Xclkbuf_1_0__f__11364_ clknet_0__11364_ VSS VSS VDD VDD clknet_1_0__leaf__11364_ sky130_fd_sc_hd__clkbuf_16
Xclkbuf_1_0__f__11365_ clknet_0__11365_ VSS VSS VDD VDD clknet_1_0__leaf__11365_ sky130_fd_sc_hd__clkbuf_16
Xclkbuf_1_0__f__11366_ clknet_0__11366_ VSS VSS VDD VDD clknet_1_0__leaf__11366_ sky130_fd_sc_hd__clkbuf_16
Xclkbuf_1_0__f__11367_ clknet_0__11367_ VSS VSS VDD VDD clknet_1_0__leaf__11367_ sky130_fd_sc_hd__clkbuf_16
Xclkbuf_1_0__f__11368_ clknet_0__11368_ VSS VSS VDD VDD clknet_1_0__leaf__11368_ sky130_fd_sc_hd__clkbuf_16
Xclkbuf_1_0__f__11369_ clknet_0__11369_ VSS VSS VDD VDD clknet_1_0__leaf__11369_ sky130_fd_sc_hd__clkbuf_16
Xclkbuf_1_0__f__11370_ clknet_0__11370_ VSS VSS VDD VDD clknet_1_0__leaf__11370_ sky130_fd_sc_hd__clkbuf_16
Xclkbuf_1_0__f__11371_ clknet_0__11371_ VSS VSS VDD VDD clknet_1_0__leaf__11371_ sky130_fd_sc_hd__clkbuf_16
Xclkbuf_1_0__f__11372_ clknet_0__11372_ VSS VSS VDD VDD clknet_1_0__leaf__11372_ sky130_fd_sc_hd__clkbuf_16
Xclkbuf_1_0__f__11373_ clknet_0__11373_ VSS VSS VDD VDD clknet_1_0__leaf__11373_ sky130_fd_sc_hd__clkbuf_16
Xclkbuf_1_0__f__11374_ clknet_0__11374_ VSS VSS VDD VDD clknet_1_0__leaf__11374_ sky130_fd_sc_hd__clkbuf_16
Xclkbuf_1_0__f__11375_ clknet_0__11375_ VSS VSS VDD VDD clknet_1_0__leaf__11375_ sky130_fd_sc_hd__clkbuf_16
Xclkbuf_1_0__f__11376_ clknet_0__11376_ VSS VSS VDD VDD clknet_1_0__leaf__11376_ sky130_fd_sc_hd__clkbuf_16
Xclkbuf_1_0__f__11377_ clknet_0__11377_ VSS VSS VDD VDD clknet_1_0__leaf__11377_ sky130_fd_sc_hd__clkbuf_16
Xclkbuf_1_0__f__11378_ clknet_0__11378_ VSS VSS VDD VDD clknet_1_0__leaf__11378_ sky130_fd_sc_hd__clkbuf_16
Xclkbuf_1_0__f__11379_ clknet_0__11379_ VSS VSS VDD VDD clknet_1_0__leaf__11379_ sky130_fd_sc_hd__clkbuf_16
Xclkbuf_1_0__f__11380_ clknet_0__11380_ VSS VSS VDD VDD clknet_1_0__leaf__11380_ sky130_fd_sc_hd__clkbuf_16
Xclkbuf_1_0__f__11381_ clknet_0__11381_ VSS VSS VDD VDD clknet_1_0__leaf__11381_ sky130_fd_sc_hd__clkbuf_16
Xclkbuf_1_0__f__11382_ clknet_0__11382_ VSS VSS VDD VDD clknet_1_0__leaf__11382_ sky130_fd_sc_hd__clkbuf_16
Xclkbuf_1_0__f__11383_ clknet_0__11383_ VSS VSS VDD VDD clknet_1_0__leaf__11383_ sky130_fd_sc_hd__clkbuf_16
Xclkbuf_1_0__f__11384_ clknet_0__11384_ VSS VSS VDD VDD clknet_1_0__leaf__11384_ sky130_fd_sc_hd__clkbuf_16
Xclkbuf_1_0__f__11385_ clknet_0__11385_ VSS VSS VDD VDD clknet_1_0__leaf__11385_ sky130_fd_sc_hd__clkbuf_16
Xclkbuf_1_0__f__11386_ clknet_0__11386_ VSS VSS VDD VDD clknet_1_0__leaf__11386_ sky130_fd_sc_hd__clkbuf_16
Xclkbuf_1_0__f__11387_ clknet_0__11387_ VSS VSS VDD VDD clknet_1_0__leaf__11387_ sky130_fd_sc_hd__clkbuf_16
Xclkbuf_1_0__f__11388_ clknet_0__11388_ VSS VSS VDD VDD clknet_1_0__leaf__11388_ sky130_fd_sc_hd__clkbuf_16
Xclkbuf_1_0__f__11389_ clknet_0__11389_ VSS VSS VDD VDD clknet_1_0__leaf__11389_ sky130_fd_sc_hd__clkbuf_16
Xclkbuf_1_0__f__11390_ clknet_0__11390_ VSS VSS VDD VDD clknet_1_0__leaf__11390_ sky130_fd_sc_hd__clkbuf_16
Xclkbuf_1_0__f__11391_ clknet_0__11391_ VSS VSS VDD VDD clknet_1_0__leaf__11391_ sky130_fd_sc_hd__clkbuf_16
Xclkbuf_1_0__f__11392_ clknet_0__11392_ VSS VSS VDD VDD clknet_1_0__leaf__11392_ sky130_fd_sc_hd__clkbuf_16
Xclkbuf_1_0__f__11393_ clknet_0__11393_ VSS VSS VDD VDD clknet_1_0__leaf__11393_ sky130_fd_sc_hd__clkbuf_16
Xclkbuf_1_0__f__11394_ clknet_0__11394_ VSS VSS VDD VDD clknet_1_0__leaf__11394_ sky130_fd_sc_hd__clkbuf_16
Xclkbuf_1_0__f__11395_ clknet_0__11395_ VSS VSS VDD VDD clknet_1_0__leaf__11395_ sky130_fd_sc_hd__clkbuf_16
Xclkbuf_1_0__f__11396_ clknet_0__11396_ VSS VSS VDD VDD clknet_1_0__leaf__11396_ sky130_fd_sc_hd__clkbuf_16
Xclkbuf_1_0__f__11397_ clknet_0__11397_ VSS VSS VDD VDD clknet_1_0__leaf__11397_ sky130_fd_sc_hd__clkbuf_16
Xclkbuf_1_0__f__11399_ clknet_0__11399_ VSS VSS VDD VDD clknet_1_0__leaf__11399_ sky130_fd_sc_hd__clkbuf_16
Xclkbuf_1_0__f__11400_ clknet_0__11400_ VSS VSS VDD VDD clknet_1_0__leaf__11400_ sky130_fd_sc_hd__clkbuf_16
Xclkbuf_1_0__f__11401_ clknet_0__11401_ VSS VSS VDD VDD clknet_1_0__leaf__11401_ sky130_fd_sc_hd__clkbuf_16
Xclkbuf_1_0__f__11402_ clknet_0__11402_ VSS VSS VDD VDD clknet_1_0__leaf__11402_ sky130_fd_sc_hd__clkbuf_16
Xclkbuf_1_0__f__11403_ clknet_0__11403_ VSS VSS VDD VDD clknet_1_0__leaf__11403_ sky130_fd_sc_hd__clkbuf_16
Xclkbuf_1_0__f__11404_ clknet_0__11404_ VSS VSS VDD VDD clknet_1_0__leaf__11404_ sky130_fd_sc_hd__clkbuf_16
Xclkbuf_1_0__f__11405_ clknet_0__11405_ VSS VSS VDD VDD clknet_1_0__leaf__11405_ sky130_fd_sc_hd__clkbuf_16
Xclkbuf_1_0__f__11406_ clknet_0__11406_ VSS VSS VDD VDD clknet_1_0__leaf__11406_ sky130_fd_sc_hd__clkbuf_16
Xclkbuf_1_0__f__11408_ clknet_0__11408_ VSS VSS VDD VDD clknet_1_0__leaf__11408_ sky130_fd_sc_hd__clkbuf_16
Xclkbuf_1_0__f__11409_ clknet_0__11409_ VSS VSS VDD VDD clknet_1_0__leaf__11409_ sky130_fd_sc_hd__clkbuf_16
Xclkbuf_1_0__f__11410_ clknet_0__11410_ VSS VSS VDD VDD clknet_1_0__leaf__11410_ sky130_fd_sc_hd__clkbuf_16
Xclkbuf_1_0__f__11411_ clknet_0__11411_ VSS VSS VDD VDD clknet_1_0__leaf__11411_ sky130_fd_sc_hd__clkbuf_16
Xclkbuf_1_0__f__11412_ clknet_0__11412_ VSS VSS VDD VDD clknet_1_0__leaf__11412_ sky130_fd_sc_hd__clkbuf_16
Xclkbuf_1_0__f__11413_ clknet_0__11413_ VSS VSS VDD VDD clknet_1_0__leaf__11413_ sky130_fd_sc_hd__clkbuf_16
Xclkbuf_1_0__f__11414_ clknet_0__11414_ VSS VSS VDD VDD clknet_1_0__leaf__11414_ sky130_fd_sc_hd__clkbuf_16
Xclkbuf_1_0__f__11416_ clknet_0__11416_ VSS VSS VDD VDD clknet_1_0__leaf__11416_ sky130_fd_sc_hd__clkbuf_16
Xclkbuf_1_0__f__11417_ clknet_0__11417_ VSS VSS VDD VDD clknet_1_0__leaf__11417_ sky130_fd_sc_hd__clkbuf_16
Xclkbuf_1_0__f__11418_ clknet_0__11418_ VSS VSS VDD VDD clknet_1_0__leaf__11418_ sky130_fd_sc_hd__clkbuf_16
Xclkbuf_1_0__f__11420_ clknet_0__11420_ VSS VSS VDD VDD clknet_1_0__leaf__11420_ sky130_fd_sc_hd__clkbuf_16
Xclkbuf_1_0__f__11424_ clknet_0__11424_ VSS VSS VDD VDD clknet_1_0__leaf__11424_ sky130_fd_sc_hd__clkbuf_16
Xclkbuf_1_0__f__11426_ clknet_0__11426_ VSS VSS VDD VDD clknet_1_0__leaf__11426_ sky130_fd_sc_hd__clkbuf_16
Xclkbuf_1_0__f__11427_ clknet_0__11427_ VSS VSS VDD VDD clknet_1_0__leaf__11427_ sky130_fd_sc_hd__clkbuf_16
Xclkbuf_1_0__f_clk delaynet_19_clk VSS VSS VDD VDD clknet_1_0__leaf_clk sky130_fd_sc_hd__clkbuf_16
Xclkbuf_1_1__f__11348_ clknet_0__11348_ VSS VSS VDD VDD clknet_1_1__leaf__11348_ sky130_fd_sc_hd__clkbuf_16
Xclkbuf_1_1__f__11352_ clknet_0__11352_ VSS VSS VDD VDD clknet_1_1__leaf__11352_ sky130_fd_sc_hd__clkbuf_16
Xclkbuf_1_1__f__11355_ clknet_0__11355_ VSS VSS VDD VDD clknet_1_1__leaf__11355_ sky130_fd_sc_hd__clkbuf_16
Xclkbuf_1_1__f__11356_ clknet_0__11356_ VSS VSS VDD VDD clknet_1_1__leaf__11356_ sky130_fd_sc_hd__clkbuf_16
Xclkbuf_1_1__f__11357_ clknet_0__11357_ VSS VSS VDD VDD clknet_1_1__leaf__11357_ sky130_fd_sc_hd__clkbuf_16
Xclkbuf_1_1__f__11358_ clknet_0__11358_ VSS VSS VDD VDD clknet_1_1__leaf__11358_ sky130_fd_sc_hd__clkbuf_16
Xclkbuf_1_1__f__11359_ clknet_0__11359_ VSS VSS VDD VDD clknet_1_1__leaf__11359_ sky130_fd_sc_hd__clkbuf_16
Xclkbuf_1_1__f__11360_ clknet_0__11360_ VSS VSS VDD VDD clknet_1_1__leaf__11360_ sky130_fd_sc_hd__clkbuf_16
Xclkbuf_1_1__f__11362_ clknet_0__11362_ VSS VSS VDD VDD clknet_1_1__leaf__11362_ sky130_fd_sc_hd__clkbuf_16
Xclkbuf_1_1__f__11363_ clknet_0__11363_ VSS VSS VDD VDD clknet_1_1__leaf__11363_ sky130_fd_sc_hd__clkbuf_16
Xclkbuf_1_1__f__11364_ clknet_0__11364_ VSS VSS VDD VDD clknet_1_1__leaf__11364_ sky130_fd_sc_hd__clkbuf_16
Xclkbuf_1_1__f__11365_ clknet_0__11365_ VSS VSS VDD VDD clknet_1_1__leaf__11365_ sky130_fd_sc_hd__clkbuf_16
Xclkbuf_1_1__f__11366_ clknet_0__11366_ VSS VSS VDD VDD clknet_1_1__leaf__11366_ sky130_fd_sc_hd__clkbuf_16
Xclkbuf_1_1__f__11367_ clknet_0__11367_ VSS VSS VDD VDD clknet_1_1__leaf__11367_ sky130_fd_sc_hd__clkbuf_16
Xclkbuf_1_1__f__11368_ clknet_0__11368_ VSS VSS VDD VDD clknet_1_1__leaf__11368_ sky130_fd_sc_hd__clkbuf_16
Xclkbuf_1_1__f__11369_ clknet_0__11369_ VSS VSS VDD VDD clknet_1_1__leaf__11369_ sky130_fd_sc_hd__clkbuf_16
Xclkbuf_1_1__f__11370_ clknet_0__11370_ VSS VSS VDD VDD clknet_1_1__leaf__11370_ sky130_fd_sc_hd__clkbuf_16
Xclkbuf_1_1__f__11371_ clknet_0__11371_ VSS VSS VDD VDD clknet_1_1__leaf__11371_ sky130_fd_sc_hd__clkbuf_16
Xclkbuf_1_1__f__11372_ clknet_0__11372_ VSS VSS VDD VDD clknet_1_1__leaf__11372_ sky130_fd_sc_hd__clkbuf_16
Xclkbuf_1_1__f__11373_ clknet_0__11373_ VSS VSS VDD VDD clknet_1_1__leaf__11373_ sky130_fd_sc_hd__clkbuf_16
Xclkbuf_1_1__f__11374_ clknet_0__11374_ VSS VSS VDD VDD clknet_1_1__leaf__11374_ sky130_fd_sc_hd__clkbuf_16
Xclkbuf_1_1__f__11375_ clknet_0__11375_ VSS VSS VDD VDD clknet_1_1__leaf__11375_ sky130_fd_sc_hd__clkbuf_16
Xclkbuf_1_1__f__11376_ clknet_0__11376_ VSS VSS VDD VDD clknet_1_1__leaf__11376_ sky130_fd_sc_hd__clkbuf_16
Xclkbuf_1_1__f__11377_ clknet_0__11377_ VSS VSS VDD VDD clknet_1_1__leaf__11377_ sky130_fd_sc_hd__clkbuf_16
Xclkbuf_1_1__f__11378_ clknet_0__11378_ VSS VSS VDD VDD clknet_1_1__leaf__11378_ sky130_fd_sc_hd__clkbuf_16
Xclkbuf_1_1__f__11379_ clknet_0__11379_ VSS VSS VDD VDD clknet_1_1__leaf__11379_ sky130_fd_sc_hd__clkbuf_16
Xclkbuf_1_1__f__11380_ clknet_0__11380_ VSS VSS VDD VDD clknet_1_1__leaf__11380_ sky130_fd_sc_hd__clkbuf_16
Xclkbuf_1_1__f__11381_ clknet_0__11381_ VSS VSS VDD VDD clknet_1_1__leaf__11381_ sky130_fd_sc_hd__clkbuf_16
Xclkbuf_1_1__f__11382_ clknet_0__11382_ VSS VSS VDD VDD clknet_1_1__leaf__11382_ sky130_fd_sc_hd__clkbuf_16
Xclkbuf_1_1__f__11383_ clknet_0__11383_ VSS VSS VDD VDD clknet_1_1__leaf__11383_ sky130_fd_sc_hd__clkbuf_16
Xclkbuf_1_1__f__11384_ clknet_0__11384_ VSS VSS VDD VDD clknet_1_1__leaf__11384_ sky130_fd_sc_hd__clkbuf_16
Xclkbuf_1_1__f__11385_ clknet_0__11385_ VSS VSS VDD VDD clknet_1_1__leaf__11385_ sky130_fd_sc_hd__clkbuf_16
Xclkbuf_1_1__f__11386_ clknet_0__11386_ VSS VSS VDD VDD clknet_1_1__leaf__11386_ sky130_fd_sc_hd__clkbuf_16
Xclkbuf_1_1__f__11387_ clknet_0__11387_ VSS VSS VDD VDD clknet_1_1__leaf__11387_ sky130_fd_sc_hd__clkbuf_16
Xclkbuf_1_1__f__11388_ clknet_0__11388_ VSS VSS VDD VDD clknet_1_1__leaf__11388_ sky130_fd_sc_hd__clkbuf_16
Xclkbuf_1_1__f__11389_ clknet_0__11389_ VSS VSS VDD VDD clknet_1_1__leaf__11389_ sky130_fd_sc_hd__clkbuf_16
Xclkbuf_1_1__f__11390_ clknet_0__11390_ VSS VSS VDD VDD clknet_1_1__leaf__11390_ sky130_fd_sc_hd__clkbuf_16
Xclkbuf_1_1__f__11391_ clknet_0__11391_ VSS VSS VDD VDD clknet_1_1__leaf__11391_ sky130_fd_sc_hd__clkbuf_16
Xclkbuf_1_1__f__11392_ clknet_0__11392_ VSS VSS VDD VDD clknet_1_1__leaf__11392_ sky130_fd_sc_hd__clkbuf_16
Xclkbuf_1_1__f__11393_ clknet_0__11393_ VSS VSS VDD VDD clknet_1_1__leaf__11393_ sky130_fd_sc_hd__clkbuf_16
Xclkbuf_1_1__f__11394_ clknet_0__11394_ VSS VSS VDD VDD clknet_1_1__leaf__11394_ sky130_fd_sc_hd__clkbuf_16
Xclkbuf_1_1__f__11395_ clknet_0__11395_ VSS VSS VDD VDD clknet_1_1__leaf__11395_ sky130_fd_sc_hd__clkbuf_16
Xclkbuf_1_1__f__11396_ clknet_0__11396_ VSS VSS VDD VDD clknet_1_1__leaf__11396_ sky130_fd_sc_hd__clkbuf_16
Xclkbuf_1_1__f__11397_ clknet_0__11397_ VSS VSS VDD VDD clknet_1_1__leaf__11397_ sky130_fd_sc_hd__clkbuf_16
Xclkbuf_1_1__f__11399_ clknet_0__11399_ VSS VSS VDD VDD clknet_1_1__leaf__11399_ sky130_fd_sc_hd__clkbuf_16
Xclkbuf_1_1__f__11400_ clknet_0__11400_ VSS VSS VDD VDD clknet_1_1__leaf__11400_ sky130_fd_sc_hd__clkbuf_16
Xclkbuf_1_1__f__11401_ clknet_0__11401_ VSS VSS VDD VDD clknet_1_1__leaf__11401_ sky130_fd_sc_hd__clkbuf_16
Xclkbuf_1_1__f__11402_ clknet_0__11402_ VSS VSS VDD VDD clknet_1_1__leaf__11402_ sky130_fd_sc_hd__clkbuf_16
Xclkbuf_1_1__f__11403_ clknet_0__11403_ VSS VSS VDD VDD clknet_1_1__leaf__11403_ sky130_fd_sc_hd__clkbuf_16
Xclkbuf_1_1__f__11404_ clknet_0__11404_ VSS VSS VDD VDD clknet_1_1__leaf__11404_ sky130_fd_sc_hd__clkbuf_16
Xclkbuf_1_1__f__11405_ clknet_0__11405_ VSS VSS VDD VDD clknet_1_1__leaf__11405_ sky130_fd_sc_hd__clkbuf_16
Xclkbuf_1_1__f__11406_ clknet_0__11406_ VSS VSS VDD VDD clknet_1_1__leaf__11406_ sky130_fd_sc_hd__clkbuf_16
Xclkbuf_1_1__f__11408_ clknet_0__11408_ VSS VSS VDD VDD clknet_1_1__leaf__11408_ sky130_fd_sc_hd__clkbuf_16
Xclkbuf_1_1__f__11409_ clknet_0__11409_ VSS VSS VDD VDD clknet_1_1__leaf__11409_ sky130_fd_sc_hd__clkbuf_16
Xclkbuf_1_1__f__11410_ clknet_0__11410_ VSS VSS VDD VDD clknet_1_1__leaf__11410_ sky130_fd_sc_hd__clkbuf_16
Xclkbuf_1_1__f__11411_ clknet_0__11411_ VSS VSS VDD VDD clknet_1_1__leaf__11411_ sky130_fd_sc_hd__clkbuf_16
Xclkbuf_1_1__f__11412_ clknet_0__11412_ VSS VSS VDD VDD clknet_1_1__leaf__11412_ sky130_fd_sc_hd__clkbuf_16
Xclkbuf_1_1__f__11413_ clknet_0__11413_ VSS VSS VDD VDD clknet_1_1__leaf__11413_ sky130_fd_sc_hd__clkbuf_16
Xclkbuf_1_1__f__11414_ clknet_0__11414_ VSS VSS VDD VDD clknet_1_1__leaf__11414_ sky130_fd_sc_hd__clkbuf_16
Xclkbuf_1_1__f__11416_ clknet_0__11416_ VSS VSS VDD VDD clknet_1_1__leaf__11416_ sky130_fd_sc_hd__clkbuf_16
Xclkbuf_1_1__f__11417_ clknet_0__11417_ VSS VSS VDD VDD clknet_1_1__leaf__11417_ sky130_fd_sc_hd__clkbuf_16
Xclkbuf_1_1__f__11418_ clknet_0__11418_ VSS VSS VDD VDD clknet_1_1__leaf__11418_ sky130_fd_sc_hd__clkbuf_16
Xclkbuf_1_1__f__11420_ clknet_0__11420_ VSS VSS VDD VDD clknet_1_1__leaf__11420_ sky130_fd_sc_hd__clkbuf_16
Xclkbuf_1_1__f__11424_ clknet_0__11424_ VSS VSS VDD VDD clknet_1_1__leaf__11424_ sky130_fd_sc_hd__clkbuf_16
Xclkbuf_1_1__f__11426_ clknet_0__11426_ VSS VSS VDD VDD clknet_1_1__leaf__11426_ sky130_fd_sc_hd__clkbuf_16
Xclkbuf_1_1__f__11427_ clknet_0__11427_ VSS VSS VDD VDD clknet_1_1__leaf__11427_ sky130_fd_sc_hd__clkbuf_16
Xclkbuf_1_1__f_clk clknet_0_clk VSS VSS VDD VDD clknet_1_1__leaf_clk sky130_fd_sc_hd__clkbuf_16
Xclkbuf_2_0__f__11361_ clknet_0__11361_ VSS VSS VDD VDD clknet_2_0__leaf__11361_ sky130_fd_sc_hd__clkbuf_16
Xclkbuf_2_0__f__11398_ clknet_0__11398_ VSS VSS VDD VDD clknet_2_0__leaf__11398_ sky130_fd_sc_hd__clkbuf_16
Xclkbuf_2_0__f__11415_ clknet_0__11415_ VSS VSS VDD VDD clknet_2_0__leaf__11415_ sky130_fd_sc_hd__clkbuf_16
Xclkbuf_2_0__f__11419_ clknet_0__11419_ VSS VSS VDD VDD clknet_2_0__leaf__11419_ sky130_fd_sc_hd__clkbuf_16
Xclkbuf_2_0__f__11421_ clknet_0__11421_ VSS VSS VDD VDD clknet_2_0__leaf__11421_ sky130_fd_sc_hd__clkbuf_16
Xclkbuf_2_0__f__11422_ clknet_0__11422_ VSS VSS VDD VDD clknet_2_0__leaf__11422_ sky130_fd_sc_hd__clkbuf_16
Xclkbuf_2_0__f__11425_ clknet_0__11425_ VSS VSS VDD VDD clknet_2_0__leaf__11425_ sky130_fd_sc_hd__clkbuf_16
Xclkbuf_2_0__f__11428_ clknet_0__11428_ VSS VSS VDD VDD clknet_2_0__leaf__11428_ sky130_fd_sc_hd__clkbuf_16
Xclkbuf_2_1__f__11361_ clknet_0__11361_ VSS VSS VDD VDD clknet_2_1__leaf__11361_ sky130_fd_sc_hd__clkbuf_16
Xclkbuf_2_1__f__11398_ clknet_0__11398_ VSS VSS VDD VDD clknet_2_1__leaf__11398_ sky130_fd_sc_hd__clkbuf_16
Xclkbuf_2_1__f__11415_ clknet_0__11415_ VSS VSS VDD VDD clknet_2_1__leaf__11415_ sky130_fd_sc_hd__clkbuf_16
Xclkbuf_2_1__f__11419_ clknet_0__11419_ VSS VSS VDD VDD clknet_2_1__leaf__11419_ sky130_fd_sc_hd__clkbuf_16
Xclkbuf_2_1__f__11421_ clknet_0__11421_ VSS VSS VDD VDD clknet_2_1__leaf__11421_ sky130_fd_sc_hd__clkbuf_16
Xclkbuf_2_1__f__11422_ clknet_0__11422_ VSS VSS VDD VDD clknet_2_1__leaf__11422_ sky130_fd_sc_hd__clkbuf_16
Xclkbuf_2_1__f__11425_ clknet_0__11425_ VSS VSS VDD VDD clknet_2_1__leaf__11425_ sky130_fd_sc_hd__clkbuf_16
Xclkbuf_2_1__f__11428_ clknet_0__11428_ VSS VSS VDD VDD clknet_2_1__leaf__11428_ sky130_fd_sc_hd__clkbuf_16
Xclkbuf_2_2__f__11361_ clknet_0__11361_ VSS VSS VDD VDD clknet_2_2__leaf__11361_ sky130_fd_sc_hd__clkbuf_16
Xclkbuf_2_2__f__11398_ clknet_0__11398_ VSS VSS VDD VDD clknet_2_2__leaf__11398_ sky130_fd_sc_hd__clkbuf_16
Xclkbuf_2_2__f__11415_ clknet_0__11415_ VSS VSS VDD VDD clknet_2_2__leaf__11415_ sky130_fd_sc_hd__clkbuf_16
Xclkbuf_2_2__f__11419_ clknet_0__11419_ VSS VSS VDD VDD clknet_2_2__leaf__11419_ sky130_fd_sc_hd__clkbuf_16
Xclkbuf_2_2__f__11421_ clknet_0__11421_ VSS VSS VDD VDD clknet_2_2__leaf__11421_ sky130_fd_sc_hd__clkbuf_16
Xclkbuf_2_2__f__11422_ clknet_0__11422_ VSS VSS VDD VDD clknet_2_2__leaf__11422_ sky130_fd_sc_hd__clkbuf_16
Xclkbuf_2_2__f__11425_ clknet_0__11425_ VSS VSS VDD VDD clknet_2_2__leaf__11425_ sky130_fd_sc_hd__clkbuf_16
Xclkbuf_2_2__f__11428_ clknet_0__11428_ VSS VSS VDD VDD clknet_2_2__leaf__11428_ sky130_fd_sc_hd__clkbuf_16
Xclkbuf_2_3__f__11361_ clknet_0__11361_ VSS VSS VDD VDD clknet_2_3__leaf__11361_ sky130_fd_sc_hd__clkbuf_16
Xclkbuf_2_3__f__11398_ clknet_0__11398_ VSS VSS VDD VDD clknet_2_3__leaf__11398_ sky130_fd_sc_hd__clkbuf_16
Xclkbuf_2_3__f__11415_ clknet_0__11415_ VSS VSS VDD VDD clknet_2_3__leaf__11415_ sky130_fd_sc_hd__clkbuf_16
Xclkbuf_2_3__f__11419_ clknet_0__11419_ VSS VSS VDD VDD clknet_2_3__leaf__11419_ sky130_fd_sc_hd__clkbuf_16
Xclkbuf_2_3__f__11421_ clknet_0__11421_ VSS VSS VDD VDD clknet_2_3__leaf__11421_ sky130_fd_sc_hd__clkbuf_16
Xclkbuf_2_3__f__11422_ clknet_0__11422_ VSS VSS VDD VDD clknet_2_3__leaf__11422_ sky130_fd_sc_hd__clkbuf_16
Xclkbuf_2_3__f__11425_ clknet_0__11425_ VSS VSS VDD VDD clknet_2_3__leaf__11425_ sky130_fd_sc_hd__clkbuf_16
Xclkbuf_2_3__f__11428_ clknet_0__11428_ VSS VSS VDD VDD clknet_2_3__leaf__11428_ sky130_fd_sc_hd__clkbuf_16
Xclkbuf_3_0__f__11407_ clknet_0__11407_ VSS VSS VDD VDD clknet_3_0__leaf__11407_ sky130_fd_sc_hd__clkbuf_16
Xclkbuf_3_0__f__11429_ clknet_0__11429_ VSS VSS VDD VDD clknet_3_0__leaf__11429_ sky130_fd_sc_hd__clkbuf_16
Xclkbuf_3_0__f_clk_regs clknet_0_clk_regs VSS VSS VDD VDD clknet_3_0__leaf_clk_regs sky130_fd_sc_hd__clkbuf_16
Xclkbuf_3_1__f__11407_ clknet_0__11407_ VSS VSS VDD VDD clknet_3_1__leaf__11407_ sky130_fd_sc_hd__clkbuf_16
Xclkbuf_3_1__f__11429_ clknet_0__11429_ VSS VSS VDD VDD clknet_3_1__leaf__11429_ sky130_fd_sc_hd__clkbuf_16
Xclkbuf_3_1__f_clk_regs clknet_0_clk_regs VSS VSS VDD VDD clknet_3_1__leaf_clk_regs sky130_fd_sc_hd__clkbuf_16
Xclkbuf_3_2__f__11407_ clknet_0__11407_ VSS VSS VDD VDD clknet_3_2__leaf__11407_ sky130_fd_sc_hd__clkbuf_16
Xclkbuf_3_2__f__11429_ clknet_0__11429_ VSS VSS VDD VDD clknet_3_2__leaf__11429_ sky130_fd_sc_hd__clkbuf_16
Xclkbuf_3_2__f_clk_regs clknet_0_clk_regs VSS VSS VDD VDD clknet_3_2__leaf_clk_regs sky130_fd_sc_hd__clkbuf_16
Xclkbuf_3_3__f__11407_ clknet_0__11407_ VSS VSS VDD VDD clknet_3_3__leaf__11407_ sky130_fd_sc_hd__clkbuf_16
Xclkbuf_3_3__f__11429_ clknet_0__11429_ VSS VSS VDD VDD clknet_3_3__leaf__11429_ sky130_fd_sc_hd__clkbuf_16
Xclkbuf_3_3__f_clk_regs clknet_0_clk_regs VSS VSS VDD VDD clknet_3_3__leaf_clk_regs sky130_fd_sc_hd__clkbuf_16
Xclkbuf_3_4__f__11407_ clknet_0__11407_ VSS VSS VDD VDD clknet_3_4__leaf__11407_ sky130_fd_sc_hd__clkbuf_16
Xclkbuf_3_4__f__11429_ clknet_0__11429_ VSS VSS VDD VDD clknet_3_4__leaf__11429_ sky130_fd_sc_hd__clkbuf_16
Xclkbuf_3_4__f_clk_regs clknet_0_clk_regs VSS VSS VDD VDD clknet_3_4__leaf_clk_regs sky130_fd_sc_hd__clkbuf_16
Xclkbuf_3_5__f__11407_ clknet_0__11407_ VSS VSS VDD VDD clknet_3_5__leaf__11407_ sky130_fd_sc_hd__clkbuf_16
Xclkbuf_3_5__f__11429_ clknet_0__11429_ VSS VSS VDD VDD clknet_3_5__leaf__11429_ sky130_fd_sc_hd__clkbuf_16
Xclkbuf_3_5__f_clk_regs clknet_0_clk_regs VSS VSS VDD VDD clknet_3_5__leaf_clk_regs sky130_fd_sc_hd__clkbuf_16
Xclkbuf_3_6__f__11407_ clknet_0__11407_ VSS VSS VDD VDD clknet_3_6__leaf__11407_ sky130_fd_sc_hd__clkbuf_16
Xclkbuf_3_6__f__11429_ clknet_0__11429_ VSS VSS VDD VDD clknet_3_6__leaf__11429_ sky130_fd_sc_hd__clkbuf_16
Xclkbuf_3_6__f_clk_regs clknet_0_clk_regs VSS VSS VDD VDD clknet_3_6__leaf_clk_regs sky130_fd_sc_hd__clkbuf_16
Xclkbuf_3_7__f__11407_ clknet_0__11407_ VSS VSS VDD VDD clknet_3_7__leaf__11407_ sky130_fd_sc_hd__clkbuf_16
Xclkbuf_3_7__f__11429_ clknet_0__11429_ VSS VSS VDD VDD clknet_3_7__leaf__11429_ sky130_fd_sc_hd__clkbuf_16
Xclkbuf_3_7__f_clk_regs clknet_0_clk_regs VSS VSS VDD VDD clknet_3_7__leaf_clk_regs sky130_fd_sc_hd__clkbuf_16
Xclkbuf_4_0_0__11423_ clknet_0__11423_ VSS VSS VDD VDD clknet_4_0_0__11423_ sky130_fd_sc_hd__clkbuf_16
Xclkbuf_4_10_0__11423_ clknet_0__11423_ VSS VSS VDD VDD clknet_4_10_0__11423_ sky130_fd_sc_hd__clkbuf_16
Xclkbuf_4_11_0__11423_ clknet_0__11423_ VSS VSS VDD VDD clknet_4_11_0__11423_ sky130_fd_sc_hd__clkbuf_16
Xclkbuf_4_12_0__11423_ clknet_0__11423_ VSS VSS VDD VDD clknet_4_12_0__11423_ sky130_fd_sc_hd__clkbuf_16
Xclkbuf_4_13_0__11423_ clknet_0__11423_ VSS VSS VDD VDD clknet_4_13_0__11423_ sky130_fd_sc_hd__clkbuf_16
Xclkbuf_4_14_0__11423_ clknet_0__11423_ VSS VSS VDD VDD clknet_4_14_0__11423_ sky130_fd_sc_hd__clkbuf_16
Xclkbuf_4_15_0__11423_ clknet_0__11423_ VSS VSS VDD VDD clknet_4_15_0__11423_ sky130_fd_sc_hd__clkbuf_16
Xclkbuf_4_1_0__11423_ clknet_0__11423_ VSS VSS VDD VDD clknet_4_1_0__11423_ sky130_fd_sc_hd__clkbuf_16
Xclkbuf_4_2_0__11423_ clknet_0__11423_ VSS VSS VDD VDD clknet_4_2_0__11423_ sky130_fd_sc_hd__clkbuf_16
Xclkbuf_4_3_0__11423_ clknet_0__11423_ VSS VSS VDD VDD clknet_4_3_0__11423_ sky130_fd_sc_hd__clkbuf_16
Xclkbuf_4_4_0__11423_ clknet_0__11423_ VSS VSS VDD VDD clknet_4_4_0__11423_ sky130_fd_sc_hd__clkbuf_16
Xclkbuf_4_5_0__11423_ clknet_0__11423_ VSS VSS VDD VDD clknet_4_5_0__11423_ sky130_fd_sc_hd__clkbuf_16
Xclkbuf_4_6_0__11423_ clknet_0__11423_ VSS VSS VDD VDD clknet_4_6_0__11423_ sky130_fd_sc_hd__clkbuf_16
Xclkbuf_4_7_0__11423_ clknet_0__11423_ VSS VSS VDD VDD clknet_4_7_0__11423_ sky130_fd_sc_hd__clkbuf_16
Xclkbuf_4_8_0__11423_ clknet_0__11423_ VSS VSS VDD VDD clknet_4_8_0__11423_ sky130_fd_sc_hd__clkbuf_16
Xclkbuf_4_9_0__11423_ clknet_0__11423_ VSS VSS VDD VDD clknet_4_9_0__11423_ sky130_fd_sc_hd__clkbuf_16
Xclkbuf_leaf_0_clk clknet_1_0__leaf_clk VSS VSS VDD VDD clknet_leaf_0_clk sky130_fd_sc_hd__clkbuf_16
Xclkbuf_leaf_10_clk delaynet_14_clk VSS VSS VDD VDD clknet_leaf_10_clk sky130_fd_sc_hd__clkbuf_16
Xclkbuf_leaf_11_clk delaynet_14_clk VSS VSS VDD VDD clknet_leaf_11_clk sky130_fd_sc_hd__clkbuf_16
Xclkbuf_leaf_12_clk delaynet_14_clk VSS VSS VDD VDD clknet_leaf_12_clk sky130_fd_sc_hd__clkbuf_16
Xclkbuf_leaf_13_clk delaynet_14_clk VSS VSS VDD VDD clknet_leaf_13_clk sky130_fd_sc_hd__clkbuf_16
Xclkbuf_leaf_14_clk delaynet_14_clk VSS VSS VDD VDD clknet_leaf_14_clk sky130_fd_sc_hd__clkbuf_16
Xclkbuf_leaf_15_clk delaynet_14_clk VSS VSS VDD VDD clknet_leaf_15_clk sky130_fd_sc_hd__clkbuf_16
Xclkbuf_leaf_16_clk clknet_1_1__leaf_clk VSS VSS VDD VDD clknet_leaf_16_clk sky130_fd_sc_hd__clkbuf_16
Xclkbuf_leaf_17_clk delaynet_14_clk VSS VSS VDD VDD clknet_leaf_17_clk sky130_fd_sc_hd__clkbuf_16
Xclkbuf_leaf_18_clk delaynet_14_clk VSS VSS VDD VDD clknet_leaf_18_clk sky130_fd_sc_hd__clkbuf_16
Xclkbuf_leaf_19_clk clknet_1_0__leaf_clk VSS VSS VDD VDD clknet_leaf_19_clk sky130_fd_sc_hd__clkbuf_16
Xclkbuf_leaf_1_clk clknet_1_0__leaf_clk VSS VSS VDD VDD clknet_leaf_1_clk sky130_fd_sc_hd__clkbuf_16
Xclkbuf_leaf_20_clk clknet_1_0__leaf_clk VSS VSS VDD VDD clknet_leaf_20_clk sky130_fd_sc_hd__clkbuf_16
Xclkbuf_leaf_21_clk clknet_1_0__leaf_clk VSS VSS VDD VDD clknet_leaf_21_clk sky130_fd_sc_hd__clkbuf_16
Xclkbuf_leaf_2_clk clknet_1_0__leaf_clk VSS VSS VDD VDD clknet_leaf_2_clk sky130_fd_sc_hd__clkbuf_16
Xclkbuf_leaf_3_clk clknet_1_0__leaf_clk VSS VSS VDD VDD clknet_leaf_3_clk sky130_fd_sc_hd__clkbuf_16
Xclkbuf_leaf_4_clk clknet_1_0__leaf_clk VSS VSS VDD VDD clknet_leaf_4_clk sky130_fd_sc_hd__clkbuf_16
Xclkbuf_leaf_5_clk clknet_1_0__leaf_clk VSS VSS VDD VDD clknet_leaf_5_clk sky130_fd_sc_hd__clkbuf_16
Xclkbuf_leaf_6_clk clknet_1_0__leaf_clk VSS VSS VDD VDD clknet_leaf_6_clk sky130_fd_sc_hd__clkbuf_16
Xclkbuf_leaf_7_clk clknet_1_0__leaf_clk VSS VSS VDD VDD clknet_leaf_7_clk sky130_fd_sc_hd__clkbuf_16
Xclkbuf_leaf_8_clk clknet_1_0__leaf_clk VSS VSS VDD VDD clknet_leaf_8_clk sky130_fd_sc_hd__clkbuf_16
Xclkbuf_leaf_9_clk clknet_1_0__leaf_clk VSS VSS VDD VDD clknet_leaf_9_clk sky130_fd_sc_hd__clkbuf_16
Xclkbuf_regs_0_clk delaynet_21_clk VSS VSS VDD VDD clk_regs sky130_fd_sc_hd__clkbuf_16
Xclkload0 clknet_1_1__leaf_clk VSS VSS VDD VDD nc_clkload0_Y sky130_fd_sc_hd__inv_16
Xclkload1 clknet_leaf_9_clk VSS VSS VDD VDD nc_clkload1_X sky130_fd_sc_hd__clkbuf_8
Xclkload10 clknet_3_6__leaf_clk_regs VSS VSS VDD VDD nc_clkload10_Y sky130_fd_sc_hd__clkinv_4
Xclkload100 clknet_2_2__leaf__11361_ VSS VSS VDD VDD nc_clkload100_Y sky130_fd_sc_hd__bufinv_16
Xclkload101 clknet_1_1__leaf__11360_ VSS VSS VDD VDD nc_clkload101_X sky130_fd_sc_hd__clkbuf_1
Xclkload102 clknet_1_1__leaf__11356_ VSS VSS VDD VDD nc_clkload102_X sky130_fd_sc_hd__clkbuf_1
Xclkload103 clknet_1_0__leaf__11355_ VSS VSS VDD VDD nc_clkload103_X sky130_fd_sc_hd__clkbuf_1
Xclkload104 clknet_1_1__leaf__11352_ VSS VSS VDD VDD nc_clkload104_X sky130_fd_sc_hd__clkbuf_1
Xclkload11 clknet_3_0__leaf__11429_ VSS VSS VDD VDD nc_clkload11_Y sky130_fd_sc_hd__clkinv_4
Xclkload12 clknet_3_1__leaf__11429_ VSS VSS VDD VDD nc_clkload12_Y sky130_fd_sc_hd__bufinv_16
Xclkload13 clknet_3_2__leaf__11429_ VSS VSS VDD VDD nc_clkload13_Y sky130_fd_sc_hd__bufinv_16
Xclkload14 clknet_3_4__leaf__11429_ VSS VSS VDD VDD nc_clkload14_Y sky130_fd_sc_hd__inv_6
Xclkload15 clknet_3_5__leaf__11429_ VSS VSS VDD VDD nc_clkload15_Y sky130_fd_sc_hd__clkinv_4
Xclkload16 clknet_3_6__leaf__11429_ VSS VSS VDD VDD nc_clkload16_Y sky130_fd_sc_hd__bufinv_16
Xclkload17 clknet_3_7__leaf__11429_ VSS VSS VDD VDD nc_clkload17_Y sky130_fd_sc_hd__clkinv_4
Xclkload18 clknet_2_1__leaf__11428_ VSS VSS VDD VDD nc_clkload18_Y sky130_fd_sc_hd__clkinv_1
Xclkload19 clknet_2_2__leaf__11428_ VSS VSS VDD VDD nc_clkload19_Y sky130_fd_sc_hd__clkinv_1
Xclkload2 clknet_leaf_16_clk VSS VSS VDD VDD nc_clkload2_X sky130_fd_sc_hd__clkbuf_8
Xclkload20 clknet_1_0__leaf__11427_ VSS VSS VDD VDD nc_clkload20_Y sky130_fd_sc_hd__clkinv_1
Xclkload21 clknet_1_0__leaf__11426_ VSS VSS VDD VDD nc_clkload21_X sky130_fd_sc_hd__clkbuf_1
Xclkload22 clknet_2_0__leaf__11425_ VSS VSS VDD VDD nc_clkload22_Y sky130_fd_sc_hd__bufinv_16
Xclkload23 clknet_2_2__leaf__11425_ VSS VSS VDD VDD nc_clkload23_Y sky130_fd_sc_hd__clkinv_1
Xclkload24 clknet_2_3__leaf__11425_ VSS VSS VDD VDD nc_clkload24_Y sky130_fd_sc_hd__clkinv_4
Xclkload25 clknet_1_0__leaf__11424_ VSS VSS VDD VDD nc_clkload25_Y sky130_fd_sc_hd__clkinv_1
Xclkload26 clknet_4_0_0__11423_ VSS VSS VDD VDD nc_clkload26_Y sky130_fd_sc_hd__clkinv_2
Xclkload27 clknet_4_1_0__11423_ VSS VSS VDD VDD nc_clkload27_Y sky130_fd_sc_hd__clkinvlp_4
Xclkload28 clknet_4_2_0__11423_ VSS VSS VDD VDD nc_clkload28_Y sky130_fd_sc_hd__inv_8
Xclkload29 clknet_4_3_0__11423_ VSS VSS VDD VDD nc_clkload29_Y sky130_fd_sc_hd__inv_6
Xclkload3 clknet_leaf_17_clk VSS VSS VDD VDD nc_clkload3_X sky130_fd_sc_hd__clkbuf_8
Xclkload30 clknet_4_4_0__11423_ VSS VSS VDD VDD nc_clkload30_Y sky130_fd_sc_hd__inv_6
Xclkload31 clknet_4_5_0__11423_ VSS VSS VDD VDD nc_clkload31_Y sky130_fd_sc_hd__inv_8
Xclkload32 clknet_4_6_0__11423_ VSS VSS VDD VDD nc_clkload32_Y sky130_fd_sc_hd__inv_6
Xclkload33 clknet_4_7_0__11423_ VSS VSS VDD VDD nc_clkload33_Y sky130_fd_sc_hd__inv_6
Xclkload34 clknet_4_8_0__11423_ VSS VSS VDD VDD nc_clkload34_Y sky130_fd_sc_hd__inv_6
Xclkload35 clknet_4_9_0__11423_ VSS VSS VDD VDD nc_clkload35_Y sky130_fd_sc_hd__inv_6
Xclkload36 clknet_4_10_0__11423_ VSS VSS VDD VDD nc_clkload36_Y sky130_fd_sc_hd__inv_6
Xclkload37 clknet_4_11_0__11423_ VSS VSS VDD VDD nc_clkload37_Y sky130_fd_sc_hd__inv_8
Xclkload38 clknet_4_12_0__11423_ VSS VSS VDD VDD nc_clkload38_Y sky130_fd_sc_hd__clkinv_4
Xclkload39 clknet_4_13_0__11423_ VSS VSS VDD VDD nc_clkload39_Y sky130_fd_sc_hd__inv_6
Xclkload4 clknet_3_0__leaf_clk_regs VSS VSS VDD VDD nc_clkload4_Y sky130_fd_sc_hd__inv_8
Xclkload40 clknet_4_14_0__11423_ VSS VSS VDD VDD nc_clkload40_Y sky130_fd_sc_hd__clkinvlp_4
Xclkload41 clknet_2_0__leaf__11422_ VSS VSS VDD VDD nc_clkload41_Y sky130_fd_sc_hd__clkinv_1
Xclkload42 clknet_2_2__leaf__11422_ VSS VSS VDD VDD nc_clkload42_Y sky130_fd_sc_hd__clkinv_2
Xclkload43 clknet_2_3__leaf__11422_ VSS VSS VDD VDD nc_clkload43_Y sky130_fd_sc_hd__inv_6
Xclkload44 clknet_2_1__leaf__11421_ VSS VSS VDD VDD nc_clkload44_Y sky130_fd_sc_hd__clkinv_4
Xclkload45 clknet_2_2__leaf__11421_ VSS VSS VDD VDD nc_clkload45_Y sky130_fd_sc_hd__inv_8
Xclkload46 clknet_2_3__leaf__11421_ VSS VSS VDD VDD nc_clkload46_Y sky130_fd_sc_hd__clkinv_4
Xclkload47 clknet_1_1__leaf__11420_ VSS VSS VDD VDD nc_clkload47_Y sky130_fd_sc_hd__clkinv_1
Xclkload48 clknet_2_0__leaf__11419_ VSS VSS VDD VDD nc_clkload48_Y sky130_fd_sc_hd__bufinv_16
Xclkload49 clknet_2_2__leaf__11419_ VSS VSS VDD VDD nc_clkload49_Y sky130_fd_sc_hd__inv_6
Xclkload5 clknet_3_1__leaf_clk_regs VSS VSS VDD VDD nc_clkload5_Y sky130_fd_sc_hd__inv_6
Xclkload50 clknet_2_3__leaf__11419_ VSS VSS VDD VDD nc_clkload50_Y sky130_fd_sc_hd__bufinv_16
Xclkload51 clknet_1_1__leaf__11418_ VSS VSS VDD VDD nc_clkload51_X sky130_fd_sc_hd__clkbuf_1
Xclkload52 clknet_1_1__leaf__11417_ VSS VSS VDD VDD nc_clkload52_Y sky130_fd_sc_hd__clkinv_1
Xclkload53 clknet_1_1__leaf__11416_ VSS VSS VDD VDD nc_clkload53_Y sky130_fd_sc_hd__clkinv_1
Xclkload54 clknet_2_0__leaf__11415_ VSS VSS VDD VDD nc_clkload54_Y sky130_fd_sc_hd__clkinv_1
Xclkload55 clknet_2_1__leaf__11415_ VSS VSS VDD VDD nc_clkload55_Y sky130_fd_sc_hd__clkinv_4
Xclkload56 clknet_2_2__leaf__11415_ VSS VSS VDD VDD nc_clkload56_Y sky130_fd_sc_hd__bufinv_16
Xclkload57 clknet_1_1__leaf__11414_ VSS VSS VDD VDD nc_clkload57_Y sky130_fd_sc_hd__clkinv_1
Xclkload58 clknet_1_0__leaf__11413_ VSS VSS VDD VDD nc_clkload58_Y sky130_fd_sc_hd__clkinv_1
Xclkload59 clknet_1_1__leaf__11412_ VSS VSS VDD VDD nc_clkload59_Y sky130_fd_sc_hd__clkinv_1
Xclkload6 clknet_3_2__leaf_clk_regs VSS VSS VDD VDD nc_clkload6_Y sky130_fd_sc_hd__clkinv_8
Xclkload60 clknet_1_1__leaf__11409_ VSS VSS VDD VDD nc_clkload60_Y sky130_fd_sc_hd__clkinv_1
Xclkload61 clknet_1_1__leaf__11408_ VSS VSS VDD VDD nc_clkload61_Y sky130_fd_sc_hd__clkinv_1
Xclkload62 clknet_3_0__leaf__11407_ VSS VSS VDD VDD nc_clkload62_Y sky130_fd_sc_hd__clkinv_4
Xclkload63 clknet_3_1__leaf__11407_ VSS VSS VDD VDD nc_clkload63_Y sky130_fd_sc_hd__inv_6
Xclkload64 clknet_3_2__leaf__11407_ VSS VSS VDD VDD nc_clkload64_Y sky130_fd_sc_hd__clkinv_1
Xclkload65 clknet_3_3__leaf__11407_ VSS VSS VDD VDD nc_clkload65_Y sky130_fd_sc_hd__inv_6
Xclkload66 clknet_3_4__leaf__11407_ VSS VSS VDD VDD nc_clkload66_Y sky130_fd_sc_hd__bufinv_16
Xclkload67 clknet_3_5__leaf__11407_ VSS VSS VDD VDD nc_clkload67_Y sky130_fd_sc_hd__clkinv_2
Xclkload68 clknet_3_6__leaf__11407_ VSS VSS VDD VDD nc_clkload68_Y sky130_fd_sc_hd__clkinv_1
Xclkload69 clknet_1_1__leaf__11406_ VSS VSS VDD VDD nc_clkload69_Y sky130_fd_sc_hd__clkinv_1
Xclkload7 clknet_3_3__leaf_clk_regs VSS VSS VDD VDD nc_clkload7_Y sky130_fd_sc_hd__inv_8
Xclkload70 clknet_1_0__leaf__11405_ VSS VSS VDD VDD nc_clkload70_Y sky130_fd_sc_hd__clkinv_1
Xclkload71 clknet_1_1__leaf__11404_ VSS VSS VDD VDD nc_clkload71_Y sky130_fd_sc_hd__clkinv_1
Xclkload72 clknet_1_1__leaf__11402_ VSS VSS VDD VDD nc_clkload72_Y sky130_fd_sc_hd__clkinv_1
Xclkload73 clknet_1_1__leaf__11401_ VSS VSS VDD VDD nc_clkload73_X sky130_fd_sc_hd__clkbuf_1
Xclkload74 clknet_1_1__leaf__11399_ VSS VSS VDD VDD nc_clkload74_Y sky130_fd_sc_hd__clkinv_1
Xclkload75 clknet_2_0__leaf__11398_ VSS VSS VDD VDD nc_clkload75_X sky130_fd_sc_hd__clkbuf_1
Xclkload76 clknet_2_2__leaf__11398_ VSS VSS VDD VDD nc_clkload76_X sky130_fd_sc_hd__clkbuf_1
Xclkload77 clknet_2_3__leaf__11398_ VSS VSS VDD VDD nc_clkload77_Y sky130_fd_sc_hd__clkinv_4
Xclkload78 clknet_1_0__leaf__11397_ VSS VSS VDD VDD nc_clkload78_Y sky130_fd_sc_hd__clkinv_1
Xclkload79 clknet_1_0__leaf__11396_ VSS VSS VDD VDD nc_clkload79_Y sky130_fd_sc_hd__clkinv_1
Xclkload8 clknet_3_4__leaf_clk_regs VSS VSS VDD VDD nc_clkload8_Y sky130_fd_sc_hd__inv_8
Xclkload80 clknet_1_1__leaf__11393_ VSS VSS VDD VDD nc_clkload80_Y sky130_fd_sc_hd__clkinv_1
Xclkload81 clknet_1_0__leaf__11392_ VSS VSS VDD VDD nc_clkload81_Y sky130_fd_sc_hd__clkinv_1
Xclkload82 clknet_1_1__leaf__11391_ VSS VSS VDD VDD nc_clkload82_Y sky130_fd_sc_hd__clkinv_1
Xclkload83 clknet_1_1__leaf__11388_ VSS VSS VDD VDD nc_clkload83_Y sky130_fd_sc_hd__clkinv_1
Xclkload84 clknet_1_0__leaf__11387_ VSS VSS VDD VDD nc_clkload84_Y sky130_fd_sc_hd__clkinv_1
Xclkload85 clknet_1_1__leaf__11386_ VSS VSS VDD VDD nc_clkload85_Y sky130_fd_sc_hd__clkinv_1
Xclkload86 clknet_1_0__leaf__11385_ VSS VSS VDD VDD nc_clkload86_Y sky130_fd_sc_hd__clkinv_1
Xclkload87 clknet_1_1__leaf__11384_ VSS VSS VDD VDD nc_clkload87_Y sky130_fd_sc_hd__clkinv_1
Xclkload88 clknet_1_0__leaf__11383_ VSS VSS VDD VDD nc_clkload88_X sky130_fd_sc_hd__clkbuf_1
Xclkload89 clknet_1_0__leaf__11382_ VSS VSS VDD VDD nc_clkload89_Y sky130_fd_sc_hd__clkinv_1
Xclkload9 clknet_3_5__leaf_clk_regs VSS VSS VDD VDD nc_clkload9_Y sky130_fd_sc_hd__clkinv_4
Xclkload90 clknet_1_1__leaf__11381_ VSS VSS VDD VDD nc_clkload90_Y sky130_fd_sc_hd__clkinv_1
Xclkload91 clknet_1_0__leaf__11377_ VSS VSS VDD VDD nc_clkload91_Y sky130_fd_sc_hd__clkinv_1
Xclkload92 clknet_1_1__leaf__11373_ VSS VSS VDD VDD nc_clkload92_Y sky130_fd_sc_hd__clkinv_1
Xclkload93 clknet_1_1__leaf__11371_ VSS VSS VDD VDD nc_clkload93_Y sky130_fd_sc_hd__clkinv_1
Xclkload94 clknet_1_1__leaf__11369_ VSS VSS VDD VDD nc_clkload94_Y sky130_fd_sc_hd__clkinv_1
Xclkload95 clknet_1_0__leaf__11366_ VSS VSS VDD VDD nc_clkload95_X sky130_fd_sc_hd__clkbuf_1
Xclkload96 clknet_1_0__leaf__11364_ VSS VSS VDD VDD nc_clkload96_X sky130_fd_sc_hd__clkbuf_1
Xclkload97 clknet_1_1__leaf__11363_ VSS VSS VDD VDD nc_clkload97_Y sky130_fd_sc_hd__clkinv_1
Xclkload98 clknet_1_0__leaf__11362_ VSS VSS VDD VDD nc_clkload98_Y sky130_fd_sc_hd__clkinv_1
Xclkload99 clknet_2_1__leaf__11361_ VSS VSS VDD VDD nc_clkload99_Y sky130_fd_sc_hd__clkinvlp_4
Xdelaybuf_0_clk clknet_leaf_18_clk VSS VSS VDD VDD delaynet_0_clk sky130_fd_sc_hd__clkbuf_16
Xdelaybuf_10_clk clknet_leaf_12_clk VSS VSS VDD VDD delaynet_10_clk sky130_fd_sc_hd__clkbuf_16
Xdelaybuf_11_clk clknet_leaf_10_clk VSS VSS VDD VDD delaynet_11_clk sky130_fd_sc_hd__clkbuf_2
Xdelaybuf_12_clk delaynet_11_clk VSS VSS VDD VDD delaynet_12_clk sky130_fd_sc_hd__clkbuf_2
Xdelaybuf_13_clk delaynet_12_clk VSS VSS VDD VDD delaynet_13_clk sky130_fd_sc_hd__clkbuf_8
Xdelaybuf_14_clk clknet_1_1__leaf_clk VSS VSS VDD VDD delaynet_14_clk sky130_fd_sc_hd__clkbuf_16
Xdelaybuf_15_clk clknet_leaf_19_clk VSS VSS VDD VDD delaynet_15_clk sky130_fd_sc_hd__clkdlybuf4s15_2
Xdelaybuf_16_clk delaynet_15_clk VSS VSS VDD VDD delaynet_16_clk sky130_fd_sc_hd__clkbuf_2
Xdelaybuf_17_clk clknet_leaf_1_clk VSS VSS VDD VDD delaynet_17_clk sky130_fd_sc_hd__clkdlybuf4s18_2
Xdelaybuf_18_clk delaynet_17_clk VSS VSS VDD VDD delaynet_18_clk sky130_fd_sc_hd__clkbuf_8
Xdelaybuf_19_clk clknet_0_clk VSS VSS VDD VDD delaynet_19_clk sky130_fd_sc_hd__clkbuf_2
Xdelaybuf_1_clk delaynet_0_clk VSS VSS VDD VDD delaynet_1_clk sky130_fd_sc_hd__clkbuf_2
Xdelaybuf_20_clk clk VSS VSS VDD VDD delaynet_20_clk sky130_fd_sc_hd__clkdlybuf4s25_2
Xdelaybuf_21_clk delaynet_20_clk VSS VSS VDD VDD delaynet_21_clk sky130_fd_sc_hd__clkdlybuf4s18_2
Xdelaybuf_2_clk delaynet_1_clk VSS VSS VDD VDD delaynet_2_clk sky130_fd_sc_hd__clkbuf_8
Xdelaybuf_3_clk clknet_leaf_16_clk VSS VSS VDD VDD delaynet_3_clk sky130_fd_sc_hd__clkbuf_4
Xdelaybuf_4_clk clknet_leaf_15_clk VSS VSS VDD VDD delaynet_4_clk sky130_fd_sc_hd__clkbuf_16
Xdelaybuf_5_clk clknet_leaf_14_clk VSS VSS VDD VDD delaynet_5_clk sky130_fd_sc_hd__clkbuf_16
Xdelaybuf_6_clk clknet_leaf_13_clk VSS VSS VDD VDD delaynet_6_clk sky130_fd_sc_hd__clkbuf_1
Xdelaybuf_7_clk delaynet_6_clk VSS VSS VDD VDD delaynet_7_clk sky130_fd_sc_hd__clkbuf_16
Xdelaybuf_8_clk delaynet_10_clk VSS VSS VDD VDD delaynet_8_clk sky130_fd_sc_hd__clkbuf_1
Xdelaybuf_9_clk delaynet_8_clk VSS VSS VDD VDD delaynet_9_clk sky130_fd_sc_hd__clkdlybuf4s18_2
Xflt$_DFFE_PN0P_ _11351_ _1107_ net1019 VSS VSS VDD VDD net145 sky130_fd_sc_hd__dfrtp_1
Xinput37 cfg_tp[0] VSS VSS VDD VDD net36 sky130_fd_sc_hd__clkdlybuf4s15_1
Xinput38 cfg_tp[1] VSS VSS VDD VDD net37 sky130_fd_sc_hd__clkdlybuf4s15_1
Xinput39 cfg_tp[2] VSS VSS VDD VDD net38 sky130_fd_sc_hd__clkdlybuf4s15_1
Xinput40 cfg_tr[0] VSS VSS VDD VDD net39 sky130_fd_sc_hd__clkdlybuf4s15_1
Xinput41 cfg_tr[1] VSS VSS VDD VDD net40 sky130_fd_sc_hd__clkdlybuf4s15_1
Xinput42 cfg_ts[0] VSS VSS VDD VDD net41 sky130_fd_sc_hd__clkdlybuf4s15_1
Xinput43 cfg_ts[1] VSS VSS VDD VDD net42 sky130_fd_sc_hd__clkdlybuf4s15_1
Xinput44 cfg_ts[2] VSS VSS VDD VDD net43 sky130_fd_sc_hd__clkdlybuf4s15_1
Xinput45 cs_n VSS VSS VDD VDD net44 sky130_fd_sc_hd__clkdlybuf4s15_1
Xinput46 mosi VSS VSS VDD VDD net45 sky130_fd_sc_hd__clkdlybuf4s15_1
Xinput47 rst_n VSS VSS VDD VDD net46 sky130_fd_sc_hd__clkbuf_2
Xinput48 sa_n[0] VSS VSS VDD VDD net47 sky130_fd_sc_hd__clkdlybuf4s15_1
Xinput49 sa_n[10] VSS VSS VDD VDD net48 sky130_fd_sc_hd__clkdlybuf4s15_1
Xinput50 sa_n[11] VSS VSS VDD VDD net49 sky130_fd_sc_hd__clkdlybuf4s15_1
Xinput51 sa_n[12] VSS VSS VDD VDD net50 sky130_fd_sc_hd__clkdlybuf4s15_1
Xinput52 sa_n[13] VSS VSS VDD VDD net51 sky130_fd_sc_hd__clkdlybuf4s15_1
Xinput53 sa_n[14] VSS VSS VDD VDD net52 sky130_fd_sc_hd__clkdlybuf4s15_1
Xinput54 sa_n[15] VSS VSS VDD VDD net53 sky130_fd_sc_hd__clkdlybuf4s15_1
Xinput55 sa_n[16] VSS VSS VDD VDD net54 sky130_fd_sc_hd__clkdlybuf4s15_1
Xinput56 sa_n[17] VSS VSS VDD VDD net55 sky130_fd_sc_hd__clkdlybuf4s15_1
Xinput57 sa_n[18] VSS VSS VDD VDD net56 sky130_fd_sc_hd__clkdlybuf4s15_1
Xinput58 sa_n[19] VSS VSS VDD VDD net57 sky130_fd_sc_hd__clkdlybuf4s15_1
Xinput59 sa_n[1] VSS VSS VDD VDD net58 sky130_fd_sc_hd__clkdlybuf4s15_1
Xinput60 sa_n[20] VSS VSS VDD VDD net59 sky130_fd_sc_hd__clkdlybuf4s15_1
Xinput61 sa_n[21] VSS VSS VDD VDD net60 sky130_fd_sc_hd__clkdlybuf4s15_1
Xinput62 sa_n[22] VSS VSS VDD VDD net61 sky130_fd_sc_hd__clkdlybuf4s15_1
Xinput63 sa_n[23] VSS VSS VDD VDD net62 sky130_fd_sc_hd__clkdlybuf4s15_1
Xinput64 sa_n[2] VSS VSS VDD VDD net63 sky130_fd_sc_hd__clkdlybuf4s15_1
Xinput65 sa_n[3] VSS VSS VDD VDD net64 sky130_fd_sc_hd__clkdlybuf4s15_1
Xinput66 sa_n[4] VSS VSS VDD VDD net65 sky130_fd_sc_hd__clkdlybuf4s15_1
Xinput67 sa_n[5] VSS VSS VDD VDD net66 sky130_fd_sc_hd__clkdlybuf4s15_1
Xinput68 sa_n[6] VSS VSS VDD VDD net67 sky130_fd_sc_hd__clkdlybuf4s15_1
Xinput69 sa_n[7] VSS VSS VDD VDD net68 sky130_fd_sc_hd__clkdlybuf4s15_1
Xinput70 sa_n[8] VSS VSS VDD VDD net69 sky130_fd_sc_hd__clkdlybuf4s15_1
Xinput71 sa_n[9] VSS VSS VDD VDD net70 sky130_fd_sc_hd__clkdlybuf4s15_1
Xinput72 sa_p[0] VSS VSS VDD VDD net71 sky130_fd_sc_hd__clkdlybuf4s15_1
Xinput73 sa_p[10] VSS VSS VDD VDD net72 sky130_fd_sc_hd__clkdlybuf4s15_1
Xinput74 sa_p[11] VSS VSS VDD VDD net73 sky130_fd_sc_hd__clkdlybuf4s15_1
Xinput75 sa_p[12] VSS VSS VDD VDD net74 sky130_fd_sc_hd__clkdlybuf4s15_1
Xinput76 sa_p[13] VSS VSS VDD VDD net75 sky130_fd_sc_hd__clkdlybuf4s15_1
Xinput77 sa_p[14] VSS VSS VDD VDD net76 sky130_fd_sc_hd__clkdlybuf4s15_1
Xinput78 sa_p[15] VSS VSS VDD VDD net77 sky130_fd_sc_hd__clkdlybuf4s15_1
Xinput79 sa_p[16] VSS VSS VDD VDD net78 sky130_fd_sc_hd__clkdlybuf4s15_1
Xinput80 sa_p[17] VSS VSS VDD VDD net79 sky130_fd_sc_hd__clkdlybuf4s15_1
Xinput81 sa_p[18] VSS VSS VDD VDD net80 sky130_fd_sc_hd__clkdlybuf4s15_1
Xinput82 sa_p[19] VSS VSS VDD VDD net81 sky130_fd_sc_hd__clkdlybuf4s15_1
Xinput83 sa_p[1] VSS VSS VDD VDD net82 sky130_fd_sc_hd__clkdlybuf4s15_1
Xinput84 sa_p[20] VSS VSS VDD VDD net83 sky130_fd_sc_hd__clkdlybuf4s15_1
Xinput85 sa_p[21] VSS VSS VDD VDD net84 sky130_fd_sc_hd__clkdlybuf4s15_1
Xinput86 sa_p[22] VSS VSS VDD VDD net85 sky130_fd_sc_hd__clkdlybuf4s15_1
Xinput87 sa_p[23] VSS VSS VDD VDD net86 sky130_fd_sc_hd__clkdlybuf4s15_1
Xinput88 sa_p[2] VSS VSS VDD VDD net87 sky130_fd_sc_hd__clkdlybuf4s15_1
Xinput89 sa_p[3] VSS VSS VDD VDD net88 sky130_fd_sc_hd__clkdlybuf4s15_1
Xinput90 sa_p[4] VSS VSS VDD VDD net89 sky130_fd_sc_hd__clkdlybuf4s15_1
Xinput91 sa_p[5] VSS VSS VDD VDD net90 sky130_fd_sc_hd__clkdlybuf4s15_1
Xinput92 sa_p[6] VSS VSS VDD VDD net91 sky130_fd_sc_hd__clkdlybuf4s15_1
Xinput93 sa_p[7] VSS VSS VDD VDD net92 sky130_fd_sc_hd__clkdlybuf4s15_1
Xinput94 sa_p[8] VSS VSS VDD VDD net93 sky130_fd_sc_hd__clkdlybuf4s15_1
Xinput95 sa_p[9] VSS VSS VDD VDD net94 sky130_fd_sc_hd__clkdlybuf4s15_1
Xinput96 sck VSS VSS VDD VDD net95 sky130_fd_sc_hd__clkdlybuf4s15_1
Xload_slew1039 net863 VSS VSS VDD VDD net1038 sky130_fd_sc_hd__buf_12
Xmiso$_DFFE_PN0P_ _11349_ _2295_ net1032 VSS VSS VDD VDD net147 sky130_fd_sc_hd__dfrtp_1
Xoutput100 net99 VSS VSS VDD VDD bln_prg[11] sky130_fd_sc_hd__clkdlybuf4s15_1
Xoutput101 net100 VSS VSS VDD VDD bln_prg[12] sky130_fd_sc_hd__clkdlybuf4s15_1
Xoutput102 net101 VSS VSS VDD VDD bln_prg[13] sky130_fd_sc_hd__clkdlybuf4s15_1
Xoutput103 net102 VSS VSS VDD VDD bln_prg[14] sky130_fd_sc_hd__clkdlybuf4s15_1
Xoutput104 net103 VSS VSS VDD VDD bln_prg[15] sky130_fd_sc_hd__clkdlybuf4s15_1
Xoutput105 net104 VSS VSS VDD VDD bln_prg[16] sky130_fd_sc_hd__clkdlybuf4s15_1
Xoutput106 net105 VSS VSS VDD VDD bln_prg[17] sky130_fd_sc_hd__clkdlybuf4s15_1
Xoutput107 net106 VSS VSS VDD VDD bln_prg[18] sky130_fd_sc_hd__clkdlybuf4s15_1
Xoutput108 net107 VSS VSS VDD VDD bln_prg[19] sky130_fd_sc_hd__clkdlybuf4s15_1
Xoutput109 net108 VSS VSS VDD VDD bln_prg[1] sky130_fd_sc_hd__clkdlybuf4s15_1
Xoutput110 net109 VSS VSS VDD VDD bln_prg[20] sky130_fd_sc_hd__clkdlybuf4s15_1
Xoutput111 net110 VSS VSS VDD VDD bln_prg[21] sky130_fd_sc_hd__clkdlybuf4s15_1
Xoutput112 net111 VSS VSS VDD VDD bln_prg[22] sky130_fd_sc_hd__clkdlybuf4s15_1
Xoutput113 net112 VSS VSS VDD VDD bln_prg[23] sky130_fd_sc_hd__clkdlybuf4s15_1
Xoutput114 net113 VSS VSS VDD VDD bln_prg[2] sky130_fd_sc_hd__clkdlybuf4s15_1
Xoutput115 net114 VSS VSS VDD VDD bln_prg[3] sky130_fd_sc_hd__clkdlybuf4s15_1
Xoutput116 net115 VSS VSS VDD VDD bln_prg[4] sky130_fd_sc_hd__clkdlybuf4s15_1
Xoutput117 net116 VSS VSS VDD VDD bln_prg[5] sky130_fd_sc_hd__clkdlybuf4s15_1
Xoutput118 net117 VSS VSS VDD VDD bln_prg[6] sky130_fd_sc_hd__clkdlybuf4s15_1
Xoutput119 net118 VSS VSS VDD VDD bln_prg[7] sky130_fd_sc_hd__clkdlybuf4s15_1
Xoutput120 net119 VSS VSS VDD VDD bln_prg[8] sky130_fd_sc_hd__clkdlybuf4s15_1
Xoutput121 net120 VSS VSS VDD VDD bln_prg[9] sky130_fd_sc_hd__clkdlybuf4s15_1
Xoutput122 net121 VSS VSS VDD VDD blp_prg[0] sky130_fd_sc_hd__clkdlybuf4s15_1
Xoutput123 net122 VSS VSS VDD VDD blp_prg[10] sky130_fd_sc_hd__clkdlybuf4s15_1
Xoutput124 net123 VSS VSS VDD VDD blp_prg[11] sky130_fd_sc_hd__clkdlybuf4s15_1
Xoutput125 net124 VSS VSS VDD VDD blp_prg[12] sky130_fd_sc_hd__clkdlybuf4s15_1
Xoutput126 net125 VSS VSS VDD VDD blp_prg[13] sky130_fd_sc_hd__clkdlybuf4s15_1
Xoutput127 net126 VSS VSS VDD VDD blp_prg[14] sky130_fd_sc_hd__clkdlybuf4s15_1
Xoutput128 net127 VSS VSS VDD VDD blp_prg[15] sky130_fd_sc_hd__clkdlybuf4s15_1
Xoutput129 net128 VSS VSS VDD VDD blp_prg[16] sky130_fd_sc_hd__clkdlybuf4s15_1
Xoutput130 net129 VSS VSS VDD VDD blp_prg[17] sky130_fd_sc_hd__clkdlybuf4s15_1
Xoutput131 net130 VSS VSS VDD VDD blp_prg[18] sky130_fd_sc_hd__clkdlybuf4s15_1
Xoutput132 net131 VSS VSS VDD VDD blp_prg[19] sky130_fd_sc_hd__clkdlybuf4s15_1
Xoutput133 net132 VSS VSS VDD VDD blp_prg[1] sky130_fd_sc_hd__clkdlybuf4s15_1
Xoutput134 net133 VSS VSS VDD VDD blp_prg[20] sky130_fd_sc_hd__clkdlybuf4s15_1
Xoutput135 net134 VSS VSS VDD VDD blp_prg[21] sky130_fd_sc_hd__clkdlybuf4s15_1
Xoutput136 net135 VSS VSS VDD VDD blp_prg[22] sky130_fd_sc_hd__clkdlybuf4s15_1
Xoutput137 net136 VSS VSS VDD VDD blp_prg[23] sky130_fd_sc_hd__clkdlybuf4s15_1
Xoutput138 net137 VSS VSS VDD VDD blp_prg[2] sky130_fd_sc_hd__clkdlybuf4s15_1
Xoutput139 net138 VSS VSS VDD VDD blp_prg[3] sky130_fd_sc_hd__clkdlybuf4s15_1
Xoutput140 net139 VSS VSS VDD VDD blp_prg[4] sky130_fd_sc_hd__clkdlybuf4s15_1
Xoutput141 net140 VSS VSS VDD VDD blp_prg[5] sky130_fd_sc_hd__clkdlybuf4s15_1
Xoutput142 net141 VSS VSS VDD VDD blp_prg[6] sky130_fd_sc_hd__clkdlybuf4s15_1
Xoutput143 net142 VSS VSS VDD VDD blp_prg[7] sky130_fd_sc_hd__clkdlybuf4s15_1
Xoutput144 net143 VSS VSS VDD VDD blp_prg[8] sky130_fd_sc_hd__clkdlybuf4s15_1
Xoutput145 net144 VSS VSS VDD VDD blp_prg[9] sky130_fd_sc_hd__clkdlybuf4s15_1
Xoutput146 net145 VSS VSS VDD VDD flt sky130_fd_sc_hd__clkdlybuf4s15_1
Xoutput147 net146 VSS VSS VDD VDD irq sky130_fd_sc_hd__clkdlybuf4s15_1
Xoutput148 net147 VSS VSS VDD VDD miso sky130_fd_sc_hd__clkdlybuf4s15_1
Xoutput149 net148 VSS VSS VDD VDD pamp[0] sky130_fd_sc_hd__clkdlybuf4s15_1
Xoutput150 net149 VSS VSS VDD VDD pamp[1] sky130_fd_sc_hd__clkdlybuf4s15_1
Xoutput151 net150 VSS VSS VDD VDD pamp[2] sky130_fd_sc_hd__clkdlybuf4s15_1
Xoutput152 net151 VSS VSS VDD VDD pamp[3] sky130_fd_sc_hd__clkdlybuf4s15_1
Xoutput153 net152 VSS VSS VDD VDD pamp[4] sky130_fd_sc_hd__clkdlybuf4s15_1
Xoutput154 net153 VSS VSS VDD VDD pk sky130_fd_sc_hd__clkdlybuf4s15_1
Xoutput155 net154 VSS VSS VDD VDD pstb sky130_fd_sc_hd__clkdlybuf4s15_1
Xoutput156 net155 VSS VSS VDD VDD ref_sel[0] sky130_fd_sc_hd__clkdlybuf4s15_1
Xoutput157 net156 VSS VSS VDD VDD ref_sel[1] sky130_fd_sc_hd__clkdlybuf4s15_1
Xoutput158 net157 VSS VSS VDD VDD ref_sel[2] sky130_fd_sc_hd__clkdlybuf4s15_1
Xoutput159 net158 VSS VSS VDD VDD sl_prg sky130_fd_sc_hd__clkdlybuf4s15_1
Xoutput160 net159 VSS VSS VDD VDD wl_on[0] sky130_fd_sc_hd__clkdlybuf4s15_1
Xoutput161 net160 VSS VSS VDD VDD wl_on[10] sky130_fd_sc_hd__clkdlybuf4s15_1
Xoutput162 net161 VSS VSS VDD VDD wl_on[11] sky130_fd_sc_hd__clkdlybuf4s15_1
Xoutput163 net162 VSS VSS VDD VDD wl_on[12] sky130_fd_sc_hd__clkdlybuf4s15_1
Xoutput164 net163 VSS VSS VDD VDD wl_on[13] sky130_fd_sc_hd__clkdlybuf4s15_1
Xoutput165 net164 VSS VSS VDD VDD wl_on[14] sky130_fd_sc_hd__clkdlybuf4s15_1
Xoutput166 net165 VSS VSS VDD VDD wl_on[15] sky130_fd_sc_hd__clkdlybuf4s15_1
Xoutput167 net166 VSS VSS VDD VDD wl_on[16] sky130_fd_sc_hd__clkdlybuf4s15_1
Xoutput168 net167 VSS VSS VDD VDD wl_on[17] sky130_fd_sc_hd__clkdlybuf4s15_1
Xoutput169 net168 VSS VSS VDD VDD wl_on[18] sky130_fd_sc_hd__clkdlybuf4s15_1
Xoutput170 net169 VSS VSS VDD VDD wl_on[19] sky130_fd_sc_hd__clkdlybuf4s15_1
Xoutput171 net170 VSS VSS VDD VDD wl_on[1] sky130_fd_sc_hd__clkdlybuf4s15_1
Xoutput172 net171 VSS VSS VDD VDD wl_on[20] sky130_fd_sc_hd__clkdlybuf4s15_1
Xoutput173 net172 VSS VSS VDD VDD wl_on[21] sky130_fd_sc_hd__clkdlybuf4s15_1
Xoutput174 net173 VSS VSS VDD VDD wl_on[22] sky130_fd_sc_hd__clkdlybuf4s15_1
Xoutput175 net174 VSS VSS VDD VDD wl_on[23] sky130_fd_sc_hd__clkdlybuf4s15_1
Xoutput176 net175 VSS VSS VDD VDD wl_on[24] sky130_fd_sc_hd__clkdlybuf4s15_1
Xoutput177 net176 VSS VSS VDD VDD wl_on[25] sky130_fd_sc_hd__clkdlybuf4s15_1
Xoutput178 net177 VSS VSS VDD VDD wl_on[26] sky130_fd_sc_hd__clkdlybuf4s15_1
Xoutput179 net178 VSS VSS VDD VDD wl_on[27] sky130_fd_sc_hd__clkdlybuf4s15_1
Xoutput180 net179 VSS VSS VDD VDD wl_on[28] sky130_fd_sc_hd__clkdlybuf4s15_1
Xoutput181 net180 VSS VSS VDD VDD wl_on[29] sky130_fd_sc_hd__clkdlybuf4s15_1
Xoutput182 net181 VSS VSS VDD VDD wl_on[2] sky130_fd_sc_hd__clkdlybuf4s15_1
Xoutput183 net182 VSS VSS VDD VDD wl_on[30] sky130_fd_sc_hd__clkdlybuf4s15_1
Xoutput184 net183 VSS VSS VDD VDD wl_on[31] sky130_fd_sc_hd__clkdlybuf4s15_1
Xoutput185 net184 VSS VSS VDD VDD wl_on[32] sky130_fd_sc_hd__clkdlybuf4s15_1
Xoutput186 net185 VSS VSS VDD VDD wl_on[33] sky130_fd_sc_hd__clkdlybuf4s15_1
Xoutput187 net186 VSS VSS VDD VDD wl_on[34] sky130_fd_sc_hd__clkdlybuf4s15_1
Xoutput188 net187 VSS VSS VDD VDD wl_on[35] sky130_fd_sc_hd__clkdlybuf4s15_1
Xoutput189 net188 VSS VSS VDD VDD wl_on[36] sky130_fd_sc_hd__clkdlybuf4s15_1
Xoutput190 net189 VSS VSS VDD VDD wl_on[37] sky130_fd_sc_hd__clkdlybuf4s15_1
Xoutput191 net190 VSS VSS VDD VDD wl_on[38] sky130_fd_sc_hd__clkdlybuf4s15_1
Xoutput192 net191 VSS VSS VDD VDD wl_on[39] sky130_fd_sc_hd__clkdlybuf4s15_1
Xoutput193 net192 VSS VSS VDD VDD wl_on[3] sky130_fd_sc_hd__clkdlybuf4s15_1
Xoutput194 net193 VSS VSS VDD VDD wl_on[40] sky130_fd_sc_hd__clkdlybuf4s15_1
Xoutput195 net194 VSS VSS VDD VDD wl_on[41] sky130_fd_sc_hd__clkdlybuf4s15_1
Xoutput196 net195 VSS VSS VDD VDD wl_on[42] sky130_fd_sc_hd__clkdlybuf4s15_1
Xoutput197 net196 VSS VSS VDD VDD wl_on[43] sky130_fd_sc_hd__clkdlybuf4s15_1
Xoutput198 net197 VSS VSS VDD VDD wl_on[44] sky130_fd_sc_hd__clkdlybuf4s15_1
Xoutput199 net198 VSS VSS VDD VDD wl_on[45] sky130_fd_sc_hd__clkdlybuf4s15_1
Xoutput200 net199 VSS VSS VDD VDD wl_on[46] sky130_fd_sc_hd__clkdlybuf4s15_1
Xoutput201 net200 VSS VSS VDD VDD wl_on[47] sky130_fd_sc_hd__clkdlybuf4s15_1
Xoutput202 net201 VSS VSS VDD VDD wl_on[48] sky130_fd_sc_hd__clkdlybuf4s15_1
Xoutput203 net202 VSS VSS VDD VDD wl_on[49] sky130_fd_sc_hd__clkdlybuf4s15_1
Xoutput204 net203 VSS VSS VDD VDD wl_on[4] sky130_fd_sc_hd__clkdlybuf4s15_1
Xoutput205 net204 VSS VSS VDD VDD wl_on[50] sky130_fd_sc_hd__clkdlybuf4s15_1
Xoutput206 net205 VSS VSS VDD VDD wl_on[51] sky130_fd_sc_hd__clkdlybuf4s15_1
Xoutput207 net206 VSS VSS VDD VDD wl_on[52] sky130_fd_sc_hd__clkdlybuf4s15_1
Xoutput208 net207 VSS VSS VDD VDD wl_on[53] sky130_fd_sc_hd__clkdlybuf4s15_1
Xoutput209 net208 VSS VSS VDD VDD wl_on[54] sky130_fd_sc_hd__clkdlybuf4s15_1
Xoutput210 net209 VSS VSS VDD VDD wl_on[55] sky130_fd_sc_hd__clkdlybuf4s15_1
Xoutput211 net210 VSS VSS VDD VDD wl_on[56] sky130_fd_sc_hd__clkdlybuf4s15_1
Xoutput212 net211 VSS VSS VDD VDD wl_on[57] sky130_fd_sc_hd__clkdlybuf4s15_1
Xoutput213 net212 VSS VSS VDD VDD wl_on[58] sky130_fd_sc_hd__clkdlybuf4s15_1
Xoutput214 net213 VSS VSS VDD VDD wl_on[59] sky130_fd_sc_hd__clkdlybuf4s15_1
Xoutput215 net214 VSS VSS VDD VDD wl_on[5] sky130_fd_sc_hd__clkdlybuf4s15_1
Xoutput216 net215 VSS VSS VDD VDD wl_on[60] sky130_fd_sc_hd__clkdlybuf4s15_1
Xoutput217 net216 VSS VSS VDD VDD wl_on[61] sky130_fd_sc_hd__clkdlybuf4s15_1
Xoutput218 net217 VSS VSS VDD VDD wl_on[62] sky130_fd_sc_hd__clkdlybuf4s15_1
Xoutput219 net218 VSS VSS VDD VDD wl_on[63] sky130_fd_sc_hd__clkdlybuf4s15_1
Xoutput220 net219 VSS VSS VDD VDD wl_on[64] sky130_fd_sc_hd__clkdlybuf4s15_1
Xoutput221 net220 VSS VSS VDD VDD wl_on[65] sky130_fd_sc_hd__clkdlybuf4s15_1
Xoutput222 net221 VSS VSS VDD VDD wl_on[66] sky130_fd_sc_hd__clkdlybuf4s15_1
Xoutput223 net222 VSS VSS VDD VDD wl_on[67] sky130_fd_sc_hd__clkdlybuf4s15_1
Xoutput224 net223 VSS VSS VDD VDD wl_on[68] sky130_fd_sc_hd__clkdlybuf4s15_1
Xoutput225 net224 VSS VSS VDD VDD wl_on[69] sky130_fd_sc_hd__clkdlybuf4s15_1
Xoutput226 net225 VSS VSS VDD VDD wl_on[6] sky130_fd_sc_hd__clkdlybuf4s15_1
Xoutput227 net226 VSS VSS VDD VDD wl_on[70] sky130_fd_sc_hd__clkdlybuf4s15_1
Xoutput228 net227 VSS VSS VDD VDD wl_on[71] sky130_fd_sc_hd__clkdlybuf4s15_1
Xoutput229 net228 VSS VSS VDD VDD wl_on[7] sky130_fd_sc_hd__clkdlybuf4s15_1
Xoutput230 net229 VSS VSS VDD VDD wl_on[8] sky130_fd_sc_hd__clkdlybuf4s15_1
Xoutput231 net230 VSS VSS VDD VDD wl_on[9] sky130_fd_sc_hd__clkdlybuf4s15_1
Xoutput232 net231 VSS VSS VDD VDD wl_prog sky130_fd_sc_hd__clkdlybuf4s15_1
Xoutput97 net96 VSS VSS VDD VDD bl_sen sky130_fd_sc_hd__clkdlybuf4s15_1
Xoutput98 net97 VSS VSS VDD VDD bln_prg[0] sky130_fd_sc_hd__clkdlybuf4s15_1
Xoutput99 net98 VSS VSS VDD VDD bln_prg[10] sky130_fd_sc_hd__clkdlybuf4s15_1
Xpamp[0]$_DFFE_PN0P_ clknet_1_1__leaf__11400_ u_core.arr_amp[0] net1029 VSS VSS VDD VDD net148 sky130_fd_sc_hd__dfrtp_1
Xpamp[1]$_DFFE_PN0P_ clknet_1_1__leaf__11400_ u_core.arr_amp[1] net1029 VSS VSS VDD VDD net149 sky130_fd_sc_hd__dfrtp_1
Xpamp[2]$_DFFE_PN0P_ clknet_1_0__leaf__11400_ u_core.arr_amp[2] net1029 VSS VSS VDD VDD net150 sky130_fd_sc_hd__dfrtp_1
Xpamp[3]$_DFFE_PN0P_ clknet_1_1__leaf__11400_ u_core.arr_amp[3] net1029 VSS VSS VDD VDD net151 sky130_fd_sc_hd__dfrtp_1
Xpamp[4]$_DFFE_PN0P_ clknet_1_0__leaf__11400_ u_core.arr_amp[4] net1029 VSS VSS VDD VDD net152 sky130_fd_sc_hd__dfrtp_1
Xpk$_DFFE_PN0P_ clknet_1_0__leaf__11400_ _0670_ net1029 VSS VSS VDD VDD net153 sky130_fd_sc_hd__dfrtp_1
Xplace1000 u_core.u_actl.st[2] VSS VSS VDD VDD net999 sky130_fd_sc_hd__buf_2
Xplace1001 u_core.arr_ack VSS VSS VDD VDD net1000 sky130_fd_sc_hd__buf_2
Xplace1002 net1003 VSS VSS VDD VDD net1001 sky130_fd_sc_hd__buf_2
Xplace1003 net1003 VSS VSS VDD VDD net1002 sky130_fd_sc_hd__buf_4
Xplace1004 net1005 VSS VSS VDD VDD net1003 sky130_fd_sc_hd__buf_4
Xplace1005 net1005 VSS VSS VDD VDD net1004 sky130_fd_sc_hd__buf_4
Xplace1006 net1035 VSS VSS VDD VDD net1005 sky130_fd_sc_hd__buf_2
Xplace1007 net1007 VSS VSS VDD VDD net1006 sky130_fd_sc_hd__buf_4
Xplace1008 net1008 VSS VSS VDD VDD net1007 sky130_fd_sc_hd__buf_2
Xplace1009 net1009 VSS VSS VDD VDD net1008 sky130_fd_sc_hd__buf_4
Xplace1010 net1010 VSS VSS VDD VDD net1009 sky130_fd_sc_hd__buf_2
Xplace1011 net1011 VSS VSS VDD VDD net1010 sky130_fd_sc_hd__buf_2
Xplace1012 net1013 VSS VSS VDD VDD net1011 sky130_fd_sc_hd__buf_2
Xplace1013 net1013 VSS VSS VDD VDD net1012 sky130_fd_sc_hd__buf_4
Xplace1014 net1014 VSS VSS VDD VDD net1013 sky130_fd_sc_hd__buf_2
Xplace1015 net1015 VSS VSS VDD VDD net1014 sky130_fd_sc_hd__buf_2
Xplace1016 net1034 VSS VSS VDD VDD net1015 sky130_fd_sc_hd__buf_2
Xplace1017 net1017 VSS VSS VDD VDD net1016 sky130_fd_sc_hd__buf_2
Xplace1018 net1018 VSS VSS VDD VDD net1017 sky130_fd_sc_hd__buf_2
Xplace1019 net1022 VSS VSS VDD VDD net1018 sky130_fd_sc_hd__buf_2
Xplace1020 net1020 VSS VSS VDD VDD net1019 sky130_fd_sc_hd__buf_2
Xplace1021 net1021 VSS VSS VDD VDD net1020 sky130_fd_sc_hd__buf_4
Xplace1022 net1022 VSS VSS VDD VDD net1021 sky130_fd_sc_hd__buf_2
Xplace1023 net1027 VSS VSS VDD VDD net1022 sky130_fd_sc_hd__buf_4
Xplace1024 net1024 VSS VSS VDD VDD net1023 sky130_fd_sc_hd__buf_4
Xplace1025 net1025 VSS VSS VDD VDD net1024 sky130_fd_sc_hd__buf_2
Xplace1026 net1026 VSS VSS VDD VDD net1025 sky130_fd_sc_hd__buf_2
Xplace1027 net1027 VSS VSS VDD VDD net1026 sky130_fd_sc_hd__buf_4
Xplace1028 net1031 VSS VSS VDD VDD net1027 sky130_fd_sc_hd__buf_2
Xplace1029 net1029 VSS VSS VDD VDD net1028 sky130_fd_sc_hd__buf_4
Xplace1030 net1030 VSS VSS VDD VDD net1029 sky130_fd_sc_hd__buf_4
Xplace1031 net1031 VSS VSS VDD VDD net1030 sky130_fd_sc_hd__buf_4
Xplace1032 net1032 VSS VSS VDD VDD net1031 sky130_fd_sc_hd__buf_2
Xplace1033 net1033 VSS VSS VDD VDD net1032 sky130_fd_sc_hd__buf_2
Xplace1034 net1034 VSS VSS VDD VDD net1033 sky130_fd_sc_hd__buf_4
Xplace1035 net1035 VSS VSS VDD VDD net1034 sky130_fd_sc_hd__buf_2
Xplace1036 net46 VSS VSS VDD VDD net1035 sky130_fd_sc_hd__buf_2
Xplace1037 net1037 VSS VSS VDD VDD net1036 sky130_fd_sc_hd__buf_2
Xplace1038 net46 VSS VSS VDD VDD net1037 sky130_fd_sc_hd__buf_4
Xplace630 _11254_ VSS VSS VDD VDD net629 sky130_fd_sc_hd__buf_2
Xplace631 _11249_ VSS VSS VDD VDD net630 sky130_fd_sc_hd__buf_2
Xplace632 _11243_ VSS VSS VDD VDD net631 sky130_fd_sc_hd__buf_2
Xplace633 _11240_ VSS VSS VDD VDD net632 sky130_fd_sc_hd__buf_2
Xplace634 _11237_ VSS VSS VDD VDD net633 sky130_fd_sc_hd__buf_2
Xplace635 _11221_ VSS VSS VDD VDD net634 sky130_fd_sc_hd__buf_2
Xplace636 _11221_ VSS VSS VDD VDD net635 sky130_fd_sc_hd__buf_2
Xplace637 net643 VSS VSS VDD VDD net636 sky130_fd_sc_hd__buf_2
Xplace638 net638 VSS VSS VDD VDD net637 sky130_fd_sc_hd__buf_4
Xplace639 net643 VSS VSS VDD VDD net638 sky130_fd_sc_hd__buf_2
Xplace640 net640 VSS VSS VDD VDD net639 sky130_fd_sc_hd__buf_2
Xplace641 net642 VSS VSS VDD VDD net640 sky130_fd_sc_hd__buf_4
Xplace642 net642 VSS VSS VDD VDD net641 sky130_fd_sc_hd__buf_4
Xplace643 net643 VSS VSS VDD VDD net642 sky130_fd_sc_hd__buf_4
Xplace644 _11133_ VSS VSS VDD VDD net643 sky130_fd_sc_hd__buf_4
Xplace645 _11133_ VSS VSS VDD VDD net644 sky130_fd_sc_hd__buf_2
Xplace646 _05468_ VSS VSS VDD VDD net645 sky130_fd_sc_hd__buf_2
Xplace647 _05149_ VSS VSS VDD VDD net646 sky130_fd_sc_hd__buf_2
Xplace648 _03733_ VSS VSS VDD VDD net647 sky130_fd_sc_hd__buf_2
Xplace649 _07702_ VSS VSS VDD VDD net648 sky130_fd_sc_hd__buf_2
Xplace650 _05510_ VSS VSS VDD VDD net649 sky130_fd_sc_hd__buf_2
Xplace651 _07358_ VSS VSS VDD VDD net650 sky130_fd_sc_hd__buf_2
Xplace652 _05466_ VSS VSS VDD VDD net651 sky130_fd_sc_hd__buf_2
Xplace653 _05147_ VSS VSS VDD VDD net652 sky130_fd_sc_hd__buf_2
Xplace654 _05512_ VSS VSS VDD VDD net653 sky130_fd_sc_hd__buf_2
Xplace655 _05472_ VSS VSS VDD VDD net654 sky130_fd_sc_hd__buf_2
Xplace656 _05438_ VSS VSS VDD VDD net655 sky130_fd_sc_hd__buf_2
Xplace657 _05366_ VSS VSS VDD VDD net656 sky130_fd_sc_hd__buf_2
Xplace658 _05366_ VSS VSS VDD VDD net657 sky130_fd_sc_hd__buf_2
Xplace659 _05308_ VSS VSS VDD VDD net658 sky130_fd_sc_hd__buf_2
Xplace660 _05219_ VSS VSS VDD VDD net659 sky130_fd_sc_hd__buf_2
Xplace661 _09988_ VSS VSS VDD VDD net660 sky130_fd_sc_hd__buf_2
Xplace662 _09435_ VSS VSS VDD VDD net661 sky130_fd_sc_hd__buf_2
Xplace663 _08198_ VSS VSS VDD VDD net662 sky130_fd_sc_hd__buf_2
Xplace664 _06502_ VSS VSS VDD VDD net663 sky130_fd_sc_hd__buf_2
Xplace665 _05944_ VSS VSS VDD VDD net664 sky130_fd_sc_hd__buf_4
Xplace666 _05890_ VSS VSS VDD VDD net665 sky130_fd_sc_hd__buf_2
Xplace667 _05218_ VSS VSS VDD VDD net666 sky130_fd_sc_hd__buf_2
Xplace668 _10013_ VSS VSS VDD VDD net667 sky130_fd_sc_hd__buf_2
Xplace669 _09978_ VSS VSS VDD VDD net668 sky130_fd_sc_hd__buf_2
Xplace670 net675 VSS VSS VDD VDD net669 sky130_fd_sc_hd__buf_4
Xplace671 net675 VSS VSS VDD VDD net670 sky130_fd_sc_hd__buf_4
Xplace672 net672 VSS VSS VDD VDD net671 sky130_fd_sc_hd__buf_2
Xplace673 net675 VSS VSS VDD VDD net672 sky130_fd_sc_hd__buf_4
Xplace674 net674 VSS VSS VDD VDD net673 sky130_fd_sc_hd__buf_4
Xplace675 net675 VSS VSS VDD VDD net674 sky130_fd_sc_hd__buf_4
Xplace676 _06499_ VSS VSS VDD VDD net675 sky130_fd_sc_hd__buf_4
Xplace677 net679 VSS VSS VDD VDD net676 sky130_fd_sc_hd__buf_2
Xplace678 net678 VSS VSS VDD VDD net677 sky130_fd_sc_hd__buf_4
Xplace679 net679 VSS VSS VDD VDD net678 sky130_fd_sc_hd__buf_4
Xplace680 _06338_ VSS VSS VDD VDD net679 sky130_fd_sc_hd__buf_4
Xplace681 _04831_ VSS VSS VDD VDD net680 sky130_fd_sc_hd__buf_2
Xplace682 _04731_ VSS VSS VDD VDD net681 sky130_fd_sc_hd__buf_4
Xplace683 _04725_ VSS VSS VDD VDD net682 sky130_fd_sc_hd__buf_4
Xplace684 _04720_ VSS VSS VDD VDD net683 sky130_fd_sc_hd__buf_2
Xplace685 _10231_ VSS VSS VDD VDD net684 sky130_fd_sc_hd__buf_2
Xplace686 _10208_ VSS VSS VDD VDD net685 sky130_fd_sc_hd__buf_2
Xplace687 _10199_ VSS VSS VDD VDD net686 sky130_fd_sc_hd__buf_4
Xplace688 _10002_ VSS VSS VDD VDD net687 sky130_fd_sc_hd__buf_2
Xplace689 _09420_ VSS VSS VDD VDD net688 sky130_fd_sc_hd__buf_2
Xplace690 _09242_ VSS VSS VDD VDD net689 sky130_fd_sc_hd__buf_2
Xplace691 _09077_ VSS VSS VDD VDD net690 sky130_fd_sc_hd__buf_2
Xplace692 _09071_ VSS VSS VDD VDD net691 sky130_fd_sc_hd__buf_2
Xplace693 _08967_ VSS VSS VDD VDD net692 sky130_fd_sc_hd__buf_2
Xplace694 _08509_ VSS VSS VDD VDD net693 sky130_fd_sc_hd__buf_2
Xplace695 _08504_ VSS VSS VDD VDD net694 sky130_fd_sc_hd__buf_2
Xplace696 _08289_ VSS VSS VDD VDD net695 sky130_fd_sc_hd__buf_2
Xplace697 _08242_ VSS VSS VDD VDD net696 sky130_fd_sc_hd__buf_2
Xplace698 _08186_ VSS VSS VDD VDD net697 sky130_fd_sc_hd__buf_2
Xplace699 _08054_ VSS VSS VDD VDD net698 sky130_fd_sc_hd__buf_2
Xplace700 _06494_ VSS VSS VDD VDD net699 sky130_fd_sc_hd__buf_2
Xplace701 _05368_ VSS VSS VDD VDD net700 sky130_fd_sc_hd__buf_2
Xplace702 _05313_ VSS VSS VDD VDD net701 sky130_fd_sc_hd__buf_2
Xplace703 _10222_ VSS VSS VDD VDD net702 sky130_fd_sc_hd__buf_2
Xplace704 _10222_ VSS VSS VDD VDD net703 sky130_fd_sc_hd__buf_2
Xplace705 _10198_ VSS VSS VDD VDD net704 sky130_fd_sc_hd__buf_2
Xplace706 _09533_ VSS VSS VDD VDD net705 sky130_fd_sc_hd__buf_2
Xplace707 _06470_ VSS VSS VDD VDD net706 sky130_fd_sc_hd__buf_4
Xplace708 net708 VSS VSS VDD VDD net707 sky130_fd_sc_hd__buf_2
Xplace709 net711 VSS VSS VDD VDD net708 sky130_fd_sc_hd__buf_4
Xplace710 net711 VSS VSS VDD VDD net709 sky130_fd_sc_hd__buf_4
Xplace711 net711 VSS VSS VDD VDD net710 sky130_fd_sc_hd__buf_4
Xplace712 _06470_ VSS VSS VDD VDD net711 sky130_fd_sc_hd__buf_4
Xplace713 _06466_ VSS VSS VDD VDD net712 sky130_fd_sc_hd__buf_4
Xplace714 _06466_ VSS VSS VDD VDD net713 sky130_fd_sc_hd__buf_2
Xplace715 net715 VSS VSS VDD VDD net714 sky130_fd_sc_hd__buf_2
Xplace716 _06466_ VSS VSS VDD VDD net715 sky130_fd_sc_hd__buf_2
Xplace717 _05315_ VSS VSS VDD VDD net716 sky130_fd_sc_hd__buf_2
Xplace718 _05194_ VSS VSS VDD VDD net717 sky130_fd_sc_hd__buf_2
Xplace719 _04477_ VSS VSS VDD VDD net718 sky130_fd_sc_hd__buf_2
Xplace720 _10890_ VSS VSS VDD VDD net719 sky130_fd_sc_hd__buf_2
Xplace721 _09956_ VSS VSS VDD VDD net720 sky130_fd_sc_hd__buf_2
Xplace722 _09956_ VSS VSS VDD VDD net721 sky130_fd_sc_hd__buf_2
Xplace723 _09889_ VSS VSS VDD VDD net722 sky130_fd_sc_hd__buf_2
Xplace724 net724 VSS VSS VDD VDD net723 sky130_fd_sc_hd__buf_4
Xplace725 _0356_[5] VSS VSS VDD VDD net724 sky130_fd_sc_hd__buf_2
Xplace726 _05134_ VSS VSS VDD VDD net725 sky130_fd_sc_hd__buf_2
Xplace727 _04583_ VSS VSS VDD VDD net726 sky130_fd_sc_hd__buf_2
Xplace728 _04364_ VSS VSS VDD VDD net727 sky130_fd_sc_hd__buf_2
Xplace729 _03790_ VSS VSS VDD VDD net728 sky130_fd_sc_hd__buf_2
Xplace730 _03731_ VSS VSS VDD VDD net729 sky130_fd_sc_hd__buf_2
Xplace731 _11197_ VSS VSS VDD VDD net730 sky130_fd_sc_hd__buf_2
Xplace732 _10894_ VSS VSS VDD VDD net731 sky130_fd_sc_hd__buf_2
Xplace733 _10870_ VSS VSS VDD VDD net732 sky130_fd_sc_hd__buf_2
Xplace734 _10854_ VSS VSS VDD VDD net733 sky130_fd_sc_hd__buf_2
Xplace735 _10769_ VSS VSS VDD VDD net734 sky130_fd_sc_hd__buf_2
Xplace736 _10736_ VSS VSS VDD VDD net735 sky130_fd_sc_hd__buf_2
Xplace737 _09496_ VSS VSS VDD VDD net736 sky130_fd_sc_hd__buf_2
Xplace738 _07255_ VSS VSS VDD VDD net737 sky130_fd_sc_hd__buf_2
Xplace739 _06968_ VSS VSS VDD VDD net738 sky130_fd_sc_hd__buf_2
Xplace740 _06826_ VSS VSS VDD VDD net739 sky130_fd_sc_hd__buf_2
Xplace741 _06801_ VSS VSS VDD VDD net740 sky130_fd_sc_hd__buf_2
Xplace742 _06751_ VSS VSS VDD VDD net741 sky130_fd_sc_hd__buf_2
Xplace743 _06728_ VSS VSS VDD VDD net742 sky130_fd_sc_hd__buf_2
Xplace744 _06718_ VSS VSS VDD VDD net743 sky130_fd_sc_hd__buf_2
Xplace745 _06694_ VSS VSS VDD VDD net744 sky130_fd_sc_hd__buf_2
Xplace746 _06677_ VSS VSS VDD VDD net745 sky130_fd_sc_hd__buf_2
Xplace747 _06668_ VSS VSS VDD VDD net746 sky130_fd_sc_hd__buf_2
Xplace748 _06650_ VSS VSS VDD VDD net747 sky130_fd_sc_hd__buf_2
Xplace749 _06638_ VSS VSS VDD VDD net748 sky130_fd_sc_hd__buf_2
Xplace750 _06590_ VSS VSS VDD VDD net749 sky130_fd_sc_hd__buf_2
Xplace751 _03424_ VSS VSS VDD VDD net750 sky130_fd_sc_hd__buf_4
Xplace752 _06080_ VSS VSS VDD VDD net751 sky130_fd_sc_hd__buf_2
Xplace753 _1357_ VSS VSS VDD VDD net752 sky130_fd_sc_hd__buf_2
Xplace754 _05896_ VSS VSS VDD VDD net753 sky130_fd_sc_hd__buf_2
Xplace755 _10904_ VSS VSS VDD VDD net754 sky130_fd_sc_hd__buf_2
Xplace756 _10902_ VSS VSS VDD VDD net755 sky130_fd_sc_hd__buf_2
Xplace757 _10901_ VSS VSS VDD VDD net756 sky130_fd_sc_hd__buf_2
Xplace758 _10893_ VSS VSS VDD VDD net757 sky130_fd_sc_hd__buf_2
Xplace759 _10840_ VSS VSS VDD VDD net758 sky130_fd_sc_hd__buf_2
Xplace760 _10820_ VSS VSS VDD VDD net759 sky130_fd_sc_hd__buf_2
Xplace761 _10792_ VSS VSS VDD VDD net760 sky130_fd_sc_hd__buf_2
Xplace762 _10782_ VSS VSS VDD VDD net761 sky130_fd_sc_hd__buf_2
Xplace763 _10744_ VSS VSS VDD VDD net762 sky130_fd_sc_hd__buf_2
Xplace764 _10594_ VSS VSS VDD VDD net763 sky130_fd_sc_hd__buf_2
Xplace765 _07267_ VSS VSS VDD VDD net764 sky130_fd_sc_hd__buf_2
Xplace766 _07189_ VSS VSS VDD VDD net765 sky130_fd_sc_hd__buf_2
Xplace767 _07159_ VSS VSS VDD VDD net766 sky130_fd_sc_hd__buf_2
Xplace768 _07136_ VSS VSS VDD VDD net767 sky130_fd_sc_hd__buf_4
Xplace769 _07123_ VSS VSS VDD VDD net768 sky130_fd_sc_hd__buf_4
Xplace770 _07089_ VSS VSS VDD VDD net769 sky130_fd_sc_hd__buf_2
Xplace771 _06998_ VSS VSS VDD VDD net770 sky130_fd_sc_hd__buf_2
Xplace772 _06967_ VSS VSS VDD VDD net771 sky130_fd_sc_hd__buf_2
Xplace773 _06937_ VSS VSS VDD VDD net772 sky130_fd_sc_hd__buf_2
Xplace774 _05918_ VSS VSS VDD VDD net773 sky130_fd_sc_hd__buf_2
Xplace775 _04733_ VSS VSS VDD VDD net774 sky130_fd_sc_hd__buf_2
Xplace776 _04722_ VSS VSS VDD VDD net775 sky130_fd_sc_hd__buf_2
Xplace777 _11259_ VSS VSS VDD VDD net776 sky130_fd_sc_hd__buf_4
Xplace778 _10846_ VSS VSS VDD VDD net777 sky130_fd_sc_hd__buf_2
Xplace779 _10795_ VSS VSS VDD VDD net778 sky130_fd_sc_hd__buf_2
Xplace780 _10783_ VSS VSS VDD VDD net779 sky130_fd_sc_hd__buf_2
Xplace781 _10781_ VSS VSS VDD VDD net780 sky130_fd_sc_hd__buf_2
Xplace782 _10729_ VSS VSS VDD VDD net781 sky130_fd_sc_hd__buf_2
Xplace783 net787 VSS VSS VDD VDD net782 sky130_fd_sc_hd__buf_2
Xplace784 net784 VSS VSS VDD VDD net783 sky130_fd_sc_hd__buf_2
Xplace785 net786 VSS VSS VDD VDD net784 sky130_fd_sc_hd__buf_2
Xplace786 net786 VSS VSS VDD VDD net785 sky130_fd_sc_hd__buf_2
Xplace787 net787 VSS VSS VDD VDD net786 sky130_fd_sc_hd__buf_4
Xplace788 _10573_ VSS VSS VDD VDD net787 sky130_fd_sc_hd__buf_4
Xplace789 _10258_ VSS VSS VDD VDD net788 sky130_fd_sc_hd__buf_2
Xplace790 _10250_ VSS VSS VDD VDD net789 sky130_fd_sc_hd__buf_2
Xplace791 _10244_ VSS VSS VDD VDD net790 sky130_fd_sc_hd__buf_2
Xplace792 _10217_ VSS VSS VDD VDD net791 sky130_fd_sc_hd__buf_2
Xplace793 _09812_ VSS VSS VDD VDD net792 sky130_fd_sc_hd__buf_2
Xplace794 _09797_ VSS VSS VDD VDD net793 sky130_fd_sc_hd__buf_2
Xplace795 _09492_ VSS VSS VDD VDD net794 sky130_fd_sc_hd__buf_2
Xplace796 _08689_ VSS VSS VDD VDD net795 sky130_fd_sc_hd__buf_2
Xplace797 _07279_ VSS VSS VDD VDD net796 sky130_fd_sc_hd__buf_2
Xplace798 _07212_ VSS VSS VDD VDD net797 sky130_fd_sc_hd__buf_2
Xplace799 _07173_ VSS VSS VDD VDD net798 sky130_fd_sc_hd__buf_2
Xplace800 _07164_ VSS VSS VDD VDD net799 sky130_fd_sc_hd__buf_2
Xplace801 _07128_ VSS VSS VDD VDD net800 sky130_fd_sc_hd__buf_4
Xplace802 _07126_ VSS VSS VDD VDD net801 sky130_fd_sc_hd__buf_2
Xplace803 _07087_ VSS VSS VDD VDD net802 sky130_fd_sc_hd__buf_2
Xplace804 _07073_ VSS VSS VDD VDD net803 sky130_fd_sc_hd__buf_2
Xplace805 _07050_ VSS VSS VDD VDD net804 sky130_fd_sc_hd__buf_2
Xplace806 _07041_ VSS VSS VDD VDD net805 sky130_fd_sc_hd__buf_2
Xplace807 _07032_ VSS VSS VDD VDD net806 sky130_fd_sc_hd__buf_2
Xplace808 _06635_ VSS VSS VDD VDD net807 sky130_fd_sc_hd__buf_4
Xplace809 _06609_ VSS VSS VDD VDD net808 sky130_fd_sc_hd__buf_4
Xplace810 net810 VSS VSS VDD VDD net809 sky130_fd_sc_hd__buf_2
Xplace811 _06609_ VSS VSS VDD VDD net810 sky130_fd_sc_hd__buf_4
Xplace812 _06606_ VSS VSS VDD VDD net811 sky130_fd_sc_hd__buf_2
Xplace813 _06602_ VSS VSS VDD VDD net812 sky130_fd_sc_hd__buf_4
Xplace814 _06596_ VSS VSS VDD VDD net813 sky130_fd_sc_hd__buf_2
Xplace815 _06596_ VSS VSS VDD VDD net814 sky130_fd_sc_hd__buf_2
Xplace816 net816 VSS VSS VDD VDD net815 sky130_fd_sc_hd__buf_4
Xplace817 _06574_ VSS VSS VDD VDD net816 sky130_fd_sc_hd__buf_4
Xplace818 net819 VSS VSS VDD VDD net817 sky130_fd_sc_hd__buf_2
Xplace819 net819 VSS VSS VDD VDD net818 sky130_fd_sc_hd__buf_4
Xplace820 _06206_ VSS VSS VDD VDD net819 sky130_fd_sc_hd__buf_2
Xplace821 _0215_ VSS VSS VDD VDD net820 sky130_fd_sc_hd__buf_2
Xplace822 _0204_ VSS VSS VDD VDD net821 sky130_fd_sc_hd__buf_4
Xplace823 _0192_ VSS VSS VDD VDD net822 sky130_fd_sc_hd__buf_2
Xplace824 _0187_ VSS VSS VDD VDD net823 sky130_fd_sc_hd__buf_2
Xplace825 _0168_ VSS VSS VDD VDD net824 sky130_fd_sc_hd__buf_2
Xplace826 _0156_ VSS VSS VDD VDD net825 sky130_fd_sc_hd__buf_2
Xplace827 _0145_ VSS VSS VDD VDD net826 sky130_fd_sc_hd__buf_2
Xplace828 _0134_ VSS VSS VDD VDD net827 sky130_fd_sc_hd__buf_2
Xplace829 _0124_ VSS VSS VDD VDD net828 sky130_fd_sc_hd__buf_2
Xplace830 _0113_ VSS VSS VDD VDD net829 sky130_fd_sc_hd__buf_2
Xplace831 _0108_ VSS VSS VDD VDD net830 sky130_fd_sc_hd__buf_2
Xplace832 _0102_ VSS VSS VDD VDD net831 sky130_fd_sc_hd__buf_2
Xplace833 _0097_ VSS VSS VDD VDD net832 sky130_fd_sc_hd__buf_2
Xplace834 _0092_ VSS VSS VDD VDD net833 sky130_fd_sc_hd__buf_2
Xplace835 _0070_ VSS VSS VDD VDD net834 sky130_fd_sc_hd__buf_2
Xplace836 _0059_ VSS VSS VDD VDD net835 sky130_fd_sc_hd__buf_2
Xplace837 _0048_ VSS VSS VDD VDD net836 sky130_fd_sc_hd__buf_2
Xplace838 _0036_ VSS VSS VDD VDD net837 sky130_fd_sc_hd__buf_4
Xplace839 _0025_ VSS VSS VDD VDD net838 sky130_fd_sc_hd__buf_2
Xplace840 _0012_ VSS VSS VDD VDD net839 sky130_fd_sc_hd__buf_2
Xplace841 _0430_ VSS VSS VDD VDD net840 sky130_fd_sc_hd__buf_2
Xplace842 _0428_ VSS VSS VDD VDD net841 sky130_fd_sc_hd__buf_2
Xplace843 _0424_ VSS VSS VDD VDD net842 sky130_fd_sc_hd__buf_2
Xplace844 _0418_ VSS VSS VDD VDD net843 sky130_fd_sc_hd__buf_2
Xplace845 _0416_ VSS VSS VDD VDD net844 sky130_fd_sc_hd__buf_2
Xplace846 _0412_ VSS VSS VDD VDD net845 sky130_fd_sc_hd__buf_2
Xplace847 _0410_ VSS VSS VDD VDD net846 sky130_fd_sc_hd__buf_2
Xplace848 _0406_ VSS VSS VDD VDD net847 sky130_fd_sc_hd__buf_2
Xplace849 _06078_ VSS VSS VDD VDD net848 sky130_fd_sc_hd__buf_2
Xplace850 _05947_ VSS VSS VDD VDD net849 sky130_fd_sc_hd__buf_2
Xplace851 _04835_ VSS VSS VDD VDD net850 sky130_fd_sc_hd__buf_2
Xplace852 _03728_ VSS VSS VDD VDD net851 sky130_fd_sc_hd__buf_2
Xplace853 net853 VSS VSS VDD VDD net852 sky130_fd_sc_hd__buf_2
Xplace854 _11138_ VSS VSS VDD VDD net853 sky130_fd_sc_hd__buf_4
Xplace855 net855 VSS VSS VDD VDD net854 sky130_fd_sc_hd__buf_2
Xplace856 net856 VSS VSS VDD VDD net855 sky130_fd_sc_hd__buf_2
Xplace857 _10590_ VSS VSS VDD VDD net856 sky130_fd_sc_hd__buf_2
Xplace858 _10522_ VSS VSS VDD VDD net857 sky130_fd_sc_hd__buf_2
Xplace859 net860 VSS VSS VDD VDD net858 sky130_fd_sc_hd__buf_2
Xplace860 net860 VSS VSS VDD VDD net859 sky130_fd_sc_hd__buf_2
Xplace861 _10263_ VSS VSS VDD VDD net860 sky130_fd_sc_hd__buf_2
Xplace862 _10240_ VSS VSS VDD VDD net861 sky130_fd_sc_hd__buf_2
Xplace863 _09808_ VSS VSS VDD VDD net862 sky130_fd_sc_hd__buf_2
Xplace864 _09581_ VSS VSS VDD VDD net863 sky130_fd_sc_hd__buf_2
Xplace865 _09577_ VSS VSS VDD VDD net864 sky130_fd_sc_hd__buf_4
Xplace866 _08081_ VSS VSS VDD VDD net865 sky130_fd_sc_hd__buf_2
Xplace867 _06585_ VSS VSS VDD VDD net866 sky130_fd_sc_hd__buf_2
Xplace868 _06258_ VSS VSS VDD VDD net867 sky130_fd_sc_hd__buf_2
Xplace869 _06254_ VSS VSS VDD VDD net868 sky130_fd_sc_hd__buf_2
Xplace870 _06250_ VSS VSS VDD VDD net869 sky130_fd_sc_hd__buf_2
Xplace871 net872 VSS VSS VDD VDD net870 sky130_fd_sc_hd__buf_4
Xplace872 net872 VSS VSS VDD VDD net871 sky130_fd_sc_hd__buf_4
Xplace873 _06204_ VSS VSS VDD VDD net872 sky130_fd_sc_hd__buf_4
Xplace874 _02800_ VSS VSS VDD VDD net873 sky130_fd_sc_hd__buf_2
Xplace875 _06033_ VSS VSS VDD VDD net874 sky130_fd_sc_hd__buf_2
Xplace876 _02625_ VSS VSS VDD VDD net875 sky130_fd_sc_hd__buf_4
Xplace877 _02490_ VSS VSS VDD VDD net876 sky130_fd_sc_hd__buf_4
Xplace878 _02515_ VSS VSS VDD VDD net877 sky130_fd_sc_hd__buf_4
Xplace879 _0725_[0] VSS VSS VDD VDD net878 sky130_fd_sc_hd__buf_2
Xplace880 _02310_ VSS VSS VDD VDD net879 sky130_fd_sc_hd__buf_4
Xplace881 _02485_ VSS VSS VDD VDD net880 sky130_fd_sc_hd__buf_2
Xplace882 _11271_ VSS VSS VDD VDD net881 sky130_fd_sc_hd__buf_4
Xplace883 _11271_ VSS VSS VDD VDD net882 sky130_fd_sc_hd__buf_4
Xplace884 _10203_ VSS VSS VDD VDD net883 sky130_fd_sc_hd__buf_2
Xplace885 _10191_ VSS VSS VDD VDD net884 sky130_fd_sc_hd__buf_2
Xplace886 _09962_ VSS VSS VDD VDD net885 sky130_fd_sc_hd__buf_2
Xplace887 _09806_ VSS VSS VDD VDD net886 sky130_fd_sc_hd__buf_2
Xplace888 _09705_ VSS VSS VDD VDD net887 sky130_fd_sc_hd__buf_2
Xplace889 _06916_ VSS VSS VDD VDD net888 sky130_fd_sc_hd__buf_2
Xplace890 _06324_ VSS VSS VDD VDD net889 sky130_fd_sc_hd__buf_2
Xplace891 _06319_ VSS VSS VDD VDD net890 sky130_fd_sc_hd__buf_2
Xplace892 _06244_ VSS VSS VDD VDD net891 sky130_fd_sc_hd__buf_2
Xplace893 _06237_ VSS VSS VDD VDD net892 sky130_fd_sc_hd__buf_2
Xplace894 _06232_ VSS VSS VDD VDD net893 sky130_fd_sc_hd__buf_2
Xplace895 _02495_ VSS VSS VDD VDD net894 sky130_fd_sc_hd__buf_2
Xplace896 u_core.u_top.u_core.state[3] VSS VSS VDD VDD net895 sky130_fd_sc_hd__buf_2
Xplace897 u_core.u_top.u_core.state[2] VSS VSS VDD VDD net896 sky130_fd_sc_hd__buf_2
Xplace898 u_core.u_top.u_core.state[1] VSS VSS VDD VDD net897 sky130_fd_sc_hd__buf_2
Xplace899 u_core.u_top.u_core.state[0] VSS VSS VDD VDD net898 sky130_fd_sc_hd__buf_2
Xplace900 u_core.u_top.u_core.s_werr VSS VSS VDD VDD net899 sky130_fd_sc_hd__buf_2
Xplace901 u_core.u_top.u_core.r_x[96] VSS VSS VDD VDD net900 sky130_fd_sc_hd__buf_2
Xplace902 u_core.u_top.u_core.r_x[94] VSS VSS VDD VDD net901 sky130_fd_sc_hd__buf_2
Xplace903 u_core.u_top.u_core.r_x[8] VSS VSS VDD VDD net902 sky130_fd_sc_hd__buf_2
Xplace904 u_core.u_top.u_core.r_x[88] VSS VSS VDD VDD net903 sky130_fd_sc_hd__buf_2
Xplace905 u_core.u_top.u_core.r_x[86] VSS VSS VDD VDD net904 sky130_fd_sc_hd__buf_2
Xplace906 u_core.u_top.u_core.r_x[84] VSS VSS VDD VDD net905 sky130_fd_sc_hd__buf_2
Xplace907 u_core.u_top.u_core.r_x[78] VSS VSS VDD VDD net906 sky130_fd_sc_hd__buf_2
Xplace908 u_core.u_top.u_core.r_x[72] VSS VSS VDD VDD net907 sky130_fd_sc_hd__buf_2
Xplace909 u_core.u_top.u_core.r_x[6] VSS VSS VDD VDD net908 sky130_fd_sc_hd__buf_2
Xplace910 u_core.u_top.u_core.r_x[68] VSS VSS VDD VDD net909 sky130_fd_sc_hd__buf_2
Xplace911 u_core.u_top.u_core.r_x[64] VSS VSS VDD VDD net910 sky130_fd_sc_hd__buf_2
Xplace912 u_core.u_top.u_core.r_x[60] VSS VSS VDD VDD net911 sky130_fd_sc_hd__buf_2
Xplace913 u_core.u_top.u_core.r_x[56] VSS VSS VDD VDD net912 sky130_fd_sc_hd__buf_2
Xplace914 u_core.u_top.u_core.r_x[52] VSS VSS VDD VDD net913 sky130_fd_sc_hd__buf_2
Xplace915 u_core.u_top.u_core.r_x[4] VSS VSS VDD VDD net914 sky130_fd_sc_hd__buf_2
Xplace916 u_core.u_top.u_core.r_x[48] VSS VSS VDD VDD net915 sky130_fd_sc_hd__buf_2
Xplace917 u_core.u_top.u_core.r_x[46] VSS VSS VDD VDD net916 sky130_fd_sc_hd__buf_2
Xplace918 u_core.u_top.u_core.r_x[44] VSS VSS VDD VDD net917 sky130_fd_sc_hd__buf_2
Xplace919 u_core.u_top.u_core.r_x[42] VSS VSS VDD VDD net918 sky130_fd_sc_hd__buf_2
Xplace920 u_core.u_top.u_core.r_x[40] VSS VSS VDD VDD net919 sky130_fd_sc_hd__buf_2
Xplace921 u_core.u_top.u_core.r_x[38] VSS VSS VDD VDD net920 sky130_fd_sc_hd__buf_2
Xplace922 u_core.u_top.u_core.r_x[36] VSS VSS VDD VDD net921 sky130_fd_sc_hd__buf_2
Xplace923 u_core.u_top.u_core.r_x[32] VSS VSS VDD VDD net922 sky130_fd_sc_hd__buf_2
Xplace924 u_core.u_top.u_core.r_x[28] VSS VSS VDD VDD net923 sky130_fd_sc_hd__buf_2
Xplace925 u_core.u_top.u_core.r_x[24] VSS VSS VDD VDD net924 sky130_fd_sc_hd__buf_2
Xplace926 u_core.u_top.u_core.r_x[20] VSS VSS VDD VDD net925 sky130_fd_sc_hd__buf_2
Xplace927 u_core.u_top.u_core.r_x[18] VSS VSS VDD VDD net926 sky130_fd_sc_hd__buf_2
Xplace928 u_core.u_top.u_core.r_x[16] VSS VSS VDD VDD net927 sky130_fd_sc_hd__buf_2
Xplace929 u_core.u_top.u_core.r_x[140] VSS VSS VDD VDD net928 sky130_fd_sc_hd__buf_2
Xplace930 u_core.u_top.u_core.r_x[138] VSS VSS VDD VDD net929 sky130_fd_sc_hd__buf_2
Xplace931 u_core.u_top.u_core.r_x[136] VSS VSS VDD VDD net930 sky130_fd_sc_hd__buf_2
Xplace932 u_core.u_top.u_core.r_x[134] VSS VSS VDD VDD net931 sky130_fd_sc_hd__buf_2
Xplace933 u_core.u_top.u_core.r_x[132] VSS VSS VDD VDD net932 sky130_fd_sc_hd__buf_2
Xplace934 u_core.u_top.u_core.r_x[130] VSS VSS VDD VDD net933 sky130_fd_sc_hd__buf_2
Xplace935 u_core.u_top.u_core.r_x[12] VSS VSS VDD VDD net934 sky130_fd_sc_hd__buf_2
Xplace936 u_core.u_top.u_core.r_x[120] VSS VSS VDD VDD net935 sky130_fd_sc_hd__buf_2
Xplace937 u_core.u_top.u_core.r_x[118] VSS VSS VDD VDD net936 sky130_fd_sc_hd__buf_2
Xplace938 u_core.u_top.u_core.r_x[116] VSS VSS VDD VDD net937 sky130_fd_sc_hd__buf_2
Xplace939 u_core.u_top.u_core.r_x[112] VSS VSS VDD VDD net938 sky130_fd_sc_hd__buf_2
Xplace940 u_core.u_top.u_core.r_x[10] VSS VSS VDD VDD net939 sky130_fd_sc_hd__buf_2
Xplace941 u_core.u_top.u_core.r_x[108] VSS VSS VDD VDD net940 sky130_fd_sc_hd__buf_2
Xplace942 u_core.u_top.u_core.r_x[106] VSS VSS VDD VDD net941 sky130_fd_sc_hd__buf_2
Xplace943 u_core.u_top.u_core.r_x[104] VSS VSS VDD VDD net942 sky130_fd_sc_hd__buf_2
Xplace944 u_core.u_top.u_core.r_x[102] VSS VSS VDD VDD net943 sky130_fd_sc_hd__buf_2
Xplace945 u_core.u_top.u_core.r_x[100] VSS VSS VDD VDD net944 sky130_fd_sc_hd__buf_2
Xplace946 u_core.u_top.u_core.r_x[0] VSS VSS VDD VDD net945 sky130_fd_sc_hd__buf_2
Xplace947 u_core.u_top.u_core.r_prow[9] VSS VSS VDD VDD net946 sky130_fd_sc_hd__buf_2
Xplace948 u_core.u_top.u_core.r_prow[8] VSS VSS VDD VDD net947 sky130_fd_sc_hd__buf_2
Xplace949 u_core.u_top.u_core.r_prow[7] VSS VSS VDD VDD net948 sky130_fd_sc_hd__buf_2
Xplace950 u_core.u_top.u_core.r_prow[6] VSS VSS VDD VDD net949 sky130_fd_sc_hd__buf_2
Xplace951 u_core.u_top.u_core.r_prow[5] VSS VSS VDD VDD net950 sky130_fd_sc_hd__buf_2
Xplace952 u_core.u_top.u_core.r_prow[4] VSS VSS VDD VDD net951 sky130_fd_sc_hd__buf_2
Xplace953 u_core.u_top.u_core.r_prow[3] VSS VSS VDD VDD net952 sky130_fd_sc_hd__buf_2
Xplace954 u_core.u_top.u_core.r_prow[2] VSS VSS VDD VDD net953 sky130_fd_sc_hd__buf_2
Xplace955 u_core.u_top.u_core.r_prow[10] VSS VSS VDD VDD net954 sky130_fd_sc_hd__buf_2
Xplace956 u_core.u_top.u_core.r_prow[0] VSS VSS VDD VDD net955 sky130_fd_sc_hd__buf_2
Xplace957 u_core.u_top.u_core.r_off[1] VSS VSS VDD VDD net956 sky130_fd_sc_hd__buf_2
Xplace958 u_core.u_top.u_core.r_off[0] VSS VSS VDD VDD net957 sky130_fd_sc_hd__buf_2
Xplace959 u_core.u_top.u_core.r_lock VSS VSS VDD VDD net958 sky130_fd_sc_hd__buf_2
Xplace960 u_core.u_top.u_core.acc[67] VSS VSS VDD VDD net959 sky130_fd_sc_hd__buf_2
Xplace961 u_core.u_top.u_core.acc[64] VSS VSS VDD VDD net960 sky130_fd_sc_hd__buf_2
Xplace962 u_core.u_top.u_core.acc[63] VSS VSS VDD VDD net961 sky130_fd_sc_hd__buf_2
Xplace963 u_core.u_top.u_core.acc[178] VSS VSS VDD VDD net962 sky130_fd_sc_hd__buf_2
Xplace964 u_core.u_top.u_core.acc[175] VSS VSS VDD VDD net963 sky130_fd_sc_hd__buf_2
Xplace965 u_core.u_top.bus_wdata[7] VSS VSS VDD VDD net964 sky130_fd_sc_hd__buf_2
Xplace966 u_core.u_top.bus_wdata[6] VSS VSS VDD VDD net965 sky130_fd_sc_hd__buf_2
Xplace967 u_core.u_top.bus_wdata[5] VSS VSS VDD VDD net966 sky130_fd_sc_hd__buf_2
Xplace968 u_core.u_top.bus_wdata[42] VSS VSS VDD VDD net967 sky130_fd_sc_hd__buf_2
Xplace969 u_core.u_top.bus_wdata[3] VSS VSS VDD VDD net968 sky130_fd_sc_hd__buf_2
Xplace970 u_core.u_top.bus_wdata[36] VSS VSS VDD VDD net969 sky130_fd_sc_hd__buf_2
Xplace971 u_core.u_top.bus_wdata[2] VSS VSS VDD VDD net970 sky130_fd_sc_hd__buf_2
Xplace972 u_core.u_top.bus_wdata[1] VSS VSS VDD VDD net971 sky130_fd_sc_hd__buf_4
Xplace973 u_core.u_top.bus_wdata[0] VSS VSS VDD VDD net972 sky130_fd_sc_hd__buf_4
Xplace974 u_core.u_top.bus_addr[2] VSS VSS VDD VDD net973 sky130_fd_sc_hd__buf_2
Xplace975 net975 VSS VSS VDD VDD net974 sky130_fd_sc_hd__buf_4
Xplace976 u_core.u_top.bus_addr[1] VSS VSS VDD VDD net975 sky130_fd_sc_hd__buf_2
Xplace977 net977 VSS VSS VDD VDD net976 sky130_fd_sc_hd__buf_2
Xplace978 u_core.u_top.bus_addr[0] VSS VSS VDD VDD net977 sky130_fd_sc_hd__buf_4
Xplace979 u_core.arr_sa_p[3] VSS VSS VDD VDD net978 sky130_fd_sc_hd__buf_2
Xplace980 u_core.arr_sa_n[3] VSS VSS VDD VDD net979 sky130_fd_sc_hd__buf_2
Xplace981 u_core.arr_sa_n[22] VSS VSS VDD VDD net980 sky130_fd_sc_hd__buf_2
Xplace982 u_core.arr_row[6] VSS VSS VDD VDD net981 sky130_fd_sc_hd__buf_2
Xplace983 u_core.arr_row[5] VSS VSS VDD VDD net982 sky130_fd_sc_hd__buf_2
Xplace984 u_core.arr_row[4] VSS VSS VDD VDD net983 sky130_fd_sc_hd__buf_2
Xplace985 u_core.arr_row[3] VSS VSS VDD VDD net984 sky130_fd_sc_hd__buf_2
Xplace986 u_core.arr_row[2] VSS VSS VDD VDD net985 sky130_fd_sc_hd__buf_2
Xplace987 u_core.arr_row[1] VSS VSS VDD VDD net986 sky130_fd_sc_hd__buf_2
Xplace988 u_core.arr_row[0] VSS VSS VDD VDD net987 sky130_fd_sc_hd__buf_2
Xplace989 _02391_ VSS VSS VDD VDD net988 sky130_fd_sc_hd__buf_4
Xplace990 _10234_ VSS VSS VDD VDD net989 sky130_fd_sc_hd__buf_2
Xplace991 _06578_ VSS VSS VDD VDD net990 sky130_fd_sc_hd__buf_2
Xplace992 u_core.u_top.u_core.lfsr[9] VSS VSS VDD VDD net991 sky130_fd_sc_hd__buf_2
Xplace993 u_core.u_top.u_core.lfsr[2] VSS VSS VDD VDD net992 sky130_fd_sc_hd__buf_4
Xplace994 _0725_[2] VSS VSS VDD VDD net993 sky130_fd_sc_hd__buf_2
Xplace995 _0725_[2] VSS VSS VDD VDD net994 sky130_fd_sc_hd__buf_2
Xplace996 _0725_[1] VSS VSS VDD VDD net995 sky130_fd_sc_hd__buf_4
Xplace997 u_core.u_top.bus_re VSS VSS VDD VDD net996 sky130_fd_sc_hd__buf_2
Xplace998 u_core.u_actl.st[5] VSS VSS VDD VDD net997 sky130_fd_sc_hd__buf_2
Xplace999 net999 VSS VSS VDD VDD net998 sky130_fd_sc_hd__buf_2
Xpstb$_DFFE_PN0P_ clknet_3_5__leaf__11407_ _1111_ net1019 VSS VSS VDD VDD net154 sky130_fd_sc_hd__dfrtp_1
Xref_sel[0]$_DFFE_PN0P_ clknet_2_2__leaf__11421_ _1109_[0] net1017 VSS VSS VDD VDD net155 sky130_fd_sc_hd__dfrtp_1
Xref_sel[1]$_DFFE_PN0P_ clknet_2_2__leaf__11421_ _1109_[1] net1016 VSS VSS VDD VDD net156 sky130_fd_sc_hd__dfrtp_1
Xref_sel[2]$_DFFE_PN0P_ clknet_2_2__leaf__11421_ _1109_[2] net1017 VSS VSS VDD VDD net157 sky130_fd_sc_hd__dfrtp_1
Xsl_prg$_DFFE_PN0P_ clknet_2_3__leaf__11421_ _1103_ net1006 VSS VSS VDD VDD net158 sky130_fd_sc_hd__dfrtp_1
Xu_core.arr_ack$_DFF_PN0_ clknet_3_7__leaf_clk_regs _1006_ net1019 VSS VSS VDD VDD u_core.arr_ack sky130_fd_sc_hd__dfrtp_1
Xu_core.arr_amp[0]$_DFFE_PN0P_ clknet_1_1__leaf__11355_ u_core.u_top.u_core.amp[0] net1029 VSS VSS VDD VDD u_core.arr_amp[0] sky130_fd_sc_hd__dfrtp_1
Xu_core.arr_amp[1]$_DFFE_PN0P_ clknet_1_1__leaf__11355_ u_core.u_top.u_core.amp[1] net1029 VSS VSS VDD VDD u_core.arr_amp[1] sky130_fd_sc_hd__dfrtp_1
Xu_core.arr_amp[2]$_DFFE_PN0P_ clknet_1_1__leaf__11355_ u_core.u_top.u_core.amp[2] net1029 VSS VSS VDD VDD u_core.arr_amp[2] sky130_fd_sc_hd__dfrtp_1
Xu_core.arr_amp[3]$_DFFE_PN0P_ clknet_1_0__leaf__11355_ u_core.u_top.u_core.amp[3] net1029 VSS VSS VDD VDD u_core.arr_amp[3] sky130_fd_sc_hd__dfrtp_1
Xu_core.arr_amp[4]$_DFFE_PN0P_ clknet_1_0__leaf__11355_ u_core.u_top.u_core.amp[4] net1029 VSS VSS VDD VDD u_core.arr_amp[4] sky130_fd_sc_hd__dfrtp_1
Xu_core.arr_mask_n[0]$_DFFE_PN0P_ clknet_2_2__leaf__11422_ _1025_[0] net1023 VSS VSS VDD VDD u_core.arr_mask_n[0] sky130_fd_sc_hd__dfrtp_1
Xu_core.arr_mask_n[10]$_DFFE_PN0P_ clknet_2_0__leaf__11422_ _1025_[10] net1009 VSS VSS VDD VDD u_core.arr_mask_n[10] sky130_fd_sc_hd__dfrtp_1
Xu_core.arr_mask_n[11]$_DFFE_PN0P_ clknet_2_0__leaf__11422_ _1025_[11] net1009 VSS VSS VDD VDD u_core.arr_mask_n[11] sky130_fd_sc_hd__dfrtp_1
Xu_core.arr_mask_n[12]$_DFFE_PN0P_ clknet_2_1__leaf__11422_ _1025_[12] net1009 VSS VSS VDD VDD u_core.arr_mask_n[12] sky130_fd_sc_hd__dfrtp_1
Xu_core.arr_mask_n[13]$_DFFE_PN0P_ clknet_2_0__leaf__11422_ _1025_[13] net1009 VSS VSS VDD VDD u_core.arr_mask_n[13] sky130_fd_sc_hd__dfrtp_1
Xu_core.arr_mask_n[14]$_DFFE_PN0P_ clknet_2_1__leaf__11422_ _1025_[14] net1009 VSS VSS VDD VDD u_core.arr_mask_n[14] sky130_fd_sc_hd__dfrtp_1
Xu_core.arr_mask_n[15]$_DFFE_PN0P_ clknet_2_1__leaf__11422_ _1025_[15] net1009 VSS VSS VDD VDD u_core.arr_mask_n[15] sky130_fd_sc_hd__dfrtp_1
Xu_core.arr_mask_n[16]$_DFFE_PN0P_ clknet_2_1__leaf__11422_ _1025_[16] net1009 VSS VSS VDD VDD u_core.arr_mask_n[16] sky130_fd_sc_hd__dfrtp_1
Xu_core.arr_mask_n[17]$_DFFE_PN0P_ clknet_2_1__leaf__11422_ _1025_[17] net1009 VSS VSS VDD VDD u_core.arr_mask_n[17] sky130_fd_sc_hd__dfrtp_1
Xu_core.arr_mask_n[18]$_DFFE_PN0P_ clknet_2_1__leaf__11422_ _1025_[18] net1010 VSS VSS VDD VDD u_core.arr_mask_n[18] sky130_fd_sc_hd__dfrtp_1
Xu_core.arr_mask_n[19]$_DFFE_PN0P_ clknet_2_1__leaf__11422_ _1025_[19] net1010 VSS VSS VDD VDD u_core.arr_mask_n[19] sky130_fd_sc_hd__dfrtp_1
Xu_core.arr_mask_n[1]$_DFFE_PN0P_ clknet_2_3__leaf__11422_ _1025_[1] net1009 VSS VSS VDD VDD u_core.arr_mask_n[1] sky130_fd_sc_hd__dfrtp_1
Xu_core.arr_mask_n[20]$_DFFE_PN0P_ clknet_2_1__leaf__11422_ _1025_[20] net1010 VSS VSS VDD VDD u_core.arr_mask_n[20] sky130_fd_sc_hd__dfrtp_1
Xu_core.arr_mask_n[21]$_DFFE_PN0P_ clknet_2_1__leaf__11422_ _1025_[21] net1010 VSS VSS VDD VDD u_core.arr_mask_n[21] sky130_fd_sc_hd__dfrtp_1
Xu_core.arr_mask_n[22]$_DFFE_PN0P_ clknet_2_0__leaf__11422_ _1025_[22] net1009 VSS VSS VDD VDD u_core.arr_mask_n[22] sky130_fd_sc_hd__dfrtp_1
Xu_core.arr_mask_n[23]$_DFFE_PN0P_ clknet_2_3__leaf__11422_ _1025_[23] net1023 VSS VSS VDD VDD u_core.arr_mask_n[23] sky130_fd_sc_hd__dfrtp_1
Xu_core.arr_mask_n[2]$_DFFE_PN0P_ clknet_2_2__leaf__11422_ _1025_[2] net1023 VSS VSS VDD VDD u_core.arr_mask_n[2] sky130_fd_sc_hd__dfrtp_1
Xu_core.arr_mask_n[3]$_DFFE_PN0P_ clknet_2_0__leaf__11422_ _1025_[3] net1009 VSS VSS VDD VDD u_core.arr_mask_n[3] sky130_fd_sc_hd__dfrtp_1
Xu_core.arr_mask_n[4]$_DFFE_PN0P_ clknet_2_0__leaf__11422_ _1025_[4] net1009 VSS VSS VDD VDD u_core.arr_mask_n[4] sky130_fd_sc_hd__dfrtp_1
Xu_core.arr_mask_n[5]$_DFFE_PN0P_ clknet_2_2__leaf__11422_ _1025_[5] net1023 VSS VSS VDD VDD u_core.arr_mask_n[5] sky130_fd_sc_hd__dfrtp_1
Xu_core.arr_mask_n[6]$_DFFE_PN0P_ clknet_2_3__leaf__11422_ _1025_[6] net1023 VSS VSS VDD VDD u_core.arr_mask_n[6] sky130_fd_sc_hd__dfrtp_1
Xu_core.arr_mask_n[7]$_DFFE_PN0P_ clknet_2_3__leaf__11422_ _1025_[7] net1024 VSS VSS VDD VDD u_core.arr_mask_n[7] sky130_fd_sc_hd__dfrtp_1
Xu_core.arr_mask_n[8]$_DFFE_PN0P_ clknet_2_2__leaf__11422_ _1025_[8] net1023 VSS VSS VDD VDD u_core.arr_mask_n[8] sky130_fd_sc_hd__dfrtp_1
Xu_core.arr_mask_n[9]$_DFFE_PN0P_ clknet_2_0__leaf__11422_ _1025_[9] net1009 VSS VSS VDD VDD u_core.arr_mask_n[9] sky130_fd_sc_hd__dfrtp_1
Xu_core.arr_mask_p[0]$_DFFE_PN0P_ clknet_2_2__leaf__11422_ _1022_[0] net1023 VSS VSS VDD VDD u_core.arr_mask_p[0] sky130_fd_sc_hd__dfrtp_1
Xu_core.arr_mask_p[10]$_DFFE_PN0P_ clknet_2_3__leaf__11422_ _1022_[10] net1023 VSS VSS VDD VDD u_core.arr_mask_p[10] sky130_fd_sc_hd__dfrtp_1
Xu_core.arr_mask_p[11]$_DFFE_PN0P_ clknet_2_3__leaf__11422_ _1022_[11] net1024 VSS VSS VDD VDD u_core.arr_mask_p[11] sky130_fd_sc_hd__dfrtp_1
Xu_core.arr_mask_p[12]$_DFFE_PN0P_ clknet_2_1__leaf__11422_ _1022_[12] net1010 VSS VSS VDD VDD u_core.arr_mask_p[12] sky130_fd_sc_hd__dfrtp_1
Xu_core.arr_mask_p[13]$_DFFE_PN0P_ clknet_2_0__leaf__11422_ _1022_[13] net1009 VSS VSS VDD VDD u_core.arr_mask_p[13] sky130_fd_sc_hd__dfrtp_1
Xu_core.arr_mask_p[14]$_DFFE_PN0P_ clknet_2_0__leaf__11422_ _1022_[14] net1009 VSS VSS VDD VDD u_core.arr_mask_p[14] sky130_fd_sc_hd__dfrtp_1
Xu_core.arr_mask_p[15]$_DFFE_PN0P_ clknet_2_1__leaf__11422_ _1022_[15] net1009 VSS VSS VDD VDD u_core.arr_mask_p[15] sky130_fd_sc_hd__dfrtp_1
Xu_core.arr_mask_p[16]$_DFFE_PN0P_ clknet_2_0__leaf__11422_ _1022_[16] net1009 VSS VSS VDD VDD u_core.arr_mask_p[16] sky130_fd_sc_hd__dfrtp_1
Xu_core.arr_mask_p[17]$_DFFE_PN0P_ clknet_2_1__leaf__11422_ _1022_[17] net1009 VSS VSS VDD VDD u_core.arr_mask_p[17] sky130_fd_sc_hd__dfrtp_1
Xu_core.arr_mask_p[18]$_DFFE_PN0P_ clknet_2_0__leaf__11422_ _1022_[18] net1009 VSS VSS VDD VDD u_core.arr_mask_p[18] sky130_fd_sc_hd__dfrtp_1
Xu_core.arr_mask_p[19]$_DFFE_PN0P_ clknet_2_1__leaf__11422_ _1022_[19] net1009 VSS VSS VDD VDD u_core.arr_mask_p[19] sky130_fd_sc_hd__dfrtp_1
Xu_core.arr_mask_p[1]$_DFFE_PN0P_ clknet_2_3__leaf__11422_ _1022_[1] net1024 VSS VSS VDD VDD u_core.arr_mask_p[1] sky130_fd_sc_hd__dfrtp_1
Xu_core.arr_mask_p[20]$_DFFE_PN0P_ clknet_2_1__leaf__11422_ _1022_[20] net1010 VSS VSS VDD VDD u_core.arr_mask_p[20] sky130_fd_sc_hd__dfrtp_1
Xu_core.arr_mask_p[21]$_DFFE_PN0P_ clknet_2_1__leaf__11422_ _1022_[21] net1009 VSS VSS VDD VDD u_core.arr_mask_p[21] sky130_fd_sc_hd__dfrtp_1
Xu_core.arr_mask_p[22]$_DFFE_PN0P_ clknet_2_0__leaf__11422_ _1022_[22] net1024 VSS VSS VDD VDD u_core.arr_mask_p[22] sky130_fd_sc_hd__dfrtp_1
Xu_core.arr_mask_p[23]$_DFFE_PN0P_ clknet_2_3__leaf__11422_ _1022_[23] net1023 VSS VSS VDD VDD u_core.arr_mask_p[23] sky130_fd_sc_hd__dfrtp_1
Xu_core.arr_mask_p[2]$_DFFE_PN0P_ clknet_2_2__leaf__11422_ _1022_[2] net1023 VSS VSS VDD VDD u_core.arr_mask_p[2] sky130_fd_sc_hd__dfrtp_1
Xu_core.arr_mask_p[3]$_DFFE_PN0P_ clknet_2_2__leaf__11422_ _1022_[3] net1023 VSS VSS VDD VDD u_core.arr_mask_p[3] sky130_fd_sc_hd__dfrtp_1
Xu_core.arr_mask_p[4]$_DFFE_PN0P_ clknet_2_0__leaf__11422_ _1022_[4] net1009 VSS VSS VDD VDD u_core.arr_mask_p[4] sky130_fd_sc_hd__dfrtp_1
Xu_core.arr_mask_p[5]$_DFFE_PN0P_ clknet_2_2__leaf__11422_ _1022_[5] net1023 VSS VSS VDD VDD u_core.arr_mask_p[5] sky130_fd_sc_hd__dfrtp_1
Xu_core.arr_mask_p[6]$_DFFE_PN0P_ clknet_2_2__leaf__11422_ _1022_[6] net1023 VSS VSS VDD VDD u_core.arr_mask_p[6] sky130_fd_sc_hd__dfrtp_1
Xu_core.arr_mask_p[7]$_DFFE_PN0P_ clknet_2_2__leaf__11422_ _1022_[7] net1023 VSS VSS VDD VDD u_core.arr_mask_p[7] sky130_fd_sc_hd__dfrtp_1
Xu_core.arr_mask_p[8]$_DFFE_PN0P_ clknet_2_2__leaf__11422_ _1022_[8] net1023 VSS VSS VDD VDD u_core.arr_mask_p[8] sky130_fd_sc_hd__dfrtp_1
Xu_core.arr_mask_p[9]$_DFFE_PN0P_ clknet_2_2__leaf__11422_ _1022_[9] net1023 VSS VSS VDD VDD u_core.arr_mask_p[9] sky130_fd_sc_hd__dfrtp_1
Xu_core.arr_op[0]$_DFFE_PN0P_ clknet_1_0__leaf__11401_ _1017_[0] net1019 VSS VSS VDD VDD u_core.arr_op[0] sky130_fd_sc_hd__dfrtp_1
Xu_core.arr_op[1]$_DFFE_PN0P_ clknet_1_0__leaf__11401_ _1017_[1] net1020 VSS VSS VDD VDD u_core.arr_op[1] sky130_fd_sc_hd__dfrtp_1
Xu_core.arr_op[2]$_DFFE_PN0P_ clknet_1_1__leaf__11401_ _1017_[2] net1019 VSS VSS VDD VDD u_core.arr_op[2] sky130_fd_sc_hd__dfrtp_1
Xu_core.arr_req$_DFFE_PN0P_ _11353_ _1073_ net1020 VSS VSS VDD VDD u_core.arr_req sky130_fd_sc_hd__dfrtp_1
Xu_core.arr_row[0]$_DFFE_PN0P_ clknet_1_1__leaf__11383_ _1019_[0] net1029 VSS VSS VDD VDD u_core.arr_row[0] sky130_fd_sc_hd__dfrtp_1
Xu_core.arr_row[1]$_DFFE_PN0P_ clknet_1_0__leaf__11383_ _1019_[1] net1029 VSS VSS VDD VDD u_core.arr_row[1] sky130_fd_sc_hd__dfrtp_1
Xu_core.arr_row[2]$_DFFE_PN0P_ clknet_1_0__leaf__11383_ _1019_[2] net1029 VSS VSS VDD VDD u_core.arr_row[2] sky130_fd_sc_hd__dfrtp_1
Xu_core.arr_row[3]$_DFFE_PN0P_ clknet_1_1__leaf__11383_ _1019_[3] net1029 VSS VSS VDD VDD u_core.arr_row[3] sky130_fd_sc_hd__dfrtp_2
Xu_core.arr_row[4]$_DFFE_PN0P_ clknet_1_1__leaf__11383_ _1019_[4] net1029 VSS VSS VDD VDD u_core.arr_row[4] sky130_fd_sc_hd__dfrtp_1
Xu_core.arr_row[5]$_DFFE_PN0P_ clknet_1_1__leaf__11383_ _1019_[5] net1029 VSS VSS VDD VDD u_core.arr_row[5] sky130_fd_sc_hd__dfrtp_1
Xu_core.arr_row[6]$_DFFE_PN0P_ clknet_1_0__leaf__11383_ _1019_[6] net1029 VSS VSS VDD VDD u_core.arr_row[6] sky130_fd_sc_hd__dfrtp_2
Xu_core.arr_sa_n[0]$_DFFE_PN0P_ clknet_2_2__leaf__11425_ _1091_[0] net1023 VSS VSS VDD VDD u_core.arr_sa_n[0] sky130_fd_sc_hd__dfrtp_1
Xu_core.arr_sa_n[10]$_DFFE_PN0P_ clknet_2_3__leaf__11425_ _1091_[10] net1009 VSS VSS VDD VDD u_core.arr_sa_n[10] sky130_fd_sc_hd__dfrtp_1
Xu_core.arr_sa_n[11]$_DFFE_PN0P_ clknet_2_1__leaf__11425_ _1091_[11] net1008 VSS VSS VDD VDD u_core.arr_sa_n[11] sky130_fd_sc_hd__dfrtp_1
Xu_core.arr_sa_n[12]$_DFFE_PN0P_ clknet_2_1__leaf__11425_ _1091_[12] net1010 VSS VSS VDD VDD u_core.arr_sa_n[12] sky130_fd_sc_hd__dfrtp_1
Xu_core.arr_sa_n[13]$_DFFE_PN0P_ clknet_2_1__leaf__11425_ _1091_[13] net1010 VSS VSS VDD VDD u_core.arr_sa_n[13] sky130_fd_sc_hd__dfrtp_1
Xu_core.arr_sa_n[14]$_DFFE_PN0P_ clknet_2_0__leaf__11425_ _1091_[14] net1009 VSS VSS VDD VDD u_core.arr_sa_n[14] sky130_fd_sc_hd__dfrtp_1
Xu_core.arr_sa_n[15]$_DFFE_PN0P_ clknet_2_0__leaf__11425_ _1091_[15] net1010 VSS VSS VDD VDD u_core.arr_sa_n[15] sky130_fd_sc_hd__dfrtp_1
Xu_core.arr_sa_n[16]$_DFFE_PN0P_ clknet_2_0__leaf__11425_ _1091_[16] net1010 VSS VSS VDD VDD u_core.arr_sa_n[16] sky130_fd_sc_hd__dfrtp_1
Xu_core.arr_sa_n[17]$_DFFE_PN0P_ clknet_2_1__leaf__11425_ _1091_[17] net1010 VSS VSS VDD VDD u_core.arr_sa_n[17] sky130_fd_sc_hd__dfrtp_1
Xu_core.arr_sa_n[18]$_DFFE_PN0P_ clknet_2_0__leaf__11425_ _1091_[18] net1010 VSS VSS VDD VDD u_core.arr_sa_n[18] sky130_fd_sc_hd__dfrtp_1
Xu_core.arr_sa_n[19]$_DFFE_PN0P_ clknet_2_1__leaf__11425_ _1091_[19] net1012 VSS VSS VDD VDD u_core.arr_sa_n[19] sky130_fd_sc_hd__dfrtp_1
Xu_core.arr_sa_n[1]$_DFFE_PN0P_ clknet_2_2__leaf__11425_ _1091_[1] net1023 VSS VSS VDD VDD u_core.arr_sa_n[1] sky130_fd_sc_hd__dfrtp_1
Xu_core.arr_sa_n[20]$_DFFE_PN0P_ clknet_2_0__leaf__11425_ _1091_[20] net1012 VSS VSS VDD VDD u_core.arr_sa_n[20] sky130_fd_sc_hd__dfrtp_1
Xu_core.arr_sa_n[21]$_DFFE_PN0P_ clknet_2_0__leaf__11425_ _1091_[21] net1010 VSS VSS VDD VDD u_core.arr_sa_n[21] sky130_fd_sc_hd__dfrtp_1
Xu_core.arr_sa_n[22]$_DFFE_PN0P_ clknet_2_0__leaf__11425_ _1091_[22] net1010 VSS VSS VDD VDD u_core.arr_sa_n[22] sky130_fd_sc_hd__dfrtp_1
Xu_core.arr_sa_n[23]$_DFFE_PN0P_ clknet_2_0__leaf__11425_ _1091_[23] net1010 VSS VSS VDD VDD u_core.arr_sa_n[23] sky130_fd_sc_hd__dfrtp_1
Xu_core.arr_sa_n[2]$_DFFE_PN0P_ clknet_2_2__leaf__11425_ _1091_[2] net1023 VSS VSS VDD VDD u_core.arr_sa_n[2] sky130_fd_sc_hd__dfrtp_1
Xu_core.arr_sa_n[3]$_DFFE_PN0P_ clknet_2_2__leaf__11425_ _1091_[3] net1023 VSS VSS VDD VDD u_core.arr_sa_n[3] sky130_fd_sc_hd__dfrtp_1
Xu_core.arr_sa_n[4]$_DFFE_PN0P_ clknet_2_3__leaf__11425_ _1091_[4] net1024 VSS VSS VDD VDD u_core.arr_sa_n[4] sky130_fd_sc_hd__dfrtp_1
Xu_core.arr_sa_n[5]$_DFFE_PN0P_ clknet_2_2__leaf__11425_ _1091_[5] net1023 VSS VSS VDD VDD u_core.arr_sa_n[5] sky130_fd_sc_hd__dfrtp_1
Xu_core.arr_sa_n[6]$_DFFE_PN0P_ clknet_2_3__leaf__11425_ _1091_[6] net1009 VSS VSS VDD VDD u_core.arr_sa_n[6] sky130_fd_sc_hd__dfrtp_1
Xu_core.arr_sa_n[7]$_DFFE_PN0P_ clknet_2_3__leaf__11425_ _1091_[7] net1009 VSS VSS VDD VDD u_core.arr_sa_n[7] sky130_fd_sc_hd__dfrtp_1
Xu_core.arr_sa_n[8]$_DFFE_PN0P_ clknet_2_3__leaf__11425_ _1091_[8] net1009 VSS VSS VDD VDD u_core.arr_sa_n[8] sky130_fd_sc_hd__dfrtp_1
Xu_core.arr_sa_n[9]$_DFFE_PN0P_ clknet_2_3__leaf__11425_ _1091_[9] net1009 VSS VSS VDD VDD u_core.arr_sa_n[9] sky130_fd_sc_hd__dfrtp_1
Xu_core.arr_sa_p[0]$_DFFE_PN0P_ clknet_2_2__leaf__11425_ _1089_[0] net1023 VSS VSS VDD VDD u_core.arr_sa_p[0] sky130_fd_sc_hd__dfrtp_1
Xu_core.arr_sa_p[10]$_DFFE_PN0P_ clknet_2_3__leaf__11425_ _1089_[10] net1009 VSS VSS VDD VDD u_core.arr_sa_p[10] sky130_fd_sc_hd__dfrtp_1
Xu_core.arr_sa_p[11]$_DFFE_PN0P_ clknet_2_1__leaf__11425_ _1089_[11] net1009 VSS VSS VDD VDD u_core.arr_sa_p[11] sky130_fd_sc_hd__dfrtp_1
Xu_core.arr_sa_p[12]$_DFFE_PN0P_ clknet_2_0__leaf__11425_ _1089_[12] net1010 VSS VSS VDD VDD u_core.arr_sa_p[12] sky130_fd_sc_hd__dfrtp_1
Xu_core.arr_sa_p[13]$_DFFE_PN0P_ clknet_2_1__leaf__11425_ _1089_[13] net1009 VSS VSS VDD VDD u_core.arr_sa_p[13] sky130_fd_sc_hd__dfrtp_1
Xu_core.arr_sa_p[14]$_DFFE_PN0P_ clknet_2_1__leaf__11425_ _1089_[14] net1009 VSS VSS VDD VDD u_core.arr_sa_p[14] sky130_fd_sc_hd__dfrtp_1
Xu_core.arr_sa_p[15]$_DFFE_PN0P_ clknet_2_1__leaf__11425_ _1089_[15] net1012 VSS VSS VDD VDD u_core.arr_sa_p[15] sky130_fd_sc_hd__dfrtp_1
Xu_core.arr_sa_p[16]$_DFFE_PN0P_ clknet_2_1__leaf__11425_ _1089_[16] net1010 VSS VSS VDD VDD u_core.arr_sa_p[16] sky130_fd_sc_hd__dfrtp_1
Xu_core.arr_sa_p[17]$_DFFE_PN0P_ clknet_2_0__leaf__11425_ _1089_[17] net1010 VSS VSS VDD VDD u_core.arr_sa_p[17] sky130_fd_sc_hd__dfrtp_1
Xu_core.arr_sa_p[18]$_DFFE_PN0P_ clknet_2_1__leaf__11425_ _1089_[18] net1012 VSS VSS VDD VDD u_core.arr_sa_p[18] sky130_fd_sc_hd__dfrtp_1
Xu_core.arr_sa_p[19]$_DFFE_PN0P_ clknet_2_0__leaf__11425_ _1089_[19] net1012 VSS VSS VDD VDD u_core.arr_sa_p[19] sky130_fd_sc_hd__dfrtp_1
Xu_core.arr_sa_p[1]$_DFFE_PN0P_ clknet_2_2__leaf__11425_ _1089_[1] net1024 VSS VSS VDD VDD u_core.arr_sa_p[1] sky130_fd_sc_hd__dfrtp_1
Xu_core.arr_sa_p[20]$_DFFE_PN0P_ clknet_2_1__leaf__11425_ _1089_[20] net1012 VSS VSS VDD VDD u_core.arr_sa_p[20] sky130_fd_sc_hd__dfrtp_1
Xu_core.arr_sa_p[21]$_DFFE_PN0P_ clknet_2_1__leaf__11425_ _1089_[21] net1010 VSS VSS VDD VDD u_core.arr_sa_p[21] sky130_fd_sc_hd__dfrtp_1
Xu_core.arr_sa_p[22]$_DFFE_PN0P_ clknet_2_1__leaf__11425_ _1089_[22] net1012 VSS VSS VDD VDD u_core.arr_sa_p[22] sky130_fd_sc_hd__dfrtp_1
Xu_core.arr_sa_p[23]$_DFFE_PN0P_ clknet_2_1__leaf__11425_ _1089_[23] net1012 VSS VSS VDD VDD u_core.arr_sa_p[23] sky130_fd_sc_hd__dfrtp_1
Xu_core.arr_sa_p[2]$_DFFE_PN0P_ clknet_2_2__leaf__11425_ _1089_[2] net1023 VSS VSS VDD VDD u_core.arr_sa_p[2] sky130_fd_sc_hd__dfrtp_1
Xu_core.arr_sa_p[3]$_DFFE_PN0P_ clknet_2_2__leaf__11425_ _1089_[3] net1023 VSS VSS VDD VDD u_core.arr_sa_p[3] sky130_fd_sc_hd__dfrtp_1
Xu_core.arr_sa_p[4]$_DFFE_PN0P_ clknet_2_2__leaf__11425_ _1089_[4] net1024 VSS VSS VDD VDD u_core.arr_sa_p[4] sky130_fd_sc_hd__dfrtp_1
Xu_core.arr_sa_p[5]$_DFFE_PN0P_ clknet_2_2__leaf__11425_ _1089_[5] net1023 VSS VSS VDD VDD u_core.arr_sa_p[5] sky130_fd_sc_hd__dfrtp_1
Xu_core.arr_sa_p[6]$_DFFE_PN0P_ clknet_2_2__leaf__11425_ _1089_[6] net1023 VSS VSS VDD VDD u_core.arr_sa_p[6] sky130_fd_sc_hd__dfrtp_1
Xu_core.arr_sa_p[7]$_DFFE_PN0P_ clknet_2_2__leaf__11425_ _1089_[7] net1023 VSS VSS VDD VDD u_core.arr_sa_p[7] sky130_fd_sc_hd__dfrtp_1
Xu_core.arr_sa_p[8]$_DFFE_PN0P_ clknet_2_3__leaf__11425_ _1089_[8] net1008 VSS VSS VDD VDD u_core.arr_sa_p[8] sky130_fd_sc_hd__dfrtp_1
Xu_core.arr_sa_p[9]$_DFFE_PN0P_ clknet_2_3__leaf__11425_ _1089_[9] net1009 VSS VSS VDD VDD u_core.arr_sa_p[9] sky130_fd_sc_hd__dfrtp_1
Xu_core.u_actl.cnt[0]$_DFFE_PN0P_ clknet_1_0__leaf__11366_ _1114_[0] net1019 VSS VSS VDD VDD u_core.u_actl.cnt[0] sky130_fd_sc_hd__dfrtp_1
Xu_core.u_actl.cnt[1]$_DFFE_PN0P_ clknet_1_0__leaf__11366_ _1114_[1] net1019 VSS VSS VDD VDD u_core.u_actl.cnt[1] sky130_fd_sc_hd__dfrtp_1
Xu_core.u_actl.cnt[2]$_DFFE_PN0P_ clknet_1_1__leaf__11366_ _1114_[2] net1019 VSS VSS VDD VDD u_core.u_actl.cnt[2] sky130_fd_sc_hd__dfrtp_1
Xu_core.u_actl.cnt[3]$_DFFE_PN0P_ clknet_1_0__leaf__11366_ _1114_[3] net1019 VSS VSS VDD VDD u_core.u_actl.cnt[3] sky130_fd_sc_hd__dfrtp_1
Xu_core.u_actl.cnt[4]$_DFFE_PN0P_ clknet_1_1__leaf__11366_ _1114_[4] net1019 VSS VSS VDD VDD u_core.u_actl.cnt[4] sky130_fd_sc_hd__dfrtp_1
Xu_core.u_actl.cnt[5]$_DFFE_PN0P_ clknet_1_1__leaf__11366_ _1114_[5] net1019 VSS VSS VDD VDD u_core.u_actl.cnt[5] sky130_fd_sc_hd__dfrtp_1
Xu_core.u_actl.cnt[6]$_DFFE_PN0P_ clknet_1_1__leaf__11366_ _1114_[6] net1019 VSS VSS VDD VDD u_core.u_actl.cnt[6] sky130_fd_sc_hd__dfrtp_1
Xu_core.u_actl.cnt[7]$_DFFE_PN0P_ clknet_1_0__leaf__11366_ _1114_[7] net1019 VSS VSS VDD VDD u_core.u_actl.cnt[7] sky130_fd_sc_hd__dfrtp_1
Xu_core.u_actl.cnt[8]$_DFFE_PN0P_ clknet_1_1__leaf__11366_ _1114_[8] net1019 VSS VSS VDD VDD u_core.u_actl.cnt[8] sky130_fd_sc_hd__dfrtp_1
Xu_core.u_actl.mn[0]$_DFFE_PN0P_ clknet_3_1__leaf__11429_ u_core.arr_mask_n[0] net1024 VSS VSS VDD VDD u_core.u_actl.mn[0] sky130_fd_sc_hd__dfrtp_1
Xu_core.u_actl.mn[10]$_DFFE_PN0P_ clknet_3_3__leaf__11429_ u_core.arr_mask_n[10] net1008 VSS VSS VDD VDD u_core.u_actl.mn[10] sky130_fd_sc_hd__dfrtp_1
Xu_core.u_actl.mn[11]$_DFFE_PN0P_ clknet_3_3__leaf__11429_ u_core.arr_mask_n[11] net1008 VSS VSS VDD VDD u_core.u_actl.mn[11] sky130_fd_sc_hd__dfrtp_1
Xu_core.u_actl.mn[12]$_DFFE_PN0P_ clknet_3_2__leaf__11429_ u_core.arr_mask_n[12] net1008 VSS VSS VDD VDD u_core.u_actl.mn[12] sky130_fd_sc_hd__dfrtp_1
Xu_core.u_actl.mn[13]$_DFFE_PN0P_ clknet_3_3__leaf__11429_ u_core.arr_mask_n[13] net1008 VSS VSS VDD VDD u_core.u_actl.mn[13] sky130_fd_sc_hd__dfrtp_1
Xu_core.u_actl.mn[14]$_DFFE_PN0P_ clknet_3_0__leaf__11429_ u_core.arr_mask_n[14] net1008 VSS VSS VDD VDD u_core.u_actl.mn[14] sky130_fd_sc_hd__dfrtp_1
Xu_core.u_actl.mn[15]$_DFFE_PN0P_ clknet_3_2__leaf__11429_ u_core.arr_mask_n[15] net1008 VSS VSS VDD VDD u_core.u_actl.mn[15] sky130_fd_sc_hd__dfrtp_1
Xu_core.u_actl.mn[16]$_DFFE_PN0P_ clknet_3_2__leaf__11429_ u_core.arr_mask_n[16] net1008 VSS VSS VDD VDD u_core.u_actl.mn[16] sky130_fd_sc_hd__dfrtp_1
Xu_core.u_actl.mn[17]$_DFFE_PN0P_ clknet_3_2__leaf__11429_ u_core.arr_mask_n[17] net1008 VSS VSS VDD VDD u_core.u_actl.mn[17] sky130_fd_sc_hd__dfrtp_1
Xu_core.u_actl.mn[18]$_DFFE_PN0P_ clknet_3_0__leaf__11429_ u_core.arr_mask_n[18] net1008 VSS VSS VDD VDD u_core.u_actl.mn[18] sky130_fd_sc_hd__dfrtp_1
Xu_core.u_actl.mn[19]$_DFFE_PN0P_ clknet_3_3__leaf__11429_ u_core.arr_mask_n[19] net1008 VSS VSS VDD VDD u_core.u_actl.mn[19] sky130_fd_sc_hd__dfrtp_1
Xu_core.u_actl.mn[1]$_DFFE_PN0P_ clknet_3_1__leaf__11429_ u_core.arr_mask_n[1] net1009 VSS VSS VDD VDD u_core.u_actl.mn[1] sky130_fd_sc_hd__dfrtp_1
Xu_core.u_actl.mn[20]$_DFFE_PN0P_ clknet_3_3__leaf__11429_ u_core.arr_mask_n[20] net1008 VSS VSS VDD VDD u_core.u_actl.mn[20] sky130_fd_sc_hd__dfrtp_1
Xu_core.u_actl.mn[21]$_DFFE_PN0P_ clknet_3_3__leaf__11429_ u_core.arr_mask_n[21] net1008 VSS VSS VDD VDD u_core.u_actl.mn[21] sky130_fd_sc_hd__dfrtp_1
Xu_core.u_actl.mn[22]$_DFFE_PN0P_ clknet_3_2__leaf__11429_ u_core.arr_mask_n[22] net1008 VSS VSS VDD VDD u_core.u_actl.mn[22] sky130_fd_sc_hd__dfrtp_1
Xu_core.u_actl.mn[23]$_DFFE_PN0P_ clknet_3_6__leaf__11429_ u_core.arr_mask_n[23] net1023 VSS VSS VDD VDD u_core.u_actl.mn[23] sky130_fd_sc_hd__dfrtp_1
Xu_core.u_actl.mn[2]$_DFFE_PN0P_ clknet_3_1__leaf__11429_ u_core.arr_mask_n[2] net1024 VSS VSS VDD VDD u_core.u_actl.mn[2] sky130_fd_sc_hd__dfrtp_1
Xu_core.u_actl.mn[3]$_DFFE_PN0P_ clknet_3_1__leaf__11429_ u_core.arr_mask_n[3] net1009 VSS VSS VDD VDD u_core.u_actl.mn[3] sky130_fd_sc_hd__dfrtp_1
Xu_core.u_actl.mn[4]$_DFFE_PN0P_ clknet_3_3__leaf__11429_ u_core.arr_mask_n[4] net1008 VSS VSS VDD VDD u_core.u_actl.mn[4] sky130_fd_sc_hd__dfrtp_1
Xu_core.u_actl.mn[5]$_DFFE_PN0P_ clknet_3_1__leaf__11429_ u_core.arr_mask_n[5] net1008 VSS VSS VDD VDD u_core.u_actl.mn[5] sky130_fd_sc_hd__dfrtp_1
Xu_core.u_actl.mn[6]$_DFFE_PN0P_ clknet_3_0__leaf__11429_ u_core.arr_mask_n[6] net1008 VSS VSS VDD VDD u_core.u_actl.mn[6] sky130_fd_sc_hd__dfrtp_1
Xu_core.u_actl.mn[7]$_DFFE_PN0P_ clknet_3_0__leaf__11429_ u_core.arr_mask_n[7] net1008 VSS VSS VDD VDD u_core.u_actl.mn[7] sky130_fd_sc_hd__dfrtp_1
Xu_core.u_actl.mn[8]$_DFFE_PN0P_ clknet_3_0__leaf__11429_ u_core.arr_mask_n[8] net1008 VSS VSS VDD VDD u_core.u_actl.mn[8] sky130_fd_sc_hd__dfrtp_1
Xu_core.u_actl.mn[9]$_DFFE_PN0P_ clknet_3_0__leaf__11429_ u_core.arr_mask_n[9] net1008 VSS VSS VDD VDD u_core.u_actl.mn[9] sky130_fd_sc_hd__dfrtp_1
Xu_core.u_actl.mp[0]$_DFFE_PN0P_ clknet_3_7__leaf__11429_ u_core.arr_mask_p[0] net1023 VSS VSS VDD VDD u_core.u_actl.mp[0] sky130_fd_sc_hd__dfrtp_1
Xu_core.u_actl.mp[10]$_DFFE_PN0P_ clknet_3_6__leaf__11429_ u_core.arr_mask_p[10] net1024 VSS VSS VDD VDD u_core.u_actl.mp[10] sky130_fd_sc_hd__dfrtp_1
Xu_core.u_actl.mp[11]$_DFFE_PN0P_ clknet_3_6__leaf__11429_ u_core.arr_mask_p[11] net1024 VSS VSS VDD VDD u_core.u_actl.mp[11] sky130_fd_sc_hd__dfrtp_1
Xu_core.u_actl.mp[12]$_DFFE_PN0P_ clknet_3_2__leaf__11429_ u_core.arr_mask_p[12] net1008 VSS VSS VDD VDD u_core.u_actl.mp[12] sky130_fd_sc_hd__dfrtp_1
Xu_core.u_actl.mp[13]$_DFFE_PN0P_ clknet_3_6__leaf__11429_ u_core.arr_mask_p[13] net1024 VSS VSS VDD VDD u_core.u_actl.mp[13] sky130_fd_sc_hd__dfrtp_1
Xu_core.u_actl.mp[14]$_DFFE_PN0P_ clknet_3_2__leaf__11429_ u_core.arr_mask_p[14] net1008 VSS VSS VDD VDD u_core.u_actl.mp[14] sky130_fd_sc_hd__dfrtp_1
Xu_core.u_actl.mp[15]$_DFFE_PN0P_ clknet_3_3__leaf__11429_ u_core.arr_mask_p[15] net1008 VSS VSS VDD VDD u_core.u_actl.mp[15] sky130_fd_sc_hd__dfrtp_1
Xu_core.u_actl.mp[16]$_DFFE_PN0P_ clknet_3_3__leaf__11429_ u_core.arr_mask_p[16] net1008 VSS VSS VDD VDD u_core.u_actl.mp[16] sky130_fd_sc_hd__dfrtp_1
Xu_core.u_actl.mp[17]$_DFFE_PN0P_ clknet_3_3__leaf__11429_ u_core.arr_mask_p[17] net1008 VSS VSS VDD VDD u_core.u_actl.mp[17] sky130_fd_sc_hd__dfrtp_1
Xu_core.u_actl.mp[18]$_DFFE_PN0P_ clknet_3_1__leaf__11429_ u_core.arr_mask_p[18] net1024 VSS VSS VDD VDD u_core.u_actl.mp[18] sky130_fd_sc_hd__dfrtp_1
Xu_core.u_actl.mp[19]$_DFFE_PN0P_ clknet_3_2__leaf__11429_ u_core.arr_mask_p[19] net1008 VSS VSS VDD VDD u_core.u_actl.mp[19] sky130_fd_sc_hd__dfrtp_1
Xu_core.u_actl.mp[1]$_DFFE_PN0P_ clknet_3_7__leaf__11429_ u_core.arr_mask_p[1] net1023 VSS VSS VDD VDD u_core.u_actl.mp[1] sky130_fd_sc_hd__dfrtp_1
Xu_core.u_actl.mp[20]$_DFFE_PN0P_ clknet_3_3__leaf__11429_ u_core.arr_mask_p[20] net1008 VSS VSS VDD VDD u_core.u_actl.mp[20] sky130_fd_sc_hd__dfrtp_1
Xu_core.u_actl.mp[21]$_DFFE_PN0P_ clknet_3_3__leaf__11429_ u_core.arr_mask_p[21] net1008 VSS VSS VDD VDD u_core.u_actl.mp[21] sky130_fd_sc_hd__dfrtp_1
Xu_core.u_actl.mp[22]$_DFFE_PN0P_ clknet_3_1__leaf__11429_ u_core.arr_mask_p[22] net1024 VSS VSS VDD VDD u_core.u_actl.mp[22] sky130_fd_sc_hd__dfrtp_1
Xu_core.u_actl.mp[23]$_DFFE_PN0P_ clknet_3_6__leaf__11429_ u_core.arr_mask_p[23] net1023 VSS VSS VDD VDD u_core.u_actl.mp[23] sky130_fd_sc_hd__dfrtp_1
Xu_core.u_actl.mp[2]$_DFFE_PN0P_ clknet_3_7__leaf__11429_ u_core.arr_mask_p[2] net1023 VSS VSS VDD VDD u_core.u_actl.mp[2] sky130_fd_sc_hd__dfrtp_1
Xu_core.u_actl.mp[3]$_DFFE_PN0P_ clknet_3_7__leaf__11429_ u_core.arr_mask_p[3] net1023 VSS VSS VDD VDD u_core.u_actl.mp[3] sky130_fd_sc_hd__dfrtp_1
Xu_core.u_actl.mp[4]$_DFFE_PN0P_ clknet_3_6__leaf__11429_ u_core.arr_mask_p[4] net1023 VSS VSS VDD VDD u_core.u_actl.mp[4] sky130_fd_sc_hd__dfrtp_1
Xu_core.u_actl.mp[5]$_DFFE_PN0P_ clknet_3_7__leaf__11429_ u_core.arr_mask_p[5] net1023 VSS VSS VDD VDD u_core.u_actl.mp[5] sky130_fd_sc_hd__dfrtp_1
Xu_core.u_actl.mp[6]$_DFFE_PN0P_ clknet_3_7__leaf__11429_ u_core.arr_mask_p[6] net1023 VSS VSS VDD VDD u_core.u_actl.mp[6] sky130_fd_sc_hd__dfrtp_1
Xu_core.u_actl.mp[7]$_DFFE_PN0P_ clknet_3_6__leaf__11429_ u_core.arr_mask_p[7] net1024 VSS VSS VDD VDD u_core.u_actl.mp[7] sky130_fd_sc_hd__dfrtp_1
Xu_core.u_actl.mp[8]$_DFFE_PN0P_ clknet_3_1__leaf__11429_ u_core.arr_mask_p[8] net1024 VSS VSS VDD VDD u_core.u_actl.mp[8] sky130_fd_sc_hd__dfrtp_1
Xu_core.u_actl.mp[9]$_DFFE_PN0P_ clknet_3_6__leaf__11429_ u_core.arr_mask_p[9] net1023 VSS VSS VDD VDD u_core.u_actl.mp[9] sky130_fd_sc_hd__dfrtp_1
Xu_core.u_actl.op[0]$_DFFE_PN0P_ clknet_3_4__leaf__11429_ u_core.arr_op[0] net1017 VSS VSS VDD VDD u_core.u_actl.op[0] sky130_fd_sc_hd__dfrtp_1
Xu_core.u_actl.op[1]$_DFFE_PN0P_ clknet_3_4__leaf__11429_ u_core.arr_op[1] net1017 VSS VSS VDD VDD u_core.u_actl.op[1] sky130_fd_sc_hd__dfrtp_1
Xu_core.u_actl.op[2]$_DFFE_PN0P_ clknet_3_4__leaf__11429_ u_core.arr_op[2] net1017 VSS VSS VDD VDD u_core.u_actl.op[2] sky130_fd_sc_hd__dfrtp_1
Xu_core.u_actl.q1_n[0]$_DFFE_PN0P_ clknet_2_2__leaf__11398_ net47 net1006 VSS VSS VDD VDD u_core.u_actl.q1_n[0] sky130_fd_sc_hd__dfrtp_1
Xu_core.u_actl.q1_n[10]$_DFFE_PN0P_ clknet_2_0__leaf__11398_ net48 net1007 VSS VSS VDD VDD u_core.u_actl.q1_n[10] sky130_fd_sc_hd__dfrtp_1
Xu_core.u_actl.q1_n[11]$_DFFE_PN0P_ clknet_2_1__leaf__11398_ net49 net1008 VSS VSS VDD VDD u_core.u_actl.q1_n[11] sky130_fd_sc_hd__dfrtp_1
Xu_core.u_actl.q1_n[12]$_DFFE_PN0P_ clknet_2_0__leaf__11398_ net50 net1012 VSS VSS VDD VDD u_core.u_actl.q1_n[12] sky130_fd_sc_hd__dfrtp_1
Xu_core.u_actl.q1_n[13]$_DFFE_PN0P_ clknet_2_1__leaf__11398_ net51 net1012 VSS VSS VDD VDD u_core.u_actl.q1_n[13] sky130_fd_sc_hd__dfrtp_1
Xu_core.u_actl.q1_n[14]$_DFFE_PN0P_ clknet_2_0__leaf__11398_ net52 net1012 VSS VSS VDD VDD u_core.u_actl.q1_n[14] sky130_fd_sc_hd__dfrtp_1
Xu_core.u_actl.q1_n[15]$_DFFE_PN0P_ clknet_2_0__leaf__11398_ net53 net1012 VSS VSS VDD VDD u_core.u_actl.q1_n[15] sky130_fd_sc_hd__dfrtp_1
Xu_core.u_actl.q1_n[16]$_DFFE_PN0P_ clknet_2_0__leaf__11398_ net54 net1013 VSS VSS VDD VDD u_core.u_actl.q1_n[16] sky130_fd_sc_hd__dfrtp_1
Xu_core.u_actl.q1_n[17]$_DFFE_PN0P_ clknet_2_1__leaf__11398_ net55 net1012 VSS VSS VDD VDD u_core.u_actl.q1_n[17] sky130_fd_sc_hd__dfrtp_1
Xu_core.u_actl.q1_n[18]$_DFFE_PN0P_ clknet_2_0__leaf__11398_ net56 net1012 VSS VSS VDD VDD u_core.u_actl.q1_n[18] sky130_fd_sc_hd__dfrtp_1
Xu_core.u_actl.q1_n[19]$_DFFE_PN0P_ clknet_2_0__leaf__11398_ net57 net1013 VSS VSS VDD VDD u_core.u_actl.q1_n[19] sky130_fd_sc_hd__dfrtp_1
Xu_core.u_actl.q1_n[1]$_DFFE_PN0P_ clknet_2_2__leaf__11398_ net58 net1006 VSS VSS VDD VDD u_core.u_actl.q1_n[1] sky130_fd_sc_hd__dfrtp_1
Xu_core.u_actl.q1_n[20]$_DFFE_PN0P_ clknet_2_0__leaf__11398_ net59 net1012 VSS VSS VDD VDD u_core.u_actl.q1_n[20] sky130_fd_sc_hd__dfrtp_1
Xu_core.u_actl.q1_n[21]$_DFFE_PN0P_ clknet_2_1__leaf__11398_ net60 net1012 VSS VSS VDD VDD u_core.u_actl.q1_n[21] sky130_fd_sc_hd__dfrtp_1
Xu_core.u_actl.q1_n[22]$_DFFE_PN0P_ clknet_2_0__leaf__11398_ net61 net1012 VSS VSS VDD VDD u_core.u_actl.q1_n[22] sky130_fd_sc_hd__dfrtp_1
Xu_core.u_actl.q1_n[23]$_DFFE_PN0P_ clknet_2_1__leaf__11398_ net62 net1013 VSS VSS VDD VDD u_core.u_actl.q1_n[23] sky130_fd_sc_hd__dfrtp_1
Xu_core.u_actl.q1_n[2]$_DFFE_PN0P_ clknet_2_2__leaf__11398_ net63 net1006 VSS VSS VDD VDD u_core.u_actl.q1_n[2] sky130_fd_sc_hd__dfrtp_1
Xu_core.u_actl.q1_n[3]$_DFFE_PN0P_ clknet_2_2__leaf__11398_ net64 net1023 VSS VSS VDD VDD u_core.u_actl.q1_n[3] sky130_fd_sc_hd__dfrtp_1
Xu_core.u_actl.q1_n[4]$_DFFE_PN0P_ clknet_2_3__leaf__11398_ net65 net1006 VSS VSS VDD VDD u_core.u_actl.q1_n[4] sky130_fd_sc_hd__dfrtp_1
Xu_core.u_actl.q1_n[5]$_DFFE_PN0P_ clknet_2_2__leaf__11398_ net66 net1006 VSS VSS VDD VDD u_core.u_actl.q1_n[5] sky130_fd_sc_hd__dfrtp_1
Xu_core.u_actl.q1_n[6]$_DFFE_PN0P_ clknet_2_3__leaf__11398_ net67 net1007 VSS VSS VDD VDD u_core.u_actl.q1_n[6] sky130_fd_sc_hd__dfrtp_1
Xu_core.u_actl.q1_n[7]$_DFFE_PN0P_ clknet_2_3__leaf__11398_ net68 net1008 VSS VSS VDD VDD u_core.u_actl.q1_n[7] sky130_fd_sc_hd__dfrtp_1
Xu_core.u_actl.q1_n[8]$_DFFE_PN0P_ clknet_2_3__leaf__11398_ net69 net1007 VSS VSS VDD VDD u_core.u_actl.q1_n[8] sky130_fd_sc_hd__dfrtp_1
Xu_core.u_actl.q1_n[9]$_DFFE_PN0P_ clknet_2_3__leaf__11398_ net70 net1007 VSS VSS VDD VDD u_core.u_actl.q1_n[9] sky130_fd_sc_hd__dfrtp_1
Xu_core.u_actl.q1_p[0]$_DFFE_PN0P_ clknet_2_2__leaf__11398_ net71 net1006 VSS VSS VDD VDD u_core.u_actl.q1_p[0] sky130_fd_sc_hd__dfrtp_1
Xu_core.u_actl.q1_p[10]$_DFFE_PN0P_ clknet_2_3__leaf__11398_ net72 net1007 VSS VSS VDD VDD u_core.u_actl.q1_p[10] sky130_fd_sc_hd__dfrtp_1
Xu_core.u_actl.q1_p[11]$_DFFE_PN0P_ clknet_2_1__leaf__11398_ net73 net1012 VSS VSS VDD VDD u_core.u_actl.q1_p[11] sky130_fd_sc_hd__dfrtp_1
Xu_core.u_actl.q1_p[12]$_DFFE_PN0P_ clknet_2_1__leaf__11398_ net74 net1012 VSS VSS VDD VDD u_core.u_actl.q1_p[12] sky130_fd_sc_hd__dfrtp_1
Xu_core.u_actl.q1_p[13]$_DFFE_PN0P_ clknet_2_1__leaf__11398_ net75 net1012 VSS VSS VDD VDD u_core.u_actl.q1_p[13] sky130_fd_sc_hd__dfrtp_1
Xu_core.u_actl.q1_p[14]$_DFFE_PN0P_ clknet_2_1__leaf__11398_ net76 net1014 VSS VSS VDD VDD u_core.u_actl.q1_p[14] sky130_fd_sc_hd__dfrtp_1
Xu_core.u_actl.q1_p[15]$_DFFE_PN0P_ clknet_2_1__leaf__11398_ net77 net1014 VSS VSS VDD VDD u_core.u_actl.q1_p[15] sky130_fd_sc_hd__dfrtp_1
Xu_core.u_actl.q1_p[16]$_DFFE_PN0P_ clknet_2_1__leaf__11398_ net78 net1014 VSS VSS VDD VDD u_core.u_actl.q1_p[16] sky130_fd_sc_hd__dfrtp_1
Xu_core.u_actl.q1_p[17]$_DFFE_PN0P_ clknet_2_0__leaf__11398_ net79 net1012 VSS VSS VDD VDD u_core.u_actl.q1_p[17] sky130_fd_sc_hd__dfrtp_1
Xu_core.u_actl.q1_p[18]$_DFFE_PN0P_ clknet_2_1__leaf__11398_ net80 net1014 VSS VSS VDD VDD u_core.u_actl.q1_p[18] sky130_fd_sc_hd__dfrtp_1
Xu_core.u_actl.q1_p[19]$_DFFE_PN0P_ clknet_2_0__leaf__11398_ net81 net1014 VSS VSS VDD VDD u_core.u_actl.q1_p[19] sky130_fd_sc_hd__dfrtp_1
Xu_core.u_actl.q1_p[1]$_DFFE_PN0P_ clknet_2_2__leaf__11398_ net82 net1006 VSS VSS VDD VDD u_core.u_actl.q1_p[1] sky130_fd_sc_hd__dfrtp_1
Xu_core.u_actl.q1_p[20]$_DFFE_PN0P_ clknet_2_1__leaf__11398_ net83 net1014 VSS VSS VDD VDD u_core.u_actl.q1_p[20] sky130_fd_sc_hd__dfrtp_1
Xu_core.u_actl.q1_p[21]$_DFFE_PN0P_ clknet_2_0__leaf__11398_ net84 net1014 VSS VSS VDD VDD u_core.u_actl.q1_p[21] sky130_fd_sc_hd__dfrtp_1
Xu_core.u_actl.q1_p[22]$_DFFE_PN0P_ clknet_2_0__leaf__11398_ net85 net1014 VSS VSS VDD VDD u_core.u_actl.q1_p[22] sky130_fd_sc_hd__dfrtp_1
Xu_core.u_actl.q1_p[23]$_DFFE_PN0P_ clknet_2_1__leaf__11398_ net86 net1013 VSS VSS VDD VDD u_core.u_actl.q1_p[23] sky130_fd_sc_hd__dfrtp_1
Xu_core.u_actl.q1_p[2]$_DFFE_PN0P_ clknet_2_2__leaf__11398_ net87 net1006 VSS VSS VDD VDD u_core.u_actl.q1_p[2] sky130_fd_sc_hd__dfrtp_1
Xu_core.u_actl.q1_p[3]$_DFFE_PN0P_ clknet_2_2__leaf__11398_ net88 net1006 VSS VSS VDD VDD u_core.u_actl.q1_p[3] sky130_fd_sc_hd__dfrtp_1
Xu_core.u_actl.q1_p[4]$_DFFE_PN0P_ clknet_2_2__leaf__11398_ net89 net1006 VSS VSS VDD VDD u_core.u_actl.q1_p[4] sky130_fd_sc_hd__dfrtp_1
Xu_core.u_actl.q1_p[5]$_DFFE_PN0P_ clknet_2_2__leaf__11398_ net90 net1006 VSS VSS VDD VDD u_core.u_actl.q1_p[5] sky130_fd_sc_hd__dfrtp_1
Xu_core.u_actl.q1_p[6]$_DFFE_PN0P_ clknet_2_2__leaf__11398_ net91 net1006 VSS VSS VDD VDD u_core.u_actl.q1_p[6] sky130_fd_sc_hd__dfrtp_1
Xu_core.u_actl.q1_p[7]$_DFFE_PN0P_ clknet_2_2__leaf__11398_ net92 net1023 VSS VSS VDD VDD u_core.u_actl.q1_p[7] sky130_fd_sc_hd__dfrtp_1
Xu_core.u_actl.q1_p[8]$_DFFE_PN0P_ clknet_2_3__leaf__11398_ net93 net1007 VSS VSS VDD VDD u_core.u_actl.q1_p[8] sky130_fd_sc_hd__dfrtp_1
Xu_core.u_actl.q1_p[9]$_DFFE_PN0P_ clknet_2_3__leaf__11398_ net94 net1007 VSS VSS VDD VDD u_core.u_actl.q1_p[9] sky130_fd_sc_hd__dfrtp_1
Xu_core.u_actl.row[0]$_DFFE_PN0P_ clknet_3_5__leaf__11429_ u_core.arr_row[0] net1029 VSS VSS VDD VDD u_core.u_actl.row[0] sky130_fd_sc_hd__dfrtp_1
Xu_core.u_actl.row[1]$_DFFE_PN0P_ clknet_3_5__leaf__11429_ u_core.arr_row[1] net1029 VSS VSS VDD VDD u_core.u_actl.row[1] sky130_fd_sc_hd__dfrtp_1
Xu_core.u_actl.row[2]$_DFFE_PN0P_ clknet_3_5__leaf__11429_ net985 net1029 VSS VSS VDD VDD u_core.u_actl.row[2] sky130_fd_sc_hd__dfrtp_1
Xu_core.u_actl.row[3]$_DFFE_PN0P_ clknet_3_5__leaf__11429_ u_core.arr_row[3] net1029 VSS VSS VDD VDD u_core.u_actl.row[3] sky130_fd_sc_hd__dfrtp_1
Xu_core.u_actl.row[4]$_DFFE_PN0P_ clknet_3_5__leaf__11429_ u_core.arr_row[4] net1029 VSS VSS VDD VDD u_core.u_actl.row[4] sky130_fd_sc_hd__dfrtp_1
Xu_core.u_actl.row[5]$_DFFE_PN0P_ clknet_3_4__leaf__11429_ net982 net1020 VSS VSS VDD VDD u_core.u_actl.row[5] sky130_fd_sc_hd__dfrtp_1
Xu_core.u_actl.row[6]$_DFFE_PN0P_ clknet_3_5__leaf__11429_ u_core.arr_row[6] net1029 VSS VSS VDD VDD u_core.u_actl.row[6] sky130_fd_sc_hd__dfrtp_1
Xu_core.u_actl.st[0]$_DFF_PN1_ clknet_3_7__leaf_clk_regs _03507_ net1019 VSS VSS VDD VDD u_core.u_actl.st[0] sky130_fd_sc_hd__dfstp_2
Xu_core.u_actl.st[10]$_DFF_PN0_ clknet_3_7__leaf_clk_regs u_core.u_actl.st[5] net1019 VSS VSS VDD VDD u_core.u_actl.st[10] sky130_fd_sc_hd__dfrtp_1
Xu_core.u_actl.st[1]$_DFF_PN0_ clknet_3_7__leaf_clk_regs _03509_ net1019 VSS VSS VDD VDD u_core.u_actl.st[1] sky130_fd_sc_hd__dfrtp_1
Xu_core.u_actl.st[2]$_DFF_PN0_ clknet_3_7__leaf_clk_regs _03510_ net1019 VSS VSS VDD VDD u_core.u_actl.st[2] sky130_fd_sc_hd__dfrtp_1
Xu_core.u_actl.st[3]$_DFF_PN0_ clknet_3_7__leaf_clk_regs _03511_ net1019 VSS VSS VDD VDD u_core.u_actl.st[3] sky130_fd_sc_hd__dfrtp_1
Xu_core.u_actl.st[4]$_DFF_PN0_ clknet_3_7__leaf_clk_regs _03512_ net1019 VSS VSS VDD VDD u_core.u_actl.st[4] sky130_fd_sc_hd__dfrtp_1
Xu_core.u_actl.st[5]$_DFF_PN0_ clknet_3_7__leaf_clk_regs u_core.u_actl.st[8] net1019 VSS VSS VDD VDD u_core.u_actl.st[5] sky130_fd_sc_hd__dfrtp_1
Xu_core.u_actl.st[6]$_DFF_PN0_ clknet_3_7__leaf_clk_regs _03514_ net1019 VSS VSS VDD VDD u_core.u_actl.st[6] sky130_fd_sc_hd__dfrtp_1
Xu_core.u_actl.st[7]$_DFF_PN0_ clknet_3_7__leaf_clk_regs _03515_ net1019 VSS VSS VDD VDD u_core.u_actl.st[7] sky130_fd_sc_hd__dfrtp_1
Xu_core.u_actl.st[8]$_DFF_PN0_ clknet_3_7__leaf_clk_regs _03516_ net1019 VSS VSS VDD VDD u_core.u_actl.st[8] sky130_fd_sc_hd__dfrtp_1
Xu_core.u_actl.st[9]$_DFF_PN0_ clknet_3_7__leaf_clk_regs _03517_ net1019 VSS VSS VDD VDD u_core.u_actl.st[9] sky130_fd_sc_hd__dfrtp_1
Xu_core.u_top.bus_addr[0]$_DFFE_PN0P_ clknet_1_1__leaf__11426_ u_core.u_top.u_spi.mosi_s[1] net1027 VSS VSS VDD VDD u_core.u_top.bus_addr[0] sky130_fd_sc_hd__dfrtp_2
Xu_core.u_top.bus_addr[1]$_DFFE_PN0P_ clknet_1_1__leaf__11426_ u_core.u_top.u_spi.cmd[0] net1027 VSS VSS VDD VDD u_core.u_top.bus_addr[1] sky130_fd_sc_hd__dfrtp_2
Xu_core.u_top.bus_addr[2]$_DFFE_PN0P_ clknet_1_1__leaf__11426_ u_core.u_top.u_spi.cmd[1] net1027 VSS VSS VDD VDD u_core.u_top.bus_addr[2] sky130_fd_sc_hd__dfrtp_2
Xu_core.u_top.bus_addr[3]$_DFFE_PN0P_ clknet_1_1__leaf__11426_ u_core.u_top.u_spi.cmd[2] net1027 VSS VSS VDD VDD u_core.u_top.bus_addr[3] sky130_fd_sc_hd__dfrtp_2
Xu_core.u_top.bus_addr[4]$_DFFE_PN0P_ clknet_1_0__leaf__11426_ u_core.u_top.u_spi.cmd[3] net1031 VSS VSS VDD VDD u_core.u_top.bus_addr[4] sky130_fd_sc_hd__dfrtp_2
Xu_core.u_top.bus_addr[5]$_DFFE_PN0P_ clknet_1_0__leaf__11426_ u_core.u_top.u_spi.cmd[4] net1031 VSS VSS VDD VDD u_core.u_top.bus_addr[5] sky130_fd_sc_hd__dfrtp_1
Xu_core.u_top.bus_re$_DFF_PN0_ clknet_3_0__leaf_clk_regs _2296_ net1031 VSS VSS VDD VDD u_core.u_top.bus_re sky130_fd_sc_hd__dfrtp_2
Xu_core.u_top.bus_wdata[0]$_DFFE_PN0P_ clknet_2_0__leaf__11415_ u_core.u_top.u_spi.mosi_s[1] net1027 VSS VSS VDD VDD u_core.u_top.bus_wdata[0] sky130_fd_sc_hd__dfrtp_1
Xu_core.u_top.bus_wdata[10]$_DFFE_PN0P_ clknet_2_3__leaf__11415_ u_core.u_top.u_spi.shift_in[9] net1021 VSS VSS VDD VDD u_core.u_top.bus_wdata[10] sky130_fd_sc_hd__dfrtp_1
Xu_core.u_top.bus_wdata[11]$_DFFE_PN0P_ clknet_2_2__leaf__11415_ u_core.u_top.u_spi.shift_in[10] net1021 VSS VSS VDD VDD u_core.u_top.bus_wdata[11] sky130_fd_sc_hd__dfrtp_1
Xu_core.u_top.bus_wdata[12]$_DFFE_PN0P_ clknet_2_2__leaf__11415_ u_core.u_top.u_spi.shift_in[11] net1021 VSS VSS VDD VDD u_core.u_top.bus_wdata[12] sky130_fd_sc_hd__dfrtp_1
Xu_core.u_top.bus_wdata[13]$_DFFE_PN0P_ clknet_2_2__leaf__11415_ u_core.u_top.u_spi.shift_in[12] net1021 VSS VSS VDD VDD u_core.u_top.bus_wdata[13] sky130_fd_sc_hd__dfrtp_1
Xu_core.u_top.bus_wdata[14]$_DFFE_PN0P_ clknet_2_2__leaf__11415_ u_core.u_top.u_spi.shift_in[13] net1021 VSS VSS VDD VDD u_core.u_top.bus_wdata[14] sky130_fd_sc_hd__dfrtp_1
Xu_core.u_top.bus_wdata[15]$_DFFE_PN0P_ clknet_2_2__leaf__11415_ u_core.u_top.u_spi.shift_in[14] net1021 VSS VSS VDD VDD u_core.u_top.bus_wdata[15] sky130_fd_sc_hd__dfrtp_1
Xu_core.u_top.bus_wdata[16]$_DFFE_PN0P_ clknet_2_2__leaf__11415_ u_core.u_top.u_spi.shift_in[15] net1021 VSS VSS VDD VDD u_core.u_top.bus_wdata[16] sky130_fd_sc_hd__dfrtp_1
Xu_core.u_top.bus_wdata[17]$_DFFE_PN0P_ clknet_2_3__leaf__11415_ u_core.u_top.u_spi.shift_in[16] net1021 VSS VSS VDD VDD u_core.u_top.bus_wdata[17] sky130_fd_sc_hd__dfrtp_1
Xu_core.u_top.bus_wdata[18]$_DFFE_PN0P_ clknet_2_3__leaf__11415_ u_core.u_top.u_spi.shift_in[17] net1018 VSS VSS VDD VDD u_core.u_top.bus_wdata[18] sky130_fd_sc_hd__dfrtp_1
Xu_core.u_top.bus_wdata[19]$_DFFE_PN0P_ clknet_2_3__leaf__11415_ u_core.u_top.u_spi.shift_in[18] net1018 VSS VSS VDD VDD u_core.u_top.bus_wdata[19] sky130_fd_sc_hd__dfrtp_1
Xu_core.u_top.bus_wdata[1]$_DFFE_PN0P_ clknet_2_0__leaf__11415_ u_core.u_top.u_spi.shift_in[0] net1027 VSS VSS VDD VDD u_core.u_top.bus_wdata[1] sky130_fd_sc_hd__dfrtp_1
Xu_core.u_top.bus_wdata[20]$_DFFE_PN0P_ clknet_2_3__leaf__11415_ u_core.u_top.u_spi.shift_in[19] net1018 VSS VSS VDD VDD u_core.u_top.bus_wdata[20] sky130_fd_sc_hd__dfrtp_1
Xu_core.u_top.bus_wdata[21]$_DFFE_PN0P_ clknet_2_3__leaf__11415_ u_core.u_top.u_spi.shift_in[20] net1018 VSS VSS VDD VDD u_core.u_top.bus_wdata[21] sky130_fd_sc_hd__dfrtp_1
Xu_core.u_top.bus_wdata[22]$_DFFE_PN0P_ clknet_2_1__leaf__11415_ u_core.u_top.u_spi.shift_in[21] net1025 VSS VSS VDD VDD u_core.u_top.bus_wdata[22] sky130_fd_sc_hd__dfrtp_1
Xu_core.u_top.bus_wdata[23]$_DFFE_PN0P_ clknet_2_1__leaf__11415_ u_core.u_top.u_spi.shift_in[22] net1025 VSS VSS VDD VDD u_core.u_top.bus_wdata[23] sky130_fd_sc_hd__dfrtp_1
Xu_core.u_top.bus_wdata[24]$_DFFE_PN0P_ clknet_2_1__leaf__11415_ u_core.u_top.u_spi.shift_in[23] net1025 VSS VSS VDD VDD u_core.u_top.bus_wdata[24] sky130_fd_sc_hd__dfrtp_1
Xu_core.u_top.bus_wdata[25]$_DFFE_PN0P_ clknet_2_1__leaf__11415_ u_core.u_top.u_spi.shift_in[24] net1025 VSS VSS VDD VDD u_core.u_top.bus_wdata[25] sky130_fd_sc_hd__dfrtp_1
Xu_core.u_top.bus_wdata[26]$_DFFE_PN0P_ clknet_2_3__leaf__11415_ u_core.u_top.u_spi.shift_in[25] net1022 VSS VSS VDD VDD u_core.u_top.bus_wdata[26] sky130_fd_sc_hd__dfrtp_1
Xu_core.u_top.bus_wdata[27]$_DFFE_PN0P_ clknet_2_3__leaf__11415_ u_core.u_top.u_spi.shift_in[26] net1022 VSS VSS VDD VDD u_core.u_top.bus_wdata[27] sky130_fd_sc_hd__dfrtp_1
Xu_core.u_top.bus_wdata[28]$_DFFE_PN0P_ clknet_2_3__leaf__11415_ u_core.u_top.u_spi.shift_in[27] net1022 VSS VSS VDD VDD u_core.u_top.bus_wdata[28] sky130_fd_sc_hd__dfrtp_1
Xu_core.u_top.bus_wdata[29]$_DFFE_PN0P_ clknet_2_3__leaf__11415_ u_core.u_top.u_spi.shift_in[28] net1018 VSS VSS VDD VDD u_core.u_top.bus_wdata[29] sky130_fd_sc_hd__dfrtp_1
Xu_core.u_top.bus_wdata[2]$_DFFE_PN0P_ clknet_2_0__leaf__11415_ u_core.u_top.u_spi.shift_in[1] net1027 VSS VSS VDD VDD u_core.u_top.bus_wdata[2] sky130_fd_sc_hd__dfrtp_1
Xu_core.u_top.bus_wdata[30]$_DFFE_PN0P_ clknet_2_3__leaf__11415_ u_core.u_top.u_spi.shift_in[29] net1018 VSS VSS VDD VDD u_core.u_top.bus_wdata[30] sky130_fd_sc_hd__dfrtp_1
Xu_core.u_top.bus_wdata[31]$_DFFE_PN0P_ clknet_2_3__leaf__11415_ u_core.u_top.u_spi.shift_in[30] net1022 VSS VSS VDD VDD u_core.u_top.bus_wdata[31] sky130_fd_sc_hd__dfrtp_1
Xu_core.u_top.bus_wdata[32]$_DFFE_PN0P_ clknet_2_3__leaf__11415_ u_core.u_top.u_spi.shift_in[31] net1022 VSS VSS VDD VDD u_core.u_top.bus_wdata[32] sky130_fd_sc_hd__dfrtp_1
Xu_core.u_top.bus_wdata[33]$_DFFE_PN0P_ clknet_2_3__leaf__11415_ u_core.u_top.u_spi.shift_in[32] net1025 VSS VSS VDD VDD u_core.u_top.bus_wdata[33] sky130_fd_sc_hd__dfrtp_1
Xu_core.u_top.bus_wdata[34]$_DFFE_PN0P_ clknet_2_0__leaf__11415_ u_core.u_top.u_spi.shift_in[33] net1026 VSS VSS VDD VDD u_core.u_top.bus_wdata[34] sky130_fd_sc_hd__dfrtp_1
Xu_core.u_top.bus_wdata[35]$_DFFE_PN0P_ clknet_2_0__leaf__11415_ u_core.u_top.u_spi.shift_in[34] net1026 VSS VSS VDD VDD u_core.u_top.bus_wdata[35] sky130_fd_sc_hd__dfrtp_1
Xu_core.u_top.bus_wdata[36]$_DFFE_PN0P_ clknet_2_0__leaf__11415_ u_core.u_top.u_spi.shift_in[35] net1027 VSS VSS VDD VDD u_core.u_top.bus_wdata[36] sky130_fd_sc_hd__dfrtp_1
Xu_core.u_top.bus_wdata[37]$_DFFE_PN0P_ clknet_2_0__leaf__11415_ u_core.u_top.u_spi.shift_in[36] net1027 VSS VSS VDD VDD u_core.u_top.bus_wdata[37] sky130_fd_sc_hd__dfrtp_1
Xu_core.u_top.bus_wdata[38]$_DFFE_PN0P_ clknet_2_0__leaf__11415_ u_core.u_top.u_spi.shift_in[37] net1027 VSS VSS VDD VDD u_core.u_top.bus_wdata[38] sky130_fd_sc_hd__dfrtp_1
Xu_core.u_top.bus_wdata[39]$_DFFE_PN0P_ clknet_2_0__leaf__11415_ u_core.u_top.u_spi.shift_in[38] net1027 VSS VSS VDD VDD u_core.u_top.bus_wdata[39] sky130_fd_sc_hd__dfrtp_1
Xu_core.u_top.bus_wdata[3]$_DFFE_PN0P_ clknet_2_0__leaf__11415_ u_core.u_top.u_spi.shift_in[2] net1027 VSS VSS VDD VDD u_core.u_top.bus_wdata[3] sky130_fd_sc_hd__dfrtp_1
Xu_core.u_top.bus_wdata[40]$_DFFE_PN0P_ clknet_2_0__leaf__11415_ u_core.u_top.u_spi.shift_in[39] net1027 VSS VSS VDD VDD u_core.u_top.bus_wdata[40] sky130_fd_sc_hd__dfrtp_1
Xu_core.u_top.bus_wdata[41]$_DFFE_PN0P_ clknet_2_0__leaf__11415_ u_core.u_top.u_spi.shift_in[40] net1026 VSS VSS VDD VDD u_core.u_top.bus_wdata[41] sky130_fd_sc_hd__dfrtp_1
Xu_core.u_top.bus_wdata[42]$_DFFE_PN0P_ clknet_2_1__leaf__11415_ u_core.u_top.u_spi.shift_in[41] net1026 VSS VSS VDD VDD u_core.u_top.bus_wdata[42] sky130_fd_sc_hd__dfrtp_1
Xu_core.u_top.bus_wdata[43]$_DFFE_PN0P_ clknet_2_2__leaf__11415_ u_core.u_top.u_spi.shift_in[42] net1021 VSS VSS VDD VDD u_core.u_top.bus_wdata[43] sky130_fd_sc_hd__dfrtp_1
Xu_core.u_top.bus_wdata[44]$_DFFE_PN0P_ clknet_2_3__leaf__11415_ u_core.u_top.u_spi.shift_in[43] net1021 VSS VSS VDD VDD u_core.u_top.bus_wdata[44] sky130_fd_sc_hd__dfrtp_1
Xu_core.u_top.bus_wdata[45]$_DFFE_PN0P_ clknet_2_2__leaf__11415_ u_core.u_top.u_spi.shift_in[44] net1021 VSS VSS VDD VDD u_core.u_top.bus_wdata[45] sky130_fd_sc_hd__dfrtp_1
Xu_core.u_top.bus_wdata[46]$_DFFE_PN0P_ clknet_2_2__leaf__11415_ u_core.u_top.u_spi.shift_in[45] net1021 VSS VSS VDD VDD u_core.u_top.bus_wdata[46] sky130_fd_sc_hd__dfrtp_1
Xu_core.u_top.bus_wdata[47]$_DFFE_PN0P_ clknet_2_2__leaf__11415_ u_core.u_top.u_spi.shift_in[46] net1021 VSS VSS VDD VDD u_core.u_top.bus_wdata[47] sky130_fd_sc_hd__dfrtp_1
Xu_core.u_top.bus_wdata[4]$_DFFE_PN0P_ clknet_2_0__leaf__11415_ u_core.u_top.u_spi.shift_in[3] net1026 VSS VSS VDD VDD u_core.u_top.bus_wdata[4] sky130_fd_sc_hd__dfrtp_1
Xu_core.u_top.bus_wdata[5]$_DFFE_PN0P_ clknet_2_1__leaf__11415_ u_core.u_top.u_spi.shift_in[4] net1026 VSS VSS VDD VDD u_core.u_top.bus_wdata[5] sky130_fd_sc_hd__dfrtp_1
Xu_core.u_top.bus_wdata[6]$_DFFE_PN0P_ clknet_2_1__leaf__11415_ u_core.u_top.u_spi.shift_in[5] net1026 VSS VSS VDD VDD u_core.u_top.bus_wdata[6] sky130_fd_sc_hd__dfrtp_1
Xu_core.u_top.bus_wdata[7]$_DFFE_PN0P_ clknet_2_1__leaf__11415_ u_core.u_top.u_spi.shift_in[6] net1026 VSS VSS VDD VDD u_core.u_top.bus_wdata[7] sky130_fd_sc_hd__dfrtp_1
Xu_core.u_top.bus_wdata[8]$_DFFE_PN0P_ clknet_2_1__leaf__11415_ u_core.u_top.u_spi.shift_in[7] net1026 VSS VSS VDD VDD u_core.u_top.bus_wdata[8] sky130_fd_sc_hd__dfrtp_1
Xu_core.u_top.bus_wdata[9]$_DFFE_PN0P_ clknet_2_2__leaf__11415_ u_core.u_top.u_spi.shift_in[8] net1022 VSS VSS VDD VDD u_core.u_top.bus_wdata[9] sky130_fd_sc_hd__dfrtp_1
Xu_core.u_top.bus_we$_DFF_PN0_ clknet_3_0__leaf_clk_regs _2297_ net1031 VSS VSS VDD VDD u_core.u_top.bus_we sky130_fd_sc_hd__dfrtp_1
Xu_core.u_top.bus_word$_DFFE_PN0P_ clknet_1_0__leaf__11426_ u_core.u_top.u_spi.cmd[5] net1031 VSS VSS VDD VDD u_core.u_top.bus_word sky130_fd_sc_hd__dfrtp_1
Xu_core.u_top.u_core.acc[0]$_DFFE_PN0P_ clknet_1_1__leaf__11369_ _1042_[0] net1033 VSS VSS VDD VDD u_core.u_top.u_core.acc[0] sky130_fd_sc_hd__dfrtp_1
Xu_core.u_top.u_core.acc[100]$_DFFE_PN0P_ clknet_1_0__leaf__11388_ _1042_[100] net1015 VSS VSS VDD VDD u_core.u_top.u_core.acc[100] sky130_fd_sc_hd__dfrtp_1
Xu_core.u_top.u_core.acc[101]$_DFFE_PN0P_ clknet_1_0__leaf__11388_ _1042_[101] net1015 VSS VSS VDD VDD u_core.u_top.u_core.acc[101] sky130_fd_sc_hd__dfrtp_1
Xu_core.u_top.u_core.acc[102]$_DFFE_PN0P_ clknet_1_0__leaf__11388_ _1042_[102] net1015 VSS VSS VDD VDD u_core.u_top.u_core.acc[102] sky130_fd_sc_hd__dfrtp_1
Xu_core.u_top.u_core.acc[103]$_DFFE_PN0P_ clknet_1_0__leaf__11388_ _1042_[103] net1015 VSS VSS VDD VDD u_core.u_top.u_core.acc[103] sky130_fd_sc_hd__dfrtp_1
Xu_core.u_top.u_core.acc[104]$_DFFE_PN0P_ clknet_1_1__leaf__11388_ _1042_[104] net1015 VSS VSS VDD VDD u_core.u_top.u_core.acc[104] sky130_fd_sc_hd__dfrtp_1
Xu_core.u_top.u_core.acc[105]$_DFFE_PN0P_ clknet_1_0__leaf__11388_ _1042_[105] net1015 VSS VSS VDD VDD u_core.u_top.u_core.acc[105] sky130_fd_sc_hd__dfrtp_1
Xu_core.u_top.u_core.acc[106]$_DFFE_PN0P_ clknet_1_0__leaf__11388_ _1042_[106] net1015 VSS VSS VDD VDD u_core.u_top.u_core.acc[106] sky130_fd_sc_hd__dfrtp_1
Xu_core.u_top.u_core.acc[107]$_DFFE_PN0P_ clknet_1_1__leaf__11388_ _1042_[107] net1015 VSS VSS VDD VDD u_core.u_top.u_core.acc[107] sky130_fd_sc_hd__dfrtp_1
Xu_core.u_top.u_core.acc[108]$_DFFE_PN0P_ clknet_1_1__leaf__11388_ _1042_[108] net1015 VSS VSS VDD VDD u_core.u_top.u_core.acc[108] sky130_fd_sc_hd__dfrtp_1
Xu_core.u_top.u_core.acc[109]$_DFFE_PN0P_ clknet_1_1__leaf__11388_ _1042_[109] net1015 VSS VSS VDD VDD u_core.u_top.u_core.acc[109] sky130_fd_sc_hd__dfrtp_1
Xu_core.u_top.u_core.acc[10]$_DFFE_PN0P_ clknet_1_1__leaf__11402_ _1042_[10] net1033 VSS VSS VDD VDD u_core.u_top.u_core.acc[10] sky130_fd_sc_hd__dfrtp_1
Xu_core.u_top.u_core.acc[110]$_DFFE_PN0P_ clknet_1_1__leaf__11384_ _1042_[110] net1015 VSS VSS VDD VDD u_core.u_top.u_core.acc[110] sky130_fd_sc_hd__dfrtp_1
Xu_core.u_top.u_core.acc[111]$_DFFE_PN0P_ clknet_1_1__leaf__11384_ _1042_[111] net1015 VSS VSS VDD VDD u_core.u_top.u_core.acc[111] sky130_fd_sc_hd__dfrtp_1
Xu_core.u_top.u_core.acc[112]$_DFFE_PN0P_ clknet_1_1__leaf__11384_ _1042_[112] net1015 VSS VSS VDD VDD u_core.u_top.u_core.acc[112] sky130_fd_sc_hd__dfrtp_1
Xu_core.u_top.u_core.acc[113]$_DFFE_PN0P_ clknet_1_0__leaf__11384_ _1042_[113] net1015 VSS VSS VDD VDD u_core.u_top.u_core.acc[113] sky130_fd_sc_hd__dfrtp_1
Xu_core.u_top.u_core.acc[114]$_DFFE_PN0P_ clknet_1_0__leaf__11384_ _1042_[114] net1015 VSS VSS VDD VDD u_core.u_top.u_core.acc[114] sky130_fd_sc_hd__dfrtp_1
Xu_core.u_top.u_core.acc[115]$_DFFE_PN0P_ clknet_1_1__leaf__11384_ _1042_[115] net1015 VSS VSS VDD VDD u_core.u_top.u_core.acc[115] sky130_fd_sc_hd__dfrtp_1
Xu_core.u_top.u_core.acc[116]$_DFFE_PN0P_ clknet_1_0__leaf__11384_ _1042_[116] net1015 VSS VSS VDD VDD u_core.u_top.u_core.acc[116] sky130_fd_sc_hd__dfrtp_1
Xu_core.u_top.u_core.acc[117]$_DFFE_PN0P_ clknet_1_0__leaf__11384_ _1042_[117] net1015 VSS VSS VDD VDD u_core.u_top.u_core.acc[117] sky130_fd_sc_hd__dfrtp_1
Xu_core.u_top.u_core.acc[118]$_DFFE_PN0P_ clknet_1_0__leaf__11384_ _1042_[118] net1015 VSS VSS VDD VDD u_core.u_top.u_core.acc[118] sky130_fd_sc_hd__dfrtp_1
Xu_core.u_top.u_core.acc[119]$_DFFE_PN0P_ clknet_1_0__leaf__11384_ _1042_[119] net1015 VSS VSS VDD VDD u_core.u_top.u_core.acc[119] sky130_fd_sc_hd__dfrtp_1
Xu_core.u_top.u_core.acc[11]$_DFFE_PN0P_ clknet_1_1__leaf__11402_ _1042_[11] net1033 VSS VSS VDD VDD u_core.u_top.u_core.acc[11] sky130_fd_sc_hd__dfrtp_1
Xu_core.u_top.u_core.acc[120]$_DFFE_PN0P_ clknet_1_0__leaf__11381_ _1042_[120] net1034 VSS VSS VDD VDD u_core.u_top.u_core.acc[120] sky130_fd_sc_hd__dfrtp_1
Xu_core.u_top.u_core.acc[121]$_DFFE_PN0P_ clknet_1_1__leaf__11381_ _1042_[121] net1034 VSS VSS VDD VDD u_core.u_top.u_core.acc[121] sky130_fd_sc_hd__dfrtp_1
Xu_core.u_top.u_core.acc[122]$_DFFE_PN0P_ clknet_1_0__leaf__11381_ _1042_[122] net1034 VSS VSS VDD VDD u_core.u_top.u_core.acc[122] sky130_fd_sc_hd__dfrtp_1
Xu_core.u_top.u_core.acc[123]$_DFFE_PN0P_ clknet_1_0__leaf__11381_ _1042_[123] net1034 VSS VSS VDD VDD u_core.u_top.u_core.acc[123] sky130_fd_sc_hd__dfrtp_1
Xu_core.u_top.u_core.acc[124]$_DFFE_PN0P_ clknet_1_1__leaf__11381_ _1042_[124] net1034 VSS VSS VDD VDD u_core.u_top.u_core.acc[124] sky130_fd_sc_hd__dfrtp_1
Xu_core.u_top.u_core.acc[125]$_DFFE_PN0P_ clknet_1_1__leaf__11381_ _1042_[125] net1034 VSS VSS VDD VDD u_core.u_top.u_core.acc[125] sky130_fd_sc_hd__dfrtp_1
Xu_core.u_top.u_core.acc[126]$_DFFE_PN0P_ clknet_1_0__leaf__11381_ _1042_[126] net1034 VSS VSS VDD VDD u_core.u_top.u_core.acc[126] sky130_fd_sc_hd__dfrtp_1
Xu_core.u_top.u_core.acc[127]$_DFFE_PN0P_ clknet_1_1__leaf__11381_ _1042_[127] net1034 VSS VSS VDD VDD u_core.u_top.u_core.acc[127] sky130_fd_sc_hd__dfrtp_1
Xu_core.u_top.u_core.acc[128]$_DFFE_PN0P_ clknet_1_0__leaf__11381_ _1042_[128] net1034 VSS VSS VDD VDD u_core.u_top.u_core.acc[128] sky130_fd_sc_hd__dfrtp_1
Xu_core.u_top.u_core.acc[129]$_DFFE_PN0P_ clknet_1_0__leaf__11381_ _1042_[129] net1034 VSS VSS VDD VDD u_core.u_top.u_core.acc[129] sky130_fd_sc_hd__dfrtp_1
Xu_core.u_top.u_core.acc[12]$_DFFE_PN0P_ clknet_1_1__leaf__11402_ _1042_[12] net1033 VSS VSS VDD VDD u_core.u_top.u_core.acc[12] sky130_fd_sc_hd__dfrtp_1
Xu_core.u_top.u_core.acc[130]$_DFFE_PN0P_ clknet_1_1__leaf__11427_ _1042_[130] net1035 VSS VSS VDD VDD u_core.u_top.u_core.acc[130] sky130_fd_sc_hd__dfrtp_1
Xu_core.u_top.u_core.acc[131]$_DFFE_PN0P_ clknet_1_1__leaf__11427_ _1042_[131] net1035 VSS VSS VDD VDD u_core.u_top.u_core.acc[131] sky130_fd_sc_hd__dfrtp_1
Xu_core.u_top.u_core.acc[132]$_DFFE_PN0P_ clknet_1_1__leaf__11427_ _1042_[132] net1035 VSS VSS VDD VDD u_core.u_top.u_core.acc[132] sky130_fd_sc_hd__dfrtp_1
Xu_core.u_top.u_core.acc[133]$_DFFE_PN0P_ clknet_1_1__leaf__11427_ _1042_[133] net1035 VSS VSS VDD VDD u_core.u_top.u_core.acc[133] sky130_fd_sc_hd__dfrtp_1
Xu_core.u_top.u_core.acc[134]$_DFFE_PN0P_ clknet_1_1__leaf__11427_ _1042_[134] net1005 VSS VSS VDD VDD u_core.u_top.u_core.acc[134] sky130_fd_sc_hd__dfrtp_1
Xu_core.u_top.u_core.acc[135]$_DFFE_PN0P_ clknet_1_1__leaf__11427_ _1042_[135] net1005 VSS VSS VDD VDD u_core.u_top.u_core.acc[135] sky130_fd_sc_hd__dfrtp_1
Xu_core.u_top.u_core.acc[136]$_DFFE_PN0P_ clknet_1_0__leaf__11427_ _1042_[136] net1005 VSS VSS VDD VDD u_core.u_top.u_core.acc[136] sky130_fd_sc_hd__dfrtp_1
Xu_core.u_top.u_core.acc[137]$_DFFE_PN0P_ clknet_1_0__leaf__11427_ _1042_[137] net1005 VSS VSS VDD VDD u_core.u_top.u_core.acc[137] sky130_fd_sc_hd__dfrtp_1
Xu_core.u_top.u_core.acc[138]$_DFFE_PN0P_ clknet_1_0__leaf__11427_ _1042_[138] net1005 VSS VSS VDD VDD u_core.u_top.u_core.acc[138] sky130_fd_sc_hd__dfrtp_1
Xu_core.u_top.u_core.acc[139]$_DFFE_PN0P_ clknet_1_0__leaf__11427_ _1042_[139] net1005 VSS VSS VDD VDD u_core.u_top.u_core.acc[139] sky130_fd_sc_hd__dfrtp_1
Xu_core.u_top.u_core.acc[13]$_DFFE_PN0P_ clknet_1_1__leaf__11402_ _1042_[13] net1036 VSS VSS VDD VDD u_core.u_top.u_core.acc[13] sky130_fd_sc_hd__dfrtp_1
Xu_core.u_top.u_core.acc[140]$_DFFE_PN0P_ clknet_1_1__leaf__11408_ _1042_[140] net1035 VSS VSS VDD VDD u_core.u_top.u_core.acc[140] sky130_fd_sc_hd__dfrtp_1
Xu_core.u_top.u_core.acc[141]$_DFFE_PN0P_ clknet_1_1__leaf__11408_ _1042_[141] net1035 VSS VSS VDD VDD u_core.u_top.u_core.acc[141] sky130_fd_sc_hd__dfrtp_1
Xu_core.u_top.u_core.acc[142]$_DFFE_PN0P_ clknet_1_1__leaf__11408_ _1042_[142] net1035 VSS VSS VDD VDD u_core.u_top.u_core.acc[142] sky130_fd_sc_hd__dfrtp_1
Xu_core.u_top.u_core.acc[143]$_DFFE_PN0P_ clknet_1_1__leaf__11408_ _1042_[143] net1035 VSS VSS VDD VDD u_core.u_top.u_core.acc[143] sky130_fd_sc_hd__dfrtp_1
Xu_core.u_top.u_core.acc[144]$_DFFE_PN0P_ clknet_1_0__leaf__11408_ _1042_[144] net1035 VSS VSS VDD VDD u_core.u_top.u_core.acc[144] sky130_fd_sc_hd__dfrtp_1
Xu_core.u_top.u_core.acc[145]$_DFFE_PN0P_ clknet_1_0__leaf__11408_ _1042_[145] net1035 VSS VSS VDD VDD u_core.u_top.u_core.acc[145] sky130_fd_sc_hd__dfrtp_1
Xu_core.u_top.u_core.acc[146]$_DFFE_PN0P_ clknet_1_0__leaf__11408_ _1042_[146] net1035 VSS VSS VDD VDD u_core.u_top.u_core.acc[146] sky130_fd_sc_hd__dfrtp_1
Xu_core.u_top.u_core.acc[147]$_DFFE_PN0P_ clknet_1_0__leaf__11408_ _1042_[147] net1035 VSS VSS VDD VDD u_core.u_top.u_core.acc[147] sky130_fd_sc_hd__dfrtp_1
Xu_core.u_top.u_core.acc[148]$_DFFE_PN0P_ clknet_1_0__leaf__11408_ _1042_[148] net1035 VSS VSS VDD VDD u_core.u_top.u_core.acc[148] sky130_fd_sc_hd__dfrtp_1
Xu_core.u_top.u_core.acc[149]$_DFFE_PN0P_ clknet_1_0__leaf__11408_ _1042_[149] net1035 VSS VSS VDD VDD u_core.u_top.u_core.acc[149] sky130_fd_sc_hd__dfrtp_1
Xu_core.u_top.u_core.acc[14]$_DFFE_PN0P_ clknet_1_0__leaf__11402_ _1042_[14] net1034 VSS VSS VDD VDD u_core.u_top.u_core.acc[14] sky130_fd_sc_hd__dfrtp_1
Xu_core.u_top.u_core.acc[150]$_DFFE_PN0P_ clknet_1_0__leaf__11399_ _1042_[150] net1005 VSS VSS VDD VDD u_core.u_top.u_core.acc[150] sky130_fd_sc_hd__dfrtp_1
Xu_core.u_top.u_core.acc[151]$_DFFE_PN0P_ clknet_1_1__leaf__11399_ _1042_[151] net1005 VSS VSS VDD VDD u_core.u_top.u_core.acc[151] sky130_fd_sc_hd__dfrtp_1
Xu_core.u_top.u_core.acc[152]$_DFFE_PN0P_ clknet_1_1__leaf__11399_ _1042_[152] net1005 VSS VSS VDD VDD u_core.u_top.u_core.acc[152] sky130_fd_sc_hd__dfrtp_1
Xu_core.u_top.u_core.acc[153]$_DFFE_PN0P_ clknet_1_1__leaf__11399_ _1042_[153] net1005 VSS VSS VDD VDD u_core.u_top.u_core.acc[153] sky130_fd_sc_hd__dfrtp_1
Xu_core.u_top.u_core.acc[154]$_DFFE_PN0P_ clknet_1_1__leaf__11399_ _1042_[154] net1005 VSS VSS VDD VDD u_core.u_top.u_core.acc[154] sky130_fd_sc_hd__dfrtp_1
Xu_core.u_top.u_core.acc[155]$_DFFE_PN0P_ clknet_1_0__leaf__11399_ _1042_[155] net1005 VSS VSS VDD VDD u_core.u_top.u_core.acc[155] sky130_fd_sc_hd__dfrtp_1
Xu_core.u_top.u_core.acc[156]$_DFFE_PN0P_ clknet_1_0__leaf__11399_ _1042_[156] net1003 VSS VSS VDD VDD u_core.u_top.u_core.acc[156] sky130_fd_sc_hd__dfrtp_1
Xu_core.u_top.u_core.acc[157]$_DFFE_PN0P_ clknet_1_0__leaf__11399_ _1042_[157] net1003 VSS VSS VDD VDD u_core.u_top.u_core.acc[157] sky130_fd_sc_hd__dfrtp_1
Xu_core.u_top.u_core.acc[158]$_DFFE_PN0P_ clknet_1_0__leaf__11399_ _1042_[158] net1003 VSS VSS VDD VDD u_core.u_top.u_core.acc[158] sky130_fd_sc_hd__dfrtp_1
Xu_core.u_top.u_core.acc[159]$_DFFE_PN0P_ clknet_1_0__leaf__11399_ _1042_[159] net1005 VSS VSS VDD VDD u_core.u_top.u_core.acc[159] sky130_fd_sc_hd__dfrtp_1
Xu_core.u_top.u_core.acc[15]$_DFFE_PN0P_ clknet_1_0__leaf__11402_ _1042_[15] net1033 VSS VSS VDD VDD u_core.u_top.u_core.acc[15] sky130_fd_sc_hd__dfrtp_1
Xu_core.u_top.u_core.acc[160]$_DFFE_PN0P_ clknet_1_1__leaf__11417_ _1042_[160] net1037 VSS VSS VDD VDD u_core.u_top.u_core.acc[160] sky130_fd_sc_hd__dfrtp_1
Xu_core.u_top.u_core.acc[161]$_DFFE_PN0P_ clknet_1_1__leaf__11417_ _1042_[161] net1037 VSS VSS VDD VDD u_core.u_top.u_core.acc[161] sky130_fd_sc_hd__dfrtp_1
Xu_core.u_top.u_core.acc[162]$_DFFE_PN0P_ clknet_1_1__leaf__11417_ _1042_[162] net1037 VSS VSS VDD VDD u_core.u_top.u_core.acc[162] sky130_fd_sc_hd__dfrtp_1
Xu_core.u_top.u_core.acc[163]$_DFFE_PN0P_ clknet_1_0__leaf__11417_ _1042_[163] net1037 VSS VSS VDD VDD u_core.u_top.u_core.acc[163] sky130_fd_sc_hd__dfrtp_1
Xu_core.u_top.u_core.acc[164]$_DFFE_PN0P_ clknet_1_0__leaf__11417_ _1042_[164] net1037 VSS VSS VDD VDD u_core.u_top.u_core.acc[164] sky130_fd_sc_hd__dfrtp_1
Xu_core.u_top.u_core.acc[165]$_DFFE_PN0P_ clknet_1_1__leaf__11417_ _1042_[165] net1037 VSS VSS VDD VDD u_core.u_top.u_core.acc[165] sky130_fd_sc_hd__dfrtp_1
Xu_core.u_top.u_core.acc[166]$_DFFE_PN0P_ clknet_1_0__leaf__11417_ _1042_[166] net1037 VSS VSS VDD VDD u_core.u_top.u_core.acc[166] sky130_fd_sc_hd__dfrtp_1
Xu_core.u_top.u_core.acc[167]$_DFFE_PN0P_ clknet_1_0__leaf__11417_ _1042_[167] net1037 VSS VSS VDD VDD u_core.u_top.u_core.acc[167] sky130_fd_sc_hd__dfrtp_1
Xu_core.u_top.u_core.acc[168]$_DFFE_PN0P_ clknet_1_0__leaf__11417_ _1042_[168] net1037 VSS VSS VDD VDD u_core.u_top.u_core.acc[168] sky130_fd_sc_hd__dfrtp_1
Xu_core.u_top.u_core.acc[169]$_DFFE_PN0P_ clknet_1_0__leaf__11417_ _1042_[169] net1037 VSS VSS VDD VDD u_core.u_top.u_core.acc[169] sky130_fd_sc_hd__dfrtp_1
Xu_core.u_top.u_core.acc[16]$_DFFE_PN0P_ clknet_1_0__leaf__11402_ _1042_[16] net1033 VSS VSS VDD VDD u_core.u_top.u_core.acc[16] sky130_fd_sc_hd__dfrtp_1
Xu_core.u_top.u_core.acc[170]$_DFFE_PN0P_ clknet_1_1__leaf__11405_ _1042_[170] net1037 VSS VSS VDD VDD u_core.u_top.u_core.acc[170] sky130_fd_sc_hd__dfrtp_1
Xu_core.u_top.u_core.acc[171]$_DFFE_PN0P_ clknet_1_1__leaf__11405_ _1042_[171] net1037 VSS VSS VDD VDD u_core.u_top.u_core.acc[171] sky130_fd_sc_hd__dfrtp_1
Xu_core.u_top.u_core.acc[172]$_DFFE_PN0P_ clknet_1_1__leaf__11405_ _1042_[172] net1037 VSS VSS VDD VDD u_core.u_top.u_core.acc[172] sky130_fd_sc_hd__dfrtp_1
Xu_core.u_top.u_core.acc[173]$_DFFE_PN0P_ clknet_1_1__leaf__11405_ _1042_[173] net1037 VSS VSS VDD VDD u_core.u_top.u_core.acc[173] sky130_fd_sc_hd__dfrtp_1
Xu_core.u_top.u_core.acc[174]$_DFFE_PN0P_ clknet_1_1__leaf__11405_ _1042_[174] net1037 VSS VSS VDD VDD u_core.u_top.u_core.acc[174] sky130_fd_sc_hd__dfrtp_1
Xu_core.u_top.u_core.acc[175]$_DFFE_PN0P_ clknet_1_0__leaf__11405_ _1042_[175] net1037 VSS VSS VDD VDD u_core.u_top.u_core.acc[175] sky130_fd_sc_hd__dfrtp_1
Xu_core.u_top.u_core.acc[176]$_DFFE_PN0P_ clknet_1_0__leaf__11405_ _1042_[176] net1037 VSS VSS VDD VDD u_core.u_top.u_core.acc[176] sky130_fd_sc_hd__dfrtp_1
Xu_core.u_top.u_core.acc[177]$_DFFE_PN0P_ clknet_1_1__leaf__11405_ _1042_[177] net1037 VSS VSS VDD VDD u_core.u_top.u_core.acc[177] sky130_fd_sc_hd__dfrtp_1
Xu_core.u_top.u_core.acc[178]$_DFFE_PN0P_ clknet_1_0__leaf__11405_ _1042_[178] net1037 VSS VSS VDD VDD u_core.u_top.u_core.acc[178] sky130_fd_sc_hd__dfrtp_1
Xu_core.u_top.u_core.acc[179]$_DFFE_PN0P_ clknet_1_0__leaf__11405_ _1042_[179] net1037 VSS VSS VDD VDD u_core.u_top.u_core.acc[179] sky130_fd_sc_hd__dfrtp_1
Xu_core.u_top.u_core.acc[17]$_DFFE_PN0P_ clknet_1_0__leaf__11402_ _1042_[17] net1034 VSS VSS VDD VDD u_core.u_top.u_core.acc[17] sky130_fd_sc_hd__dfrtp_1
Xu_core.u_top.u_core.acc[180]$_DFFE_PN0P_ clknet_1_1__leaf__11412_ _1042_[180] net1037 VSS VSS VDD VDD u_core.u_top.u_core.acc[180] sky130_fd_sc_hd__dfrtp_1
Xu_core.u_top.u_core.acc[181]$_DFFE_PN0P_ clknet_1_1__leaf__11412_ _1042_[181] net1037 VSS VSS VDD VDD u_core.u_top.u_core.acc[181] sky130_fd_sc_hd__dfrtp_1
Xu_core.u_top.u_core.acc[182]$_DFFE_PN0P_ clknet_1_1__leaf__11412_ _1042_[182] net1037 VSS VSS VDD VDD u_core.u_top.u_core.acc[182] sky130_fd_sc_hd__dfrtp_1
Xu_core.u_top.u_core.acc[183]$_DFFE_PN0P_ clknet_1_1__leaf__11412_ _1042_[183] net1037 VSS VSS VDD VDD u_core.u_top.u_core.acc[183] sky130_fd_sc_hd__dfrtp_1
Xu_core.u_top.u_core.acc[184]$_DFFE_PN0P_ clknet_1_0__leaf__11412_ _1042_[184] net1037 VSS VSS VDD VDD u_core.u_top.u_core.acc[184] sky130_fd_sc_hd__dfrtp_1
Xu_core.u_top.u_core.acc[185]$_DFFE_PN0P_ clknet_1_0__leaf__11412_ _1042_[185] net1037 VSS VSS VDD VDD u_core.u_top.u_core.acc[185] sky130_fd_sc_hd__dfrtp_1
Xu_core.u_top.u_core.acc[186]$_DFFE_PN0P_ clknet_1_0__leaf__11412_ _1042_[186] net1037 VSS VSS VDD VDD u_core.u_top.u_core.acc[186] sky130_fd_sc_hd__dfrtp_1
Xu_core.u_top.u_core.acc[187]$_DFFE_PN0P_ clknet_1_0__leaf__11412_ _1042_[187] net1037 VSS VSS VDD VDD u_core.u_top.u_core.acc[187] sky130_fd_sc_hd__dfrtp_1
Xu_core.u_top.u_core.acc[188]$_DFFE_PN0P_ clknet_1_0__leaf__11412_ _1042_[188] net1037 VSS VSS VDD VDD u_core.u_top.u_core.acc[188] sky130_fd_sc_hd__dfrtp_1
Xu_core.u_top.u_core.acc[189]$_DFFE_PN0P_ clknet_1_0__leaf__11412_ _1042_[189] net1037 VSS VSS VDD VDD u_core.u_top.u_core.acc[189] sky130_fd_sc_hd__dfrtp_1
Xu_core.u_top.u_core.acc[18]$_DFFE_PN0P_ clknet_1_0__leaf__11402_ _1042_[18] net1034 VSS VSS VDD VDD u_core.u_top.u_core.acc[18] sky130_fd_sc_hd__dfrtp_1
Xu_core.u_top.u_core.acc[190]$_DFFE_PN0P_ clknet_1_1__leaf__11372_ _1042_[190] net1037 VSS VSS VDD VDD u_core.u_top.u_core.acc[190] sky130_fd_sc_hd__dfrtp_1
Xu_core.u_top.u_core.acc[191]$_DFFE_PN0P_ clknet_1_1__leaf__11372_ _1042_[191] net1037 VSS VSS VDD VDD u_core.u_top.u_core.acc[191] sky130_fd_sc_hd__dfrtp_1
Xu_core.u_top.u_core.acc[192]$_DFFE_PN0P_ clknet_1_1__leaf__11372_ _1042_[192] net1037 VSS VSS VDD VDD u_core.u_top.u_core.acc[192] sky130_fd_sc_hd__dfrtp_1
Xu_core.u_top.u_core.acc[193]$_DFFE_PN0P_ clknet_1_1__leaf__11372_ _1042_[193] net1037 VSS VSS VDD VDD u_core.u_top.u_core.acc[193] sky130_fd_sc_hd__dfrtp_1
Xu_core.u_top.u_core.acc[194]$_DFFE_PN0P_ clknet_1_1__leaf__11372_ _1042_[194] net1037 VSS VSS VDD VDD u_core.u_top.u_core.acc[194] sky130_fd_sc_hd__dfrtp_1
Xu_core.u_top.u_core.acc[195]$_DFFE_PN0P_ clknet_1_0__leaf__11372_ _1042_[195] net1037 VSS VSS VDD VDD u_core.u_top.u_core.acc[195] sky130_fd_sc_hd__dfrtp_1
Xu_core.u_top.u_core.acc[196]$_DFFE_PN0P_ clknet_1_0__leaf__11372_ _1042_[196] net1037 VSS VSS VDD VDD u_core.u_top.u_core.acc[196] sky130_fd_sc_hd__dfrtp_1
Xu_core.u_top.u_core.acc[197]$_DFFE_PN0P_ clknet_1_0__leaf__11372_ _1042_[197] net1037 VSS VSS VDD VDD u_core.u_top.u_core.acc[197] sky130_fd_sc_hd__dfrtp_1
Xu_core.u_top.u_core.acc[198]$_DFFE_PN0P_ clknet_1_0__leaf__11372_ _1042_[198] net1037 VSS VSS VDD VDD u_core.u_top.u_core.acc[198] sky130_fd_sc_hd__dfrtp_1
Xu_core.u_top.u_core.acc[199]$_DFFE_PN0P_ clknet_1_0__leaf__11372_ _1042_[199] net1037 VSS VSS VDD VDD u_core.u_top.u_core.acc[199] sky130_fd_sc_hd__dfrtp_1
Xu_core.u_top.u_core.acc[19]$_DFFE_PN0P_ clknet_1_0__leaf__11402_ _1042_[19] net1034 VSS VSS VDD VDD u_core.u_top.u_core.acc[19] sky130_fd_sc_hd__dfrtp_1
Xu_core.u_top.u_core.acc[1]$_DFFE_PN0P_ clknet_1_1__leaf__11369_ _1042_[1] net1033 VSS VSS VDD VDD u_core.u_top.u_core.acc[1] sky130_fd_sc_hd__dfrtp_1
Xu_core.u_top.u_core.acc[200]$_DFFE_PN0P_ clknet_1_1__leaf__11404_ _1042_[200] net1037 VSS VSS VDD VDD u_core.u_top.u_core.acc[200] sky130_fd_sc_hd__dfrtp_1
Xu_core.u_top.u_core.acc[201]$_DFFE_PN0P_ clknet_1_1__leaf__11404_ _1042_[201] net1037 VSS VSS VDD VDD u_core.u_top.u_core.acc[201] sky130_fd_sc_hd__dfrtp_1
Xu_core.u_top.u_core.acc[202]$_DFFE_PN0P_ clknet_1_1__leaf__11404_ _1042_[202] net46 VSS VSS VDD VDD u_core.u_top.u_core.acc[202] sky130_fd_sc_hd__dfrtp_1
Xu_core.u_top.u_core.acc[203]$_DFFE_PN0P_ clknet_1_0__leaf__11404_ _1042_[203] net46 VSS VSS VDD VDD u_core.u_top.u_core.acc[203] sky130_fd_sc_hd__dfrtp_1
Xu_core.u_top.u_core.acc[204]$_DFFE_PN0P_ clknet_1_0__leaf__11404_ _1042_[204] net46 VSS VSS VDD VDD u_core.u_top.u_core.acc[204] sky130_fd_sc_hd__dfrtp_1
Xu_core.u_top.u_core.acc[205]$_DFFE_PN0P_ clknet_1_1__leaf__11404_ _1042_[205] net46 VSS VSS VDD VDD u_core.u_top.u_core.acc[205] sky130_fd_sc_hd__dfrtp_1
Xu_core.u_top.u_core.acc[206]$_DFFE_PN0P_ clknet_1_0__leaf__11404_ _1042_[206] net46 VSS VSS VDD VDD u_core.u_top.u_core.acc[206] sky130_fd_sc_hd__dfrtp_1
Xu_core.u_top.u_core.acc[207]$_DFFE_PN0P_ clknet_1_0__leaf__11404_ _1042_[207] net46 VSS VSS VDD VDD u_core.u_top.u_core.acc[207] sky130_fd_sc_hd__dfrtp_1
Xu_core.u_top.u_core.acc[208]$_DFFE_PN0P_ clknet_1_0__leaf__11404_ _1042_[208] net46 VSS VSS VDD VDD u_core.u_top.u_core.acc[208] sky130_fd_sc_hd__dfrtp_1
Xu_core.u_top.u_core.acc[209]$_DFFE_PN0P_ clknet_1_0__leaf__11404_ _1042_[209] net46 VSS VSS VDD VDD u_core.u_top.u_core.acc[209] sky130_fd_sc_hd__dfrtp_1
Xu_core.u_top.u_core.acc[20]$_DFFE_PN0P_ clknet_1_1__leaf__11413_ _1042_[20] net1033 VSS VSS VDD VDD u_core.u_top.u_core.acc[20] sky130_fd_sc_hd__dfrtp_1
Xu_core.u_top.u_core.acc[210]$_DFFE_PN0P_ clknet_1_0__leaf__11424_ _1042_[210] net1035 VSS VSS VDD VDD u_core.u_top.u_core.acc[210] sky130_fd_sc_hd__dfrtp_1
Xu_core.u_top.u_core.acc[211]$_DFFE_PN0P_ clknet_1_1__leaf__11424_ _1042_[211] net1035 VSS VSS VDD VDD u_core.u_top.u_core.acc[211] sky130_fd_sc_hd__dfrtp_1
Xu_core.u_top.u_core.acc[212]$_DFFE_PN0P_ clknet_1_1__leaf__11424_ _1042_[212] net1035 VSS VSS VDD VDD u_core.u_top.u_core.acc[212] sky130_fd_sc_hd__dfrtp_1
Xu_core.u_top.u_core.acc[213]$_DFFE_PN0P_ clknet_1_1__leaf__11424_ _1042_[213] net1035 VSS VSS VDD VDD u_core.u_top.u_core.acc[213] sky130_fd_sc_hd__dfrtp_1
Xu_core.u_top.u_core.acc[214]$_DFFE_PN0P_ clknet_1_1__leaf__11424_ _1042_[214] net1035 VSS VSS VDD VDD u_core.u_top.u_core.acc[214] sky130_fd_sc_hd__dfrtp_1
Xu_core.u_top.u_core.acc[215]$_DFFE_PN0P_ clknet_1_0__leaf__11424_ _1042_[215] net1035 VSS VSS VDD VDD u_core.u_top.u_core.acc[215] sky130_fd_sc_hd__dfrtp_1
Xu_core.u_top.u_core.acc[216]$_DFFE_PN0P_ clknet_1_0__leaf__11424_ _1042_[216] net46 VSS VSS VDD VDD u_core.u_top.u_core.acc[216] sky130_fd_sc_hd__dfrtp_1
Xu_core.u_top.u_core.acc[217]$_DFFE_PN0P_ clknet_1_1__leaf__11424_ _1042_[217] net46 VSS VSS VDD VDD u_core.u_top.u_core.acc[217] sky130_fd_sc_hd__dfrtp_1
Xu_core.u_top.u_core.acc[218]$_DFFE_PN0P_ clknet_1_0__leaf__11424_ _1042_[218] net46 VSS VSS VDD VDD u_core.u_top.u_core.acc[218] sky130_fd_sc_hd__dfrtp_1
Xu_core.u_top.u_core.acc[219]$_DFFE_PN0P_ clknet_1_1__leaf__11424_ _1042_[219] net1035 VSS VSS VDD VDD u_core.u_top.u_core.acc[219] sky130_fd_sc_hd__dfrtp_1
Xu_core.u_top.u_core.acc[21]$_DFFE_PN0P_ clknet_1_1__leaf__11413_ _1042_[21] net1033 VSS VSS VDD VDD u_core.u_top.u_core.acc[21] sky130_fd_sc_hd__dfrtp_1
Xu_core.u_top.u_core.acc[220]$_DFFE_PN0P_ clknet_1_1__leaf__11392_ _1042_[220] net46 VSS VSS VDD VDD u_core.u_top.u_core.acc[220] sky130_fd_sc_hd__dfrtp_1
Xu_core.u_top.u_core.acc[221]$_DFFE_PN0P_ clknet_1_1__leaf__11392_ _1042_[221] net1037 VSS VSS VDD VDD u_core.u_top.u_core.acc[221] sky130_fd_sc_hd__dfrtp_1
Xu_core.u_top.u_core.acc[222]$_DFFE_PN0P_ clknet_1_1__leaf__11392_ _1042_[222] net46 VSS VSS VDD VDD u_core.u_top.u_core.acc[222] sky130_fd_sc_hd__dfrtp_1
Xu_core.u_top.u_core.acc[223]$_DFFE_PN0P_ clknet_1_1__leaf__11392_ _1042_[223] net46 VSS VSS VDD VDD u_core.u_top.u_core.acc[223] sky130_fd_sc_hd__dfrtp_1
Xu_core.u_top.u_core.acc[224]$_DFFE_PN0P_ clknet_1_1__leaf__11392_ _1042_[224] net46 VSS VSS VDD VDD u_core.u_top.u_core.acc[224] sky130_fd_sc_hd__dfrtp_1
Xu_core.u_top.u_core.acc[225]$_DFFE_PN0P_ clknet_1_1__leaf__11392_ _1042_[225] net46 VSS VSS VDD VDD u_core.u_top.u_core.acc[225] sky130_fd_sc_hd__dfrtp_1
Xu_core.u_top.u_core.acc[226]$_DFFE_PN0P_ clknet_1_0__leaf__11392_ _1042_[226] net46 VSS VSS VDD VDD u_core.u_top.u_core.acc[226] sky130_fd_sc_hd__dfrtp_1
Xu_core.u_top.u_core.acc[227]$_DFFE_PN0P_ clknet_1_0__leaf__11392_ _1042_[227] net46 VSS VSS VDD VDD u_core.u_top.u_core.acc[227] sky130_fd_sc_hd__dfrtp_1
Xu_core.u_top.u_core.acc[228]$_DFFE_PN0P_ clknet_1_0__leaf__11392_ _1042_[228] net46 VSS VSS VDD VDD u_core.u_top.u_core.acc[228] sky130_fd_sc_hd__dfrtp_1
Xu_core.u_top.u_core.acc[229]$_DFFE_PN0P_ clknet_1_0__leaf__11392_ _1042_[229] net46 VSS VSS VDD VDD u_core.u_top.u_core.acc[229] sky130_fd_sc_hd__dfrtp_1
Xu_core.u_top.u_core.acc[22]$_DFFE_PN0P_ clknet_1_1__leaf__11413_ _1042_[22] net1033 VSS VSS VDD VDD u_core.u_top.u_core.acc[22] sky130_fd_sc_hd__dfrtp_1
Xu_core.u_top.u_core.acc[230]$_DFFE_PN0P_ clknet_1_1__leaf__11358_ _1042_[230] net1036 VSS VSS VDD VDD u_core.u_top.u_core.acc[230] sky130_fd_sc_hd__dfrtp_1
Xu_core.u_top.u_core.acc[231]$_DFFE_PN0P_ clknet_1_1__leaf__11358_ _1042_[231] net1036 VSS VSS VDD VDD u_core.u_top.u_core.acc[231] sky130_fd_sc_hd__dfrtp_1
Xu_core.u_top.u_core.acc[232]$_DFFE_PN0P_ clknet_1_1__leaf__11358_ _1042_[232] net1036 VSS VSS VDD VDD u_core.u_top.u_core.acc[232] sky130_fd_sc_hd__dfrtp_1
Xu_core.u_top.u_core.acc[233]$_DFFE_PN0P_ clknet_1_1__leaf__11358_ _1042_[233] net1036 VSS VSS VDD VDD u_core.u_top.u_core.acc[233] sky130_fd_sc_hd__dfrtp_1
Xu_core.u_top.u_core.acc[234]$_DFFE_PN0P_ clknet_1_0__leaf__11358_ _1042_[234] net1037 VSS VSS VDD VDD u_core.u_top.u_core.acc[234] sky130_fd_sc_hd__dfrtp_1
Xu_core.u_top.u_core.acc[235]$_DFFE_PN0P_ clknet_1_1__leaf__11358_ _1042_[235] net1036 VSS VSS VDD VDD u_core.u_top.u_core.acc[235] sky130_fd_sc_hd__dfrtp_1
Xu_core.u_top.u_core.acc[236]$_DFFE_PN0P_ clknet_1_0__leaf__11358_ _1042_[236] net1037 VSS VSS VDD VDD u_core.u_top.u_core.acc[236] sky130_fd_sc_hd__dfrtp_1
Xu_core.u_top.u_core.acc[237]$_DFFE_PN0P_ clknet_1_0__leaf__11358_ _1042_[237] net1037 VSS VSS VDD VDD u_core.u_top.u_core.acc[237] sky130_fd_sc_hd__dfrtp_1
Xu_core.u_top.u_core.acc[238]$_DFFE_PN0P_ clknet_1_0__leaf__11358_ _1042_[238] net1037 VSS VSS VDD VDD u_core.u_top.u_core.acc[238] sky130_fd_sc_hd__dfrtp_1
Xu_core.u_top.u_core.acc[239]$_DFFE_PN0P_ clknet_1_0__leaf__11358_ _1042_[239] net1036 VSS VSS VDD VDD u_core.u_top.u_core.acc[239] sky130_fd_sc_hd__dfrtp_1
Xu_core.u_top.u_core.acc[23]$_DFFE_PN0P_ clknet_1_1__leaf__11413_ _1042_[23] net1033 VSS VSS VDD VDD u_core.u_top.u_core.acc[23] sky130_fd_sc_hd__dfrtp_1
Xu_core.u_top.u_core.acc[24]$_DFFE_PN0P_ clknet_1_1__leaf__11413_ _1042_[24] net1033 VSS VSS VDD VDD u_core.u_top.u_core.acc[24] sky130_fd_sc_hd__dfrtp_1
Xu_core.u_top.u_core.acc[25]$_DFFE_PN0P_ clknet_1_0__leaf__11413_ _1042_[25] net1033 VSS VSS VDD VDD u_core.u_top.u_core.acc[25] sky130_fd_sc_hd__dfrtp_1
Xu_core.u_top.u_core.acc[26]$_DFFE_PN0P_ clknet_1_0__leaf__11413_ _1042_[26] net1033 VSS VSS VDD VDD u_core.u_top.u_core.acc[26] sky130_fd_sc_hd__dfrtp_1
Xu_core.u_top.u_core.acc[27]$_DFFE_PN0P_ clknet_1_1__leaf__11413_ _1042_[27] net1033 VSS VSS VDD VDD u_core.u_top.u_core.acc[27] sky130_fd_sc_hd__dfrtp_1
Xu_core.u_top.u_core.acc[28]$_DFFE_PN0P_ clknet_1_0__leaf__11413_ _1042_[28] net1033 VSS VSS VDD VDD u_core.u_top.u_core.acc[28] sky130_fd_sc_hd__dfrtp_1
Xu_core.u_top.u_core.acc[29]$_DFFE_PN0P_ clknet_1_0__leaf__11413_ _1042_[29] net1033 VSS VSS VDD VDD u_core.u_top.u_core.acc[29] sky130_fd_sc_hd__dfrtp_1
Xu_core.u_top.u_core.acc[2]$_DFFE_PN0P_ clknet_1_1__leaf__11369_ _1042_[2] net1032 VSS VSS VDD VDD u_core.u_top.u_core.acc[2] sky130_fd_sc_hd__dfrtp_1
Xu_core.u_top.u_core.acc[30]$_DFFE_PN0P_ clknet_1_1__leaf__11411_ _1042_[30] net1033 VSS VSS VDD VDD u_core.u_top.u_core.acc[30] sky130_fd_sc_hd__dfrtp_1
Xu_core.u_top.u_core.acc[31]$_DFFE_PN0P_ clknet_1_1__leaf__11411_ _1042_[31] net1033 VSS VSS VDD VDD u_core.u_top.u_core.acc[31] sky130_fd_sc_hd__dfrtp_1
Xu_core.u_top.u_core.acc[32]$_DFFE_PN0P_ clknet_1_1__leaf__11411_ _1042_[32] net1033 VSS VSS VDD VDD u_core.u_top.u_core.acc[32] sky130_fd_sc_hd__dfrtp_1
Xu_core.u_top.u_core.acc[33]$_DFFE_PN0P_ clknet_1_1__leaf__11411_ _1042_[33] net1033 VSS VSS VDD VDD u_core.u_top.u_core.acc[33] sky130_fd_sc_hd__dfrtp_1
Xu_core.u_top.u_core.acc[34]$_DFFE_PN0P_ clknet_1_0__leaf__11411_ _1042_[34] net1033 VSS VSS VDD VDD u_core.u_top.u_core.acc[34] sky130_fd_sc_hd__dfrtp_1
Xu_core.u_top.u_core.acc[35]$_DFFE_PN0P_ clknet_1_1__leaf__11411_ _1042_[35] net1033 VSS VSS VDD VDD u_core.u_top.u_core.acc[35] sky130_fd_sc_hd__dfrtp_1
Xu_core.u_top.u_core.acc[36]$_DFFE_PN0P_ clknet_1_0__leaf__11411_ _1042_[36] net1033 VSS VSS VDD VDD u_core.u_top.u_core.acc[36] sky130_fd_sc_hd__dfrtp_1
Xu_core.u_top.u_core.acc[37]$_DFFE_PN0P_ clknet_1_0__leaf__11411_ _1042_[37] net1033 VSS VSS VDD VDD u_core.u_top.u_core.acc[37] sky130_fd_sc_hd__dfrtp_1
Xu_core.u_top.u_core.acc[38]$_DFFE_PN0P_ clknet_1_0__leaf__11411_ _1042_[38] net1033 VSS VSS VDD VDD u_core.u_top.u_core.acc[38] sky130_fd_sc_hd__dfrtp_1
Xu_core.u_top.u_core.acc[39]$_DFFE_PN0P_ clknet_1_0__leaf__11411_ _1042_[39] net1033 VSS VSS VDD VDD u_core.u_top.u_core.acc[39] sky130_fd_sc_hd__dfrtp_1
Xu_core.u_top.u_core.acc[3]$_DFFE_PN0P_ clknet_1_0__leaf__11369_ _1042_[3] net1033 VSS VSS VDD VDD u_core.u_top.u_core.acc[3] sky130_fd_sc_hd__dfrtp_1
Xu_core.u_top.u_core.acc[40]$_DFFE_PN0P_ clknet_1_1__leaf__11390_ _1042_[40] net1034 VSS VSS VDD VDD u_core.u_top.u_core.acc[40] sky130_fd_sc_hd__dfrtp_1
Xu_core.u_top.u_core.acc[41]$_DFFE_PN0P_ clknet_1_1__leaf__11390_ _1042_[41] net1034 VSS VSS VDD VDD u_core.u_top.u_core.acc[41] sky130_fd_sc_hd__dfrtp_1
Xu_core.u_top.u_core.acc[42]$_DFFE_PN0P_ clknet_1_1__leaf__11390_ _1042_[42] net1034 VSS VSS VDD VDD u_core.u_top.u_core.acc[42] sky130_fd_sc_hd__dfrtp_1
Xu_core.u_top.u_core.acc[43]$_DFFE_PN0P_ clknet_1_1__leaf__11390_ _1042_[43] net1034 VSS VSS VDD VDD u_core.u_top.u_core.acc[43] sky130_fd_sc_hd__dfrtp_1
Xu_core.u_top.u_core.acc[44]$_DFFE_PN0P_ clknet_1_1__leaf__11390_ _1042_[44] net1034 VSS VSS VDD VDD u_core.u_top.u_core.acc[44] sky130_fd_sc_hd__dfrtp_1
Xu_core.u_top.u_core.acc[45]$_DFFE_PN0P_ clknet_1_0__leaf__11390_ _1042_[45] net1035 VSS VSS VDD VDD u_core.u_top.u_core.acc[45] sky130_fd_sc_hd__dfrtp_1
Xu_core.u_top.u_core.acc[46]$_DFFE_PN0P_ clknet_1_0__leaf__11390_ _1042_[46] net1035 VSS VSS VDD VDD u_core.u_top.u_core.acc[46] sky130_fd_sc_hd__dfrtp_1
Xu_core.u_top.u_core.acc[47]$_DFFE_PN0P_ clknet_1_0__leaf__11390_ _1042_[47] net1035 VSS VSS VDD VDD u_core.u_top.u_core.acc[47] sky130_fd_sc_hd__dfrtp_1
Xu_core.u_top.u_core.acc[48]$_DFFE_PN0P_ clknet_1_0__leaf__11390_ _1042_[48] net1035 VSS VSS VDD VDD u_core.u_top.u_core.acc[48] sky130_fd_sc_hd__dfrtp_1
Xu_core.u_top.u_core.acc[49]$_DFFE_PN0P_ clknet_1_0__leaf__11390_ _1042_[49] net1035 VSS VSS VDD VDD u_core.u_top.u_core.acc[49] sky130_fd_sc_hd__dfrtp_1
Xu_core.u_top.u_core.acc[4]$_DFFE_PN0P_ clknet_1_1__leaf__11369_ _1042_[4] net1033 VSS VSS VDD VDD u_core.u_top.u_core.acc[4] sky130_fd_sc_hd__dfrtp_1
Xu_core.u_top.u_core.acc[50]$_DFFE_PN0P_ clknet_1_0__leaf__11397_ _1042_[50] net1036 VSS VSS VDD VDD u_core.u_top.u_core.acc[50] sky130_fd_sc_hd__dfrtp_1
Xu_core.u_top.u_core.acc[51]$_DFFE_PN0P_ clknet_1_0__leaf__11397_ _1042_[51] net1036 VSS VSS VDD VDD u_core.u_top.u_core.acc[51] sky130_fd_sc_hd__dfrtp_1
Xu_core.u_top.u_core.acc[52]$_DFFE_PN0P_ clknet_1_0__leaf__11397_ _1042_[52] net1036 VSS VSS VDD VDD u_core.u_top.u_core.acc[52] sky130_fd_sc_hd__dfrtp_1
Xu_core.u_top.u_core.acc[53]$_DFFE_PN0P_ clknet_1_1__leaf__11397_ _1042_[53] net1036 VSS VSS VDD VDD u_core.u_top.u_core.acc[53] sky130_fd_sc_hd__dfrtp_1
Xu_core.u_top.u_core.acc[54]$_DFFE_PN0P_ clknet_1_0__leaf__11397_ _1042_[54] net1036 VSS VSS VDD VDD u_core.u_top.u_core.acc[54] sky130_fd_sc_hd__dfrtp_1
Xu_core.u_top.u_core.acc[55]$_DFFE_PN0P_ clknet_1_1__leaf__11397_ _1042_[55] net1036 VSS VSS VDD VDD u_core.u_top.u_core.acc[55] sky130_fd_sc_hd__dfrtp_1
Xu_core.u_top.u_core.acc[56]$_DFFE_PN0P_ clknet_1_1__leaf__11397_ _1042_[56] net1036 VSS VSS VDD VDD u_core.u_top.u_core.acc[56] sky130_fd_sc_hd__dfrtp_1
Xu_core.u_top.u_core.acc[57]$_DFFE_PN0P_ clknet_1_1__leaf__11397_ _1042_[57] net1036 VSS VSS VDD VDD u_core.u_top.u_core.acc[57] sky130_fd_sc_hd__dfrtp_1
Xu_core.u_top.u_core.acc[58]$_DFFE_PN0P_ clknet_1_1__leaf__11397_ _1042_[58] net1036 VSS VSS VDD VDD u_core.u_top.u_core.acc[58] sky130_fd_sc_hd__dfrtp_1
Xu_core.u_top.u_core.acc[59]$_DFFE_PN0P_ clknet_1_1__leaf__11397_ _1042_[59] net1036 VSS VSS VDD VDD u_core.u_top.u_core.acc[59] sky130_fd_sc_hd__dfrtp_1
Xu_core.u_top.u_core.acc[5]$_DFFE_PN0P_ clknet_1_0__leaf__11369_ _1042_[5] net1033 VSS VSS VDD VDD u_core.u_top.u_core.acc[5] sky130_fd_sc_hd__dfrtp_1
Xu_core.u_top.u_core.acc[60]$_DFFE_PN0P_ clknet_1_1__leaf__11414_ _1042_[60] net1034 VSS VSS VDD VDD u_core.u_top.u_core.acc[60] sky130_fd_sc_hd__dfrtp_1
Xu_core.u_top.u_core.acc[61]$_DFFE_PN0P_ clknet_1_1__leaf__11414_ _1042_[61] net1034 VSS VSS VDD VDD u_core.u_top.u_core.acc[61] sky130_fd_sc_hd__dfrtp_1
Xu_core.u_top.u_core.acc[62]$_DFFE_PN0P_ clknet_1_1__leaf__11414_ _1042_[62] net1034 VSS VSS VDD VDD u_core.u_top.u_core.acc[62] sky130_fd_sc_hd__dfrtp_1
Xu_core.u_top.u_core.acc[63]$_DFFE_PN0P_ clknet_1_0__leaf__11414_ _1042_[63] net1035 VSS VSS VDD VDD u_core.u_top.u_core.acc[63] sky130_fd_sc_hd__dfrtp_1
Xu_core.u_top.u_core.acc[64]$_DFFE_PN0P_ clknet_1_0__leaf__11414_ _1042_[64] net1035 VSS VSS VDD VDD u_core.u_top.u_core.acc[64] sky130_fd_sc_hd__dfrtp_1
Xu_core.u_top.u_core.acc[65]$_DFFE_PN0P_ clknet_1_1__leaf__11414_ _1042_[65] net1035 VSS VSS VDD VDD u_core.u_top.u_core.acc[65] sky130_fd_sc_hd__dfrtp_1
Xu_core.u_top.u_core.acc[66]$_DFFE_PN0P_ clknet_1_0__leaf__11414_ _1042_[66] net1035 VSS VSS VDD VDD u_core.u_top.u_core.acc[66] sky130_fd_sc_hd__dfrtp_1
Xu_core.u_top.u_core.acc[67]$_DFFE_PN0P_ clknet_1_0__leaf__11414_ _1042_[67] net1035 VSS VSS VDD VDD u_core.u_top.u_core.acc[67] sky130_fd_sc_hd__dfrtp_1
Xu_core.u_top.u_core.acc[68]$_DFFE_PN0P_ clknet_1_0__leaf__11414_ _1042_[68] net1035 VSS VSS VDD VDD u_core.u_top.u_core.acc[68] sky130_fd_sc_hd__dfrtp_1
Xu_core.u_top.u_core.acc[69]$_DFFE_PN0P_ clknet_1_0__leaf__11414_ _1042_[69] net1035 VSS VSS VDD VDD u_core.u_top.u_core.acc[69] sky130_fd_sc_hd__dfrtp_1
Xu_core.u_top.u_core.acc[6]$_DFFE_PN0P_ clknet_1_0__leaf__11369_ _1042_[6] net1033 VSS VSS VDD VDD u_core.u_top.u_core.acc[6] sky130_fd_sc_hd__dfrtp_1
Xu_core.u_top.u_core.acc[70]$_DFFE_PN0P_ clknet_1_0__leaf__11379_ _1042_[70] net1036 VSS VSS VDD VDD u_core.u_top.u_core.acc[70] sky130_fd_sc_hd__dfrtp_1
Xu_core.u_top.u_core.acc[71]$_DFFE_PN0P_ clknet_1_0__leaf__11379_ _1042_[71] net1036 VSS VSS VDD VDD u_core.u_top.u_core.acc[71] sky130_fd_sc_hd__dfrtp_1
Xu_core.u_top.u_core.acc[72]$_DFFE_PN0P_ clknet_1_0__leaf__11379_ _1042_[72] net1036 VSS VSS VDD VDD u_core.u_top.u_core.acc[72] sky130_fd_sc_hd__dfrtp_1
Xu_core.u_top.u_core.acc[73]$_DFFE_PN0P_ clknet_1_1__leaf__11379_ _1042_[73] net1036 VSS VSS VDD VDD u_core.u_top.u_core.acc[73] sky130_fd_sc_hd__dfrtp_1
Xu_core.u_top.u_core.acc[74]$_DFFE_PN0P_ clknet_1_0__leaf__11379_ _1042_[74] net1036 VSS VSS VDD VDD u_core.u_top.u_core.acc[74] sky130_fd_sc_hd__dfrtp_1
Xu_core.u_top.u_core.acc[75]$_DFFE_PN0P_ clknet_1_0__leaf__11379_ _1042_[75] net1036 VSS VSS VDD VDD u_core.u_top.u_core.acc[75] sky130_fd_sc_hd__dfrtp_1
Xu_core.u_top.u_core.acc[76]$_DFFE_PN0P_ clknet_1_1__leaf__11379_ _1042_[76] net1036 VSS VSS VDD VDD u_core.u_top.u_core.acc[76] sky130_fd_sc_hd__dfrtp_1
Xu_core.u_top.u_core.acc[77]$_DFFE_PN0P_ clknet_1_1__leaf__11379_ _1042_[77] net1036 VSS VSS VDD VDD u_core.u_top.u_core.acc[77] sky130_fd_sc_hd__dfrtp_1
Xu_core.u_top.u_core.acc[78]$_DFFE_PN0P_ clknet_1_1__leaf__11379_ _1042_[78] net1036 VSS VSS VDD VDD u_core.u_top.u_core.acc[78] sky130_fd_sc_hd__dfrtp_1
Xu_core.u_top.u_core.acc[79]$_DFFE_PN0P_ clknet_1_1__leaf__11379_ _1042_[79] net1036 VSS VSS VDD VDD u_core.u_top.u_core.acc[79] sky130_fd_sc_hd__dfrtp_1
Xu_core.u_top.u_core.acc[7]$_DFFE_PN0P_ clknet_1_0__leaf__11369_ _1042_[7] net1033 VSS VSS VDD VDD u_core.u_top.u_core.acc[7] sky130_fd_sc_hd__dfrtp_1
Xu_core.u_top.u_core.acc[80]$_DFFE_PN0P_ clknet_1_1__leaf__11394_ _1042_[80] net1015 VSS VSS VDD VDD u_core.u_top.u_core.acc[80] sky130_fd_sc_hd__dfrtp_1
Xu_core.u_top.u_core.acc[81]$_DFFE_PN0P_ clknet_1_1__leaf__11394_ _1042_[81] net1015 VSS VSS VDD VDD u_core.u_top.u_core.acc[81] sky130_fd_sc_hd__dfrtp_1
Xu_core.u_top.u_core.acc[82]$_DFFE_PN0P_ clknet_1_1__leaf__11394_ _1042_[82] net1015 VSS VSS VDD VDD u_core.u_top.u_core.acc[82] sky130_fd_sc_hd__dfrtp_1
Xu_core.u_top.u_core.acc[83]$_DFFE_PN0P_ clknet_1_0__leaf__11394_ _1042_[83] net1015 VSS VSS VDD VDD u_core.u_top.u_core.acc[83] sky130_fd_sc_hd__dfrtp_1
Xu_core.u_top.u_core.acc[84]$_DFFE_PN0P_ clknet_1_0__leaf__11394_ _1042_[84] net1015 VSS VSS VDD VDD u_core.u_top.u_core.acc[84] sky130_fd_sc_hd__dfrtp_1
Xu_core.u_top.u_core.acc[85]$_DFFE_PN0P_ clknet_1_0__leaf__11394_ _1042_[85] net1015 VSS VSS VDD VDD u_core.u_top.u_core.acc[85] sky130_fd_sc_hd__dfrtp_1
Xu_core.u_top.u_core.acc[86]$_DFFE_PN0P_ clknet_1_0__leaf__11394_ _1042_[86] net1015 VSS VSS VDD VDD u_core.u_top.u_core.acc[86] sky130_fd_sc_hd__dfrtp_1
Xu_core.u_top.u_core.acc[87]$_DFFE_PN0P_ clknet_1_1__leaf__11394_ _1042_[87] net1015 VSS VSS VDD VDD u_core.u_top.u_core.acc[87] sky130_fd_sc_hd__dfrtp_1
Xu_core.u_top.u_core.acc[88]$_DFFE_PN0P_ clknet_1_0__leaf__11394_ _1042_[88] net1015 VSS VSS VDD VDD u_core.u_top.u_core.acc[88] sky130_fd_sc_hd__dfrtp_1
Xu_core.u_top.u_core.acc[89]$_DFFE_PN0P_ clknet_1_1__leaf__11394_ _1042_[89] net1015 VSS VSS VDD VDD u_core.u_top.u_core.acc[89] sky130_fd_sc_hd__dfrtp_1
Xu_core.u_top.u_core.acc[8]$_DFFE_PN0P_ clknet_1_0__leaf__11369_ _1042_[8] net1033 VSS VSS VDD VDD u_core.u_top.u_core.acc[8] sky130_fd_sc_hd__dfrtp_1
Xu_core.u_top.u_core.acc[90]$_DFFE_PN0P_ clknet_1_1__leaf__11367_ _1042_[90] net1034 VSS VSS VDD VDD u_core.u_top.u_core.acc[90] sky130_fd_sc_hd__dfrtp_1
Xu_core.u_top.u_core.acc[91]$_DFFE_PN0P_ clknet_1_1__leaf__11367_ _1042_[91] net1034 VSS VSS VDD VDD u_core.u_top.u_core.acc[91] sky130_fd_sc_hd__dfrtp_1
Xu_core.u_top.u_core.acc[92]$_DFFE_PN0P_ clknet_1_1__leaf__11367_ _1042_[92] net1034 VSS VSS VDD VDD u_core.u_top.u_core.acc[92] sky130_fd_sc_hd__dfrtp_1
Xu_core.u_top.u_core.acc[93]$_DFFE_PN0P_ clknet_1_1__leaf__11367_ _1042_[93] net1034 VSS VSS VDD VDD u_core.u_top.u_core.acc[93] sky130_fd_sc_hd__dfrtp_1
Xu_core.u_top.u_core.acc[94]$_DFFE_PN0P_ clknet_1_1__leaf__11367_ _1042_[94] net1034 VSS VSS VDD VDD u_core.u_top.u_core.acc[94] sky130_fd_sc_hd__dfrtp_1
Xu_core.u_top.u_core.acc[95]$_DFFE_PN0P_ clknet_1_0__leaf__11367_ _1042_[95] net1034 VSS VSS VDD VDD u_core.u_top.u_core.acc[95] sky130_fd_sc_hd__dfrtp_1
Xu_core.u_top.u_core.acc[96]$_DFFE_PN0P_ clknet_1_0__leaf__11367_ _1042_[96] net1015 VSS VSS VDD VDD u_core.u_top.u_core.acc[96] sky130_fd_sc_hd__dfrtp_1
Xu_core.u_top.u_core.acc[97]$_DFFE_PN0P_ clknet_1_0__leaf__11367_ _1042_[97] net1015 VSS VSS VDD VDD u_core.u_top.u_core.acc[97] sky130_fd_sc_hd__dfrtp_1
Xu_core.u_top.u_core.acc[98]$_DFFE_PN0P_ clknet_1_0__leaf__11367_ _1042_[98] net1015 VSS VSS VDD VDD u_core.u_top.u_core.acc[98] sky130_fd_sc_hd__dfrtp_1
Xu_core.u_top.u_core.acc[99]$_DFFE_PN0P_ clknet_1_0__leaf__11367_ _1042_[99] net1015 VSS VSS VDD VDD u_core.u_top.u_core.acc[99] sky130_fd_sc_hd__dfrtp_1
Xu_core.u_top.u_core.acc[9]$_DFFE_PN0P_ clknet_1_0__leaf__11369_ _1042_[9] net1033 VSS VSS VDD VDD u_core.u_top.u_core.acc[9] sky130_fd_sc_hd__dfrtp_1
Xu_core.u_top.u_core.amp[0]$_DFFE_PN0P_ clknet_1_1__leaf__11356_ _1064_[0] net1029 VSS VSS VDD VDD u_core.u_top.u_core.amp[0] sky130_fd_sc_hd__dfrtp_1
Xu_core.u_top.u_core.amp[1]$_DFFE_PN0P_ clknet_1_1__leaf__11356_ _1064_[1] net1029 VSS VSS VDD VDD u_core.u_top.u_core.amp[1] sky130_fd_sc_hd__dfrtp_1
Xu_core.u_top.u_core.amp[2]$_DFFE_PN0P_ clknet_1_0__leaf__11356_ _1064_[2] net1029 VSS VSS VDD VDD u_core.u_top.u_core.amp[2] sky130_fd_sc_hd__dfrtp_1
Xu_core.u_top.u_core.amp[3]$_DFFE_PN0P_ clknet_1_0__leaf__11356_ _1064_[3] net1029 VSS VSS VDD VDD u_core.u_top.u_core.amp[3] sky130_fd_sc_hd__dfrtp_1
Xu_core.u_top.u_core.amp[4]$_DFFE_PN0P_ clknet_1_0__leaf__11356_ _1064_[4] net1029 VSS VSS VDD VDD u_core.u_top.u_core.amp[4] sky130_fd_sc_hd__dfrtp_1
Xu_core.u_top.u_core.d_acc[0]$_DFFE_PN0P_ clknet_1_0__leaf__11386_ _0226_[0] net1010 VSS VSS VDD VDD u_core.u_top.u_core.d_acc[0] sky130_fd_sc_hd__dfrtp_1
Xu_core.u_top.u_core.d_acc[100]$_DFFE_PN0P_ clknet_1_1__leaf__11368_ _0279_[0] net1002 VSS VSS VDD VDD u_core.u_top.u_core.d_acc[100] sky130_fd_sc_hd__dfrtp_1
Xu_core.u_top.u_core.d_acc[101]$_DFFE_PN0P_ clknet_1_1__leaf__11368_ _0279_[1] net1002 VSS VSS VDD VDD u_core.u_top.u_core.d_acc[101] sky130_fd_sc_hd__dfrtp_1
Xu_core.u_top.u_core.d_acc[102]$_DFFE_PN0P_ clknet_1_0__leaf__11368_ _0279_[2] net1002 VSS VSS VDD VDD u_core.u_top.u_core.d_acc[102] sky130_fd_sc_hd__dfrtp_1
Xu_core.u_top.u_core.d_acc[103]$_DFFE_PN0P_ clknet_1_0__leaf__11368_ _0279_[3] net1003 VSS VSS VDD VDD u_core.u_top.u_core.d_acc[103] sky130_fd_sc_hd__dfrtp_1
Xu_core.u_top.u_core.d_acc[104]$_DFFE_PN0P_ clknet_1_0__leaf__11368_ _0279_[4] net1003 VSS VSS VDD VDD u_core.u_top.u_core.d_acc[104] sky130_fd_sc_hd__dfrtp_1
Xu_core.u_top.u_core.d_acc[105]$_DFFE_PN0P_ clknet_1_0__leaf__11368_ _0279_[5] net1003 VSS VSS VDD VDD u_core.u_top.u_core.d_acc[105] sky130_fd_sc_hd__dfrtp_1
Xu_core.u_top.u_core.d_acc[106]$_DFFE_PN0P_ clknet_1_0__leaf__11368_ _0279_[6] net1003 VSS VSS VDD VDD u_core.u_top.u_core.d_acc[106] sky130_fd_sc_hd__dfrtp_1
Xu_core.u_top.u_core.d_acc[107]$_DFFE_PN0P_ clknet_1_1__leaf__11368_ _0279_[7] net1002 VSS VSS VDD VDD u_core.u_top.u_core.d_acc[107] sky130_fd_sc_hd__dfrtp_1
Xu_core.u_top.u_core.d_acc[108]$_DFFE_PN0P_ clknet_1_1__leaf__11368_ _0279_[8] net1002 VSS VSS VDD VDD u_core.u_top.u_core.d_acc[108] sky130_fd_sc_hd__dfrtp_1
Xu_core.u_top.u_core.d_acc[109]$_DFFE_PN0P_ clknet_1_1__leaf__11368_ _0279_[9] net1002 VSS VSS VDD VDD u_core.u_top.u_core.d_acc[109] sky130_fd_sc_hd__dfrtp_1
Xu_core.u_top.u_core.d_acc[10]$_DFFE_PN0P_ clknet_1_1__leaf__11403_ _0232_[0] net1012 VSS VSS VDD VDD u_core.u_top.u_core.d_acc[10] sky130_fd_sc_hd__dfrtp_1
Xu_core.u_top.u_core.d_acc[110]$_DFFE_PN0P_ clknet_1_1__leaf__11377_ _0284_[0] net1003 VSS VSS VDD VDD u_core.u_top.u_core.d_acc[110] sky130_fd_sc_hd__dfrtp_1
Xu_core.u_top.u_core.d_acc[111]$_DFFE_PN0P_ clknet_1_1__leaf__11377_ _0284_[1] net1003 VSS VSS VDD VDD u_core.u_top.u_core.d_acc[111] sky130_fd_sc_hd__dfrtp_1
Xu_core.u_top.u_core.d_acc[112]$_DFFE_PN0P_ clknet_1_0__leaf__11377_ _0284_[2] net1003 VSS VSS VDD VDD u_core.u_top.u_core.d_acc[112] sky130_fd_sc_hd__dfrtp_1
Xu_core.u_top.u_core.d_acc[113]$_DFFE_PN0P_ clknet_1_0__leaf__11377_ _0284_[3] net1003 VSS VSS VDD VDD u_core.u_top.u_core.d_acc[113] sky130_fd_sc_hd__dfrtp_1
Xu_core.u_top.u_core.d_acc[114]$_DFFE_PN0P_ clknet_1_0__leaf__11377_ _0284_[4] net1003 VSS VSS VDD VDD u_core.u_top.u_core.d_acc[114] sky130_fd_sc_hd__dfrtp_1
Xu_core.u_top.u_core.d_acc[115]$_DFFE_PN0P_ clknet_1_1__leaf__11377_ _0284_[5] net1003 VSS VSS VDD VDD u_core.u_top.u_core.d_acc[115] sky130_fd_sc_hd__dfrtp_1
Xu_core.u_top.u_core.d_acc[116]$_DFFE_PN0P_ clknet_1_1__leaf__11377_ _0284_[6] net1003 VSS VSS VDD VDD u_core.u_top.u_core.d_acc[116] sky130_fd_sc_hd__dfrtp_1
Xu_core.u_top.u_core.d_acc[117]$_DFFE_PN0P_ clknet_1_0__leaf__11377_ _0284_[7] net1003 VSS VSS VDD VDD u_core.u_top.u_core.d_acc[117] sky130_fd_sc_hd__dfrtp_1
Xu_core.u_top.u_core.d_acc[118]$_DFFE_PN0P_ clknet_1_1__leaf__11377_ _0284_[8] net1003 VSS VSS VDD VDD u_core.u_top.u_core.d_acc[118] sky130_fd_sc_hd__dfrtp_1
Xu_core.u_top.u_core.d_acc[119]$_DFFE_PN0P_ clknet_1_1__leaf__11377_ _0284_[9] net1003 VSS VSS VDD VDD u_core.u_top.u_core.d_acc[119] sky130_fd_sc_hd__dfrtp_1
Xu_core.u_top.u_core.d_acc[11]$_DFFE_PN0P_ clknet_1_1__leaf__11403_ _0232_[1] net1012 VSS VSS VDD VDD u_core.u_top.u_core.d_acc[11] sky130_fd_sc_hd__dfrtp_1
Xu_core.u_top.u_core.d_acc[120]$_DFFE_PN0P_ clknet_1_1__leaf__11376_ _0289_[0] net1005 VSS VSS VDD VDD u_core.u_top.u_core.d_acc[120] sky130_fd_sc_hd__dfrtp_1
Xu_core.u_top.u_core.d_acc[121]$_DFFE_PN0P_ clknet_1_1__leaf__11376_ _0289_[1] net1005 VSS VSS VDD VDD u_core.u_top.u_core.d_acc[121] sky130_fd_sc_hd__dfrtp_1
Xu_core.u_top.u_core.d_acc[122]$_DFFE_PN0P_ clknet_1_1__leaf__11376_ _0289_[2] net1003 VSS VSS VDD VDD u_core.u_top.u_core.d_acc[122] sky130_fd_sc_hd__dfrtp_1
Xu_core.u_top.u_core.d_acc[123]$_DFFE_PN0P_ clknet_1_0__leaf__11376_ _0289_[3] net1003 VSS VSS VDD VDD u_core.u_top.u_core.d_acc[123] sky130_fd_sc_hd__dfrtp_1
Xu_core.u_top.u_core.d_acc[124]$_DFFE_PN0P_ clknet_1_0__leaf__11376_ _0289_[4] net1003 VSS VSS VDD VDD u_core.u_top.u_core.d_acc[124] sky130_fd_sc_hd__dfrtp_1
Xu_core.u_top.u_core.d_acc[125]$_DFFE_PN0P_ clknet_1_0__leaf__11376_ _0289_[5] net1003 VSS VSS VDD VDD u_core.u_top.u_core.d_acc[125] sky130_fd_sc_hd__dfrtp_1
Xu_core.u_top.u_core.d_acc[126]$_DFFE_PN0P_ clknet_1_0__leaf__11376_ _0289_[6] net1003 VSS VSS VDD VDD u_core.u_top.u_core.d_acc[126] sky130_fd_sc_hd__dfrtp_1
Xu_core.u_top.u_core.d_acc[127]$_DFFE_PN0P_ clknet_1_0__leaf__11376_ _0289_[7] net1003 VSS VSS VDD VDD u_core.u_top.u_core.d_acc[127] sky130_fd_sc_hd__dfrtp_1
Xu_core.u_top.u_core.d_acc[128]$_DFFE_PN0P_ clknet_1_1__leaf__11376_ _0289_[8] net1005 VSS VSS VDD VDD u_core.u_top.u_core.d_acc[128] sky130_fd_sc_hd__dfrtp_1
Xu_core.u_top.u_core.d_acc[129]$_DFFE_PN0P_ clknet_1_1__leaf__11376_ _0289_[9] net1005 VSS VSS VDD VDD u_core.u_top.u_core.d_acc[129] sky130_fd_sc_hd__dfrtp_1
Xu_core.u_top.u_core.d_acc[12]$_DFFE_PN0P_ clknet_1_1__leaf__11403_ _0232_[2] net1012 VSS VSS VDD VDD u_core.u_top.u_core.d_acc[12] sky130_fd_sc_hd__dfrtp_1
Xu_core.u_top.u_core.d_acc[130]$_DFFE_PN0P_ clknet_1_1__leaf__11393_ _0294_[0] net1004 VSS VSS VDD VDD u_core.u_top.u_core.d_acc[130] sky130_fd_sc_hd__dfrtp_1
Xu_core.u_top.u_core.d_acc[131]$_DFFE_PN0P_ clknet_1_1__leaf__11393_ _0294_[1] net1004 VSS VSS VDD VDD u_core.u_top.u_core.d_acc[131] sky130_fd_sc_hd__dfrtp_1
Xu_core.u_top.u_core.d_acc[132]$_DFFE_PN0P_ clknet_1_1__leaf__11393_ _0294_[2] net1004 VSS VSS VDD VDD u_core.u_top.u_core.d_acc[132] sky130_fd_sc_hd__dfrtp_1
Xu_core.u_top.u_core.d_acc[133]$_DFFE_PN0P_ clknet_1_0__leaf__11393_ _0294_[3] net1005 VSS VSS VDD VDD u_core.u_top.u_core.d_acc[133] sky130_fd_sc_hd__dfrtp_1
Xu_core.u_top.u_core.d_acc[134]$_DFFE_PN0P_ clknet_1_0__leaf__11393_ _0294_[4] net1005 VSS VSS VDD VDD u_core.u_top.u_core.d_acc[134] sky130_fd_sc_hd__dfrtp_1
Xu_core.u_top.u_core.d_acc[135]$_DFFE_PN0P_ clknet_1_0__leaf__11393_ _0294_[5] net1005 VSS VSS VDD VDD u_core.u_top.u_core.d_acc[135] sky130_fd_sc_hd__dfrtp_1
Xu_core.u_top.u_core.d_acc[136]$_DFFE_PN0P_ clknet_1_0__leaf__11393_ _0294_[6] net1005 VSS VSS VDD VDD u_core.u_top.u_core.d_acc[136] sky130_fd_sc_hd__dfrtp_1
Xu_core.u_top.u_core.d_acc[137]$_DFFE_PN0P_ clknet_1_0__leaf__11393_ _0294_[7] net1004 VSS VSS VDD VDD u_core.u_top.u_core.d_acc[137] sky130_fd_sc_hd__dfrtp_1
Xu_core.u_top.u_core.d_acc[138]$_DFFE_PN0P_ clknet_1_1__leaf__11393_ _0294_[8] net1004 VSS VSS VDD VDD u_core.u_top.u_core.d_acc[138] sky130_fd_sc_hd__dfrtp_1
Xu_core.u_top.u_core.d_acc[139]$_DFFE_PN0P_ clknet_1_0__leaf__11393_ _0294_[9] net1004 VSS VSS VDD VDD u_core.u_top.u_core.d_acc[139] sky130_fd_sc_hd__dfrtp_1
Xu_core.u_top.u_core.d_acc[13]$_DFFE_PN0P_ clknet_1_1__leaf__11403_ _0232_[3] net1012 VSS VSS VDD VDD u_core.u_top.u_core.d_acc[13] sky130_fd_sc_hd__dfrtp_1
Xu_core.u_top.u_core.d_acc[140]$_DFFE_PN0P_ clknet_1_0__leaf__11391_ _0300_[0] net1004 VSS VSS VDD VDD u_core.u_top.u_core.d_acc[140] sky130_fd_sc_hd__dfrtp_1
Xu_core.u_top.u_core.d_acc[141]$_DFFE_PN0P_ clknet_1_0__leaf__11391_ _0300_[1] net1004 VSS VSS VDD VDD u_core.u_top.u_core.d_acc[141] sky130_fd_sc_hd__dfrtp_1
Xu_core.u_top.u_core.d_acc[142]$_DFFE_PN0P_ clknet_1_0__leaf__11391_ _0300_[2] net1004 VSS VSS VDD VDD u_core.u_top.u_core.d_acc[142] sky130_fd_sc_hd__dfrtp_1
Xu_core.u_top.u_core.d_acc[143]$_DFFE_PN0P_ clknet_1_0__leaf__11391_ _0300_[3] net1004 VSS VSS VDD VDD u_core.u_top.u_core.d_acc[143] sky130_fd_sc_hd__dfrtp_1
Xu_core.u_top.u_core.d_acc[144]$_DFFE_PN0P_ clknet_1_0__leaf__11391_ _0300_[4] net1004 VSS VSS VDD VDD u_core.u_top.u_core.d_acc[144] sky130_fd_sc_hd__dfrtp_1
Xu_core.u_top.u_core.d_acc[145]$_DFFE_PN0P_ clknet_1_1__leaf__11391_ _0300_[5] net1004 VSS VSS VDD VDD u_core.u_top.u_core.d_acc[145] sky130_fd_sc_hd__dfrtp_1
Xu_core.u_top.u_core.d_acc[146]$_DFFE_PN0P_ clknet_1_1__leaf__11391_ _0300_[6] net1004 VSS VSS VDD VDD u_core.u_top.u_core.d_acc[146] sky130_fd_sc_hd__dfrtp_1
Xu_core.u_top.u_core.d_acc[147]$_DFFE_PN0P_ clknet_1_1__leaf__11391_ _0300_[7] net1004 VSS VSS VDD VDD u_core.u_top.u_core.d_acc[147] sky130_fd_sc_hd__dfrtp_1
Xu_core.u_top.u_core.d_acc[148]$_DFFE_PN0P_ clknet_1_1__leaf__11391_ _0300_[8] net1004 VSS VSS VDD VDD u_core.u_top.u_core.d_acc[148] sky130_fd_sc_hd__dfrtp_1
Xu_core.u_top.u_core.d_acc[149]$_DFFE_PN0P_ clknet_1_0__leaf__11391_ _0300_[9] net1004 VSS VSS VDD VDD u_core.u_top.u_core.d_acc[149] sky130_fd_sc_hd__dfrtp_1
Xu_core.u_top.u_core.d_acc[14]$_DFFE_PN0P_ clknet_1_1__leaf__11403_ _0232_[4] net1012 VSS VSS VDD VDD u_core.u_top.u_core.d_acc[14] sky130_fd_sc_hd__dfrtp_1
Xu_core.u_top.u_core.d_acc[150]$_DFFE_PN0P_ clknet_1_0__leaf__11363_ _0306_[0] net1004 VSS VSS VDD VDD u_core.u_top.u_core.d_acc[150] sky130_fd_sc_hd__dfrtp_1
Xu_core.u_top.u_core.d_acc[151]$_DFFE_PN0P_ clknet_1_0__leaf__11363_ _0306_[1] net1004 VSS VSS VDD VDD u_core.u_top.u_core.d_acc[151] sky130_fd_sc_hd__dfrtp_1
Xu_core.u_top.u_core.d_acc[152]$_DFFE_PN0P_ clknet_1_0__leaf__11363_ _0306_[2] net1004 VSS VSS VDD VDD u_core.u_top.u_core.d_acc[152] sky130_fd_sc_hd__dfrtp_1
Xu_core.u_top.u_core.d_acc[153]$_DFFE_PN0P_ clknet_1_0__leaf__11363_ _0306_[3] net1004 VSS VSS VDD VDD u_core.u_top.u_core.d_acc[153] sky130_fd_sc_hd__dfrtp_1
Xu_core.u_top.u_core.d_acc[154]$_DFFE_PN0P_ clknet_1_0__leaf__11363_ _0306_[4] net1014 VSS VSS VDD VDD u_core.u_top.u_core.d_acc[154] sky130_fd_sc_hd__dfrtp_1
Xu_core.u_top.u_core.d_acc[155]$_DFFE_PN0P_ clknet_1_1__leaf__11363_ _0306_[5] net1014 VSS VSS VDD VDD u_core.u_top.u_core.d_acc[155] sky130_fd_sc_hd__dfrtp_1
Xu_core.u_top.u_core.d_acc[156]$_DFFE_PN0P_ clknet_1_1__leaf__11363_ _0306_[6] net1014 VSS VSS VDD VDD u_core.u_top.u_core.d_acc[156] sky130_fd_sc_hd__dfrtp_1
Xu_core.u_top.u_core.d_acc[157]$_DFFE_PN0P_ clknet_1_1__leaf__11363_ _0306_[7] net1014 VSS VSS VDD VDD u_core.u_top.u_core.d_acc[157] sky130_fd_sc_hd__dfrtp_1
Xu_core.u_top.u_core.d_acc[158]$_DFFE_PN0P_ clknet_1_1__leaf__11363_ _0306_[8] net1014 VSS VSS VDD VDD u_core.u_top.u_core.d_acc[158] sky130_fd_sc_hd__dfrtp_1
Xu_core.u_top.u_core.d_acc[159]$_DFFE_PN0P_ clknet_1_0__leaf__11363_ _0306_[9] net1014 VSS VSS VDD VDD u_core.u_top.u_core.d_acc[159] sky130_fd_sc_hd__dfrtp_1
Xu_core.u_top.u_core.d_acc[15]$_DFFE_PN0P_ clknet_1_0__leaf__11403_ _0232_[5] net1012 VSS VSS VDD VDD u_core.u_top.u_core.d_acc[15] sky130_fd_sc_hd__dfrtp_1
Xu_core.u_top.u_core.d_acc[160]$_DFFE_PN0P_ clknet_1_1__leaf__11374_ _0311_[0] net1013 VSS VSS VDD VDD u_core.u_top.u_core.d_acc[160] sky130_fd_sc_hd__dfrtp_1
Xu_core.u_top.u_core.d_acc[161]$_DFFE_PN0P_ clknet_1_1__leaf__11374_ _0311_[1] net1013 VSS VSS VDD VDD u_core.u_top.u_core.d_acc[161] sky130_fd_sc_hd__dfrtp_1
Xu_core.u_top.u_core.d_acc[162]$_DFFE_PN0P_ clknet_1_1__leaf__11374_ _0311_[2] net1013 VSS VSS VDD VDD u_core.u_top.u_core.d_acc[162] sky130_fd_sc_hd__dfrtp_1
Xu_core.u_top.u_core.d_acc[163]$_DFFE_PN0P_ clknet_1_1__leaf__11374_ _0311_[3] net1013 VSS VSS VDD VDD u_core.u_top.u_core.d_acc[163] sky130_fd_sc_hd__dfrtp_1
Xu_core.u_top.u_core.d_acc[164]$_DFFE_PN0P_ clknet_1_0__leaf__11374_ _0311_[4] net1013 VSS VSS VDD VDD u_core.u_top.u_core.d_acc[164] sky130_fd_sc_hd__dfrtp_1
Xu_core.u_top.u_core.d_acc[165]$_DFFE_PN0P_ clknet_1_0__leaf__11374_ _0311_[5] net1013 VSS VSS VDD VDD u_core.u_top.u_core.d_acc[165] sky130_fd_sc_hd__dfrtp_1
Xu_core.u_top.u_core.d_acc[166]$_DFFE_PN0P_ clknet_1_1__leaf__11374_ _0311_[6] net1012 VSS VSS VDD VDD u_core.u_top.u_core.d_acc[166] sky130_fd_sc_hd__dfrtp_1
Xu_core.u_top.u_core.d_acc[167]$_DFFE_PN0P_ clknet_1_0__leaf__11374_ _0311_[7] net1013 VSS VSS VDD VDD u_core.u_top.u_core.d_acc[167] sky130_fd_sc_hd__dfrtp_1
Xu_core.u_top.u_core.d_acc[168]$_DFFE_PN0P_ clknet_1_0__leaf__11374_ _0311_[8] net1013 VSS VSS VDD VDD u_core.u_top.u_core.d_acc[168] sky130_fd_sc_hd__dfrtp_1
Xu_core.u_top.u_core.d_acc[169]$_DFFE_PN0P_ clknet_1_0__leaf__11374_ _0311_[9] net1013 VSS VSS VDD VDD u_core.u_top.u_core.d_acc[169] sky130_fd_sc_hd__dfrtp_1
Xu_core.u_top.u_core.d_acc[16]$_DFFE_PN0P_ clknet_1_0__leaf__11403_ _0232_[6] net1012 VSS VSS VDD VDD u_core.u_top.u_core.d_acc[16] sky130_fd_sc_hd__dfrtp_1
Xu_core.u_top.u_core.d_acc[170]$_DFFE_PN0P_ clknet_1_1__leaf__11373_ _0316_[0] net1010 VSS VSS VDD VDD u_core.u_top.u_core.d_acc[170] sky130_fd_sc_hd__dfrtp_1
Xu_core.u_top.u_core.d_acc[171]$_DFFE_PN0P_ clknet_1_1__leaf__11373_ _0316_[1] net1010 VSS VSS VDD VDD u_core.u_top.u_core.d_acc[171] sky130_fd_sc_hd__dfrtp_1
Xu_core.u_top.u_core.d_acc[172]$_DFFE_PN0P_ clknet_1_1__leaf__11373_ _0316_[2] net1010 VSS VSS VDD VDD u_core.u_top.u_core.d_acc[172] sky130_fd_sc_hd__dfrtp_1
Xu_core.u_top.u_core.d_acc[173]$_DFFE_PN0P_ clknet_1_1__leaf__11373_ _0316_[3] net1013 VSS VSS VDD VDD u_core.u_top.u_core.d_acc[173] sky130_fd_sc_hd__dfrtp_1
Xu_core.u_top.u_core.d_acc[174]$_DFFE_PN0P_ clknet_1_0__leaf__11373_ _0316_[4] net1013 VSS VSS VDD VDD u_core.u_top.u_core.d_acc[174] sky130_fd_sc_hd__dfrtp_1
Xu_core.u_top.u_core.d_acc[175]$_DFFE_PN0P_ clknet_1_0__leaf__11373_ _0316_[5] net1013 VSS VSS VDD VDD u_core.u_top.u_core.d_acc[175] sky130_fd_sc_hd__dfrtp_1
Xu_core.u_top.u_core.d_acc[176]$_DFFE_PN0P_ clknet_1_0__leaf__11373_ _0316_[6] net1013 VSS VSS VDD VDD u_core.u_top.u_core.d_acc[176] sky130_fd_sc_hd__dfrtp_1
Xu_core.u_top.u_core.d_acc[177]$_DFFE_PN0P_ clknet_1_0__leaf__11373_ _0316_[7] net1013 VSS VSS VDD VDD u_core.u_top.u_core.d_acc[177] sky130_fd_sc_hd__dfrtp_1
Xu_core.u_top.u_core.d_acc[178]$_DFFE_PN0P_ clknet_1_0__leaf__11373_ _0316_[8] net1013 VSS VSS VDD VDD u_core.u_top.u_core.d_acc[178] sky130_fd_sc_hd__dfrtp_1
Xu_core.u_top.u_core.d_acc[179]$_DFFE_PN0P_ clknet_1_0__leaf__11373_ _0316_[9] net1013 VSS VSS VDD VDD u_core.u_top.u_core.d_acc[179] sky130_fd_sc_hd__dfrtp_1
Xu_core.u_top.u_core.d_acc[17]$_DFFE_PN0P_ clknet_1_0__leaf__11403_ _0232_[7] net1012 VSS VSS VDD VDD u_core.u_top.u_core.d_acc[17] sky130_fd_sc_hd__dfrtp_1
Xu_core.u_top.u_core.d_acc[180]$_DFFE_PN0P_ clknet_1_1__leaf__11387_ _0322_[0] net1010 VSS VSS VDD VDD u_core.u_top.u_core.d_acc[180] sky130_fd_sc_hd__dfrtp_1
Xu_core.u_top.u_core.d_acc[181]$_DFFE_PN0P_ clknet_1_1__leaf__11387_ _0322_[1] net1010 VSS VSS VDD VDD u_core.u_top.u_core.d_acc[181] sky130_fd_sc_hd__dfrtp_1
Xu_core.u_top.u_core.d_acc[182]$_DFFE_PN0P_ clknet_1_1__leaf__11387_ _0322_[2] net1010 VSS VSS VDD VDD u_core.u_top.u_core.d_acc[182] sky130_fd_sc_hd__dfrtp_1
Xu_core.u_top.u_core.d_acc[183]$_DFFE_PN0P_ clknet_1_1__leaf__11387_ _0322_[3] net1011 VSS VSS VDD VDD u_core.u_top.u_core.d_acc[183] sky130_fd_sc_hd__dfrtp_1
Xu_core.u_top.u_core.d_acc[184]$_DFFE_PN0P_ clknet_1_1__leaf__11387_ _0322_[4] net1011 VSS VSS VDD VDD u_core.u_top.u_core.d_acc[184] sky130_fd_sc_hd__dfrtp_1
Xu_core.u_top.u_core.d_acc[185]$_DFFE_PN0P_ clknet_1_0__leaf__11387_ _0322_[5] net1011 VSS VSS VDD VDD u_core.u_top.u_core.d_acc[185] sky130_fd_sc_hd__dfrtp_1
Xu_core.u_top.u_core.d_acc[186]$_DFFE_PN0P_ clknet_1_0__leaf__11387_ _0322_[6] net1011 VSS VSS VDD VDD u_core.u_top.u_core.d_acc[186] sky130_fd_sc_hd__dfrtp_1
Xu_core.u_top.u_core.d_acc[187]$_DFFE_PN0P_ clknet_1_0__leaf__11387_ _0322_[7] net1013 VSS VSS VDD VDD u_core.u_top.u_core.d_acc[187] sky130_fd_sc_hd__dfrtp_1
Xu_core.u_top.u_core.d_acc[188]$_DFFE_PN0P_ clknet_1_0__leaf__11387_ _0322_[8] net1013 VSS VSS VDD VDD u_core.u_top.u_core.d_acc[188] sky130_fd_sc_hd__dfrtp_1
Xu_core.u_top.u_core.d_acc[189]$_DFFE_PN0P_ clknet_1_1__leaf__11387_ _0322_[9] net1011 VSS VSS VDD VDD u_core.u_top.u_core.d_acc[189] sky130_fd_sc_hd__dfrtp_1
Xu_core.u_top.u_core.d_acc[18]$_DFFE_PN0P_ clknet_1_0__leaf__11403_ _0232_[8] net1012 VSS VSS VDD VDD u_core.u_top.u_core.d_acc[18] sky130_fd_sc_hd__dfrtp_1
Xu_core.u_top.u_core.d_acc[190]$_DFFE_PN0P_ clknet_1_1__leaf__11385_ _0327_[0] net1014 VSS VSS VDD VDD u_core.u_top.u_core.d_acc[190] sky130_fd_sc_hd__dfrtp_1
Xu_core.u_top.u_core.d_acc[191]$_DFFE_PN0P_ clknet_1_1__leaf__11385_ _0327_[1] net1014 VSS VSS VDD VDD u_core.u_top.u_core.d_acc[191] sky130_fd_sc_hd__dfrtp_1
Xu_core.u_top.u_core.d_acc[192]$_DFFE_PN0P_ clknet_1_1__leaf__11385_ _0327_[2] net1014 VSS VSS VDD VDD u_core.u_top.u_core.d_acc[192] sky130_fd_sc_hd__dfrtp_1
Xu_core.u_top.u_core.d_acc[193]$_DFFE_PN0P_ clknet_1_1__leaf__11385_ _0327_[3] net1014 VSS VSS VDD VDD u_core.u_top.u_core.d_acc[193] sky130_fd_sc_hd__dfrtp_1
Xu_core.u_top.u_core.d_acc[194]$_DFFE_PN0P_ clknet_1_1__leaf__11385_ _0327_[4] net1014 VSS VSS VDD VDD u_core.u_top.u_core.d_acc[194] sky130_fd_sc_hd__dfrtp_1
Xu_core.u_top.u_core.d_acc[195]$_DFFE_PN0P_ clknet_1_1__leaf__11385_ _0327_[5] net1014 VSS VSS VDD VDD u_core.u_top.u_core.d_acc[195] sky130_fd_sc_hd__dfrtp_1
Xu_core.u_top.u_core.d_acc[196]$_DFFE_PN0P_ clknet_1_0__leaf__11385_ _0327_[6] net1004 VSS VSS VDD VDD u_core.u_top.u_core.d_acc[196] sky130_fd_sc_hd__dfrtp_1
Xu_core.u_top.u_core.d_acc[197]$_DFFE_PN0P_ clknet_1_0__leaf__11385_ _0327_[7] net1004 VSS VSS VDD VDD u_core.u_top.u_core.d_acc[197] sky130_fd_sc_hd__dfrtp_1
Xu_core.u_top.u_core.d_acc[198]$_DFFE_PN0P_ clknet_1_0__leaf__11385_ _0327_[8] net1004 VSS VSS VDD VDD u_core.u_top.u_core.d_acc[198] sky130_fd_sc_hd__dfrtp_1
Xu_core.u_top.u_core.d_acc[199]$_DFFE_PN0P_ clknet_1_0__leaf__11385_ _0327_[9] net1004 VSS VSS VDD VDD u_core.u_top.u_core.d_acc[199] sky130_fd_sc_hd__dfrtp_1
Xu_core.u_top.u_core.d_acc[19]$_DFFE_PN0P_ clknet_1_0__leaf__11403_ _0232_[9] net1012 VSS VSS VDD VDD u_core.u_top.u_core.d_acc[19] sky130_fd_sc_hd__dfrtp_1
Xu_core.u_top.u_core.d_acc[1]$_DFFE_PN0P_ clknet_1_0__leaf__11386_ _0226_[1] net1010 VSS VSS VDD VDD u_core.u_top.u_core.d_acc[1] sky130_fd_sc_hd__dfrtp_1
Xu_core.u_top.u_core.d_acc[200]$_DFFE_PN0P_ clknet_1_1__leaf__11362_ _0333_[0] net1002 VSS VSS VDD VDD u_core.u_top.u_core.d_acc[200] sky130_fd_sc_hd__dfrtp_1
Xu_core.u_top.u_core.d_acc[201]$_DFFE_PN0P_ clknet_1_1__leaf__11362_ _0333_[1] net1002 VSS VSS VDD VDD u_core.u_top.u_core.d_acc[201] sky130_fd_sc_hd__dfrtp_1
Xu_core.u_top.u_core.d_acc[202]$_DFFE_PN0P_ clknet_1_1__leaf__11362_ _0333_[2] net1002 VSS VSS VDD VDD u_core.u_top.u_core.d_acc[202] sky130_fd_sc_hd__dfrtp_1
Xu_core.u_top.u_core.d_acc[203]$_DFFE_PN0P_ clknet_1_1__leaf__11362_ _0333_[3] net1002 VSS VSS VDD VDD u_core.u_top.u_core.d_acc[203] sky130_fd_sc_hd__dfrtp_1
Xu_core.u_top.u_core.d_acc[204]$_DFFE_PN0P_ clknet_1_1__leaf__11362_ _0333_[4] net1002 VSS VSS VDD VDD u_core.u_top.u_core.d_acc[204] sky130_fd_sc_hd__dfrtp_1
Xu_core.u_top.u_core.d_acc[205]$_DFFE_PN0P_ clknet_1_1__leaf__11362_ _0333_[5] net1002 VSS VSS VDD VDD u_core.u_top.u_core.d_acc[205] sky130_fd_sc_hd__dfrtp_1
Xu_core.u_top.u_core.d_acc[206]$_DFFE_PN0P_ clknet_1_0__leaf__11362_ _0333_[6] net1002 VSS VSS VDD VDD u_core.u_top.u_core.d_acc[206] sky130_fd_sc_hd__dfrtp_1
Xu_core.u_top.u_core.d_acc[207]$_DFFE_PN0P_ clknet_1_0__leaf__11362_ _0333_[7] net1002 VSS VSS VDD VDD u_core.u_top.u_core.d_acc[207] sky130_fd_sc_hd__dfrtp_1
Xu_core.u_top.u_core.d_acc[208]$_DFFE_PN0P_ clknet_1_0__leaf__11362_ _0333_[8] net1002 VSS VSS VDD VDD u_core.u_top.u_core.d_acc[208] sky130_fd_sc_hd__dfrtp_1
Xu_core.u_top.u_core.d_acc[209]$_DFFE_PN0P_ clknet_1_0__leaf__11362_ _0333_[9] net1002 VSS VSS VDD VDD u_core.u_top.u_core.d_acc[209] sky130_fd_sc_hd__dfrtp_1
Xu_core.u_top.u_core.d_acc[20]$_DFFE_PN0P_ clknet_1_0__leaf__11416_ _0238_[0] net1013 VSS VSS VDD VDD u_core.u_top.u_core.d_acc[20] sky130_fd_sc_hd__dfrtp_1
Xu_core.u_top.u_core.d_acc[210]$_DFFE_PN0P_ clknet_1_0__leaf__11371_ _0338_[0] net1002 VSS VSS VDD VDD u_core.u_top.u_core.d_acc[210] sky130_fd_sc_hd__dfrtp_1
Xu_core.u_top.u_core.d_acc[211]$_DFFE_PN0P_ clknet_1_0__leaf__11371_ _0338_[1] net1002 VSS VSS VDD VDD u_core.u_top.u_core.d_acc[211] sky130_fd_sc_hd__dfrtp_1
Xu_core.u_top.u_core.d_acc[212]$_DFFE_PN0P_ clknet_1_1__leaf__11371_ _0338_[2] net1002 VSS VSS VDD VDD u_core.u_top.u_core.d_acc[212] sky130_fd_sc_hd__dfrtp_1
Xu_core.u_top.u_core.d_acc[213]$_DFFE_PN0P_ clknet_1_0__leaf__11371_ _0338_[3] net1002 VSS VSS VDD VDD u_core.u_top.u_core.d_acc[213] sky130_fd_sc_hd__dfrtp_1
Xu_core.u_top.u_core.d_acc[214]$_DFFE_PN0P_ clknet_1_0__leaf__11371_ _0338_[4] net1002 VSS VSS VDD VDD u_core.u_top.u_core.d_acc[214] sky130_fd_sc_hd__dfrtp_1
Xu_core.u_top.u_core.d_acc[215]$_DFFE_PN0P_ clknet_1_0__leaf__11371_ _0338_[5] net1002 VSS VSS VDD VDD u_core.u_top.u_core.d_acc[215] sky130_fd_sc_hd__dfrtp_1
Xu_core.u_top.u_core.d_acc[216]$_DFFE_PN0P_ clknet_1_1__leaf__11371_ _0338_[6] net1004 VSS VSS VDD VDD u_core.u_top.u_core.d_acc[216] sky130_fd_sc_hd__dfrtp_1
Xu_core.u_top.u_core.d_acc[217]$_DFFE_PN0P_ clknet_1_1__leaf__11371_ _0338_[7] net1004 VSS VSS VDD VDD u_core.u_top.u_core.d_acc[217] sky130_fd_sc_hd__dfrtp_1
Xu_core.u_top.u_core.d_acc[218]$_DFFE_PN0P_ clknet_1_0__leaf__11371_ _0338_[8] net1004 VSS VSS VDD VDD u_core.u_top.u_core.d_acc[218] sky130_fd_sc_hd__dfrtp_1
Xu_core.u_top.u_core.d_acc[219]$_DFFE_PN0P_ clknet_1_1__leaf__11371_ _0338_[9] net1004 VSS VSS VDD VDD u_core.u_top.u_core.d_acc[219] sky130_fd_sc_hd__dfrtp_1
Xu_core.u_top.u_core.d_acc[21]$_DFFE_PN0P_ clknet_1_0__leaf__11416_ _0238_[1] net1013 VSS VSS VDD VDD u_core.u_top.u_core.d_acc[21] sky130_fd_sc_hd__dfrtp_1
Xu_core.u_top.u_core.d_acc[220]$_DFFE_PN0P_ clknet_1_0__leaf__11370_ _0344_[0] net1002 VSS VSS VDD VDD u_core.u_top.u_core.d_acc[220] sky130_fd_sc_hd__dfrtp_1
Xu_core.u_top.u_core.d_acc[221]$_DFFE_PN0P_ clknet_1_0__leaf__11370_ _0344_[1] net1002 VSS VSS VDD VDD u_core.u_top.u_core.d_acc[221] sky130_fd_sc_hd__dfrtp_1
Xu_core.u_top.u_core.d_acc[222]$_DFFE_PN0P_ clknet_1_0__leaf__11370_ _0344_[2] net1002 VSS VSS VDD VDD u_core.u_top.u_core.d_acc[222] sky130_fd_sc_hd__dfrtp_1
Xu_core.u_top.u_core.d_acc[223]$_DFFE_PN0P_ clknet_1_1__leaf__11370_ _0344_[3] net1002 VSS VSS VDD VDD u_core.u_top.u_core.d_acc[223] sky130_fd_sc_hd__dfrtp_1
Xu_core.u_top.u_core.d_acc[224]$_DFFE_PN0P_ clknet_1_0__leaf__11370_ _0344_[4] net1002 VSS VSS VDD VDD u_core.u_top.u_core.d_acc[224] sky130_fd_sc_hd__dfrtp_1
Xu_core.u_top.u_core.d_acc[225]$_DFFE_PN0P_ clknet_1_0__leaf__11370_ _0344_[5] net1002 VSS VSS VDD VDD u_core.u_top.u_core.d_acc[225] sky130_fd_sc_hd__dfrtp_1
Xu_core.u_top.u_core.d_acc[226]$_DFFE_PN0P_ clknet_1_1__leaf__11370_ _0344_[6] net1002 VSS VSS VDD VDD u_core.u_top.u_core.d_acc[226] sky130_fd_sc_hd__dfrtp_1
Xu_core.u_top.u_core.d_acc[227]$_DFFE_PN0P_ clknet_1_1__leaf__11370_ _0344_[7] net1002 VSS VSS VDD VDD u_core.u_top.u_core.d_acc[227] sky130_fd_sc_hd__dfrtp_1
Xu_core.u_top.u_core.d_acc[228]$_DFFE_PN0P_ clknet_1_1__leaf__11370_ _0344_[8] net1002 VSS VSS VDD VDD u_core.u_top.u_core.d_acc[228] sky130_fd_sc_hd__dfrtp_1
Xu_core.u_top.u_core.d_acc[229]$_DFFE_PN0P_ clknet_1_1__leaf__11370_ _0344_[9] net1002 VSS VSS VDD VDD u_core.u_top.u_core.d_acc[229] sky130_fd_sc_hd__dfrtp_1
Xu_core.u_top.u_core.d_acc[22]$_DFFE_PN0P_ clknet_1_1__leaf__11416_ _0238_[2] net1014 VSS VSS VDD VDD u_core.u_top.u_core.d_acc[22] sky130_fd_sc_hd__dfrtp_1
Xu_core.u_top.u_core.d_acc[230]$_DFFE_PN0P_ clknet_1_1__leaf__11382_ _0349_[0] net1003 VSS VSS VDD VDD u_core.u_top.u_core.d_acc[230] sky130_fd_sc_hd__dfrtp_1
Xu_core.u_top.u_core.d_acc[231]$_DFFE_PN0P_ clknet_1_0__leaf__11382_ _0349_[1] net1003 VSS VSS VDD VDD u_core.u_top.u_core.d_acc[231] sky130_fd_sc_hd__dfrtp_1
Xu_core.u_top.u_core.d_acc[232]$_DFFE_PN0P_ clknet_1_1__leaf__11382_ _0349_[2] net1003 VSS VSS VDD VDD u_core.u_top.u_core.d_acc[232] sky130_fd_sc_hd__dfrtp_1
Xu_core.u_top.u_core.d_acc[233]$_DFFE_PN0P_ clknet_1_1__leaf__11382_ _0349_[3] net1003 VSS VSS VDD VDD u_core.u_top.u_core.d_acc[233] sky130_fd_sc_hd__dfrtp_1
Xu_core.u_top.u_core.d_acc[234]$_DFFE_PN0P_ clknet_1_1__leaf__11382_ _0349_[4] net1003 VSS VSS VDD VDD u_core.u_top.u_core.d_acc[234] sky130_fd_sc_hd__dfrtp_1
Xu_core.u_top.u_core.d_acc[235]$_DFFE_PN0P_ clknet_1_1__leaf__11382_ _0349_[5] net1003 VSS VSS VDD VDD u_core.u_top.u_core.d_acc[235] sky130_fd_sc_hd__dfrtp_1
Xu_core.u_top.u_core.d_acc[236]$_DFFE_PN0P_ clknet_1_0__leaf__11382_ _0349_[6] net1001 VSS VSS VDD VDD u_core.u_top.u_core.d_acc[236] sky130_fd_sc_hd__dfrtp_1
Xu_core.u_top.u_core.d_acc[237]$_DFFE_PN0P_ clknet_1_1__leaf__11382_ _0349_[7] net1001 VSS VSS VDD VDD u_core.u_top.u_core.d_acc[237] sky130_fd_sc_hd__dfrtp_1
Xu_core.u_top.u_core.d_acc[238]$_DFFE_PN0P_ clknet_1_0__leaf__11382_ _0349_[8] net1001 VSS VSS VDD VDD u_core.u_top.u_core.d_acc[238] sky130_fd_sc_hd__dfrtp_1
Xu_core.u_top.u_core.d_acc[239]$_DFFE_PN0P_ clknet_1_0__leaf__11382_ _0349_[9] net1001 VSS VSS VDD VDD u_core.u_top.u_core.d_acc[239] sky130_fd_sc_hd__dfrtp_1
Xu_core.u_top.u_core.d_acc[23]$_DFFE_PN0P_ clknet_1_1__leaf__11416_ _0238_[3] net1014 VSS VSS VDD VDD u_core.u_top.u_core.d_acc[23] sky130_fd_sc_hd__dfrtp_1
Xu_core.u_top.u_core.d_acc[24]$_DFFE_PN0P_ clknet_1_1__leaf__11416_ _0238_[4] net1014 VSS VSS VDD VDD u_core.u_top.u_core.d_acc[24] sky130_fd_sc_hd__dfrtp_1
Xu_core.u_top.u_core.d_acc[25]$_DFFE_PN0P_ clknet_1_1__leaf__11416_ _0238_[5] net1014 VSS VSS VDD VDD u_core.u_top.u_core.d_acc[25] sky130_fd_sc_hd__dfrtp_1
Xu_core.u_top.u_core.d_acc[26]$_DFFE_PN0P_ clknet_1_0__leaf__11416_ _0238_[6] net1014 VSS VSS VDD VDD u_core.u_top.u_core.d_acc[26] sky130_fd_sc_hd__dfrtp_1
Xu_core.u_top.u_core.d_acc[27]$_DFFE_PN0P_ clknet_1_0__leaf__11416_ _0238_[7] net1014 VSS VSS VDD VDD u_core.u_top.u_core.d_acc[27] sky130_fd_sc_hd__dfrtp_1
Xu_core.u_top.u_core.d_acc[28]$_DFFE_PN0P_ clknet_1_0__leaf__11416_ _0238_[8] net1014 VSS VSS VDD VDD u_core.u_top.u_core.d_acc[28] sky130_fd_sc_hd__dfrtp_1
Xu_core.u_top.u_core.d_acc[29]$_DFFE_PN0P_ clknet_1_0__leaf__11416_ _0238_[9] net1013 VSS VSS VDD VDD u_core.u_top.u_core.d_acc[29] sky130_fd_sc_hd__dfrtp_1
Xu_core.u_top.u_core.d_acc[2]$_DFFE_PN0P_ clknet_1_0__leaf__11386_ _0226_[2] net1010 VSS VSS VDD VDD u_core.u_top.u_core.d_acc[2] sky130_fd_sc_hd__dfrtp_1
Xu_core.u_top.u_core.d_acc[30]$_DFFE_PN0P_ clknet_1_1__leaf__11375_ _0243_[0] net1014 VSS VSS VDD VDD u_core.u_top.u_core.d_acc[30] sky130_fd_sc_hd__dfrtp_1
Xu_core.u_top.u_core.d_acc[31]$_DFFE_PN0P_ clknet_1_1__leaf__11375_ _0243_[1] net1014 VSS VSS VDD VDD u_core.u_top.u_core.d_acc[31] sky130_fd_sc_hd__dfrtp_1
Xu_core.u_top.u_core.d_acc[32]$_DFFE_PN0P_ clknet_1_1__leaf__11375_ _0243_[2] net1014 VSS VSS VDD VDD u_core.u_top.u_core.d_acc[32] sky130_fd_sc_hd__dfrtp_1
Xu_core.u_top.u_core.d_acc[33]$_DFFE_PN0P_ clknet_1_1__leaf__11375_ _0243_[3] net1014 VSS VSS VDD VDD u_core.u_top.u_core.d_acc[33] sky130_fd_sc_hd__dfrtp_1
Xu_core.u_top.u_core.d_acc[34]$_DFFE_PN0P_ clknet_1_0__leaf__11375_ _0243_[4] net1004 VSS VSS VDD VDD u_core.u_top.u_core.d_acc[34] sky130_fd_sc_hd__dfrtp_1
Xu_core.u_top.u_core.d_acc[35]$_DFFE_PN0P_ clknet_1_0__leaf__11375_ _0243_[5] net1004 VSS VSS VDD VDD u_core.u_top.u_core.d_acc[35] sky130_fd_sc_hd__dfrtp_1
Xu_core.u_top.u_core.d_acc[36]$_DFFE_PN0P_ clknet_1_0__leaf__11375_ _0243_[6] net1004 VSS VSS VDD VDD u_core.u_top.u_core.d_acc[36] sky130_fd_sc_hd__dfrtp_1
Xu_core.u_top.u_core.d_acc[37]$_DFFE_PN0P_ clknet_1_0__leaf__11375_ _0243_[7] net1004 VSS VSS VDD VDD u_core.u_top.u_core.d_acc[37] sky130_fd_sc_hd__dfrtp_1
Xu_core.u_top.u_core.d_acc[38]$_DFFE_PN0P_ clknet_1_0__leaf__11375_ _0243_[8] net1004 VSS VSS VDD VDD u_core.u_top.u_core.d_acc[38] sky130_fd_sc_hd__dfrtp_1
Xu_core.u_top.u_core.d_acc[39]$_DFFE_PN0P_ clknet_1_1__leaf__11375_ _0243_[9] net1004 VSS VSS VDD VDD u_core.u_top.u_core.d_acc[39] sky130_fd_sc_hd__dfrtp_1
Xu_core.u_top.u_core.d_acc[3]$_DFFE_PN0P_ clknet_1_0__leaf__11386_ _0226_[3] net1010 VSS VSS VDD VDD u_core.u_top.u_core.d_acc[3] sky130_fd_sc_hd__dfrtp_1
Xu_core.u_top.u_core.d_acc[40]$_DFFE_PN0P_ clknet_1_1__leaf__11406_ _0249_[0] net1002 VSS VSS VDD VDD u_core.u_top.u_core.d_acc[40] sky130_fd_sc_hd__dfrtp_1
Xu_core.u_top.u_core.d_acc[41]$_DFFE_PN0P_ clknet_1_1__leaf__11406_ _0249_[1] net1002 VSS VSS VDD VDD u_core.u_top.u_core.d_acc[41] sky130_fd_sc_hd__dfrtp_1
Xu_core.u_top.u_core.d_acc[42]$_DFFE_PN0P_ clknet_1_1__leaf__11406_ _0249_[2] net1002 VSS VSS VDD VDD u_core.u_top.u_core.d_acc[42] sky130_fd_sc_hd__dfrtp_1
Xu_core.u_top.u_core.d_acc[43]$_DFFE_PN0P_ clknet_1_1__leaf__11406_ _0249_[3] net1002 VSS VSS VDD VDD u_core.u_top.u_core.d_acc[43] sky130_fd_sc_hd__dfrtp_1
Xu_core.u_top.u_core.d_acc[44]$_DFFE_PN0P_ clknet_1_0__leaf__11406_ _0249_[4] net1002 VSS VSS VDD VDD u_core.u_top.u_core.d_acc[44] sky130_fd_sc_hd__dfrtp_1
Xu_core.u_top.u_core.d_acc[45]$_DFFE_PN0P_ clknet_1_0__leaf__11406_ _0249_[5] net1002 VSS VSS VDD VDD u_core.u_top.u_core.d_acc[45] sky130_fd_sc_hd__dfrtp_1
Xu_core.u_top.u_core.d_acc[46]$_DFFE_PN0P_ clknet_1_0__leaf__11406_ _0249_[6] net1002 VSS VSS VDD VDD u_core.u_top.u_core.d_acc[46] sky130_fd_sc_hd__dfrtp_1
Xu_core.u_top.u_core.d_acc[47]$_DFFE_PN0P_ clknet_1_0__leaf__11406_ _0249_[7] net1002 VSS VSS VDD VDD u_core.u_top.u_core.d_acc[47] sky130_fd_sc_hd__dfrtp_1
Xu_core.u_top.u_core.d_acc[48]$_DFFE_PN0P_ clknet_1_0__leaf__11406_ _0249_[8] net1002 VSS VSS VDD VDD u_core.u_top.u_core.d_acc[48] sky130_fd_sc_hd__dfrtp_1
Xu_core.u_top.u_core.d_acc[49]$_DFFE_PN0P_ clknet_1_0__leaf__11406_ _0249_[9] net1002 VSS VSS VDD VDD u_core.u_top.u_core.d_acc[49] sky130_fd_sc_hd__dfrtp_1
Xu_core.u_top.u_core.d_acc[4]$_DFFE_PN0P_ clknet_1_0__leaf__11386_ _0226_[4] net1012 VSS VSS VDD VDD u_core.u_top.u_core.d_acc[4] sky130_fd_sc_hd__dfrtp_1
Xu_core.u_top.u_core.d_acc[50]$_DFFE_PN0P_ clknet_1_1__leaf__11409_ _0254_[0] net1002 VSS VSS VDD VDD u_core.u_top.u_core.d_acc[50] sky130_fd_sc_hd__dfrtp_1
Xu_core.u_top.u_core.d_acc[51]$_DFFE_PN0P_ clknet_1_1__leaf__11409_ _0254_[1] net1002 VSS VSS VDD VDD u_core.u_top.u_core.d_acc[51] sky130_fd_sc_hd__dfrtp_1
Xu_core.u_top.u_core.d_acc[52]$_DFFE_PN0P_ clknet_1_1__leaf__11409_ _0254_[2] net1002 VSS VSS VDD VDD u_core.u_top.u_core.d_acc[52] sky130_fd_sc_hd__dfrtp_1
Xu_core.u_top.u_core.d_acc[53]$_DFFE_PN0P_ clknet_1_1__leaf__11409_ _0254_[3] net1003 VSS VSS VDD VDD u_core.u_top.u_core.d_acc[53] sky130_fd_sc_hd__dfrtp_1
Xu_core.u_top.u_core.d_acc[54]$_DFFE_PN0P_ clknet_1_0__leaf__11409_ _0254_[4] net1003 VSS VSS VDD VDD u_core.u_top.u_core.d_acc[54] sky130_fd_sc_hd__dfrtp_1
Xu_core.u_top.u_core.d_acc[55]$_DFFE_PN0P_ clknet_1_0__leaf__11409_ _0254_[5] net1003 VSS VSS VDD VDD u_core.u_top.u_core.d_acc[55] sky130_fd_sc_hd__dfrtp_1
Xu_core.u_top.u_core.d_acc[56]$_DFFE_PN0P_ clknet_1_0__leaf__11409_ _0254_[6] net1003 VSS VSS VDD VDD u_core.u_top.u_core.d_acc[56] sky130_fd_sc_hd__dfrtp_1
Xu_core.u_top.u_core.d_acc[57]$_DFFE_PN0P_ clknet_1_0__leaf__11409_ _0254_[7] net1003 VSS VSS VDD VDD u_core.u_top.u_core.d_acc[57] sky130_fd_sc_hd__dfrtp_1
Xu_core.u_top.u_core.d_acc[58]$_DFFE_PN0P_ clknet_1_0__leaf__11409_ _0254_[8] net1003 VSS VSS VDD VDD u_core.u_top.u_core.d_acc[58] sky130_fd_sc_hd__dfrtp_1
Xu_core.u_top.u_core.d_acc[59]$_DFFE_PN0P_ clknet_1_0__leaf__11409_ _0254_[9] net1003 VSS VSS VDD VDD u_core.u_top.u_core.d_acc[59] sky130_fd_sc_hd__dfrtp_1
Xu_core.u_top.u_core.d_acc[5]$_DFFE_PN0P_ clknet_1_1__leaf__11386_ _0226_[5] net1012 VSS VSS VDD VDD u_core.u_top.u_core.d_acc[5] sky130_fd_sc_hd__dfrtp_1
Xu_core.u_top.u_core.d_acc[60]$_DFFE_PN0P_ clknet_1_0__leaf__11365_ _0259_[0] net1003 VSS VSS VDD VDD u_core.u_top.u_core.d_acc[60] sky130_fd_sc_hd__dfrtp_1
Xu_core.u_top.u_core.d_acc[61]$_DFFE_PN0P_ clknet_1_0__leaf__11365_ _0259_[1] net1003 VSS VSS VDD VDD u_core.u_top.u_core.d_acc[61] sky130_fd_sc_hd__dfrtp_1
Xu_core.u_top.u_core.d_acc[62]$_DFFE_PN0P_ clknet_1_0__leaf__11365_ _0259_[2] net1003 VSS VSS VDD VDD u_core.u_top.u_core.d_acc[62] sky130_fd_sc_hd__dfrtp_1
Xu_core.u_top.u_core.d_acc[63]$_DFFE_PN0P_ clknet_1_0__leaf__11365_ _0259_[3] net1003 VSS VSS VDD VDD u_core.u_top.u_core.d_acc[63] sky130_fd_sc_hd__dfrtp_1
Xu_core.u_top.u_core.d_acc[64]$_DFFE_PN0P_ clknet_1_0__leaf__11365_ _0259_[4] net1003 VSS VSS VDD VDD u_core.u_top.u_core.d_acc[64] sky130_fd_sc_hd__dfrtp_1
Xu_core.u_top.u_core.d_acc[65]$_DFFE_PN0P_ clknet_1_1__leaf__11365_ _0259_[5] net1001 VSS VSS VDD VDD u_core.u_top.u_core.d_acc[65] sky130_fd_sc_hd__dfrtp_1
Xu_core.u_top.u_core.d_acc[66]$_DFFE_PN0P_ clknet_1_1__leaf__11365_ _0259_[6] net1001 VSS VSS VDD VDD u_core.u_top.u_core.d_acc[66] sky130_fd_sc_hd__dfrtp_1
Xu_core.u_top.u_core.d_acc[67]$_DFFE_PN0P_ clknet_1_1__leaf__11365_ _0259_[7] net1001 VSS VSS VDD VDD u_core.u_top.u_core.d_acc[67] sky130_fd_sc_hd__dfrtp_1
Xu_core.u_top.u_core.d_acc[68]$_DFFE_PN0P_ clknet_1_1__leaf__11365_ _0259_[8] net1001 VSS VSS VDD VDD u_core.u_top.u_core.d_acc[68] sky130_fd_sc_hd__dfrtp_1
Xu_core.u_top.u_core.d_acc[69]$_DFFE_PN0P_ clknet_1_1__leaf__11365_ _0259_[9] net1001 VSS VSS VDD VDD u_core.u_top.u_core.d_acc[69] sky130_fd_sc_hd__dfrtp_1
Xu_core.u_top.u_core.d_acc[6]$_DFFE_PN0P_ clknet_1_0__leaf__11386_ _0226_[6] net1012 VSS VSS VDD VDD u_core.u_top.u_core.d_acc[6] sky130_fd_sc_hd__dfrtp_1
Xu_core.u_top.u_core.d_acc[70]$_DFFE_PN0P_ clknet_1_1__leaf__11359_ _0264_[0] net1001 VSS VSS VDD VDD u_core.u_top.u_core.d_acc[70] sky130_fd_sc_hd__dfrtp_1
Xu_core.u_top.u_core.d_acc[71]$_DFFE_PN0P_ clknet_1_1__leaf__11359_ _0264_[1] net1001 VSS VSS VDD VDD u_core.u_top.u_core.d_acc[71] sky130_fd_sc_hd__dfrtp_1
Xu_core.u_top.u_core.d_acc[72]$_DFFE_PN0P_ clknet_1_0__leaf__11359_ _0264_[2] net1001 VSS VSS VDD VDD u_core.u_top.u_core.d_acc[72] sky130_fd_sc_hd__dfrtp_1
Xu_core.u_top.u_core.d_acc[73]$_DFFE_PN0P_ clknet_1_1__leaf__11359_ _0264_[3] net1001 VSS VSS VDD VDD u_core.u_top.u_core.d_acc[73] sky130_fd_sc_hd__dfrtp_1
Xu_core.u_top.u_core.d_acc[74]$_DFFE_PN0P_ clknet_1_0__leaf__11359_ _0264_[4] net1001 VSS VSS VDD VDD u_core.u_top.u_core.d_acc[74] sky130_fd_sc_hd__dfrtp_1
Xu_core.u_top.u_core.d_acc[75]$_DFFE_PN0P_ clknet_1_1__leaf__11359_ _0264_[5] net1001 VSS VSS VDD VDD u_core.u_top.u_core.d_acc[75] sky130_fd_sc_hd__dfrtp_1
Xu_core.u_top.u_core.d_acc[76]$_DFFE_PN0P_ clknet_1_0__leaf__11359_ _0264_[6] net1001 VSS VSS VDD VDD u_core.u_top.u_core.d_acc[76] sky130_fd_sc_hd__dfrtp_1
Xu_core.u_top.u_core.d_acc[77]$_DFFE_PN0P_ clknet_1_0__leaf__11359_ _0264_[7] net1001 VSS VSS VDD VDD u_core.u_top.u_core.d_acc[77] sky130_fd_sc_hd__dfrtp_1
Xu_core.u_top.u_core.d_acc[78]$_DFFE_PN0P_ clknet_1_0__leaf__11359_ _0264_[8] net1001 VSS VSS VDD VDD u_core.u_top.u_core.d_acc[78] sky130_fd_sc_hd__dfrtp_1
Xu_core.u_top.u_core.d_acc[79]$_DFFE_PN0P_ clknet_1_1__leaf__11359_ _0264_[9] net1001 VSS VSS VDD VDD u_core.u_top.u_core.d_acc[79] sky130_fd_sc_hd__dfrtp_1
Xu_core.u_top.u_core.d_acc[7]$_DFFE_PN0P_ clknet_1_1__leaf__11386_ _0226_[7] net1012 VSS VSS VDD VDD u_core.u_top.u_core.d_acc[7] sky130_fd_sc_hd__dfrtp_1
Xu_core.u_top.u_core.d_acc[80]$_DFFE_PN0P_ clknet_1_0__leaf__11396_ _0269_[0] net1001 VSS VSS VDD VDD u_core.u_top.u_core.d_acc[80] sky130_fd_sc_hd__dfrtp_1
Xu_core.u_top.u_core.d_acc[81]$_DFFE_PN0P_ clknet_1_0__leaf__11396_ _0269_[1] net1001 VSS VSS VDD VDD u_core.u_top.u_core.d_acc[81] sky130_fd_sc_hd__dfrtp_1
Xu_core.u_top.u_core.d_acc[82]$_DFFE_PN0P_ clknet_1_0__leaf__11396_ _0269_[2] net1001 VSS VSS VDD VDD u_core.u_top.u_core.d_acc[82] sky130_fd_sc_hd__dfrtp_1
Xu_core.u_top.u_core.d_acc[83]$_DFFE_PN0P_ clknet_1_0__leaf__11396_ _0269_[3] net1001 VSS VSS VDD VDD u_core.u_top.u_core.d_acc[83] sky130_fd_sc_hd__dfrtp_1
Xu_core.u_top.u_core.d_acc[84]$_DFFE_PN0P_ clknet_1_1__leaf__11396_ _0269_[4] net1001 VSS VSS VDD VDD u_core.u_top.u_core.d_acc[84] sky130_fd_sc_hd__dfrtp_1
Xu_core.u_top.u_core.d_acc[85]$_DFFE_PN0P_ clknet_1_1__leaf__11396_ _0269_[5] net1001 VSS VSS VDD VDD u_core.u_top.u_core.d_acc[85] sky130_fd_sc_hd__dfrtp_1
Xu_core.u_top.u_core.d_acc[86]$_DFFE_PN0P_ clknet_1_1__leaf__11396_ _0269_[6] net1001 VSS VSS VDD VDD u_core.u_top.u_core.d_acc[86] sky130_fd_sc_hd__dfrtp_1
Xu_core.u_top.u_core.d_acc[87]$_DFFE_PN0P_ clknet_1_1__leaf__11396_ _0269_[7] net1001 VSS VSS VDD VDD u_core.u_top.u_core.d_acc[87] sky130_fd_sc_hd__dfrtp_1
Xu_core.u_top.u_core.d_acc[88]$_DFFE_PN0P_ clknet_1_1__leaf__11396_ _0269_[8] net1001 VSS VSS VDD VDD u_core.u_top.u_core.d_acc[88] sky130_fd_sc_hd__dfrtp_1
Xu_core.u_top.u_core.d_acc[89]$_DFFE_PN0P_ clknet_1_1__leaf__11396_ _0269_[9] net1001 VSS VSS VDD VDD u_core.u_top.u_core.d_acc[89] sky130_fd_sc_hd__dfrtp_1
Xu_core.u_top.u_core.d_acc[8]$_DFFE_PN0P_ clknet_1_1__leaf__11386_ _0226_[8] net1012 VSS VSS VDD VDD u_core.u_top.u_core.d_acc[8] sky130_fd_sc_hd__dfrtp_1
Xu_core.u_top.u_core.d_acc[90]$_DFFE_PN0P_ clknet_1_1__leaf__11395_ _0274_[0] net1001 VSS VSS VDD VDD u_core.u_top.u_core.d_acc[90] sky130_fd_sc_hd__dfrtp_1
Xu_core.u_top.u_core.d_acc[91]$_DFFE_PN0P_ clknet_1_1__leaf__11395_ _0274_[1] net1001 VSS VSS VDD VDD u_core.u_top.u_core.d_acc[91] sky130_fd_sc_hd__dfrtp_1
Xu_core.u_top.u_core.d_acc[92]$_DFFE_PN0P_ clknet_1_1__leaf__11395_ _0274_[2] net1001 VSS VSS VDD VDD u_core.u_top.u_core.d_acc[92] sky130_fd_sc_hd__dfrtp_1
Xu_core.u_top.u_core.d_acc[93]$_DFFE_PN0P_ clknet_1_1__leaf__11395_ _0274_[3] net1001 VSS VSS VDD VDD u_core.u_top.u_core.d_acc[93] sky130_fd_sc_hd__dfrtp_1
Xu_core.u_top.u_core.d_acc[94]$_DFFE_PN0P_ clknet_1_1__leaf__11395_ _0274_[4] net1001 VSS VSS VDD VDD u_core.u_top.u_core.d_acc[94] sky130_fd_sc_hd__dfrtp_1
Xu_core.u_top.u_core.d_acc[95]$_DFFE_PN0P_ clknet_1_0__leaf__11395_ _0274_[5] net1003 VSS VSS VDD VDD u_core.u_top.u_core.d_acc[95] sky130_fd_sc_hd__dfrtp_1
Xu_core.u_top.u_core.d_acc[96]$_DFFE_PN0P_ clknet_1_0__leaf__11395_ _0274_[6] net1003 VSS VSS VDD VDD u_core.u_top.u_core.d_acc[96] sky130_fd_sc_hd__dfrtp_1
Xu_core.u_top.u_core.d_acc[97]$_DFFE_PN0P_ clknet_1_0__leaf__11395_ _0274_[7] net1003 VSS VSS VDD VDD u_core.u_top.u_core.d_acc[97] sky130_fd_sc_hd__dfrtp_1
Xu_core.u_top.u_core.d_acc[98]$_DFFE_PN0P_ clknet_1_0__leaf__11395_ _0274_[8] net1003 VSS VSS VDD VDD u_core.u_top.u_core.d_acc[98] sky130_fd_sc_hd__dfrtp_1
Xu_core.u_top.u_core.d_acc[99]$_DFFE_PN0P_ clknet_1_0__leaf__11395_ _0274_[9] net1003 VSS VSS VDD VDD u_core.u_top.u_core.d_acc[99] sky130_fd_sc_hd__dfrtp_1
Xu_core.u_top.u_core.d_acc[9]$_DFFE_PN0P_ clknet_1_1__leaf__11386_ _0226_[9] net1010 VSS VSS VDD VDD u_core.u_top.u_core.d_acc[9] sky130_fd_sc_hd__dfrtp_1
Xu_core.u_top.u_core.lfsr[0]$_DFF_PN1_ clknet_3_5__leaf_clk_regs net878 net1011 VSS VSS VDD VDD _0725_[1] sky130_fd_sc_hd__dfstp_2
Xu_core.u_top.u_core.lfsr[10]$_DFF_PN1_ clknet_3_3__leaf_clk_regs net991 net1005 VSS VSS VDD VDD u_core.u_top.u_core.lfsr[10] sky130_fd_sc_hd__dfstp_2
Xu_core.u_top.u_core.lfsr[11]$_DFF_PN1_ clknet_3_3__leaf_clk_regs u_core.u_top.u_core.lfsr[10] net1005 VSS VSS VDD VDD u_core.u_top.u_core.lfsr[11] sky130_fd_sc_hd__dfstp_2
Xu_core.u_top.u_core.lfsr[12]$_DFF_PN0_ clknet_3_3__leaf_clk_regs u_core.u_top.u_core.lfsr[11] net1005 VSS VSS VDD VDD u_core.u_top.u_core.lfsr[12] sky130_fd_sc_hd__dfrtp_1
Xu_core.u_top.u_core.lfsr[13]$_DFF_PN1_ clknet_3_3__leaf_clk_regs u_core.u_top.u_core.lfsr[12] net1005 VSS VSS VDD VDD u_core.u_top.u_core.lfsr[13] sky130_fd_sc_hd__dfstp_2
Xu_core.u_top.u_core.lfsr[14]$_DFF_PN0_ clknet_3_3__leaf_clk_regs u_core.u_top.u_core.lfsr[13] net1005 VSS VSS VDD VDD u_core.u_top.u_core.lfsr[14] sky130_fd_sc_hd__dfrtp_1
Xu_core.u_top.u_core.lfsr[15]$_DFF_PN1_ clknet_3_3__leaf_clk_regs u_core.u_top.u_core.lfsr[14] net1004 VSS VSS VDD VDD u_core.u_top.u_core.lfsr[15] sky130_fd_sc_hd__dfstp_2
Xu_core.u_top.u_core.lfsr[1]$_DFF_PN0_ clknet_3_6__leaf_clk_regs net995 net1024 VSS VSS VDD VDD _0725_[2] sky130_fd_sc_hd__dfrtp_1
Xu_core.u_top.u_core.lfsr[2]$_DFF_PN0_ clknet_3_6__leaf_clk_regs net993 net1024 VSS VSS VDD VDD u_core.u_top.u_core.lfsr[2] sky130_fd_sc_hd__dfrtp_1
Xu_core.u_top.u_core.lfsr[3]$_DFF_PN0_ clknet_3_2__leaf_clk_regs net992 net1013 VSS VSS VDD VDD u_core.u_top.u_core.lfsr[3] sky130_fd_sc_hd__dfrtp_1
Xu_core.u_top.u_core.lfsr[4]$_DFF_PN0_ clknet_3_2__leaf_clk_regs u_core.u_top.u_core.lfsr[3] net1002 VSS VSS VDD VDD u_core.u_top.u_core.lfsr[4] sky130_fd_sc_hd__dfrtp_1
Xu_core.u_top.u_core.lfsr[5]$_DFF_PN1_ clknet_3_2__leaf_clk_regs u_core.u_top.u_core.lfsr[4] net1002 VSS VSS VDD VDD u_core.u_top.u_core.lfsr[5] sky130_fd_sc_hd__dfstp_2
Xu_core.u_top.u_core.lfsr[6]$_DFF_PN1_ clknet_3_3__leaf_clk_regs u_core.u_top.u_core.lfsr[5] net1003 VSS VSS VDD VDD u_core.u_top.u_core.lfsr[6] sky130_fd_sc_hd__dfstp_2
Xu_core.u_top.u_core.lfsr[7]$_DFF_PN1_ clknet_3_2__leaf_clk_regs u_core.u_top.u_core.lfsr[6] net1001 VSS VSS VDD VDD u_core.u_top.u_core.lfsr[7] sky130_fd_sc_hd__dfstp_2
Xu_core.u_top.u_core.lfsr[8]$_DFF_PN0_ clknet_3_2__leaf_clk_regs u_core.u_top.u_core.lfsr[7] net1001 VSS VSS VDD VDD u_core.u_top.u_core.lfsr[8] sky130_fd_sc_hd__dfrtp_1
Xu_core.u_top.u_core.lfsr[9]$_DFF_PN0_ clknet_3_2__leaf_clk_regs u_core.u_top.u_core.lfsr[8] net1003 VSS VSS VDD VDD u_core.u_top.u_core.lfsr[9] sky130_fd_sc_hd__dfrtp_1
Xu_core.u_top.u_core.lfsr_m72[3]$_DFF_PN0_ clknet_3_7__leaf_clk_regs u_core.u_top.u_core.m72_next[3] net1020 VSS VSS VDD VDD u_core.u_top.u_core.lfsr_m72[3] sky130_fd_sc_hd__dfrtp_1
Xu_core.u_top.u_core.lfsr_m72[4]$_DFF_PN1_ clknet_3_7__leaf_clk_regs u_core.u_top.u_core.m72_next[4] net1020 VSS VSS VDD VDD u_core.u_top.u_core.lfsr_m72[4] sky130_fd_sc_hd__dfstp_2
Xu_core.u_top.u_core.lfsr_m72[5]$_DFF_PN1_ clknet_3_7__leaf_clk_regs u_core.u_top.u_core.m72_next[5] net1020 VSS VSS VDD VDD u_core.u_top.u_core.lfsr_m72[5] sky130_fd_sc_hd__dfstp_2
Xu_core.u_top.u_core.lfsr_m72[6]$_DFF_PN0_ clknet_3_7__leaf_clk_regs u_core.u_top.u_core.m72_next[6] net1020 VSS VSS VDD VDD u_core.u_top.u_core.lfsr_m72[6] sky130_fd_sc_hd__dfrtp_1
Xu_core.u_top.u_core.m_fail[0]$_DFFE_PN0P_ clknet_1_1__leaf__11378_ _1052_[0] net1017 VSS VSS VDD VDD u_core.u_top.u_core.m_fail[0] sky130_fd_sc_hd__dfrtp_1
Xu_core.u_top.u_core.m_fail[10]$_DFFE_PN0P_ clknet_1_1__leaf__11378_ _1052_[10] net1018 VSS VSS VDD VDD u_core.u_top.u_core.m_fail[10] sky130_fd_sc_hd__dfrtp_1
Xu_core.u_top.u_core.m_fail[11]$_DFFE_PN0P_ clknet_1_1__leaf__11378_ _1052_[11] net1025 VSS VSS VDD VDD u_core.u_top.u_core.m_fail[11] sky130_fd_sc_hd__dfrtp_1
Xu_core.u_top.u_core.m_fail[12]$_DFFE_PN0P_ clknet_1_0__leaf__11378_ _1052_[12] net1026 VSS VSS VDD VDD u_core.u_top.u_core.m_fail[12] sky130_fd_sc_hd__dfrtp_1
Xu_core.u_top.u_core.m_fail[13]$_DFFE_PN0P_ clknet_1_0__leaf__11378_ _1052_[13] net1024 VSS VSS VDD VDD u_core.u_top.u_core.m_fail[13] sky130_fd_sc_hd__dfrtp_1
Xu_core.u_top.u_core.m_fail[14]$_DFFE_PN0P_ clknet_1_0__leaf__11378_ _1052_[14] net1024 VSS VSS VDD VDD u_core.u_top.u_core.m_fail[14] sky130_fd_sc_hd__dfrtp_1
Xu_core.u_top.u_core.m_fail[15]$_DFFE_PN0P_ clknet_1_0__leaf__11378_ _1052_[15] net1026 VSS VSS VDD VDD u_core.u_top.u_core.m_fail[15] sky130_fd_sc_hd__dfrtp_1
Xu_core.u_top.u_core.m_fail[16]$_DFFE_PN0P_ clknet_1_0__leaf__11378_ _1052_[16] net1024 VSS VSS VDD VDD u_core.u_top.u_core.m_fail[16] sky130_fd_sc_hd__dfrtp_1
Xu_core.u_top.u_core.m_fail[17]$_DFFE_PN0P_ clknet_1_0__leaf__11378_ _1052_[17] net1026 VSS VSS VDD VDD u_core.u_top.u_core.m_fail[17] sky130_fd_sc_hd__dfrtp_1
Xu_core.u_top.u_core.m_fail[18]$_DFFE_PN0P_ clknet_1_0__leaf__11378_ _1052_[18] net1026 VSS VSS VDD VDD u_core.u_top.u_core.m_fail[18] sky130_fd_sc_hd__dfrtp_1
Xu_core.u_top.u_core.m_fail[19]$_DFFE_PN0P_ clknet_1_0__leaf__11378_ _1052_[19] net1026 VSS VSS VDD VDD u_core.u_top.u_core.m_fail[19] sky130_fd_sc_hd__dfrtp_1
Xu_core.u_top.u_core.m_fail[1]$_DFFE_PN0P_ clknet_1_1__leaf__11378_ _1052_[1] net1022 VSS VSS VDD VDD u_core.u_top.u_core.m_fail[1] sky130_fd_sc_hd__dfrtp_1
Xu_core.u_top.u_core.m_fail[20]$_DFFE_PN0P_ clknet_1_0__leaf__11378_ _1052_[20] net1026 VSS VSS VDD VDD u_core.u_top.u_core.m_fail[20] sky130_fd_sc_hd__dfrtp_1
Xu_core.u_top.u_core.m_fail[21]$_DFFE_PN0P_ clknet_1_0__leaf__11378_ _1052_[21] net1026 VSS VSS VDD VDD u_core.u_top.u_core.m_fail[21] sky130_fd_sc_hd__dfrtp_1
Xu_core.u_top.u_core.m_fail[22]$_DFFE_PN0P_ clknet_1_1__leaf__11378_ _1052_[22] net1025 VSS VSS VDD VDD u_core.u_top.u_core.m_fail[22] sky130_fd_sc_hd__dfrtp_1
Xu_core.u_top.u_core.m_fail[23]$_DFFE_PN0P_ clknet_1_1__leaf__11378_ _1052_[23] net1022 VSS VSS VDD VDD u_core.u_top.u_core.m_fail[23] sky130_fd_sc_hd__dfrtp_1
Xu_core.u_top.u_core.m_fail[2]$_DFFE_PN0P_ clknet_1_1__leaf__11378_ _1052_[2] net1017 VSS VSS VDD VDD u_core.u_top.u_core.m_fail[2] sky130_fd_sc_hd__dfrtp_1
Xu_core.u_top.u_core.m_fail[3]$_DFFE_PN0P_ clknet_1_0__leaf__11378_ _1052_[3] net1025 VSS VSS VDD VDD u_core.u_top.u_core.m_fail[3] sky130_fd_sc_hd__dfrtp_1
Xu_core.u_top.u_core.m_fail[4]$_DFFE_PN0P_ clknet_1_0__leaf__11378_ _1052_[4] net1025 VSS VSS VDD VDD u_core.u_top.u_core.m_fail[4] sky130_fd_sc_hd__dfrtp_1
Xu_core.u_top.u_core.m_fail[5]$_DFFE_PN0P_ clknet_1_1__leaf__11378_ _1052_[5] net1022 VSS VSS VDD VDD u_core.u_top.u_core.m_fail[5] sky130_fd_sc_hd__dfrtp_1
Xu_core.u_top.u_core.m_fail[6]$_DFFE_PN0P_ clknet_1_1__leaf__11378_ _1052_[6] net1017 VSS VSS VDD VDD u_core.u_top.u_core.m_fail[6] sky130_fd_sc_hd__dfrtp_1
Xu_core.u_top.u_core.m_fail[7]$_DFFE_PN0P_ clknet_1_1__leaf__11378_ _1052_[7] net1018 VSS VSS VDD VDD u_core.u_top.u_core.m_fail[7] sky130_fd_sc_hd__dfrtp_1
Xu_core.u_top.u_core.m_fail[8]$_DFFE_PN0P_ clknet_1_1__leaf__11378_ _1052_[8] net1018 VSS VSS VDD VDD u_core.u_top.u_core.m_fail[8] sky130_fd_sc_hd__dfrtp_1
Xu_core.u_top.u_core.m_fail[9]$_DFFE_PN0P_ clknet_1_1__leaf__11378_ _1052_[9] net1018 VSS VSS VDD VDD u_core.u_top.u_core.m_fail[9] sky130_fd_sc_hd__dfrtp_1
Xu_core.u_top.u_core.pend_n[0]$_DFFE_PN0P_ clknet_2_2__leaf__11428_ _1060_[0] net1017 VSS VSS VDD VDD u_core.u_top.u_core.pend_n[0] sky130_fd_sc_hd__dfrtp_1
Xu_core.u_top.u_core.pend_n[10]$_DFFE_PN0P_ clknet_2_3__leaf__11428_ _1060_[10] net1024 VSS VSS VDD VDD u_core.u_top.u_core.pend_n[10] sky130_fd_sc_hd__dfrtp_1
Xu_core.u_top.u_core.pend_n[11]$_DFFE_PN0P_ clknet_2_1__leaf__11428_ _1060_[11] net1011 VSS VSS VDD VDD u_core.u_top.u_core.pend_n[11] sky130_fd_sc_hd__dfrtp_1
Xu_core.u_top.u_core.pend_n[12]$_DFFE_PN0P_ clknet_2_0__leaf__11428_ _1060_[12] net1011 VSS VSS VDD VDD u_core.u_top.u_core.pend_n[12] sky130_fd_sc_hd__dfrtp_1
Xu_core.u_top.u_core.pend_n[13]$_DFFE_PN0P_ clknet_2_1__leaf__11428_ _1060_[13] net1011 VSS VSS VDD VDD u_core.u_top.u_core.pend_n[13] sky130_fd_sc_hd__dfrtp_1
Xu_core.u_top.u_core.pend_n[14]$_DFFE_PN0P_ clknet_2_1__leaf__11428_ _1060_[14] net1011 VSS VSS VDD VDD u_core.u_top.u_core.pend_n[14] sky130_fd_sc_hd__dfrtp_1
Xu_core.u_top.u_core.pend_n[15]$_DFFE_PN0P_ clknet_2_0__leaf__11428_ _1060_[15] net1011 VSS VSS VDD VDD u_core.u_top.u_core.pend_n[15] sky130_fd_sc_hd__dfrtp_1
Xu_core.u_top.u_core.pend_n[16]$_DFFE_PN0P_ clknet_2_0__leaf__11428_ _1060_[16] net1011 VSS VSS VDD VDD u_core.u_top.u_core.pend_n[16] sky130_fd_sc_hd__dfrtp_1
Xu_core.u_top.u_core.pend_n[17]$_DFFE_PN0P_ clknet_2_0__leaf__11428_ _1060_[17] net1011 VSS VSS VDD VDD u_core.u_top.u_core.pend_n[17] sky130_fd_sc_hd__dfrtp_1
Xu_core.u_top.u_core.pend_n[18]$_DFFE_PN0P_ clknet_2_0__leaf__11428_ _1060_[18] net1011 VSS VSS VDD VDD u_core.u_top.u_core.pend_n[18] sky130_fd_sc_hd__dfrtp_1
Xu_core.u_top.u_core.pend_n[19]$_DFFE_PN0P_ clknet_2_1__leaf__11428_ _1060_[19] net1010 VSS VSS VDD VDD u_core.u_top.u_core.pend_n[19] sky130_fd_sc_hd__dfrtp_1
Xu_core.u_top.u_core.pend_n[1]$_DFFE_PN0P_ clknet_2_3__leaf__11428_ _1060_[1] net1024 VSS VSS VDD VDD u_core.u_top.u_core.pend_n[1] sky130_fd_sc_hd__dfrtp_1
Xu_core.u_top.u_core.pend_n[20]$_DFFE_PN0P_ clknet_2_0__leaf__11428_ _1060_[20] net1011 VSS VSS VDD VDD u_core.u_top.u_core.pend_n[20] sky130_fd_sc_hd__dfrtp_1
Xu_core.u_top.u_core.pend_n[21]$_DFFE_PN0P_ clknet_2_1__leaf__11428_ _1060_[21] net1010 VSS VSS VDD VDD u_core.u_top.u_core.pend_n[21] sky130_fd_sc_hd__dfrtp_1
Xu_core.u_top.u_core.pend_n[22]$_DFFE_PN0P_ clknet_2_3__leaf__11428_ _1060_[22] net1024 VSS VSS VDD VDD u_core.u_top.u_core.pend_n[22] sky130_fd_sc_hd__dfrtp_1
Xu_core.u_top.u_core.pend_n[23]$_DFFE_PN0P_ clknet_2_3__leaf__11428_ _1060_[23] net1025 VSS VSS VDD VDD u_core.u_top.u_core.pend_n[23] sky130_fd_sc_hd__dfrtp_1
Xu_core.u_top.u_core.pend_n[2]$_DFFE_PN0P_ clknet_2_2__leaf__11428_ _1060_[2] net1017 VSS VSS VDD VDD u_core.u_top.u_core.pend_n[2] sky130_fd_sc_hd__dfrtp_1
Xu_core.u_top.u_core.pend_n[3]$_DFFE_PN0P_ clknet_2_1__leaf__11428_ _1060_[3] net1011 VSS VSS VDD VDD u_core.u_top.u_core.pend_n[3] sky130_fd_sc_hd__dfrtp_1
Xu_core.u_top.u_core.pend_n[4]$_DFFE_PN0P_ clknet_2_0__leaf__11428_ _1060_[4] net1024 VSS VSS VDD VDD u_core.u_top.u_core.pend_n[4] sky130_fd_sc_hd__dfrtp_1
Xu_core.u_top.u_core.pend_n[5]$_DFFE_PN0P_ clknet_2_2__leaf__11428_ _1060_[5] net1017 VSS VSS VDD VDD u_core.u_top.u_core.pend_n[5] sky130_fd_sc_hd__dfrtp_1
Xu_core.u_top.u_core.pend_n[6]$_DFFE_PN0P_ clknet_2_2__leaf__11428_ _1060_[6] net1018 VSS VSS VDD VDD u_core.u_top.u_core.pend_n[6] sky130_fd_sc_hd__dfrtp_1
Xu_core.u_top.u_core.pend_n[7]$_DFFE_PN0P_ clknet_2_3__leaf__11428_ _1060_[7] net1024 VSS VSS VDD VDD u_core.u_top.u_core.pend_n[7] sky130_fd_sc_hd__dfrtp_1
Xu_core.u_top.u_core.pend_n[8]$_DFFE_PN0P_ clknet_2_2__leaf__11428_ _1060_[8] net1018 VSS VSS VDD VDD u_core.u_top.u_core.pend_n[8] sky130_fd_sc_hd__dfrtp_1
Xu_core.u_top.u_core.pend_n[9]$_DFFE_PN0P_ clknet_2_3__leaf__11428_ _1060_[9] net1025 VSS VSS VDD VDD u_core.u_top.u_core.pend_n[9] sky130_fd_sc_hd__dfrtp_1
Xu_core.u_top.u_core.pend_p[0]$_DFFE_PN0P_ clknet_2_2__leaf__11428_ _1056_[0] net1017 VSS VSS VDD VDD u_core.u_top.u_core.pend_p[0] sky130_fd_sc_hd__dfrtp_1
Xu_core.u_top.u_core.pend_p[10]$_DFFE_PN0P_ clknet_2_3__leaf__11428_ _1056_[10] net1024 VSS VSS VDD VDD u_core.u_top.u_core.pend_p[10] sky130_fd_sc_hd__dfrtp_1
Xu_core.u_top.u_core.pend_p[11]$_DFFE_PN0P_ clknet_2_3__leaf__11428_ _1056_[11] net1024 VSS VSS VDD VDD u_core.u_top.u_core.pend_p[11] sky130_fd_sc_hd__dfrtp_1
Xu_core.u_top.u_core.pend_p[12]$_DFFE_PN0P_ clknet_2_0__leaf__11428_ _1056_[12] net1010 VSS VSS VDD VDD u_core.u_top.u_core.pend_p[12] sky130_fd_sc_hd__dfrtp_1
Xu_core.u_top.u_core.pend_p[13]$_DFFE_PN0P_ clknet_2_1__leaf__11428_ _1056_[13] net1011 VSS VSS VDD VDD u_core.u_top.u_core.pend_p[13] sky130_fd_sc_hd__dfrtp_1
Xu_core.u_top.u_core.pend_p[14]$_DFFE_PN0P_ clknet_2_1__leaf__11428_ _1056_[14] net1011 VSS VSS VDD VDD u_core.u_top.u_core.pend_p[14] sky130_fd_sc_hd__dfrtp_1
Xu_core.u_top.u_core.pend_p[15]$_DFFE_PN0P_ clknet_2_1__leaf__11428_ _1056_[15] net1011 VSS VSS VDD VDD u_core.u_top.u_core.pend_p[15] sky130_fd_sc_hd__dfrtp_1
Xu_core.u_top.u_core.pend_p[16]$_DFFE_PN0P_ clknet_2_0__leaf__11428_ _1056_[16] net1011 VSS VSS VDD VDD u_core.u_top.u_core.pend_p[16] sky130_fd_sc_hd__dfrtp_1
Xu_core.u_top.u_core.pend_p[17]$_DFFE_PN0P_ clknet_2_0__leaf__11428_ _1056_[17] net1011 VSS VSS VDD VDD u_core.u_top.u_core.pend_p[17] sky130_fd_sc_hd__dfrtp_1
Xu_core.u_top.u_core.pend_p[18]$_DFFE_PN0P_ clknet_2_0__leaf__11428_ _1056_[18] net1011 VSS VSS VDD VDD u_core.u_top.u_core.pend_p[18] sky130_fd_sc_hd__dfrtp_1
Xu_core.u_top.u_core.pend_p[19]$_DFFE_PN0P_ clknet_2_1__leaf__11428_ _1056_[19] net1010 VSS VSS VDD VDD u_core.u_top.u_core.pend_p[19] sky130_fd_sc_hd__dfrtp_1
Xu_core.u_top.u_core.pend_p[1]$_DFFE_PN0P_ clknet_2_3__leaf__11428_ _1056_[1] net1024 VSS VSS VDD VDD u_core.u_top.u_core.pend_p[1] sky130_fd_sc_hd__dfrtp_1
Xu_core.u_top.u_core.pend_p[20]$_DFFE_PN0P_ clknet_2_0__leaf__11428_ _1056_[20] net1011 VSS VSS VDD VDD u_core.u_top.u_core.pend_p[20] sky130_fd_sc_hd__dfrtp_1
Xu_core.u_top.u_core.pend_p[21]$_DFFE_PN0P_ clknet_2_1__leaf__11428_ _1056_[21] net1011 VSS VSS VDD VDD u_core.u_top.u_core.pend_p[21] sky130_fd_sc_hd__dfrtp_1
Xu_core.u_top.u_core.pend_p[22]$_DFFE_PN0P_ clknet_2_3__leaf__11428_ _1056_[22] net1024 VSS VSS VDD VDD u_core.u_top.u_core.pend_p[22] sky130_fd_sc_hd__dfrtp_1
Xu_core.u_top.u_core.pend_p[23]$_DFFE_PN0P_ clknet_2_3__leaf__11428_ _1056_[23] net1025 VSS VSS VDD VDD u_core.u_top.u_core.pend_p[23] sky130_fd_sc_hd__dfrtp_1
Xu_core.u_top.u_core.pend_p[2]$_DFFE_PN0P_ clknet_2_2__leaf__11428_ _1056_[2] net1017 VSS VSS VDD VDD u_core.u_top.u_core.pend_p[2] sky130_fd_sc_hd__dfrtp_1
Xu_core.u_top.u_core.pend_p[3]$_DFFE_PN0P_ clknet_2_3__leaf__11428_ _1056_[3] net1024 VSS VSS VDD VDD u_core.u_top.u_core.pend_p[3] sky130_fd_sc_hd__dfrtp_1
Xu_core.u_top.u_core.pend_p[4]$_DFFE_PN0P_ clknet_2_0__leaf__11428_ _1056_[4] net1024 VSS VSS VDD VDD u_core.u_top.u_core.pend_p[4] sky130_fd_sc_hd__dfrtp_1
Xu_core.u_top.u_core.pend_p[5]$_DFFE_PN0P_ clknet_2_2__leaf__11428_ _1056_[5] net1017 VSS VSS VDD VDD u_core.u_top.u_core.pend_p[5] sky130_fd_sc_hd__dfrtp_1
Xu_core.u_top.u_core.pend_p[6]$_DFFE_PN0P_ clknet_2_2__leaf__11428_ _1056_[6] net1018 VSS VSS VDD VDD u_core.u_top.u_core.pend_p[6] sky130_fd_sc_hd__dfrtp_1
Xu_core.u_top.u_core.pend_p[7]$_DFFE_PN0P_ clknet_2_2__leaf__11428_ _1056_[7] net1023 VSS VSS VDD VDD u_core.u_top.u_core.pend_p[7] sky130_fd_sc_hd__dfrtp_1
Xu_core.u_top.u_core.pend_p[8]$_DFFE_PN0P_ clknet_2_3__leaf__11428_ _1056_[8] net1018 VSS VSS VDD VDD u_core.u_top.u_core.pend_p[8] sky130_fd_sc_hd__dfrtp_1
Xu_core.u_top.u_core.pend_p[9]$_DFFE_PN0P_ clknet_2_2__leaf__11428_ _1056_[9] net1025 VSS VSS VDD VDD u_core.u_top.u_core.pend_p[9] sky130_fd_sc_hd__dfrtp_1
Xu_core.u_top.u_core.r_cnt[0]$_DFFE_PN0P_ clknet_1_0__leaf__11364_ _1049_[0] net1020 VSS VSS VDD VDD u_core.u_top.u_core.r_cnt[0] sky130_fd_sc_hd__dfrtp_1
Xu_core.u_top.u_core.r_cnt[1]$_DFFE_PN0P_ clknet_1_0__leaf__11364_ _1049_[1] net1020 VSS VSS VDD VDD u_core.u_top.u_core.r_cnt[1] sky130_fd_sc_hd__dfrtp_1
Xu_core.u_top.u_core.r_cnt[2]$_DFFE_PN0P_ clknet_1_1__leaf__11364_ _1049_[2] net1020 VSS VSS VDD VDD u_core.u_top.u_core.r_cnt[2] sky130_fd_sc_hd__dfrtp_1
Xu_core.u_top.u_core.r_cnt[3]$_DFFE_PN0P_ clknet_1_1__leaf__11364_ _1049_[3] net1020 VSS VSS VDD VDD u_core.u_top.u_core.r_cnt[3] sky130_fd_sc_hd__dfrtp_1
Xu_core.u_top.u_core.r_cnt[4]$_DFFE_PN0P_ clknet_1_1__leaf__11364_ _1049_[4] net1020 VSS VSS VDD VDD u_core.u_top.u_core.r_cnt[4] sky130_fd_sc_hd__dfrtp_1
Xu_core.u_top.u_core.r_cnt[5]$_DFFE_PN0P_ clknet_1_1__leaf__11364_ _1049_[5] net1020 VSS VSS VDD VDD u_core.u_top.u_core.r_cnt[5] sky130_fd_sc_hd__dfrtp_1
Xu_core.u_top.u_core.r_cnt[6]$_DFFE_PN0P_ clknet_1_0__leaf__11364_ _1049_[6] net1020 VSS VSS VDD VDD u_core.u_top.u_core.r_cnt[6] sky130_fd_sc_hd__dfrtp_1
Xu_core.u_top.u_core.r_en$_DFFE_PN0P_ clknet_1_1__leaf__11348_ _10191_ net1026 VSS VSS VDD VDD u_core.u_top.u_core.r_en sky130_fd_sc_hd__dfrtp_1
Xu_core.u_top.u_core.r_ie$_DFFE_PN0P_ clknet_1_0__leaf__11348_ _0352_ net1026 VSS VSS VDD VDD u_core.u_top.u_core.r_ie sky130_fd_sc_hd__dfrtp_1
Xu_core.u_top.u_core.r_lock$_DFFE_PN0P_ _11350_ net35 net1026 VSS VSS VDD VDD u_core.u_top.u_core.r_lock sky130_fd_sc_hd__dfrtp_1
Xu_core.u_top.u_core.r_lock$_DFFE_PN0P__36 VSS VSS VDD VDD net35 nc_\u_core.u_top.u_core.r_lock$_DFFE_PN0P__36_LO sky130_fd_sc_hd__conb_1
Xu_core.u_top.u_core.r_mode$_DFFE_PN0P_ _11346_ _2033_[1] net1025 VSS VSS VDD VDD u_core.u_top.u_core.r_mode sky130_fd_sc_hd__dfrtp_1
Xu_core.u_top.u_core.r_noshuf$_DFFE_PN0P_ clknet_1_1__leaf__11352_ _2076_ net1022 VSS VSS VDD VDD u_core.u_top.u_core.r_noshuf sky130_fd_sc_hd__dfrtp_1
Xu_core.u_top.u_core.r_off[0]$_DFFE_PN0P_ clknet_1_0__leaf__11418_ u_core.u_top.u_core.lfsr[8] net1005 VSS VSS VDD VDD u_core.u_top.u_core.r_off[0] sky130_fd_sc_hd__dfrtp_2
Xu_core.u_top.u_core.r_off[1]$_DFFE_PN0P_ clknet_1_0__leaf__11418_ net991 net1005 VSS VSS VDD VDD u_core.u_top.u_core.r_off[1] sky130_fd_sc_hd__dfrtp_4
Xu_core.u_top.u_core.r_off[2]$_DFFE_PN0P_ clknet_1_1__leaf__11418_ u_core.u_top.u_core.lfsr[10] net1005 VSS VSS VDD VDD u_core.u_top.u_core.r_off[2] sky130_fd_sc_hd__dfrtp_1
Xu_core.u_top.u_core.r_off[3]$_DFFE_PN0P_ clknet_1_0__leaf__11418_ u_core.u_top.u_core.lfsr[11] net1005 VSS VSS VDD VDD u_core.u_top.u_core.r_off[3] sky130_fd_sc_hd__dfrtp_1
Xu_core.u_top.u_core.r_off[4]$_DFFE_PN0P_ clknet_1_0__leaf__11418_ u_core.u_top.u_core.lfsr[12] net1005 VSS VSS VDD VDD u_core.u_top.u_core.r_off[4] sky130_fd_sc_hd__dfrtp_1
Xu_core.u_top.u_core.r_off[5]$_DFFE_PN0P_ clknet_1_1__leaf__11418_ u_core.u_top.u_core.lfsr[13] net1005 VSS VSS VDD VDD u_core.u_top.u_core.r_off[5] sky130_fd_sc_hd__dfrtp_1
Xu_core.u_top.u_core.r_off[6]$_DFFE_PN0P_ clknet_1_1__leaf__11418_ u_core.u_top.u_core.lfsr[14] net1005 VSS VSS VDD VDD u_core.u_top.u_core.r_off[6] sky130_fd_sc_hd__dfrtp_1
Xu_core.u_top.u_core.r_off[8]$_DFFE_PN0P_ clknet_1_1__leaf__11418_ u_core.u_top.u_core.lfsr[15] net1014 VSS VSS VDD VDD u_core.u_top.u_core.r_off[7] sky130_fd_sc_hd__dfrtp_1
Xu_core.u_top.u_core.r_pdata[0]$_DFF_PN0_ clknet_3_7__leaf_clk_regs _1044_[0] net1020 VSS VSS VDD VDD u_core.u_top.u_core.r_pdata[0] sky130_fd_sc_hd__dfrtp_1
Xu_core.u_top.u_core.r_pdata[10]$_DFF_PN0_ clknet_3_5__leaf_clk_regs _1044_[10] net1018 VSS VSS VDD VDD u_core.u_top.u_core.r_pdata[10] sky130_fd_sc_hd__dfrtp_1
Xu_core.u_top.u_core.r_pdata[11]$_DFF_PN0_ clknet_3_5__leaf_clk_regs _1044_[11] net1021 VSS VSS VDD VDD u_core.u_top.u_core.r_pdata[11] sky130_fd_sc_hd__dfrtp_1
Xu_core.u_top.u_core.r_pdata[12]$_DFF_PN0_ clknet_3_6__leaf_clk_regs _1044_[12] net1018 VSS VSS VDD VDD u_core.u_top.u_core.r_pdata[12] sky130_fd_sc_hd__dfrtp_1
Xu_core.u_top.u_core.r_pdata[13]$_DFF_PN0_ clknet_3_7__leaf_clk_regs _1044_[13] net1018 VSS VSS VDD VDD u_core.u_top.u_core.r_pdata[13] sky130_fd_sc_hd__dfrtp_1
Xu_core.u_top.u_core.r_pdata[14]$_DFF_PN0_ clknet_3_6__leaf_clk_regs _1044_[14] net1018 VSS VSS VDD VDD u_core.u_top.u_core.r_pdata[14] sky130_fd_sc_hd__dfrtp_1
Xu_core.u_top.u_core.r_pdata[15]$_DFF_PN0_ clknet_3_6__leaf_clk_regs _1044_[15] net1020 VSS VSS VDD VDD u_core.u_top.u_core.r_pdata[15] sky130_fd_sc_hd__dfrtp_1
Xu_core.u_top.u_core.r_pdata[16]$_DFF_PN0_ clknet_3_6__leaf_clk_regs _1044_[16] net1018 VSS VSS VDD VDD u_core.u_top.u_core.r_pdata[16] sky130_fd_sc_hd__dfrtp_1
Xu_core.u_top.u_core.r_pdata[17]$_DFF_PN0_ clknet_3_6__leaf_clk_regs _1044_[17] net1020 VSS VSS VDD VDD u_core.u_top.u_core.r_pdata[17] sky130_fd_sc_hd__dfrtp_1
Xu_core.u_top.u_core.r_pdata[18]$_DFF_PN0_ clknet_3_6__leaf_clk_regs _1044_[18] net1018 VSS VSS VDD VDD u_core.u_top.u_core.r_pdata[18] sky130_fd_sc_hd__dfrtp_1
Xu_core.u_top.u_core.r_pdata[19]$_DFF_PN0_ clknet_3_6__leaf_clk_regs _1044_[19] net1018 VSS VSS VDD VDD u_core.u_top.u_core.r_pdata[19] sky130_fd_sc_hd__dfrtp_1
Xu_core.u_top.u_core.r_pdata[1]$_DFF_PN0_ clknet_3_7__leaf_clk_regs _1044_[1] net1020 VSS VSS VDD VDD u_core.u_top.u_core.r_pdata[1] sky130_fd_sc_hd__dfrtp_1
Xu_core.u_top.u_core.r_pdata[20]$_DFF_PN0_ clknet_3_6__leaf_clk_regs _1044_[20] net1018 VSS VSS VDD VDD u_core.u_top.u_core.r_pdata[20] sky130_fd_sc_hd__dfrtp_1
Xu_core.u_top.u_core.r_pdata[21]$_DFF_PN0_ clknet_3_6__leaf_clk_regs _1044_[21] net1018 VSS VSS VDD VDD u_core.u_top.u_core.r_pdata[21] sky130_fd_sc_hd__dfrtp_1
Xu_core.u_top.u_core.r_pdata[22]$_DFF_PN0_ clknet_3_5__leaf_clk_regs _1044_[22] net1025 VSS VSS VDD VDD u_core.u_top.u_core.r_pdata[22] sky130_fd_sc_hd__dfrtp_1
Xu_core.u_top.u_core.r_pdata[23]$_DFF_PN0_ clknet_3_1__leaf_clk_regs _1044_[23] net1025 VSS VSS VDD VDD u_core.u_top.u_core.r_pdata[23] sky130_fd_sc_hd__dfrtp_1
Xu_core.u_top.u_core.r_pdata[24]$_DFF_PN0_ clknet_3_1__leaf_clk_regs _1044_[24] net1026 VSS VSS VDD VDD u_core.u_top.u_core.r_pdata[24] sky130_fd_sc_hd__dfrtp_1
Xu_core.u_top.u_core.r_pdata[25]$_DFF_PN0_ clknet_3_0__leaf_clk_regs _1044_[25] net1026 VSS VSS VDD VDD u_core.u_top.u_core.r_pdata[25] sky130_fd_sc_hd__dfrtp_1
Xu_core.u_top.u_core.r_pdata[26]$_DFF_PN0_ clknet_3_1__leaf_clk_regs _1044_[26] net1024 VSS VSS VDD VDD u_core.u_top.u_core.r_pdata[26] sky130_fd_sc_hd__dfrtp_1
Xu_core.u_top.u_core.r_pdata[27]$_DFF_PN0_ clknet_3_5__leaf_clk_regs _1044_[27] net1022 VSS VSS VDD VDD u_core.u_top.u_core.r_pdata[27] sky130_fd_sc_hd__dfrtp_1
Xu_core.u_top.u_core.r_pdata[28]$_DFF_PN0_ clknet_3_5__leaf_clk_regs _1044_[28] net1025 VSS VSS VDD VDD u_core.u_top.u_core.r_pdata[28] sky130_fd_sc_hd__dfrtp_1
Xu_core.u_top.u_core.r_pdata[29]$_DFF_PN0_ clknet_3_5__leaf_clk_regs _1044_[29] net1018 VSS VSS VDD VDD u_core.u_top.u_core.r_pdata[29] sky130_fd_sc_hd__dfrtp_1
Xu_core.u_top.u_core.r_pdata[2]$_DFF_PN0_ clknet_3_5__leaf_clk_regs _1044_[2] net1025 VSS VSS VDD VDD u_core.u_top.u_core.r_pdata[2] sky130_fd_sc_hd__dfrtp_1
Xu_core.u_top.u_core.r_pdata[30]$_DFF_PN0_ clknet_3_1__leaf_clk_regs _1044_[30] net1026 VSS VSS VDD VDD u_core.u_top.u_core.r_pdata[30] sky130_fd_sc_hd__dfrtp_1
Xu_core.u_top.u_core.r_pdata[31]$_DFF_PN0_ clknet_3_1__leaf_clk_regs _1044_[31] net1025 VSS VSS VDD VDD u_core.u_top.u_core.r_pdata[31] sky130_fd_sc_hd__dfrtp_1
Xu_core.u_top.u_core.r_pdata[32]$_DFF_PN0_ clknet_3_1__leaf_clk_regs _1044_[32] net1025 VSS VSS VDD VDD u_core.u_top.u_core.r_pdata[32] sky130_fd_sc_hd__dfrtp_1
Xu_core.u_top.u_core.r_pdata[33]$_DFF_PN0_ clknet_3_1__leaf_clk_regs _1044_[33] net1025 VSS VSS VDD VDD u_core.u_top.u_core.r_pdata[33] sky130_fd_sc_hd__dfrtp_1
Xu_core.u_top.u_core.r_pdata[34]$_DFF_PN0_ clknet_3_1__leaf_clk_regs _1044_[34] net1026 VSS VSS VDD VDD u_core.u_top.u_core.r_pdata[34] sky130_fd_sc_hd__dfrtp_1
Xu_core.u_top.u_core.r_pdata[35]$_DFF_PN0_ clknet_3_0__leaf_clk_regs _1044_[35] net1026 VSS VSS VDD VDD u_core.u_top.u_core.r_pdata[35] sky130_fd_sc_hd__dfrtp_1
Xu_core.u_top.u_core.r_pdata[36]$_DFF_PN0_ clknet_3_1__leaf_clk_regs _1044_[36] net1011 VSS VSS VDD VDD u_core.u_top.u_core.r_pdata[36] sky130_fd_sc_hd__dfrtp_1
Xu_core.u_top.u_core.r_pdata[37]$_DFF_PN0_ clknet_3_0__leaf_clk_regs _1044_[37] net1027 VSS VSS VDD VDD u_core.u_top.u_core.r_pdata[37] sky130_fd_sc_hd__dfrtp_1
Xu_core.u_top.u_core.r_pdata[38]$_DFF_PN0_ clknet_3_3__leaf_clk_regs _1044_[38] net1011 VSS VSS VDD VDD u_core.u_top.u_core.r_pdata[38] sky130_fd_sc_hd__dfrtp_1
Xu_core.u_top.u_core.r_pdata[39]$_DFF_PN0_ clknet_3_0__leaf_clk_regs _1044_[39] net1027 VSS VSS VDD VDD u_core.u_top.u_core.r_pdata[39] sky130_fd_sc_hd__dfrtp_1
Xu_core.u_top.u_core.r_pdata[3]$_DFF_PN0_ clknet_3_4__leaf_clk_regs _1044_[3] net1022 VSS VSS VDD VDD u_core.u_top.u_core.r_pdata[3] sky130_fd_sc_hd__dfrtp_1
Xu_core.u_top.u_core.r_pdata[40]$_DFF_PN0_ clknet_3_3__leaf_clk_regs _1044_[40] net1011 VSS VSS VDD VDD u_core.u_top.u_core.r_pdata[40] sky130_fd_sc_hd__dfrtp_1
Xu_core.u_top.u_core.r_pdata[41]$_DFF_PN0_ clknet_3_0__leaf_clk_regs _1044_[41] net1027 VSS VSS VDD VDD u_core.u_top.u_core.r_pdata[41] sky130_fd_sc_hd__dfrtp_1
Xu_core.u_top.u_core.r_pdata[42]$_DFF_PN0_ clknet_3_1__leaf_clk_regs _1044_[42] net1026 VSS VSS VDD VDD u_core.u_top.u_core.r_pdata[42] sky130_fd_sc_hd__dfrtp_1
Xu_core.u_top.u_core.r_pdata[43]$_DFF_PN0_ clknet_3_0__leaf_clk_regs _1044_[43] net1026 VSS VSS VDD VDD u_core.u_top.u_core.r_pdata[43] sky130_fd_sc_hd__dfrtp_1
Xu_core.u_top.u_core.r_pdata[44]$_DFF_PN0_ clknet_3_5__leaf_clk_regs _1044_[44] net1025 VSS VSS VDD VDD u_core.u_top.u_core.r_pdata[44] sky130_fd_sc_hd__dfrtp_1
Xu_core.u_top.u_core.r_pdata[45]$_DFF_PN0_ clknet_3_5__leaf_clk_regs _1044_[45] net1022 VSS VSS VDD VDD u_core.u_top.u_core.r_pdata[45] sky130_fd_sc_hd__dfrtp_1
Xu_core.u_top.u_core.r_pdata[46]$_DFF_PN0_ clknet_3_5__leaf_clk_regs _1044_[46] net1018 VSS VSS VDD VDD u_core.u_top.u_core.r_pdata[46] sky130_fd_sc_hd__dfrtp_1
Xu_core.u_top.u_core.r_pdata[47]$_DFF_PN0_ clknet_3_5__leaf_clk_regs _1044_[47] net1021 VSS VSS VDD VDD u_core.u_top.u_core.r_pdata[47] sky130_fd_sc_hd__dfrtp_1
Xu_core.u_top.u_core.r_pdata[4]$_DFF_PN0_ clknet_3_6__leaf_clk_regs _1044_[4] net1018 VSS VSS VDD VDD u_core.u_top.u_core.r_pdata[4] sky130_fd_sc_hd__dfrtp_1
Xu_core.u_top.u_core.r_pdata[5]$_DFF_PN0_ clknet_3_6__leaf_clk_regs _1044_[5] net1020 VSS VSS VDD VDD u_core.u_top.u_core.r_pdata[5] sky130_fd_sc_hd__dfrtp_1
Xu_core.u_top.u_core.r_pdata[6]$_DFF_PN0_ clknet_3_1__leaf_clk_regs _1044_[6] net1025 VSS VSS VDD VDD u_core.u_top.u_core.r_pdata[6] sky130_fd_sc_hd__dfrtp_1
Xu_core.u_top.u_core.r_pdata[7]$_DFF_PN0_ clknet_3_5__leaf_clk_regs _1044_[7] net1026 VSS VSS VDD VDD u_core.u_top.u_core.r_pdata[7] sky130_fd_sc_hd__dfrtp_1
Xu_core.u_top.u_core.r_pdata[8]$_DFF_PN0_ clknet_3_1__leaf_clk_regs _1044_[8] net1025 VSS VSS VDD VDD u_core.u_top.u_core.r_pdata[8] sky130_fd_sc_hd__dfrtp_1
Xu_core.u_top.u_core.r_pdata[9]$_DFF_PN0_ clknet_3_4__leaf_clk_regs _1044_[9] net1022 VSS VSS VDD VDD u_core.u_top.u_core.r_pdata[9] sky130_fd_sc_hd__dfrtp_1
Xu_core.u_top.u_core.r_piter[0]$_DFFE_PN0P_ clknet_1_0__leaf__11357_ _1047_[0] net1020 VSS VSS VDD VDD u_core.u_top.u_core.r_piter[0] sky130_fd_sc_hd__dfrtp_1
Xu_core.u_top.u_core.r_piter[1]$_DFFE_PN0P_ clknet_1_0__leaf__11357_ _1047_[1] net1020 VSS VSS VDD VDD _0969_[1070] sky130_fd_sc_hd__dfrtp_1
Xu_core.u_top.u_core.r_piter[2]$_DFFE_PN0P_ clknet_1_0__leaf__11357_ _1047_[2] net1020 VSS VSS VDD VDD u_core.u_top.u_core.r_piter[2] sky130_fd_sc_hd__dfrtp_1
Xu_core.u_top.u_core.r_piter[3]$_DFFE_PN0P_ clknet_1_1__leaf__11357_ _1047_[3] net1020 VSS VSS VDD VDD u_core.u_top.u_core.r_piter[3] sky130_fd_sc_hd__dfrtp_1
Xu_core.u_top.u_core.r_piter[4]$_DFFE_PN0P_ clknet_1_1__leaf__11357_ _1047_[4] net1020 VSS VSS VDD VDD u_core.u_top.u_core.r_piter[4] sky130_fd_sc_hd__dfrtp_1
Xu_core.u_top.u_core.r_piter[5]$_DFFE_PN0P_ clknet_1_1__leaf__11357_ _1047_[5] net1020 VSS VSS VDD VDD u_core.u_top.u_core.r_piter[5] sky130_fd_sc_hd__dfrtp_1
Xu_core.u_top.u_core.r_prow[0]$_DFFE_PN0P_ clknet_1_0__leaf__11420_ net972 net1032 VSS VSS VDD VDD u_core.u_top.u_core.r_prow[0] sky130_fd_sc_hd__dfrtp_1
Xu_core.u_top.u_core.r_prow[10]$_DFFE_PN0P_ clknet_1_1__leaf__11420_ u_core.u_top.bus_wdata[10] net1021 VSS VSS VDD VDD u_core.u_top.u_core.r_prow[10] sky130_fd_sc_hd__dfrtp_1
Xu_core.u_top.u_core.r_prow[11]$_DFFE_PN0P_ clknet_1_1__leaf__11420_ u_core.u_top.bus_wdata[11] net1021 VSS VSS VDD VDD u_core.u_top.u_core.r_prow[11] sky130_fd_sc_hd__dfrtp_1
Xu_core.u_top.u_core.r_prow[1]$_DFFE_PN0P_ clknet_1_0__leaf__11420_ net971 net1032 VSS VSS VDD VDD u_core.u_top.u_core.r_prow[1] sky130_fd_sc_hd__dfrtp_1
Xu_core.u_top.u_core.r_prow[2]$_DFFE_PN0P_ clknet_1_0__leaf__11420_ net970 net1022 VSS VSS VDD VDD u_core.u_top.u_core.r_prow[2] sky130_fd_sc_hd__dfrtp_1
Xu_core.u_top.u_core.r_prow[3]$_DFFE_PN0P_ clknet_1_0__leaf__11420_ net968 net1022 VSS VSS VDD VDD u_core.u_top.u_core.r_prow[3] sky130_fd_sc_hd__dfrtp_1
Xu_core.u_top.u_core.r_prow[4]$_DFFE_PN0P_ clknet_1_1__leaf__11420_ u_core.u_top.bus_wdata[4] net1022 VSS VSS VDD VDD u_core.u_top.u_core.r_prow[4] sky130_fd_sc_hd__dfrtp_1
Xu_core.u_top.u_core.r_prow[5]$_DFFE_PN0P_ clknet_1_0__leaf__11420_ net966 net1032 VSS VSS VDD VDD u_core.u_top.u_core.r_prow[5] sky130_fd_sc_hd__dfrtp_1
Xu_core.u_top.u_core.r_prow[6]$_DFFE_PN0P_ clknet_1_0__leaf__11420_ net965 net1022 VSS VSS VDD VDD u_core.u_top.u_core.r_prow[6] sky130_fd_sc_hd__dfrtp_1
Xu_core.u_top.u_core.r_prow[7]$_DFFE_PN0P_ clknet_1_0__leaf__11420_ net964 net1022 VSS VSS VDD VDD u_core.u_top.u_core.r_prow[7] sky130_fd_sc_hd__dfrtp_1
Xu_core.u_top.u_core.r_prow[8]$_DFFE_PN0P_ clknet_1_1__leaf__11420_ u_core.u_top.bus_wdata[8] net1031 VSS VSS VDD VDD u_core.u_top.u_core.r_prow[8] sky130_fd_sc_hd__dfrtp_1
Xu_core.u_top.u_core.r_prow[9]$_DFFE_PN0P_ clknet_1_1__leaf__11420_ u_core.u_top.bus_wdata[9] net1022 VSS VSS VDD VDD u_core.u_top.u_core.r_prow[9] sky130_fd_sc_hd__dfrtp_1
Xu_core.u_top.u_core.r_tile[0]$_DFFE_PN0P_ clknet_1_0__leaf__11410_ net972 net1026 VSS VSS VDD VDD u_core.u_top.u_core.r_tile[0] sky130_fd_sc_hd__dfrtp_1
Xu_core.u_top.u_core.r_tile[10]$_DFFE_PN0P_ clknet_1_1__leaf__11410_ u_core.u_top.bus_wdata[10] net1021 VSS VSS VDD VDD u_core.u_top.u_core.r_tile[10] sky130_fd_sc_hd__dfrtp_1
Xu_core.u_top.u_core.r_tile[11]$_DFFE_PN0P_ clknet_1_1__leaf__11410_ u_core.u_top.bus_wdata[11] net1021 VSS VSS VDD VDD u_core.u_top.u_core.r_tile[11] sky130_fd_sc_hd__dfrtp_1
Xu_core.u_top.u_core.r_tile[1]$_DFFE_PN0P_ clknet_1_1__leaf__11410_ net971 net1022 VSS VSS VDD VDD u_core.u_top.u_core.r_tile[1] sky130_fd_sc_hd__dfrtp_1
Xu_core.u_top.u_core.r_tile[2]$_DFFE_PN0P_ clknet_1_1__leaf__11410_ net970 net1022 VSS VSS VDD VDD u_core.u_top.u_core.r_tile[2] sky130_fd_sc_hd__dfrtp_1
Xu_core.u_top.u_core.r_tile[3]$_DFFE_PN0P_ clknet_1_0__leaf__11410_ net968 net1026 VSS VSS VDD VDD u_core.u_top.u_core.r_tile[3] sky130_fd_sc_hd__dfrtp_1
Xu_core.u_top.u_core.r_tile[4]$_DFFE_PN0P_ clknet_1_0__leaf__11410_ u_core.u_top.bus_wdata[4] net1022 VSS VSS VDD VDD u_core.u_top.u_core.r_tile[4] sky130_fd_sc_hd__dfrtp_1
Xu_core.u_top.u_core.r_tile[5]$_DFFE_PN0P_ clknet_1_1__leaf__11410_ net966 net1021 VSS VSS VDD VDD u_core.u_top.u_core.r_tile[5] sky130_fd_sc_hd__dfrtp_1
Xu_core.u_top.u_core.r_tile[6]$_DFFE_PN0P_ clknet_1_0__leaf__11410_ net965 net1026 VSS VSS VDD VDD u_core.u_top.u_core.r_tile[6] sky130_fd_sc_hd__dfrtp_1
Xu_core.u_top.u_core.r_tile[7]$_DFFE_PN0P_ clknet_1_0__leaf__11410_ net964 net1022 VSS VSS VDD VDD u_core.u_top.u_core.r_tile[7] sky130_fd_sc_hd__dfrtp_1
Xu_core.u_top.u_core.r_tile[8]$_DFFE_PN0P_ clknet_1_0__leaf__11410_ u_core.u_top.bus_wdata[8] net1022 VSS VSS VDD VDD u_core.u_top.u_core.r_tile[8] sky130_fd_sc_hd__dfrtp_1
Xu_core.u_top.u_core.r_tile[9]$_DFFE_PN0P_ clknet_1_1__leaf__11410_ u_core.u_top.bus_wdata[9] net1022 VSS VSS VDD VDD u_core.u_top.u_core.r_tile[9] sky130_fd_sc_hd__dfrtp_1
Xu_core.u_top.u_core.r_varprog$_DFFE_PN0P_ clknet_1_0__leaf__11352_ _2079_ net1022 VSS VSS VDD VDD u_core.u_top.u_core.r_varprog sky130_fd_sc_hd__dfrtp_1
Xu_core.u_top.u_core.r_x[0]$_DFFE_PN0P_ clknet_4_9_0__11423_ _0359_[0] net1029 VSS VSS VDD VDD u_core.u_top.u_core.r_x[0] sky130_fd_sc_hd__dfrtp_1
Xu_core.u_top.u_core.r_x[100]$_DFFE_PN0P_ clknet_4_4_0__11423_ _0359_[100] net1031 VSS VSS VDD VDD u_core.u_top.u_core.r_x[100] sky130_fd_sc_hd__dfrtp_1
Xu_core.u_top.u_core.r_x[101]$_DFFE_PN0P_ clknet_4_15_0__11423_ _0359_[101] net1028 VSS VSS VDD VDD u_core.u_top.u_core.r_x[101] sky130_fd_sc_hd__dfrtp_1
Xu_core.u_top.u_core.r_x[102]$_DFFE_PN0P_ clknet_4_2_0__11423_ _0359_[102] net1030 VSS VSS VDD VDD u_core.u_top.u_core.r_x[102] sky130_fd_sc_hd__dfrtp_1
Xu_core.u_top.u_core.r_x[103]$_DFFE_PN0P_ clknet_4_1_0__11423_ _0359_[103] net1031 VSS VSS VDD VDD u_core.u_top.u_core.r_x[103] sky130_fd_sc_hd__dfrtp_1
Xu_core.u_top.u_core.r_x[104]$_DFFE_PN0P_ clknet_4_5_0__11423_ _0359_[104] net1031 VSS VSS VDD VDD u_core.u_top.u_core.r_x[104] sky130_fd_sc_hd__dfrtp_1
Xu_core.u_top.u_core.r_x[105]$_DFFE_PN0P_ clknet_4_5_0__11423_ _0359_[105] net1031 VSS VSS VDD VDD u_core.u_top.u_core.r_x[105] sky130_fd_sc_hd__dfrtp_1
Xu_core.u_top.u_core.r_x[106]$_DFFE_PN0P_ clknet_4_3_0__11423_ _0359_[106] net1030 VSS VSS VDD VDD u_core.u_top.u_core.r_x[106] sky130_fd_sc_hd__dfrtp_1
Xu_core.u_top.u_core.r_x[107]$_DFFE_PN0P_ clknet_4_6_0__11423_ _0359_[107] net1030 VSS VSS VDD VDD u_core.u_top.u_core.r_x[107] sky130_fd_sc_hd__dfrtp_1
Xu_core.u_top.u_core.r_x[108]$_DFFE_PN0P_ clknet_4_15_0__11423_ _0359_[108] net1028 VSS VSS VDD VDD u_core.u_top.u_core.r_x[108] sky130_fd_sc_hd__dfrtp_1
Xu_core.u_top.u_core.r_x[109]$_DFFE_PN0P_ clknet_4_13_0__11423_ _0359_[109] net1028 VSS VSS VDD VDD u_core.u_top.u_core.r_x[109] sky130_fd_sc_hd__dfrtp_1
Xu_core.u_top.u_core.r_x[10]$_DFFE_PN0P_ clknet_4_3_0__11423_ _0359_[10] net1030 VSS VSS VDD VDD u_core.u_top.u_core.r_x[10] sky130_fd_sc_hd__dfrtp_1
Xu_core.u_top.u_core.r_x[110]$_DFFE_PN0P_ clknet_4_10_0__11423_ _0359_[110] net1029 VSS VSS VDD VDD u_core.u_top.u_core.r_x[110] sky130_fd_sc_hd__dfrtp_1
Xu_core.u_top.u_core.r_x[111]$_DFFE_PN0P_ clknet_4_10_0__11423_ _0359_[111] net1028 VSS VSS VDD VDD u_core.u_top.u_core.r_x[111] sky130_fd_sc_hd__dfrtp_1
Xu_core.u_top.u_core.r_x[112]$_DFFE_PN0P_ clknet_4_14_0__11423_ _0359_[112] net1028 VSS VSS VDD VDD u_core.u_top.u_core.r_x[112] sky130_fd_sc_hd__dfrtp_1
Xu_core.u_top.u_core.r_x[113]$_DFFE_PN0P_ clknet_4_14_0__11423_ _0359_[113] net1028 VSS VSS VDD VDD u_core.u_top.u_core.r_x[113] sky130_fd_sc_hd__dfrtp_1
Xu_core.u_top.u_core.r_x[114]$_DFFE_PN0P_ clknet_4_8_0__11423_ _0359_[114] net1029 VSS VSS VDD VDD u_core.u_top.u_core.r_x[114] sky130_fd_sc_hd__dfrtp_1
Xu_core.u_top.u_core.r_x[115]$_DFFE_PN0P_ clknet_4_0_0__11423_ _0359_[115] net1032 VSS VSS VDD VDD u_core.u_top.u_core.r_x[115] sky130_fd_sc_hd__dfrtp_1
Xu_core.u_top.u_core.r_x[116]$_DFFE_PN0P_ clknet_4_14_0__11423_ _0359_[116] net1028 VSS VSS VDD VDD u_core.u_top.u_core.r_x[116] sky130_fd_sc_hd__dfrtp_1
Xu_core.u_top.u_core.r_x[117]$_DFFE_PN0P_ clknet_4_12_0__11423_ _0359_[117] net1028 VSS VSS VDD VDD u_core.u_top.u_core.r_x[117] sky130_fd_sc_hd__dfrtp_1
Xu_core.u_top.u_core.r_x[118]$_DFFE_PN0P_ clknet_4_3_0__11423_ _0359_[118] net1030 VSS VSS VDD VDD u_core.u_top.u_core.r_x[118] sky130_fd_sc_hd__dfrtp_1
Xu_core.u_top.u_core.r_x[119]$_DFFE_PN0P_ clknet_4_1_0__11423_ _0359_[119] net1030 VSS VSS VDD VDD u_core.u_top.u_core.r_x[119] sky130_fd_sc_hd__dfrtp_1
Xu_core.u_top.u_core.r_x[11]$_DFFE_PN0P_ clknet_4_6_0__11423_ _0359_[11] net1030 VSS VSS VDD VDD u_core.u_top.u_core.r_x[11] sky130_fd_sc_hd__dfrtp_1
Xu_core.u_top.u_core.r_x[120]$_DFFE_PN0P_ clknet_4_7_0__11423_ _0359_[120] net1030 VSS VSS VDD VDD u_core.u_top.u_core.r_x[120] sky130_fd_sc_hd__dfrtp_1
Xu_core.u_top.u_core.r_x[121]$_DFFE_PN0P_ clknet_4_7_0__11423_ _0359_[121] net1030 VSS VSS VDD VDD u_core.u_top.u_core.r_x[121] sky130_fd_sc_hd__dfrtp_1
Xu_core.u_top.u_core.r_x[122]$_DFFE_PN0P_ clknet_4_10_0__11423_ _0359_[122] net1029 VSS VSS VDD VDD u_core.u_top.u_core.r_x[122] sky130_fd_sc_hd__dfrtp_1
Xu_core.u_top.u_core.r_x[123]$_DFFE_PN0P_ clknet_4_10_0__11423_ _0359_[123] net1029 VSS VSS VDD VDD u_core.u_top.u_core.r_x[123] sky130_fd_sc_hd__dfrtp_1
Xu_core.u_top.u_core.r_x[124]$_DFFE_PN0P_ clknet_4_14_0__11423_ _0359_[124] net1028 VSS VSS VDD VDD u_core.u_top.u_core.r_x[124] sky130_fd_sc_hd__dfrtp_1
Xu_core.u_top.u_core.r_x[125]$_DFFE_PN0P_ clknet_4_14_0__11423_ _0359_[125] net1028 VSS VSS VDD VDD u_core.u_top.u_core.r_x[125] sky130_fd_sc_hd__dfrtp_1
Xu_core.u_top.u_core.r_x[126]$_DFFE_PN0P_ clknet_4_10_0__11423_ _0359_[126] net1029 VSS VSS VDD VDD u_core.u_top.u_core.r_x[126] sky130_fd_sc_hd__dfrtp_1
Xu_core.u_top.u_core.r_x[127]$_DFFE_PN0P_ clknet_4_10_0__11423_ _0359_[127] net1028 VSS VSS VDD VDD u_core.u_top.u_core.r_x[127] sky130_fd_sc_hd__dfrtp_1
Xu_core.u_top.u_core.r_x[128]$_DFFE_PN0P_ clknet_4_10_0__11423_ _0359_[128] net1028 VSS VSS VDD VDD u_core.u_top.u_core.r_x[128] sky130_fd_sc_hd__dfrtp_1
Xu_core.u_top.u_core.r_x[129]$_DFFE_PN0P_ clknet_4_15_0__11423_ _0359_[129] net1028 VSS VSS VDD VDD u_core.u_top.u_core.r_x[129] sky130_fd_sc_hd__dfrtp_1
Xu_core.u_top.u_core.r_x[12]$_DFFE_PN0P_ clknet_4_12_0__11423_ _0359_[12] net1028 VSS VSS VDD VDD u_core.u_top.u_core.r_x[12] sky130_fd_sc_hd__dfrtp_1
Xu_core.u_top.u_core.r_x[130]$_DFFE_PN0P_ clknet_4_1_0__11423_ _0359_[130] net1030 VSS VSS VDD VDD u_core.u_top.u_core.r_x[130] sky130_fd_sc_hd__dfrtp_1
Xu_core.u_top.u_core.r_x[131]$_DFFE_PN0P_ clknet_4_1_0__11423_ _0359_[131] net1031 VSS VSS VDD VDD u_core.u_top.u_core.r_x[131] sky130_fd_sc_hd__dfrtp_1
Xu_core.u_top.u_core.r_x[132]$_DFFE_PN0P_ clknet_4_8_0__11423_ _0359_[132] net1030 VSS VSS VDD VDD u_core.u_top.u_core.r_x[132] sky130_fd_sc_hd__dfrtp_1
Xu_core.u_top.u_core.r_x[133]$_DFFE_PN0P_ clknet_4_15_0__11423_ _0359_[133] net1028 VSS VSS VDD VDD u_core.u_top.u_core.r_x[133] sky130_fd_sc_hd__dfrtp_1
Xu_core.u_top.u_core.r_x[134]$_DFFE_PN0P_ clknet_4_3_0__11423_ _0359_[134] net1030 VSS VSS VDD VDD u_core.u_top.u_core.r_x[134] sky130_fd_sc_hd__dfrtp_1
Xu_core.u_top.u_core.r_x[135]$_DFFE_PN0P_ clknet_4_1_0__11423_ _0359_[135] net1031 VSS VSS VDD VDD u_core.u_top.u_core.r_x[135] sky130_fd_sc_hd__dfrtp_1
Xu_core.u_top.u_core.r_x[136]$_DFFE_PN0P_ clknet_4_1_0__11423_ _0359_[136] net1031 VSS VSS VDD VDD u_core.u_top.u_core.r_x[136] sky130_fd_sc_hd__dfrtp_1
Xu_core.u_top.u_core.r_x[137]$_DFFE_PN0P_ clknet_4_7_0__11423_ _0359_[137] net1030 VSS VSS VDD VDD u_core.u_top.u_core.r_x[137] sky130_fd_sc_hd__dfrtp_1
Xu_core.u_top.u_core.r_x[138]$_DFFE_PN0P_ clknet_4_3_0__11423_ _0359_[138] net1030 VSS VSS VDD VDD u_core.u_top.u_core.r_x[138] sky130_fd_sc_hd__dfrtp_1
Xu_core.u_top.u_core.r_x[139]$_DFFE_PN0P_ clknet_4_6_0__11423_ _0359_[139] net1029 VSS VSS VDD VDD u_core.u_top.u_core.r_x[139] sky130_fd_sc_hd__dfrtp_1
Xu_core.u_top.u_core.r_x[13]$_DFFE_PN0P_ clknet_4_13_0__11423_ _0359_[13] net1028 VSS VSS VDD VDD u_core.u_top.u_core.r_x[13] sky130_fd_sc_hd__dfrtp_1
Xu_core.u_top.u_core.r_x[140]$_DFFE_PN0P_ clknet_4_14_0__11423_ _0359_[140] net1028 VSS VSS VDD VDD u_core.u_top.u_core.r_x[140] sky130_fd_sc_hd__dfrtp_1
Xu_core.u_top.u_core.r_x[141]$_DFFE_PN0P_ clknet_4_15_0__11423_ _0359_[141] net1028 VSS VSS VDD VDD u_core.u_top.u_core.r_x[141] sky130_fd_sc_hd__dfrtp_1
Xu_core.u_top.u_core.r_x[142]$_DFFE_PN0P_ clknet_4_14_0__11423_ _0359_[142] net1028 VSS VSS VDD VDD u_core.u_top.u_core.r_x[142] sky130_fd_sc_hd__dfrtp_1
Xu_core.u_top.u_core.r_x[143]$_DFFE_PN0P_ clknet_4_14_0__11423_ _0359_[143] net1028 VSS VSS VDD VDD u_core.u_top.u_core.r_x[143] sky130_fd_sc_hd__dfrtp_1
Xu_core.u_top.u_core.r_x[14]$_DFFE_PN0P_ clknet_4_9_0__11423_ _0359_[14] net1029 VSS VSS VDD VDD u_core.u_top.u_core.r_x[14] sky130_fd_sc_hd__dfrtp_1
Xu_core.u_top.u_core.r_x[15]$_DFFE_PN0P_ clknet_4_9_0__11423_ _0359_[15] net1028 VSS VSS VDD VDD u_core.u_top.u_core.r_x[15] sky130_fd_sc_hd__dfrtp_1
Xu_core.u_top.u_core.r_x[16]$_DFFE_PN0P_ clknet_4_9_0__11423_ _0359_[16] net1030 VSS VSS VDD VDD u_core.u_top.u_core.r_x[16] sky130_fd_sc_hd__dfrtp_1
Xu_core.u_top.u_core.r_x[17]$_DFFE_PN0P_ clknet_4_13_0__11423_ _0359_[17] net1020 VSS VSS VDD VDD u_core.u_top.u_core.r_x[17] sky130_fd_sc_hd__dfrtp_1
Xu_core.u_top.u_core.r_x[18]$_DFFE_PN0P_ clknet_4_2_0__11423_ _0359_[18] net1032 VSS VSS VDD VDD u_core.u_top.u_core.r_x[18] sky130_fd_sc_hd__dfrtp_1
Xu_core.u_top.u_core.r_x[19]$_DFFE_PN0P_ clknet_4_0_0__11423_ _0359_[19] net1032 VSS VSS VDD VDD u_core.u_top.u_core.r_x[19] sky130_fd_sc_hd__dfrtp_1
Xu_core.u_top.u_core.r_x[1]$_DFFE_PN0P_ clknet_4_12_0__11423_ _0359_[1] net1028 VSS VSS VDD VDD u_core.u_top.u_core.r_x[1] sky130_fd_sc_hd__dfrtp_1
Xu_core.u_top.u_core.r_x[20]$_DFFE_PN0P_ clknet_4_12_0__11423_ _0359_[20] net1021 VSS VSS VDD VDD u_core.u_top.u_core.r_x[20] sky130_fd_sc_hd__dfrtp_1
Xu_core.u_top.u_core.r_x[21]$_DFFE_PN0P_ clknet_4_13_0__11423_ _0359_[21] net1020 VSS VSS VDD VDD u_core.u_top.u_core.r_x[21] sky130_fd_sc_hd__dfrtp_1
Xu_core.u_top.u_core.r_x[22]$_DFFE_PN0P_ clknet_4_2_0__11423_ _0359_[22] net1030 VSS VSS VDD VDD u_core.u_top.u_core.r_x[22] sky130_fd_sc_hd__dfrtp_1
Xu_core.u_top.u_core.r_x[23]$_DFFE_PN0P_ clknet_4_0_0__11423_ _0359_[23] net1032 VSS VSS VDD VDD u_core.u_top.u_core.r_x[23] sky130_fd_sc_hd__dfrtp_1
Xu_core.u_top.u_core.r_x[24]$_DFFE_PN0P_ clknet_4_4_0__11423_ _0359_[24] net1031 VSS VSS VDD VDD u_core.u_top.u_core.r_x[24] sky130_fd_sc_hd__dfrtp_1
Xu_core.u_top.u_core.r_x[25]$_DFFE_PN0P_ clknet_4_7_0__11423_ _0359_[25] net1030 VSS VSS VDD VDD u_core.u_top.u_core.r_x[25] sky130_fd_sc_hd__dfrtp_1
Xu_core.u_top.u_core.r_x[26]$_DFFE_PN0P_ clknet_4_0_0__11423_ _0359_[26] net1032 VSS VSS VDD VDD u_core.u_top.u_core.r_x[26] sky130_fd_sc_hd__dfrtp_1
Xu_core.u_top.u_core.r_x[27]$_DFFE_PN0P_ clknet_4_6_0__11423_ _0359_[27] net1029 VSS VSS VDD VDD u_core.u_top.u_core.r_x[27] sky130_fd_sc_hd__dfrtp_1
Xu_core.u_top.u_core.r_x[28]$_DFFE_PN0P_ clknet_4_13_0__11423_ _0359_[28] net1021 VSS VSS VDD VDD u_core.u_top.u_core.r_x[28] sky130_fd_sc_hd__dfrtp_1
Xu_core.u_top.u_core.r_x[29]$_DFFE_PN0P_ clknet_4_13_0__11423_ _0359_[29] net1020 VSS VSS VDD VDD u_core.u_top.u_core.r_x[29] sky130_fd_sc_hd__dfrtp_1
Xu_core.u_top.u_core.r_x[2]$_DFFE_PN0P_ clknet_4_2_0__11423_ _0359_[2] net1030 VSS VSS VDD VDD u_core.u_top.u_core.r_x[2] sky130_fd_sc_hd__dfrtp_1
Xu_core.u_top.u_core.r_x[30]$_DFFE_PN0P_ clknet_4_12_0__11423_ _0359_[30] net1030 VSS VSS VDD VDD u_core.u_top.u_core.r_x[30] sky130_fd_sc_hd__dfrtp_1
Xu_core.u_top.u_core.r_x[31]$_DFFE_PN0P_ clknet_4_9_0__11423_ _0359_[31] net1028 VSS VSS VDD VDD u_core.u_top.u_core.r_x[31] sky130_fd_sc_hd__dfrtp_1
Xu_core.u_top.u_core.r_x[32]$_DFFE_PN0P_ clknet_4_12_0__11423_ _0359_[32] net1029 VSS VSS VDD VDD u_core.u_top.u_core.r_x[32] sky130_fd_sc_hd__dfrtp_1
Xu_core.u_top.u_core.r_x[33]$_DFFE_PN0P_ clknet_4_15_0__11423_ _0359_[33] net1028 VSS VSS VDD VDD u_core.u_top.u_core.r_x[33] sky130_fd_sc_hd__dfrtp_1
Xu_core.u_top.u_core.r_x[34]$_DFFE_PN0P_ clknet_4_0_0__11423_ _0359_[34] net1032 VSS VSS VDD VDD u_core.u_top.u_core.r_x[34] sky130_fd_sc_hd__dfrtp_1
Xu_core.u_top.u_core.r_x[35]$_DFFE_PN0P_ clknet_4_0_0__11423_ _0359_[35] net1032 VSS VSS VDD VDD u_core.u_top.u_core.r_x[35] sky130_fd_sc_hd__dfrtp_1
Xu_core.u_top.u_core.r_x[36]$_DFFE_PN0P_ clknet_4_5_0__11423_ _0359_[36] net1031 VSS VSS VDD VDD u_core.u_top.u_core.r_x[36] sky130_fd_sc_hd__dfrtp_1
Xu_core.u_top.u_core.r_x[37]$_DFFE_PN0P_ clknet_4_13_0__11423_ _0359_[37] net1020 VSS VSS VDD VDD u_core.u_top.u_core.r_x[37] sky130_fd_sc_hd__dfrtp_1
Xu_core.u_top.u_core.r_x[38]$_DFFE_PN0P_ clknet_4_0_0__11423_ _0359_[38] net1032 VSS VSS VDD VDD u_core.u_top.u_core.r_x[38] sky130_fd_sc_hd__dfrtp_1
Xu_core.u_top.u_core.r_x[39]$_DFFE_PN0P_ clknet_4_1_0__11423_ _0359_[39] net1032 VSS VSS VDD VDD u_core.u_top.u_core.r_x[39] sky130_fd_sc_hd__dfrtp_1
Xu_core.u_top.u_core.r_x[3]$_DFFE_PN0P_ clknet_4_0_0__11423_ _0359_[3] net1032 VSS VSS VDD VDD u_core.u_top.u_core.r_x[3] sky130_fd_sc_hd__dfrtp_1
Xu_core.u_top.u_core.r_x[40]$_DFFE_PN0P_ clknet_4_4_0__11423_ _0359_[40] net1031 VSS VSS VDD VDD u_core.u_top.u_core.r_x[40] sky130_fd_sc_hd__dfrtp_1
Xu_core.u_top.u_core.r_x[41]$_DFFE_PN0P_ clknet_4_5_0__11423_ _0359_[41] net1022 VSS VSS VDD VDD u_core.u_top.u_core.r_x[41] sky130_fd_sc_hd__dfrtp_1
Xu_core.u_top.u_core.r_x[42]$_DFFE_PN0P_ clknet_4_1_0__11423_ _0359_[42] net1030 VSS VSS VDD VDD u_core.u_top.u_core.r_x[42] sky130_fd_sc_hd__dfrtp_1
Xu_core.u_top.u_core.r_x[43]$_DFFE_PN0P_ clknet_4_6_0__11423_ _0359_[43] net1029 VSS VSS VDD VDD u_core.u_top.u_core.r_x[43] sky130_fd_sc_hd__dfrtp_1
Xu_core.u_top.u_core.r_x[44]$_DFFE_PN0P_ clknet_4_12_0__11423_ _0359_[44] net1029 VSS VSS VDD VDD u_core.u_top.u_core.r_x[44] sky130_fd_sc_hd__dfrtp_1
Xu_core.u_top.u_core.r_x[45]$_DFFE_PN0P_ clknet_4_15_0__11423_ _0359_[45] net1028 VSS VSS VDD VDD u_core.u_top.u_core.r_x[45] sky130_fd_sc_hd__dfrtp_1
Xu_core.u_top.u_core.r_x[46]$_DFFE_PN0P_ clknet_4_12_0__11423_ _0359_[46] net1029 VSS VSS VDD VDD u_core.u_top.u_core.r_x[46] sky130_fd_sc_hd__dfrtp_1
Xu_core.u_top.u_core.r_x[47]$_DFFE_PN0P_ clknet_4_9_0__11423_ _0359_[47] net1028 VSS VSS VDD VDD u_core.u_top.u_core.r_x[47] sky130_fd_sc_hd__dfrtp_1
Xu_core.u_top.u_core.r_x[48]$_DFFE_PN0P_ clknet_4_8_0__11423_ _0359_[48] net1028 VSS VSS VDD VDD u_core.u_top.u_core.r_x[48] sky130_fd_sc_hd__dfrtp_1
Xu_core.u_top.u_core.r_x[49]$_DFFE_PN0P_ clknet_4_11_0__11423_ _0359_[49] net1028 VSS VSS VDD VDD u_core.u_top.u_core.r_x[49] sky130_fd_sc_hd__dfrtp_1
Xu_core.u_top.u_core.r_x[4]$_DFFE_PN0P_ clknet_4_9_0__11423_ _0359_[4] net1030 VSS VSS VDD VDD u_core.u_top.u_core.r_x[4] sky130_fd_sc_hd__dfrtp_1
Xu_core.u_top.u_core.r_x[50]$_DFFE_PN0P_ clknet_4_3_0__11423_ _0359_[50] net1030 VSS VSS VDD VDD u_core.u_top.u_core.r_x[50] sky130_fd_sc_hd__dfrtp_1
Xu_core.u_top.u_core.r_x[51]$_DFFE_PN0P_ clknet_4_0_0__11423_ _0359_[51] net1032 VSS VSS VDD VDD u_core.u_top.u_core.r_x[51] sky130_fd_sc_hd__dfrtp_1
Xu_core.u_top.u_core.r_x[52]$_DFFE_PN0P_ clknet_4_11_0__11423_ _0359_[52] net1028 VSS VSS VDD VDD u_core.u_top.u_core.r_x[52] sky130_fd_sc_hd__dfrtp_1
Xu_core.u_top.u_core.r_x[53]$_DFFE_PN0P_ clknet_4_11_0__11423_ _0359_[53] net1028 VSS VSS VDD VDD u_core.u_top.u_core.r_x[53] sky130_fd_sc_hd__dfrtp_1
Xu_core.u_top.u_core.r_x[54]$_DFFE_PN0P_ clknet_4_2_0__11423_ _0359_[54] net1030 VSS VSS VDD VDD u_core.u_top.u_core.r_x[54] sky130_fd_sc_hd__dfrtp_1
Xu_core.u_top.u_core.r_x[55]$_DFFE_PN0P_ clknet_4_1_0__11423_ _0359_[55] net1032 VSS VSS VDD VDD u_core.u_top.u_core.r_x[55] sky130_fd_sc_hd__dfrtp_1
Xu_core.u_top.u_core.r_x[56]$_DFFE_PN0P_ clknet_4_5_0__11423_ _0359_[56] net1030 VSS VSS VDD VDD u_core.u_top.u_core.r_x[56] sky130_fd_sc_hd__dfrtp_1
Xu_core.u_top.u_core.r_x[57]$_DFFE_PN0P_ clknet_4_7_0__11423_ _0359_[57] net1030 VSS VSS VDD VDD u_core.u_top.u_core.r_x[57] sky130_fd_sc_hd__dfrtp_1
Xu_core.u_top.u_core.r_x[58]$_DFFE_PN0P_ clknet_4_3_0__11423_ _0359_[58] net1030 VSS VSS VDD VDD u_core.u_top.u_core.r_x[58] sky130_fd_sc_hd__dfrtp_1
Xu_core.u_top.u_core.r_x[59]$_DFFE_PN0P_ clknet_4_6_0__11423_ _0359_[59] net1029 VSS VSS VDD VDD u_core.u_top.u_core.r_x[59] sky130_fd_sc_hd__dfrtp_1
Xu_core.u_top.u_core.r_x[5]$_DFFE_PN0P_ clknet_4_12_0__11423_ _0359_[5] net1028 VSS VSS VDD VDD u_core.u_top.u_core.r_x[5] sky130_fd_sc_hd__dfrtp_1
Xu_core.u_top.u_core.r_x[60]$_DFFE_PN0P_ clknet_4_11_0__11423_ _0359_[60] net1028 VSS VSS VDD VDD u_core.u_top.u_core.r_x[60] sky130_fd_sc_hd__dfrtp_1
Xu_core.u_top.u_core.r_x[61]$_DFFE_PN0P_ clknet_4_9_0__11423_ _0359_[61] net1028 VSS VSS VDD VDD u_core.u_top.u_core.r_x[61] sky130_fd_sc_hd__dfrtp_1
Xu_core.u_top.u_core.r_x[62]$_DFFE_PN0P_ clknet_4_8_0__11423_ _0359_[62] net1029 VSS VSS VDD VDD u_core.u_top.u_core.r_x[62] sky130_fd_sc_hd__dfrtp_1
Xu_core.u_top.u_core.r_x[63]$_DFFE_PN0P_ clknet_4_11_0__11423_ _0359_[63] net1028 VSS VSS VDD VDD u_core.u_top.u_core.r_x[63] sky130_fd_sc_hd__dfrtp_1
Xu_core.u_top.u_core.r_x[64]$_DFFE_PN0P_ clknet_4_10_0__11423_ _0359_[64] net1028 VSS VSS VDD VDD u_core.u_top.u_core.r_x[64] sky130_fd_sc_hd__dfrtp_1
Xu_core.u_top.u_core.r_x[65]$_DFFE_PN0P_ clknet_4_15_0__11423_ _0359_[65] net1028 VSS VSS VDD VDD u_core.u_top.u_core.r_x[65] sky130_fd_sc_hd__dfrtp_1
Xu_core.u_top.u_core.r_x[66]$_DFFE_PN0P_ clknet_4_8_0__11423_ _0359_[66] net1029 VSS VSS VDD VDD u_core.u_top.u_core.r_x[66] sky130_fd_sc_hd__dfrtp_1
Xu_core.u_top.u_core.r_x[67]$_DFFE_PN0P_ clknet_4_0_0__11423_ _0359_[67] net1032 VSS VSS VDD VDD u_core.u_top.u_core.r_x[67] sky130_fd_sc_hd__dfrtp_1
Xu_core.u_top.u_core.r_x[68]$_DFFE_PN0P_ clknet_4_9_0__11423_ _0359_[68] net1022 VSS VSS VDD VDD u_core.u_top.u_core.r_x[68] sky130_fd_sc_hd__dfrtp_1
Xu_core.u_top.u_core.r_x[69]$_DFFE_PN0P_ clknet_4_15_0__11423_ _0359_[69] net1028 VSS VSS VDD VDD u_core.u_top.u_core.r_x[69] sky130_fd_sc_hd__dfrtp_1
Xu_core.u_top.u_core.r_x[6]$_DFFE_PN0P_ clknet_4_0_0__11423_ _0359_[6] net1030 VSS VSS VDD VDD u_core.u_top.u_core.r_x[6] sky130_fd_sc_hd__dfrtp_1
Xu_core.u_top.u_core.r_x[70]$_DFFE_PN0P_ clknet_4_3_0__11423_ _0359_[70] net1030 VSS VSS VDD VDD u_core.u_top.u_core.r_x[70] sky130_fd_sc_hd__dfrtp_1
Xu_core.u_top.u_core.r_x[71]$_DFFE_PN0P_ clknet_4_1_0__11423_ _0359_[71] net1030 VSS VSS VDD VDD u_core.u_top.u_core.r_x[71] sky130_fd_sc_hd__dfrtp_1
Xu_core.u_top.u_core.r_x[72]$_DFFE_PN0P_ clknet_4_4_0__11423_ _0359_[72] net1031 VSS VSS VDD VDD u_core.u_top.u_core.r_x[72] sky130_fd_sc_hd__dfrtp_1
Xu_core.u_top.u_core.r_x[73]$_DFFE_PN0P_ clknet_4_7_0__11423_ _0359_[73] net1030 VSS VSS VDD VDD u_core.u_top.u_core.r_x[73] sky130_fd_sc_hd__dfrtp_1
Xu_core.u_top.u_core.r_x[74]$_DFFE_PN0P_ clknet_4_8_0__11423_ _0359_[74] net1029 VSS VSS VDD VDD u_core.u_top.u_core.r_x[74] sky130_fd_sc_hd__dfrtp_1
Xu_core.u_top.u_core.r_x[75]$_DFFE_PN0P_ clknet_4_6_0__11423_ _0359_[75] net1028 VSS VSS VDD VDD u_core.u_top.u_core.r_x[75] sky130_fd_sc_hd__dfrtp_1
Xu_core.u_top.u_core.r_x[76]$_DFFE_PN0P_ clknet_4_15_0__11423_ _0359_[76] net1028 VSS VSS VDD VDD u_core.u_top.u_core.r_x[76] sky130_fd_sc_hd__dfrtp_1
Xu_core.u_top.u_core.r_x[77]$_DFFE_PN0P_ clknet_4_15_0__11423_ _0359_[77] net1028 VSS VSS VDD VDD u_core.u_top.u_core.r_x[77] sky130_fd_sc_hd__dfrtp_1
Xu_core.u_top.u_core.r_x[78]$_DFFE_PN0P_ clknet_4_14_0__11423_ _0359_[78] net1028 VSS VSS VDD VDD u_core.u_top.u_core.r_x[78] sky130_fd_sc_hd__dfrtp_1
Xu_core.u_top.u_core.r_x[79]$_DFFE_PN0P_ clknet_4_10_0__11423_ _0359_[79] net1028 VSS VSS VDD VDD u_core.u_top.u_core.r_x[79] sky130_fd_sc_hd__dfrtp_1
Xu_core.u_top.u_core.r_x[7]$_DFFE_PN0P_ clknet_4_0_0__11423_ _0359_[7] net1032 VSS VSS VDD VDD u_core.u_top.u_core.r_x[7] sky130_fd_sc_hd__dfrtp_1
Xu_core.u_top.u_core.r_x[80]$_DFFE_PN0P_ clknet_4_11_0__11423_ _0359_[80] net1028 VSS VSS VDD VDD u_core.u_top.u_core.r_x[80] sky130_fd_sc_hd__dfrtp_1
Xu_core.u_top.u_core.r_x[81]$_DFFE_PN0P_ clknet_4_15_0__11423_ _0359_[81] net1028 VSS VSS VDD VDD u_core.u_top.u_core.r_x[81] sky130_fd_sc_hd__dfrtp_1
Xu_core.u_top.u_core.r_x[82]$_DFFE_PN0P_ clknet_4_3_0__11423_ _0359_[82] net1029 VSS VSS VDD VDD u_core.u_top.u_core.r_x[82] sky130_fd_sc_hd__dfrtp_1
Xu_core.u_top.u_core.r_x[83]$_DFFE_PN0P_ clknet_4_0_0__11423_ _0359_[83] net1032 VSS VSS VDD VDD u_core.u_top.u_core.r_x[83] sky130_fd_sc_hd__dfrtp_1
Xu_core.u_top.u_core.r_x[84]$_DFFE_PN0P_ clknet_4_13_0__11423_ _0359_[84] net1029 VSS VSS VDD VDD u_core.u_top.u_core.r_x[84] sky130_fd_sc_hd__dfrtp_1
Xu_core.u_top.u_core.r_x[85]$_DFFE_PN0P_ clknet_4_15_0__11423_ _0359_[85] net1028 VSS VSS VDD VDD u_core.u_top.u_core.r_x[85] sky130_fd_sc_hd__dfrtp_1
Xu_core.u_top.u_core.r_x[86]$_DFFE_PN0P_ clknet_4_2_0__11423_ _0359_[86] net1030 VSS VSS VDD VDD u_core.u_top.u_core.r_x[86] sky130_fd_sc_hd__dfrtp_1
Xu_core.u_top.u_core.r_x[87]$_DFFE_PN0P_ clknet_4_1_0__11423_ _0359_[87] net1031 VSS VSS VDD VDD u_core.u_top.u_core.r_x[87] sky130_fd_sc_hd__dfrtp_1
Xu_core.u_top.u_core.r_x[88]$_DFFE_PN0P_ clknet_4_4_0__11423_ _0359_[88] net1031 VSS VSS VDD VDD u_core.u_top.u_core.r_x[88] sky130_fd_sc_hd__dfrtp_1
Xu_core.u_top.u_core.r_x[89]$_DFFE_PN0P_ clknet_4_7_0__11423_ _0359_[89] net1021 VSS VSS VDD VDD u_core.u_top.u_core.r_x[89] sky130_fd_sc_hd__dfrtp_1
Xu_core.u_top.u_core.r_x[8]$_DFFE_PN0P_ clknet_4_4_0__11423_ _0359_[8] net1031 VSS VSS VDD VDD u_core.u_top.u_core.r_x[8] sky130_fd_sc_hd__dfrtp_1
Xu_core.u_top.u_core.r_x[90]$_DFFE_PN0P_ clknet_4_6_0__11423_ _0359_[90] net1030 VSS VSS VDD VDD u_core.u_top.u_core.r_x[90] sky130_fd_sc_hd__dfrtp_1
Xu_core.u_top.u_core.r_x[91]$_DFFE_PN0P_ clknet_4_6_0__11423_ _0359_[91] net1028 VSS VSS VDD VDD u_core.u_top.u_core.r_x[91] sky130_fd_sc_hd__dfrtp_1
Xu_core.u_top.u_core.r_x[92]$_DFFE_PN0P_ clknet_4_15_0__11423_ _0359_[92] net1028 VSS VSS VDD VDD u_core.u_top.u_core.r_x[92] sky130_fd_sc_hd__dfrtp_1
Xu_core.u_top.u_core.r_x[93]$_DFFE_PN0P_ clknet_4_15_0__11423_ _0359_[93] net1020 VSS VSS VDD VDD u_core.u_top.u_core.r_x[93] sky130_fd_sc_hd__dfrtp_1
Xu_core.u_top.u_core.r_x[94]$_DFFE_PN0P_ clknet_4_14_0__11423_ _0359_[94] net1028 VSS VSS VDD VDD u_core.u_top.u_core.r_x[94] sky130_fd_sc_hd__dfrtp_1
Xu_core.u_top.u_core.r_x[95]$_DFFE_PN0P_ clknet_4_14_0__11423_ _0359_[95] net1028 VSS VSS VDD VDD u_core.u_top.u_core.r_x[95] sky130_fd_sc_hd__dfrtp_1
Xu_core.u_top.u_core.r_x[96]$_DFFE_PN0P_ clknet_4_12_0__11423_ _0359_[96] net1030 VSS VSS VDD VDD u_core.u_top.u_core.r_x[96] sky130_fd_sc_hd__dfrtp_1
Xu_core.u_top.u_core.r_x[97]$_DFFE_PN0P_ clknet_4_15_0__11423_ _0359_[97] net1028 VSS VSS VDD VDD u_core.u_top.u_core.r_x[97] sky130_fd_sc_hd__dfrtp_1
Xu_core.u_top.u_core.r_x[98]$_DFFE_PN0P_ clknet_4_8_0__11423_ _0359_[98] net1029 VSS VSS VDD VDD u_core.u_top.u_core.r_x[98] sky130_fd_sc_hd__dfrtp_1
Xu_core.u_top.u_core.r_x[99]$_DFFE_PN0P_ clknet_4_4_0__11423_ _0359_[99] net1031 VSS VSS VDD VDD u_core.u_top.u_core.r_x[99] sky130_fd_sc_hd__dfrtp_1
Xu_core.u_top.u_core.r_x[9]$_DFFE_PN0P_ clknet_4_7_0__11423_ _0359_[9] net1022 VSS VSS VDD VDD u_core.u_top.u_core.r_x[9] sky130_fd_sc_hd__dfrtp_1
Xu_core.u_top.u_core.r_zskip$_DFFE_PN0P_ clknet_1_0__leaf__11352_ _2082_ net1022 VSS VSS VDD VDD u_core.u_top.u_core.r_zskip sky130_fd_sc_hd__dfrtp_1
Xu_core.u_top.u_core.s_done$_DFF_PN0_ clknet_3_4__leaf_clk_regs _1029_ net1025 VSS VSS VDD VDD u_core.u_top.u_core.s_done sky130_fd_sc_hd__dfrtp_1
Xu_core.u_top.u_core.s_sat$_DFFE_PN0P_ _11345_ _1038_ net1027 VSS VSS VDD VDD u_core.u_top.u_core.s_sat sky130_fd_sc_hd__dfrtp_1
Xu_core.u_top.u_core.s_werr$_DFFE_PN0P_ _11347_ _1036_ net1020 VSS VSS VDD VDD u_core.u_top.u_core.s_werr sky130_fd_sc_hd__dfrtp_1
Xu_core.u_top.u_core.state[0]$_DFFE_PN0P_ clknet_1_1__leaf__11380_ _1085_[0] net1020 VSS VSS VDD VDD u_core.u_top.u_core.state[0] sky130_fd_sc_hd__dfrtp_1
Xu_core.u_top.u_core.state[1]$_DFFE_PN0P_ clknet_1_1__leaf__11380_ _1085_[1] net1020 VSS VSS VDD VDD u_core.u_top.u_core.state[1] sky130_fd_sc_hd__dfrtp_1
Xu_core.u_top.u_core.state[2]$_DFFE_PN0P_ clknet_1_0__leaf__11380_ _1085_[2] net1020 VSS VSS VDD VDD u_core.u_top.u_core.state[2] sky130_fd_sc_hd__dfrtp_1
Xu_core.u_top.u_core.state[3]$_DFFE_PN0P_ clknet_1_0__leaf__11380_ _1085_[3] net1020 VSS VSS VDD VDD u_core.u_top.u_core.state[3] sky130_fd_sc_hd__dfrtp_1
Xu_core.u_top.u_spi.bitcnt[0]$_DFFE_PN0P_ clknet_1_0__leaf__11360_ _2294_[0] net1032 VSS VSS VDD VDD u_core.u_top.u_spi.bitcnt[0] sky130_fd_sc_hd__dfrtp_1
Xu_core.u_top.u_spi.bitcnt[1]$_DFFE_PN0P_ clknet_1_0__leaf__11360_ _2294_[1] net1032 VSS VSS VDD VDD u_core.u_top.u_spi.bitcnt[1] sky130_fd_sc_hd__dfrtp_1
Xu_core.u_top.u_spi.bitcnt[2]$_DFFE_PN0P_ clknet_1_0__leaf__11360_ _2294_[2] net1032 VSS VSS VDD VDD u_core.u_top.u_spi.bitcnt[2] sky130_fd_sc_hd__dfrtp_1
Xu_core.u_top.u_spi.bitcnt[3]$_DFFE_PN0P_ clknet_1_0__leaf__11360_ _2294_[3] net1032 VSS VSS VDD VDD u_core.u_top.u_spi.bitcnt[3] sky130_fd_sc_hd__dfrtp_1
Xu_core.u_top.u_spi.bitcnt[4]$_DFFE_PN0P_ clknet_1_1__leaf__11360_ _2294_[4] net1032 VSS VSS VDD VDD u_core.u_top.u_spi.bitcnt[4] sky130_fd_sc_hd__dfrtp_1
Xu_core.u_top.u_spi.bitcnt[5]$_DFFE_PN0P_ clknet_1_1__leaf__11360_ _2294_[5] net1031 VSS VSS VDD VDD u_core.u_top.u_spi.bitcnt[5] sky130_fd_sc_hd__dfrtp_1
Xu_core.u_top.u_spi.bitcnt[6]$_DFFE_PN0P_ clknet_1_1__leaf__11360_ _2294_[6] net1031 VSS VSS VDD VDD u_core.u_top.u_spi.bitcnt[6] sky130_fd_sc_hd__dfrtp_1
Xu_core.u_top.u_spi.cmd[0]$_DFFE_PN0P_ clknet_1_1__leaf__11389_ u_core.u_top.u_spi.mosi_s[1] net1031 VSS VSS VDD VDD u_core.u_top.u_spi.cmd[0] sky130_fd_sc_hd__dfrtp_1
Xu_core.u_top.u_spi.cmd[1]$_DFFE_PN0P_ clknet_1_0__leaf__11389_ u_core.u_top.u_spi.cmd[0] net1027 VSS VSS VDD VDD u_core.u_top.u_spi.cmd[1] sky130_fd_sc_hd__dfrtp_1
Xu_core.u_top.u_spi.cmd[2]$_DFFE_PN0P_ clknet_1_1__leaf__11389_ u_core.u_top.u_spi.cmd[1] net1027 VSS VSS VDD VDD u_core.u_top.u_spi.cmd[2] sky130_fd_sc_hd__dfrtp_1
Xu_core.u_top.u_spi.cmd[3]$_DFFE_PN0P_ clknet_1_1__leaf__11389_ u_core.u_top.u_spi.cmd[2] net1031 VSS VSS VDD VDD u_core.u_top.u_spi.cmd[3] sky130_fd_sc_hd__dfrtp_1
Xu_core.u_top.u_spi.cmd[4]$_DFFE_PN0P_ clknet_1_1__leaf__11389_ u_core.u_top.u_spi.cmd[3] net1031 VSS VSS VDD VDD u_core.u_top.u_spi.cmd[4] sky130_fd_sc_hd__dfrtp_1
Xu_core.u_top.u_spi.cmd[5]$_DFFE_PN0P_ clknet_1_0__leaf__11389_ u_core.u_top.u_spi.cmd[4] net1031 VSS VSS VDD VDD u_core.u_top.u_spi.cmd[5] sky130_fd_sc_hd__dfrtp_1
Xu_core.u_top.u_spi.cmd[6]$_DFFE_PN0P_ clknet_1_0__leaf__11389_ u_core.u_top.u_spi.cmd[5] net1031 VSS VSS VDD VDD u_core.u_top.u_spi.cmd[6] sky130_fd_sc_hd__dfrtp_1
Xu_core.u_top.u_spi.cmd[7]$_DFFE_PN0P_ clknet_1_0__leaf__11389_ u_core.u_top.u_spi.cmd[6] net1031 VSS VSS VDD VDD u_core.u_top.u_spi.cmd[7] sky130_fd_sc_hd__dfrtp_1
Xu_core.u_top.u_spi.cs_s[0]$_DFF_PN1_ clknet_3_4__leaf_clk_regs net44 net1032 VSS VSS VDD VDD u_core.u_top.u_spi.cs_s[0] sky130_fd_sc_hd__dfstp_2
Xu_core.u_top.u_spi.cs_s[1]$_DFF_PN1_ clknet_3_4__leaf_clk_regs u_core.u_top.u_spi.cs_s[0] net1032 VSS VSS VDD VDD u_core.u_top.u_spi.cs_s[1] sky130_fd_sc_hd__dfstp_2
Xu_core.u_top.u_spi.err_latch$_DFFE_PN0P_ _11354_ _2241_ net1031 VSS VSS VDD VDD u_core.u_top.u_spi.err_latch sky130_fd_sc_hd__dfrtp_1
Xu_core.u_top.u_spi.mosi_s[0]$_DFF_PN0_ clknet_3_4__leaf_clk_regs net45 net1032 VSS VSS VDD VDD u_core.u_top.u_spi.mosi_s[0] sky130_fd_sc_hd__dfrtp_1
Xu_core.u_top.u_spi.mosi_s[1]$_DFF_PN0_ clknet_3_4__leaf_clk_regs u_core.u_top.u_spi.mosi_s[0] net1032 VSS VSS VDD VDD u_core.u_top.u_spi.mosi_s[1] sky130_fd_sc_hd__dfrtp_1
Xu_core.u_top.u_spi.sck_s[0]$_DFF_PN0_ clknet_3_4__leaf_clk_regs net95 net1032 VSS VSS VDD VDD u_core.u_top.u_spi.sck_s[0] sky130_fd_sc_hd__dfrtp_1
Xu_core.u_top.u_spi.sck_s[1]$_DFF_PN0_ clknet_3_4__leaf_clk_regs u_core.u_top.u_spi.sck_s[0] net1032 VSS VSS VDD VDD u_core.u_top.u_spi.sck_s[1] sky130_fd_sc_hd__dfrtp_1
Xu_core.u_top.u_spi.sck_s[2]$_DFF_PN0_ clknet_3_0__leaf_clk_regs u_core.u_top.u_spi.sck_s[1] net1032 VSS VSS VDD VDD u_core.u_top.u_spi.sck_s[2] sky130_fd_sc_hd__dfrtp_1
Xu_core.u_top.u_spi.shift_in[0]$_DFFE_PN0P_ clknet_2_0__leaf__11361_ u_core.u_top.u_spi.mosi_s[1] net1027 VSS VSS VDD VDD u_core.u_top.u_spi.shift_in[0] sky130_fd_sc_hd__dfrtp_1
Xu_core.u_top.u_spi.shift_in[10]$_DFFE_PN0P_ clknet_2_2__leaf__11361_ u_core.u_top.u_spi.shift_in[9] net1021 VSS VSS VDD VDD u_core.u_top.u_spi.shift_in[10] sky130_fd_sc_hd__dfrtp_1
Xu_core.u_top.u_spi.shift_in[11]$_DFFE_PN0P_ clknet_2_3__leaf__11361_ u_core.u_top.u_spi.shift_in[10] net1021 VSS VSS VDD VDD u_core.u_top.u_spi.shift_in[11] sky130_fd_sc_hd__dfrtp_1
Xu_core.u_top.u_spi.shift_in[12]$_DFFE_PN0P_ clknet_2_2__leaf__11361_ u_core.u_top.u_spi.shift_in[11] net1021 VSS VSS VDD VDD u_core.u_top.u_spi.shift_in[12] sky130_fd_sc_hd__dfrtp_1
Xu_core.u_top.u_spi.shift_in[13]$_DFFE_PN0P_ clknet_2_2__leaf__11361_ u_core.u_top.u_spi.shift_in[12] net1021 VSS VSS VDD VDD u_core.u_top.u_spi.shift_in[13] sky130_fd_sc_hd__dfrtp_1
Xu_core.u_top.u_spi.shift_in[14]$_DFFE_PN0P_ clknet_2_2__leaf__11361_ u_core.u_top.u_spi.shift_in[13] net1021 VSS VSS VDD VDD u_core.u_top.u_spi.shift_in[14] sky130_fd_sc_hd__dfrtp_1
Xu_core.u_top.u_spi.shift_in[15]$_DFFE_PN0P_ clknet_2_3__leaf__11361_ u_core.u_top.u_spi.shift_in[14] net1021 VSS VSS VDD VDD u_core.u_top.u_spi.shift_in[15] sky130_fd_sc_hd__dfrtp_1
Xu_core.u_top.u_spi.shift_in[16]$_DFFE_PN0P_ clknet_2_3__leaf__11361_ u_core.u_top.u_spi.shift_in[15] net1021 VSS VSS VDD VDD u_core.u_top.u_spi.shift_in[16] sky130_fd_sc_hd__dfrtp_1
Xu_core.u_top.u_spi.shift_in[17]$_DFFE_PN0P_ clknet_2_3__leaf__11361_ u_core.u_top.u_spi.shift_in[16] net1018 VSS VSS VDD VDD u_core.u_top.u_spi.shift_in[17] sky130_fd_sc_hd__dfrtp_1
Xu_core.u_top.u_spi.shift_in[18]$_DFFE_PN0P_ clknet_2_3__leaf__11361_ u_core.u_top.u_spi.shift_in[17] net1018 VSS VSS VDD VDD u_core.u_top.u_spi.shift_in[18] sky130_fd_sc_hd__dfrtp_1
Xu_core.u_top.u_spi.shift_in[19]$_DFFE_PN0P_ clknet_2_3__leaf__11361_ u_core.u_top.u_spi.shift_in[18] net1018 VSS VSS VDD VDD u_core.u_top.u_spi.shift_in[19] sky130_fd_sc_hd__dfrtp_1
Xu_core.u_top.u_spi.shift_in[1]$_DFFE_PN0P_ clknet_2_0__leaf__11361_ u_core.u_top.u_spi.shift_in[0] net1027 VSS VSS VDD VDD u_core.u_top.u_spi.shift_in[1] sky130_fd_sc_hd__dfrtp_1
Xu_core.u_top.u_spi.shift_in[20]$_DFFE_PN0P_ clknet_2_3__leaf__11361_ u_core.u_top.u_spi.shift_in[19] net1018 VSS VSS VDD VDD u_core.u_top.u_spi.shift_in[20] sky130_fd_sc_hd__dfrtp_1
Xu_core.u_top.u_spi.shift_in[21]$_DFFE_PN0P_ clknet_2_1__leaf__11361_ u_core.u_top.u_spi.shift_in[20] net1025 VSS VSS VDD VDD u_core.u_top.u_spi.shift_in[21] sky130_fd_sc_hd__dfrtp_1
Xu_core.u_top.u_spi.shift_in[22]$_DFFE_PN0P_ clknet_2_1__leaf__11361_ u_core.u_top.u_spi.shift_in[21] net1025 VSS VSS VDD VDD u_core.u_top.u_spi.shift_in[22] sky130_fd_sc_hd__dfrtp_1
Xu_core.u_top.u_spi.shift_in[23]$_DFFE_PN0P_ clknet_2_1__leaf__11361_ u_core.u_top.u_spi.shift_in[22] net1025 VSS VSS VDD VDD u_core.u_top.u_spi.shift_in[23] sky130_fd_sc_hd__dfrtp_1
Xu_core.u_top.u_spi.shift_in[24]$_DFFE_PN0P_ clknet_2_1__leaf__11361_ u_core.u_top.u_spi.shift_in[23] net1025 VSS VSS VDD VDD u_core.u_top.u_spi.shift_in[24] sky130_fd_sc_hd__dfrtp_1
Xu_core.u_top.u_spi.shift_in[25]$_DFFE_PN0P_ clknet_2_1__leaf__11361_ u_core.u_top.u_spi.shift_in[24] net1025 VSS VSS VDD VDD u_core.u_top.u_spi.shift_in[25] sky130_fd_sc_hd__dfrtp_1
Xu_core.u_top.u_spi.shift_in[26]$_DFFE_PN0P_ clknet_2_3__leaf__11361_ u_core.u_top.u_spi.shift_in[25] net1022 VSS VSS VDD VDD u_core.u_top.u_spi.shift_in[26] sky130_fd_sc_hd__dfrtp_1
Xu_core.u_top.u_spi.shift_in[27]$_DFFE_PN0P_ clknet_2_3__leaf__11361_ u_core.u_top.u_spi.shift_in[26] net1022 VSS VSS VDD VDD u_core.u_top.u_spi.shift_in[27] sky130_fd_sc_hd__dfrtp_1
Xu_core.u_top.u_spi.shift_in[28]$_DFFE_PN0P_ clknet_2_3__leaf__11361_ u_core.u_top.u_spi.shift_in[27] net1018 VSS VSS VDD VDD u_core.u_top.u_spi.shift_in[28] sky130_fd_sc_hd__dfrtp_1
Xu_core.u_top.u_spi.shift_in[29]$_DFFE_PN0P_ clknet_2_3__leaf__11361_ u_core.u_top.u_spi.shift_in[28] net1018 VSS VSS VDD VDD u_core.u_top.u_spi.shift_in[29] sky130_fd_sc_hd__dfrtp_1
Xu_core.u_top.u_spi.shift_in[2]$_DFFE_PN0P_ clknet_2_0__leaf__11361_ u_core.u_top.u_spi.shift_in[1] net1027 VSS VSS VDD VDD u_core.u_top.u_spi.shift_in[2] sky130_fd_sc_hd__dfrtp_1
Xu_core.u_top.u_spi.shift_in[30]$_DFFE_PN0P_ clknet_2_3__leaf__11361_ u_core.u_top.u_spi.shift_in[29] net1022 VSS VSS VDD VDD u_core.u_top.u_spi.shift_in[30] sky130_fd_sc_hd__dfrtp_1
Xu_core.u_top.u_spi.shift_in[31]$_DFFE_PN0P_ clknet_2_3__leaf__11361_ u_core.u_top.u_spi.shift_in[30] net1022 VSS VSS VDD VDD u_core.u_top.u_spi.shift_in[31] sky130_fd_sc_hd__dfrtp_1
Xu_core.u_top.u_spi.shift_in[32]$_DFFE_PN0P_ clknet_2_3__leaf__11361_ u_core.u_top.u_spi.shift_in[31] net1025 VSS VSS VDD VDD u_core.u_top.u_spi.shift_in[32] sky130_fd_sc_hd__dfrtp_1
Xu_core.u_top.u_spi.shift_in[33]$_DFFE_PN0P_ clknet_2_1__leaf__11361_ u_core.u_top.u_spi.shift_in[32] net1026 VSS VSS VDD VDD u_core.u_top.u_spi.shift_in[33] sky130_fd_sc_hd__dfrtp_1
Xu_core.u_top.u_spi.shift_in[34]$_DFFE_PN0P_ clknet_2_0__leaf__11361_ u_core.u_top.u_spi.shift_in[33] net1026 VSS VSS VDD VDD u_core.u_top.u_spi.shift_in[34] sky130_fd_sc_hd__dfrtp_1
Xu_core.u_top.u_spi.shift_in[35]$_DFFE_PN0P_ clknet_2_0__leaf__11361_ u_core.u_top.u_spi.shift_in[34] net1027 VSS VSS VDD VDD u_core.u_top.u_spi.shift_in[35] sky130_fd_sc_hd__dfrtp_1
Xu_core.u_top.u_spi.shift_in[36]$_DFFE_PN0P_ clknet_2_0__leaf__11361_ u_core.u_top.u_spi.shift_in[35] net1027 VSS VSS VDD VDD u_core.u_top.u_spi.shift_in[36] sky130_fd_sc_hd__dfrtp_1
Xu_core.u_top.u_spi.shift_in[37]$_DFFE_PN0P_ clknet_2_0__leaf__11361_ u_core.u_top.u_spi.shift_in[36] net1027 VSS VSS VDD VDD u_core.u_top.u_spi.shift_in[37] sky130_fd_sc_hd__dfrtp_1
Xu_core.u_top.u_spi.shift_in[38]$_DFFE_PN0P_ clknet_2_0__leaf__11361_ u_core.u_top.u_spi.shift_in[37] net1027 VSS VSS VDD VDD u_core.u_top.u_spi.shift_in[38] sky130_fd_sc_hd__dfrtp_1
Xu_core.u_top.u_spi.shift_in[39]$_DFFE_PN0P_ clknet_2_0__leaf__11361_ u_core.u_top.u_spi.shift_in[38] net1027 VSS VSS VDD VDD u_core.u_top.u_spi.shift_in[39] sky130_fd_sc_hd__dfrtp_1
Xu_core.u_top.u_spi.shift_in[3]$_DFFE_PN0P_ clknet_2_0__leaf__11361_ u_core.u_top.u_spi.shift_in[2] net1027 VSS VSS VDD VDD u_core.u_top.u_spi.shift_in[3] sky130_fd_sc_hd__dfrtp_1
Xu_core.u_top.u_spi.shift_in[40]$_DFFE_PN0P_ clknet_2_0__leaf__11361_ u_core.u_top.u_spi.shift_in[39] net1027 VSS VSS VDD VDD u_core.u_top.u_spi.shift_in[40] sky130_fd_sc_hd__dfrtp_1
Xu_core.u_top.u_spi.shift_in[41]$_DFFE_PN0P_ clknet_2_0__leaf__11361_ u_core.u_top.u_spi.shift_in[40] net1026 VSS VSS VDD VDD u_core.u_top.u_spi.shift_in[41] sky130_fd_sc_hd__dfrtp_1
Xu_core.u_top.u_spi.shift_in[42]$_DFFE_PN0P_ clknet_2_1__leaf__11361_ u_core.u_top.u_spi.shift_in[41] net1026 VSS VSS VDD VDD u_core.u_top.u_spi.shift_in[42] sky130_fd_sc_hd__dfrtp_1
Xu_core.u_top.u_spi.shift_in[43]$_DFFE_PN0P_ clknet_2_2__leaf__11361_ u_core.u_top.u_spi.shift_in[42] net1021 VSS VSS VDD VDD u_core.u_top.u_spi.shift_in[43] sky130_fd_sc_hd__dfrtp_1
Xu_core.u_top.u_spi.shift_in[44]$_DFFE_PN0P_ clknet_2_2__leaf__11361_ u_core.u_top.u_spi.shift_in[43] net1021 VSS VSS VDD VDD u_core.u_top.u_spi.shift_in[44] sky130_fd_sc_hd__dfrtp_1
Xu_core.u_top.u_spi.shift_in[45]$_DFFE_PN0P_ clknet_2_2__leaf__11361_ u_core.u_top.u_spi.shift_in[44] net1021 VSS VSS VDD VDD u_core.u_top.u_spi.shift_in[45] sky130_fd_sc_hd__dfrtp_1
Xu_core.u_top.u_spi.shift_in[46]$_DFFE_PN0P_ clknet_2_2__leaf__11361_ u_core.u_top.u_spi.shift_in[45] net1021 VSS VSS VDD VDD u_core.u_top.u_spi.shift_in[46] sky130_fd_sc_hd__dfrtp_1
Xu_core.u_top.u_spi.shift_in[4]$_DFFE_PN0P_ clknet_2_0__leaf__11361_ u_core.u_top.u_spi.shift_in[3] net1026 VSS VSS VDD VDD u_core.u_top.u_spi.shift_in[4] sky130_fd_sc_hd__dfrtp_1
Xu_core.u_top.u_spi.shift_in[5]$_DFFE_PN0P_ clknet_2_0__leaf__11361_ u_core.u_top.u_spi.shift_in[4] net1026 VSS VSS VDD VDD u_core.u_top.u_spi.shift_in[5] sky130_fd_sc_hd__dfrtp_1
Xu_core.u_top.u_spi.shift_in[6]$_DFFE_PN0P_ clknet_2_1__leaf__11361_ u_core.u_top.u_spi.shift_in[5] net1026 VSS VSS VDD VDD u_core.u_top.u_spi.shift_in[6] sky130_fd_sc_hd__dfrtp_1
Xu_core.u_top.u_spi.shift_in[7]$_DFFE_PN0P_ clknet_2_1__leaf__11361_ u_core.u_top.u_spi.shift_in[6] net1026 VSS VSS VDD VDD u_core.u_top.u_spi.shift_in[7] sky130_fd_sc_hd__dfrtp_1
Xu_core.u_top.u_spi.shift_in[8]$_DFFE_PN0P_ clknet_2_2__leaf__11361_ u_core.u_top.u_spi.shift_in[7] net1022 VSS VSS VDD VDD u_core.u_top.u_spi.shift_in[8] sky130_fd_sc_hd__dfrtp_1
Xu_core.u_top.u_spi.shift_in[9]$_DFFE_PN0P_ clknet_2_2__leaf__11361_ u_core.u_top.u_spi.shift_in[8] net1022 VSS VSS VDD VDD u_core.u_top.u_spi.shift_in[9] sky130_fd_sc_hd__dfrtp_1
Xu_core.u_top.u_spi.shift_out[0]$_DFFE_PN0N_ clknet_2_0__leaf__11419_ _2236_[0] net1027 VSS VSS VDD VDD u_core.u_top.u_spi.shift_out[0] sky130_fd_sc_hd__dfrtp_1
Xu_core.u_top.u_spi.shift_out[10]$_DFFE_PN0N_ clknet_2_0__leaf__11419_ _2236_[10] net1022 VSS VSS VDD VDD u_core.u_top.u_spi.shift_out[10] sky130_fd_sc_hd__dfrtp_1
Xu_core.u_top.u_spi.shift_out[11]$_DFFE_PN0N_ clknet_2_0__leaf__11419_ _2236_[11] net1022 VSS VSS VDD VDD u_core.u_top.u_spi.shift_out[11] sky130_fd_sc_hd__dfrtp_1
Xu_core.u_top.u_spi.shift_out[12]$_DFFE_PN0N_ clknet_2_3__leaf__11419_ _2236_[12] net1018 VSS VSS VDD VDD u_core.u_top.u_spi.shift_out[12] sky130_fd_sc_hd__dfrtp_1
Xu_core.u_top.u_spi.shift_out[13]$_DFFE_PN0N_ clknet_2_3__leaf__11419_ _2236_[13] net1018 VSS VSS VDD VDD u_core.u_top.u_spi.shift_out[13] sky130_fd_sc_hd__dfrtp_1
Xu_core.u_top.u_spi.shift_out[14]$_DFFE_PN0N_ clknet_2_3__leaf__11419_ _2236_[14] net1020 VSS VSS VDD VDD u_core.u_top.u_spi.shift_out[14] sky130_fd_sc_hd__dfrtp_1
Xu_core.u_top.u_spi.shift_out[15]$_DFFE_PN0N_ clknet_2_2__leaf__11419_ _2236_[15] net1020 VSS VSS VDD VDD u_core.u_top.u_spi.shift_out[15] sky130_fd_sc_hd__dfrtp_1
Xu_core.u_top.u_spi.shift_out[16]$_DFFE_PN0N_ clknet_2_2__leaf__11419_ _2236_[16] net1020 VSS VSS VDD VDD u_core.u_top.u_spi.shift_out[16] sky130_fd_sc_hd__dfrtp_1
Xu_core.u_top.u_spi.shift_out[17]$_DFFE_PN0N_ clknet_2_2__leaf__11419_ _2236_[17] net1020 VSS VSS VDD VDD u_core.u_top.u_spi.shift_out[17] sky130_fd_sc_hd__dfrtp_1
Xu_core.u_top.u_spi.shift_out[18]$_DFFE_PN0N_ clknet_2_3__leaf__11419_ _2236_[18] net1020 VSS VSS VDD VDD u_core.u_top.u_spi.shift_out[18] sky130_fd_sc_hd__dfrtp_1
Xu_core.u_top.u_spi.shift_out[19]$_DFFE_PN0N_ clknet_2_3__leaf__11419_ _2236_[19] net1020 VSS VSS VDD VDD u_core.u_top.u_spi.shift_out[19] sky130_fd_sc_hd__dfrtp_1
Xu_core.u_top.u_spi.shift_out[1]$_DFFE_PN0N_ clknet_2_0__leaf__11419_ _2236_[1] net1026 VSS VSS VDD VDD u_core.u_top.u_spi.shift_out[1] sky130_fd_sc_hd__dfrtp_1
Xu_core.u_top.u_spi.shift_out[20]$_DFFE_PN0N_ clknet_2_2__leaf__11419_ _2236_[20] net1020 VSS VSS VDD VDD u_core.u_top.u_spi.shift_out[20] sky130_fd_sc_hd__dfrtp_1
Xu_core.u_top.u_spi.shift_out[21]$_DFFE_PN0N_ clknet_2_2__leaf__11419_ _2236_[21] net1020 VSS VSS VDD VDD u_core.u_top.u_spi.shift_out[21] sky130_fd_sc_hd__dfrtp_1
Xu_core.u_top.u_spi.shift_out[22]$_DFFE_PN0N_ clknet_2_1__leaf__11419_ _2236_[22] net1022 VSS VSS VDD VDD u_core.u_top.u_spi.shift_out[22] sky130_fd_sc_hd__dfrtp_1
Xu_core.u_top.u_spi.shift_out[23]$_DFFE_PN0N_ clknet_2_1__leaf__11419_ _2236_[23] net1022 VSS VSS VDD VDD u_core.u_top.u_spi.shift_out[23] sky130_fd_sc_hd__dfrtp_1
Xu_core.u_top.u_spi.shift_out[24]$_DFFE_PN0N_ clknet_2_1__leaf__11419_ _2236_[24] net1025 VSS VSS VDD VDD u_core.u_top.u_spi.shift_out[24] sky130_fd_sc_hd__dfrtp_1
Xu_core.u_top.u_spi.shift_out[25]$_DFFE_PN0N_ clknet_2_1__leaf__11419_ _2236_[25] net1022 VSS VSS VDD VDD u_core.u_top.u_spi.shift_out[25] sky130_fd_sc_hd__dfrtp_1
Xu_core.u_top.u_spi.shift_out[26]$_DFFE_PN0N_ clknet_2_1__leaf__11419_ _2236_[26] net1022 VSS VSS VDD VDD u_core.u_top.u_spi.shift_out[26] sky130_fd_sc_hd__dfrtp_1
Xu_core.u_top.u_spi.shift_out[27]$_DFFE_PN0N_ clknet_2_3__leaf__11419_ _2236_[27] net1018 VSS VSS VDD VDD u_core.u_top.u_spi.shift_out[27] sky130_fd_sc_hd__dfrtp_1
Xu_core.u_top.u_spi.shift_out[28]$_DFFE_PN0N_ clknet_2_3__leaf__11419_ _2236_[28] net1020 VSS VSS VDD VDD u_core.u_top.u_spi.shift_out[28] sky130_fd_sc_hd__dfrtp_1
Xu_core.u_top.u_spi.shift_out[29]$_DFFE_PN0N_ clknet_2_2__leaf__11419_ _2236_[29] net1020 VSS VSS VDD VDD u_core.u_top.u_spi.shift_out[29] sky130_fd_sc_hd__dfrtp_1
Xu_core.u_top.u_spi.shift_out[2]$_DFFE_PN0N_ clknet_2_0__leaf__11419_ _2236_[2] net1026 VSS VSS VDD VDD u_core.u_top.u_spi.shift_out[2] sky130_fd_sc_hd__dfrtp_1
Xu_core.u_top.u_spi.shift_out[30]$_DFFE_PN0N_ clknet_2_2__leaf__11419_ _2236_[30] net1020 VSS VSS VDD VDD u_core.u_top.u_spi.shift_out[30] sky130_fd_sc_hd__dfrtp_1
Xu_core.u_top.u_spi.shift_out[31]$_DFFE_PN0N_ clknet_2_2__leaf__11419_ _2236_[31] net1020 VSS VSS VDD VDD u_core.u_top.u_spi.shift_out[31] sky130_fd_sc_hd__dfrtp_1
Xu_core.u_top.u_spi.shift_out[32]$_DFFE_PN0N_ clknet_2_3__leaf__11419_ _2236_[32] net1020 VSS VSS VDD VDD u_core.u_top.u_spi.shift_out[32] sky130_fd_sc_hd__dfrtp_1
Xu_core.u_top.u_spi.shift_out[33]$_DFFE_PN0N_ clknet_2_3__leaf__11419_ _2236_[33] net1020 VSS VSS VDD VDD u_core.u_top.u_spi.shift_out[33] sky130_fd_sc_hd__dfrtp_1
Xu_core.u_top.u_spi.shift_out[34]$_DFFE_PN0N_ clknet_2_1__leaf__11419_ _2236_[34] net1026 VSS VSS VDD VDD u_core.u_top.u_spi.shift_out[34] sky130_fd_sc_hd__dfrtp_1
Xu_core.u_top.u_spi.shift_out[35]$_DFFE_PN0N_ clknet_2_1__leaf__11419_ _2236_[35] net1026 VSS VSS VDD VDD u_core.u_top.u_spi.shift_out[35] sky130_fd_sc_hd__dfrtp_1
Xu_core.u_top.u_spi.shift_out[36]$_DFFE_PN0N_ clknet_2_1__leaf__11419_ _2236_[36] net1026 VSS VSS VDD VDD u_core.u_top.u_spi.shift_out[36] sky130_fd_sc_hd__dfrtp_1
Xu_core.u_top.u_spi.shift_out[37]$_DFFE_PN0N_ clknet_2_1__leaf__11419_ _2236_[37] net1026 VSS VSS VDD VDD u_core.u_top.u_spi.shift_out[37] sky130_fd_sc_hd__dfrtp_1
Xu_core.u_top.u_spi.shift_out[38]$_DFFE_PN0N_ clknet_2_1__leaf__11419_ _2236_[38] net1026 VSS VSS VDD VDD u_core.u_top.u_spi.shift_out[38] sky130_fd_sc_hd__dfrtp_1
Xu_core.u_top.u_spi.shift_out[39]$_DFFE_PN0N_ clknet_2_1__leaf__11419_ _2236_[39] net1026 VSS VSS VDD VDD u_core.u_top.u_spi.shift_out[39] sky130_fd_sc_hd__dfrtp_1
Xu_core.u_top.u_spi.shift_out[3]$_DFFE_PN0N_ clknet_2_0__leaf__11419_ _2236_[3] net1027 VSS VSS VDD VDD u_core.u_top.u_spi.shift_out[3] sky130_fd_sc_hd__dfrtp_1
Xu_core.u_top.u_spi.shift_out[40]$_DFFE_PN0N_ clknet_2_1__leaf__11419_ _2236_[40] net1026 VSS VSS VDD VDD u_core.u_top.u_spi.shift_out[40] sky130_fd_sc_hd__dfrtp_1
Xu_core.u_top.u_spi.shift_out[41]$_DFFE_PN0N_ clknet_2_1__leaf__11419_ _2236_[41] net1026 VSS VSS VDD VDD u_core.u_top.u_spi.shift_out[41] sky130_fd_sc_hd__dfrtp_1
Xu_core.u_top.u_spi.shift_out[42]$_DFFE_PN0N_ clknet_2_1__leaf__11419_ _2236_[42] net1026 VSS VSS VDD VDD u_core.u_top.u_spi.shift_out[42] sky130_fd_sc_hd__dfrtp_1
Xu_core.u_top.u_spi.shift_out[43]$_DFFE_PN0N_ clknet_2_1__leaf__11419_ _2236_[43] net1025 VSS VSS VDD VDD u_core.u_top.u_spi.shift_out[43] sky130_fd_sc_hd__dfrtp_1
Xu_core.u_top.u_spi.shift_out[44]$_DFFE_PN0N_ clknet_2_1__leaf__11419_ _2236_[44] net1022 VSS VSS VDD VDD u_core.u_top.u_spi.shift_out[44] sky130_fd_sc_hd__dfrtp_1
Xu_core.u_top.u_spi.shift_out[45]$_DFFE_PN0N_ clknet_2_3__leaf__11419_ _2236_[45] net1022 VSS VSS VDD VDD u_core.u_top.u_spi.shift_out[45] sky130_fd_sc_hd__dfrtp_1
Xu_core.u_top.u_spi.shift_out[46]$_DFFE_PN0N_ clknet_2_3__leaf__11419_ _2236_[46] net1021 VSS VSS VDD VDD u_core.u_top.u_spi.shift_out[46] sky130_fd_sc_hd__dfrtp_1
Xu_core.u_top.u_spi.shift_out[47]$_DFFE_PN0N_ clknet_2_3__leaf__11419_ _2236_[47] net1021 VSS VSS VDD VDD u_core.u_top.u_spi.shift_out[47] sky130_fd_sc_hd__dfrtp_1
Xu_core.u_top.u_spi.shift_out[4]$_DFFE_PN0N_ clknet_2_0__leaf__11419_ _2236_[4] net1027 VSS VSS VDD VDD u_core.u_top.u_spi.shift_out[4] sky130_fd_sc_hd__dfrtp_1
Xu_core.u_top.u_spi.shift_out[5]$_DFFE_PN0N_ clknet_2_0__leaf__11419_ _2236_[5] net1027 VSS VSS VDD VDD u_core.u_top.u_spi.shift_out[5] sky130_fd_sc_hd__dfrtp_1
Xu_core.u_top.u_spi.shift_out[6]$_DFFE_PN0N_ clknet_2_0__leaf__11419_ _2236_[6] net1027 VSS VSS VDD VDD u_core.u_top.u_spi.shift_out[6] sky130_fd_sc_hd__dfrtp_1
Xu_core.u_top.u_spi.shift_out[7]$_DFFE_PN0N_ clknet_2_0__leaf__11419_ _2236_[7] net1022 VSS VSS VDD VDD u_core.u_top.u_spi.shift_out[7] sky130_fd_sc_hd__dfrtp_1
Xu_core.u_top.u_spi.shift_out[8]$_DFFE_PN0N_ clknet_2_0__leaf__11419_ _2236_[8] net1022 VSS VSS VDD VDD u_core.u_top.u_spi.shift_out[8] sky130_fd_sc_hd__dfrtp_1
Xu_core.u_top.u_spi.shift_out[9]$_DFFE_PN0N_ clknet_2_0__leaf__11419_ _2236_[9] net1022 VSS VSS VDD VDD u_core.u_top.u_spi.shift_out[9] sky130_fd_sc_hd__dfrtp_1
Xwire1040 _1305_ VSS VSS VDD VDD net1039 sky130_fd_sc_hd__buf_2
Xwire1041 _08867_ VSS VSS VDD VDD net1040 sky130_fd_sc_hd__buf_1
Xwl_on[0]$_DFFE_PN0P_ clknet_3_0__leaf__11407_ _1093_[0] net1017 VSS VSS VDD VDD net159 sky130_fd_sc_hd__dfrtp_1
Xwl_on[10]$_DFFE_PN0P_ clknet_3_7__leaf__11407_ _1093_[10] net1016 VSS VSS VDD VDD net160 sky130_fd_sc_hd__dfrtp_1
Xwl_on[11]$_DFFE_PN0P_ clknet_3_2__leaf__11407_ _1093_[11] net1023 VSS VSS VDD VDD net161 sky130_fd_sc_hd__dfrtp_1
Xwl_on[12]$_DFFE_PN0P_ clknet_3_2__leaf__11407_ _1093_[12] net1023 VSS VSS VDD VDD net162 sky130_fd_sc_hd__dfrtp_1
Xwl_on[13]$_DFFE_PN0P_ clknet_3_2__leaf__11407_ _1093_[13] net1023 VSS VSS VDD VDD net163 sky130_fd_sc_hd__dfrtp_1
Xwl_on[14]$_DFFE_PN0P_ clknet_3_2__leaf__11407_ _1093_[14] net1017 VSS VSS VDD VDD net164 sky130_fd_sc_hd__dfrtp_1
Xwl_on[15]$_DFFE_PN0P_ clknet_3_2__leaf__11407_ _1093_[15] net1023 VSS VSS VDD VDD net165 sky130_fd_sc_hd__dfrtp_1
Xwl_on[16]$_DFFE_PN0P_ clknet_3_3__leaf__11407_ _1093_[16] net1017 VSS VSS VDD VDD net166 sky130_fd_sc_hd__dfrtp_1
Xwl_on[17]$_DFFE_PN0P_ clknet_3_1__leaf__11407_ _1093_[17] net1017 VSS VSS VDD VDD net167 sky130_fd_sc_hd__dfrtp_1
Xwl_on[18]$_DFFE_PN0P_ clknet_3_4__leaf__11407_ _1093_[18] net1016 VSS VSS VDD VDD net168 sky130_fd_sc_hd__dfrtp_1
Xwl_on[19]$_DFFE_PN0P_ clknet_3_4__leaf__11407_ _1093_[19] net1019 VSS VSS VDD VDD net169 sky130_fd_sc_hd__dfrtp_1
Xwl_on[1]$_DFFE_PN0P_ clknet_3_6__leaf__11407_ _1093_[1] net1016 VSS VSS VDD VDD net170 sky130_fd_sc_hd__dfrtp_1
Xwl_on[20]$_DFFE_PN0P_ clknet_3_4__leaf__11407_ _1093_[20] net1019 VSS VSS VDD VDD net171 sky130_fd_sc_hd__dfrtp_1
Xwl_on[21]$_DFFE_PN0P_ clknet_3_6__leaf__11407_ _1093_[21] net1016 VSS VSS VDD VDD net172 sky130_fd_sc_hd__dfrtp_1
Xwl_on[22]$_DFFE_PN0P_ clknet_3_6__leaf__11407_ _1093_[22] net1016 VSS VSS VDD VDD net173 sky130_fd_sc_hd__dfrtp_1
Xwl_on[23]$_DFFE_PN0P_ clknet_3_6__leaf__11407_ _1093_[23] net1016 VSS VSS VDD VDD net174 sky130_fd_sc_hd__dfrtp_1
Xwl_on[24]$_DFFE_PN0P_ clknet_3_4__leaf__11407_ _1093_[24] net1019 VSS VSS VDD VDD net175 sky130_fd_sc_hd__dfrtp_1
Xwl_on[25]$_DFFE_PN0P_ clknet_3_6__leaf__11407_ _1093_[25] net1016 VSS VSS VDD VDD net176 sky130_fd_sc_hd__dfrtp_1
Xwl_on[26]$_DFFE_PN0P_ clknet_3_6__leaf__11407_ _1093_[26] net1016 VSS VSS VDD VDD net177 sky130_fd_sc_hd__dfrtp_1
Xwl_on[27]$_DFFE_PN0P_ clknet_3_2__leaf__11407_ _1093_[27] net1017 VSS VSS VDD VDD net178 sky130_fd_sc_hd__dfrtp_1
Xwl_on[28]$_DFFE_PN0P_ clknet_3_3__leaf__11407_ _1093_[28] net1017 VSS VSS VDD VDD net179 sky130_fd_sc_hd__dfrtp_1
Xwl_on[29]$_DFFE_PN0P_ clknet_3_3__leaf__11407_ _1093_[29] net1023 VSS VSS VDD VDD net180 sky130_fd_sc_hd__dfrtp_1
Xwl_on[2]$_DFFE_PN0P_ clknet_3_5__leaf__11407_ _1093_[2] net1016 VSS VSS VDD VDD net181 sky130_fd_sc_hd__dfrtp_1
Xwl_on[30]$_DFFE_PN0P_ clknet_3_3__leaf__11407_ _1093_[30] net1017 VSS VSS VDD VDD net182 sky130_fd_sc_hd__dfrtp_1
Xwl_on[31]$_DFFE_PN0P_ clknet_3_1__leaf__11407_ _1093_[31] net1017 VSS VSS VDD VDD net183 sky130_fd_sc_hd__dfrtp_1
Xwl_on[32]$_DFFE_PN0P_ clknet_3_0__leaf__11407_ _1093_[32] net1017 VSS VSS VDD VDD net184 sky130_fd_sc_hd__dfrtp_1
Xwl_on[33]$_DFFE_PN0P_ clknet_3_0__leaf__11407_ _1093_[33] net1017 VSS VSS VDD VDD net185 sky130_fd_sc_hd__dfrtp_1
Xwl_on[34]$_DFFE_PN0P_ clknet_3_4__leaf__11407_ _1093_[34] net1016 VSS VSS VDD VDD net186 sky130_fd_sc_hd__dfrtp_1
Xwl_on[35]$_DFFE_PN0P_ clknet_3_4__leaf__11407_ _1093_[35] net1016 VSS VSS VDD VDD net187 sky130_fd_sc_hd__dfrtp_1
Xwl_on[36]$_DFFE_PN0P_ clknet_3_4__leaf__11407_ _1093_[36] net1019 VSS VSS VDD VDD net188 sky130_fd_sc_hd__dfrtp_1
Xwl_on[37]$_DFFE_PN0P_ clknet_3_6__leaf__11407_ _1093_[37] net1016 VSS VSS VDD VDD net189 sky130_fd_sc_hd__dfrtp_1
Xwl_on[38]$_DFFE_PN0P_ clknet_3_6__leaf__11407_ _1093_[38] net1016 VSS VSS VDD VDD net190 sky130_fd_sc_hd__dfrtp_1
Xwl_on[39]$_DFFE_PN0P_ clknet_3_1__leaf__11407_ _1093_[39] net1016 VSS VSS VDD VDD net191 sky130_fd_sc_hd__dfrtp_1
Xwl_on[3]$_DFFE_PN0P_ clknet_3_7__leaf__11407_ _1093_[3] net1019 VSS VSS VDD VDD net192 sky130_fd_sc_hd__dfrtp_1
Xwl_on[40]$_DFFE_PN0P_ clknet_3_4__leaf__11407_ _1093_[40] net1016 VSS VSS VDD VDD net193 sky130_fd_sc_hd__dfrtp_1
Xwl_on[41]$_DFFE_PN0P_ clknet_3_6__leaf__11407_ _1093_[41] net1016 VSS VSS VDD VDD net194 sky130_fd_sc_hd__dfrtp_1
Xwl_on[42]$_DFFE_PN0P_ clknet_3_1__leaf__11407_ _1093_[42] net1016 VSS VSS VDD VDD net195 sky130_fd_sc_hd__dfrtp_1
Xwl_on[43]$_DFFE_PN0P_ clknet_3_2__leaf__11407_ _1093_[43] net1023 VSS VSS VDD VDD net196 sky130_fd_sc_hd__dfrtp_1
Xwl_on[44]$_DFFE_PN0P_ clknet_3_2__leaf__11407_ _1093_[44] net1023 VSS VSS VDD VDD net197 sky130_fd_sc_hd__dfrtp_1
Xwl_on[45]$_DFFE_PN0P_ clknet_3_2__leaf__11407_ _1093_[45] net1023 VSS VSS VDD VDD net198 sky130_fd_sc_hd__dfrtp_1
Xwl_on[46]$_DFFE_PN0P_ clknet_3_2__leaf__11407_ _1093_[46] net1017 VSS VSS VDD VDD net199 sky130_fd_sc_hd__dfrtp_1
Xwl_on[47]$_DFFE_PN0P_ clknet_3_2__leaf__11407_ _1093_[47] net1023 VSS VSS VDD VDD net200 sky130_fd_sc_hd__dfrtp_1
Xwl_on[48]$_DFFE_PN0P_ clknet_3_0__leaf__11407_ _1093_[48] net1017 VSS VSS VDD VDD net201 sky130_fd_sc_hd__dfrtp_1
Xwl_on[49]$_DFFE_PN0P_ clknet_3_0__leaf__11407_ _1093_[49] net1017 VSS VSS VDD VDD net202 sky130_fd_sc_hd__dfrtp_1
Xwl_on[4]$_DFFE_PN0P_ clknet_3_5__leaf__11407_ _1093_[4] net1019 VSS VSS VDD VDD net203 sky130_fd_sc_hd__dfrtp_1
Xwl_on[50]$_DFFE_PN0P_ clknet_3_4__leaf__11407_ _1093_[50] net1016 VSS VSS VDD VDD net204 sky130_fd_sc_hd__dfrtp_1
Xwl_on[51]$_DFFE_PN0P_ clknet_3_5__leaf__11407_ _1093_[51] net1019 VSS VSS VDD VDD net205 sky130_fd_sc_hd__dfrtp_1
Xwl_on[52]$_DFFE_PN0P_ clknet_3_5__leaf__11407_ _1093_[52] net1019 VSS VSS VDD VDD net206 sky130_fd_sc_hd__dfrtp_1
Xwl_on[53]$_DFFE_PN0P_ clknet_3_7__leaf__11407_ _1093_[53] net1016 VSS VSS VDD VDD net207 sky130_fd_sc_hd__dfrtp_1
Xwl_on[54]$_DFFE_PN0P_ clknet_3_7__leaf__11407_ _1093_[54] net1016 VSS VSS VDD VDD net208 sky130_fd_sc_hd__dfrtp_1
Xwl_on[55]$_DFFE_PN0P_ clknet_3_6__leaf__11407_ _1093_[55] net1016 VSS VSS VDD VDD net209 sky130_fd_sc_hd__dfrtp_1
Xwl_on[56]$_DFFE_PN0P_ clknet_3_5__leaf__11407_ _1093_[56] net1019 VSS VSS VDD VDD net210 sky130_fd_sc_hd__dfrtp_1
Xwl_on[57]$_DFFE_PN0P_ clknet_3_7__leaf__11407_ _1093_[57] net1016 VSS VSS VDD VDD net211 sky130_fd_sc_hd__dfrtp_1
Xwl_on[58]$_DFFE_PN0P_ clknet_3_7__leaf__11407_ _1093_[58] net1016 VSS VSS VDD VDD net212 sky130_fd_sc_hd__dfrtp_1
Xwl_on[59]$_DFFE_PN0P_ clknet_3_1__leaf__11407_ _1093_[59] net1017 VSS VSS VDD VDD net213 sky130_fd_sc_hd__dfrtp_1
Xwl_on[5]$_DFFE_PN0P_ clknet_3_7__leaf__11407_ _1093_[5] net1016 VSS VSS VDD VDD net214 sky130_fd_sc_hd__dfrtp_1
Xwl_on[60]$_DFFE_PN0P_ clknet_3_0__leaf__11407_ _1093_[60] net1017 VSS VSS VDD VDD net215 sky130_fd_sc_hd__dfrtp_1
Xwl_on[61]$_DFFE_PN0P_ clknet_3_3__leaf__11407_ _1093_[61] net1017 VSS VSS VDD VDD net216 sky130_fd_sc_hd__dfrtp_1
Xwl_on[62]$_DFFE_PN0P_ clknet_3_1__leaf__11407_ _1093_[62] net1017 VSS VSS VDD VDD net217 sky130_fd_sc_hd__dfrtp_1
Xwl_on[63]$_DFFE_PN0P_ clknet_3_3__leaf__11407_ _1093_[63] net1017 VSS VSS VDD VDD net218 sky130_fd_sc_hd__dfrtp_1
Xwl_on[64]$_DFFE_PN0P_ clknet_3_0__leaf__11407_ _1093_[64] net1017 VSS VSS VDD VDD net219 sky130_fd_sc_hd__dfrtp_1
Xwl_on[65]$_DFFE_PN0P_ clknet_3_6__leaf__11407_ _1093_[65] net1016 VSS VSS VDD VDD net220 sky130_fd_sc_hd__dfrtp_1
Xwl_on[66]$_DFFE_PN0P_ clknet_3_5__leaf__11407_ _1093_[66] net1016 VSS VSS VDD VDD net221 sky130_fd_sc_hd__dfrtp_1
Xwl_on[67]$_DFFE_PN0P_ clknet_3_5__leaf__11407_ _1093_[67] net1019 VSS VSS VDD VDD net222 sky130_fd_sc_hd__dfrtp_1
Xwl_on[68]$_DFFE_PN0P_ clknet_3_5__leaf__11407_ _1093_[68] net1019 VSS VSS VDD VDD net223 sky130_fd_sc_hd__dfrtp_1
Xwl_on[69]$_DFFE_PN0P_ clknet_3_7__leaf__11407_ _1093_[69] net1016 VSS VSS VDD VDD net224 sky130_fd_sc_hd__dfrtp_1
Xwl_on[6]$_DFFE_PN0P_ clknet_3_7__leaf__11407_ _1093_[6] net1016 VSS VSS VDD VDD net225 sky130_fd_sc_hd__dfrtp_1
Xwl_on[70]$_DFFE_PN0P_ clknet_3_7__leaf__11407_ _1093_[70] net1016 VSS VSS VDD VDD net226 sky130_fd_sc_hd__dfrtp_1
Xwl_on[71]$_DFFE_PN0P_ clknet_3_7__leaf__11407_ _1093_[71] net1016 VSS VSS VDD VDD net227 sky130_fd_sc_hd__dfrtp_1
Xwl_on[7]$_DFFE_PN0P_ clknet_3_7__leaf__11407_ _1093_[7] net1016 VSS VSS VDD VDD net228 sky130_fd_sc_hd__dfrtp_1
Xwl_on[8]$_DFFE_PN0P_ clknet_3_5__leaf__11407_ _1093_[8] net1019 VSS VSS VDD VDD net229 sky130_fd_sc_hd__dfrtp_1
Xwl_on[9]$_DFFE_PN0P_ clknet_3_7__leaf__11407_ _1093_[9] net1016 VSS VSS VDD VDD net230 sky130_fd_sc_hd__dfrtp_1
Xwl_prog$_DFFE_PN0P_ clknet_2_2__leaf__11421_ _1095_ net1017 VSS VSS VDD VDD net231 sky130_fd_sc_hd__dfrtp_1
XANTENNA_1 _0215_ VSS VSS VDD VDD sky130_fd_sc_hd__diode_2
XANTENNA_10 net840 VSS VSS VDD VDD sky130_fd_sc_hd__diode_2
XANTENNA_100 _02495_ VSS VSS VDD VDD sky130_fd_sc_hd__diode_2
XANTENNA_1000 clk VSS VSS VDD VDD sky130_fd_sc_hd__diode_2
XANTENNA_1001 clk VSS VSS VDD VDD sky130_fd_sc_hd__diode_2
XANTENNA_1002 net44 VSS VSS VDD VDD sky130_fd_sc_hd__diode_2
XANTENNA_1003 net154 VSS VSS VDD VDD sky130_fd_sc_hd__diode_2
XANTENNA_1004 net154 VSS VSS VDD VDD sky130_fd_sc_hd__diode_2
XANTENNA_1005 net154 VSS VSS VDD VDD sky130_fd_sc_hd__diode_2
XANTENNA_1006 net154 VSS VSS VDD VDD sky130_fd_sc_hd__diode_2
XANTENNA_1007 net154 VSS VSS VDD VDD sky130_fd_sc_hd__diode_2
XANTENNA_1008 net154 VSS VSS VDD VDD sky130_fd_sc_hd__diode_2
XANTENNA_1009 net154 VSS VSS VDD VDD sky130_fd_sc_hd__diode_2
XANTENNA_101 _0249_[9] VSS VSS VDD VDD sky130_fd_sc_hd__diode_2
XANTENNA_1010 net154 VSS VSS VDD VDD sky130_fd_sc_hd__diode_2
XANTENNA_1011 net154 VSS VSS VDD VDD sky130_fd_sc_hd__diode_2
XANTENNA_1012 net154 VSS VSS VDD VDD sky130_fd_sc_hd__diode_2
XANTENNA_1013 net154 VSS VSS VDD VDD sky130_fd_sc_hd__diode_2
XANTENNA_1014 net95 VSS VSS VDD VDD sky130_fd_sc_hd__diode_2
XANTENNA_1015 u_core.arr_mask_n[0] VSS VSS VDD VDD sky130_fd_sc_hd__diode_2
XANTENNA_1016 u_core.arr_mask_n[22] VSS VSS VDD VDD sky130_fd_sc_hd__diode_2
XANTENNA_1017 u_core.arr_mask_n[23] VSS VSS VDD VDD sky130_fd_sc_hd__diode_2
XANTENNA_1018 u_core.arr_mask_p[6] VSS VSS VDD VDD sky130_fd_sc_hd__diode_2
XANTENNA_1019 u_core.arr_row[3] VSS VSS VDD VDD sky130_fd_sc_hd__diode_2
XANTENNA_102 _02515_ VSS VSS VDD VDD sky130_fd_sc_hd__diode_2
XANTENNA_1020 u_core.arr_sa_n[23] VSS VSS VDD VDD sky130_fd_sc_hd__diode_2
XANTENNA_1021 u_core.arr_sa_n[9] VSS VSS VDD VDD sky130_fd_sc_hd__diode_2
XANTENNA_1022 u_core.arr_sa_p[22] VSS VSS VDD VDD sky130_fd_sc_hd__diode_2
XANTENNA_1023 u_core.arr_sa_p[8] VSS VSS VDD VDD sky130_fd_sc_hd__diode_2
XANTENNA_1024 u_core.u_actl.q1_n[23] VSS VSS VDD VDD sky130_fd_sc_hd__diode_2
XANTENNA_1025 u_core.u_top.bus_addr[0] VSS VSS VDD VDD sky130_fd_sc_hd__diode_2
XANTENNA_1026 u_core.u_top.bus_re VSS VSS VDD VDD sky130_fd_sc_hd__diode_2
XANTENNA_1027 u_core.u_top.bus_wdata[26] VSS VSS VDD VDD sky130_fd_sc_hd__diode_2
XANTENNA_1028 u_core.u_top.bus_wdata[29] VSS VSS VDD VDD sky130_fd_sc_hd__diode_2
XANTENNA_1029 u_core.u_top.bus_wdata[42] VSS VSS VDD VDD sky130_fd_sc_hd__diode_2
XANTENNA_103 _0254_[3] VSS VSS VDD VDD sky130_fd_sc_hd__diode_2
XANTENNA_1030 u_core.u_top.bus_wdata[42] VSS VSS VDD VDD sky130_fd_sc_hd__diode_2
XANTENNA_1031 u_core.u_top.bus_wdata[43] VSS VSS VDD VDD sky130_fd_sc_hd__diode_2
XANTENNA_1032 u_core.u_top.bus_wdata[4] VSS VSS VDD VDD sky130_fd_sc_hd__diode_2
XANTENNA_1033 u_core.u_top.u_core.acc[0] VSS VSS VDD VDD sky130_fd_sc_hd__diode_2
XANTENNA_1034 u_core.u_top.u_core.acc[103] VSS VSS VDD VDD sky130_fd_sc_hd__diode_2
XANTENNA_1035 u_core.u_top.u_core.acc[103] VSS VSS VDD VDD sky130_fd_sc_hd__diode_2
XANTENNA_1036 u_core.u_top.u_core.acc[113] VSS VSS VDD VDD sky130_fd_sc_hd__diode_2
XANTENNA_1037 u_core.u_top.u_core.acc[151] VSS VSS VDD VDD sky130_fd_sc_hd__diode_2
XANTENNA_1038 u_core.u_top.u_core.acc[159] VSS VSS VDD VDD sky130_fd_sc_hd__diode_2
XANTENNA_1039 u_core.u_top.u_core.acc[177] VSS VSS VDD VDD sky130_fd_sc_hd__diode_2
XANTENNA_104 _02924_ VSS VSS VDD VDD sky130_fd_sc_hd__diode_2
XANTENNA_1040 u_core.u_top.u_core.acc[227] VSS VSS VDD VDD sky130_fd_sc_hd__diode_2
XANTENNA_1041 u_core.u_top.u_core.acc[24] VSS VSS VDD VDD sky130_fd_sc_hd__diode_2
XANTENNA_1042 u_core.u_top.u_core.acc[4] VSS VSS VDD VDD sky130_fd_sc_hd__diode_2
XANTENNA_1043 u_core.u_top.u_core.acc[4] VSS VSS VDD VDD sky130_fd_sc_hd__diode_2
XANTENNA_1044 u_core.u_top.u_core.acc[7] VSS VSS VDD VDD sky130_fd_sc_hd__diode_2
XANTENNA_1045 u_core.u_top.u_core.acc[8] VSS VSS VDD VDD sky130_fd_sc_hd__diode_2
XANTENNA_1046 u_core.u_top.u_core.acc_upd[136] VSS VSS VDD VDD sky130_fd_sc_hd__diode_2
XANTENNA_1047 u_core.u_top.u_core.acc_upd[136] VSS VSS VDD VDD sky130_fd_sc_hd__diode_2
XANTENNA_1048 u_core.u_top.u_core.acc_upd[216] VSS VSS VDD VDD sky130_fd_sc_hd__diode_2
XANTENNA_1049 u_core.u_top.u_core.amp[3] VSS VSS VDD VDD sky130_fd_sc_hd__diode_2
XANTENNA_105 _0327_[4] VSS VSS VDD VDD sky130_fd_sc_hd__diode_2
XANTENNA_1050 u_core.u_top.u_core.lfsr_m72[3] VSS VSS VDD VDD sky130_fd_sc_hd__diode_2
XANTENNA_1051 u_core.u_top.u_core.lfsr_m72[6] VSS VSS VDD VDD sky130_fd_sc_hd__diode_2
XANTENNA_1052 u_core.u_top.u_core.lfsr_m72[6] VSS VSS VDD VDD sky130_fd_sc_hd__diode_2
XANTENNA_1053 u_core.u_top.u_core.m_fail[14] VSS VSS VDD VDD sky130_fd_sc_hd__diode_2
XANTENNA_1054 u_core.u_top.u_core.r_off[0] VSS VSS VDD VDD sky130_fd_sc_hd__diode_2
XANTENNA_1055 u_core.u_top.u_core.r_off[0] VSS VSS VDD VDD sky130_fd_sc_hd__diode_2
XANTENNA_1056 u_core.u_top.u_core.r_off[0] VSS VSS VDD VDD sky130_fd_sc_hd__diode_2
XANTENNA_1057 u_core.u_top.u_core.r_off[0] VSS VSS VDD VDD sky130_fd_sc_hd__diode_2
XANTENNA_1058 u_core.u_top.u_core.r_off[0] VSS VSS VDD VDD sky130_fd_sc_hd__diode_2
XANTENNA_1059 u_core.u_top.u_core.r_off[0] VSS VSS VDD VDD sky130_fd_sc_hd__diode_2
XANTENNA_106 _0333_[0] VSS VSS VDD VDD sky130_fd_sc_hd__diode_2
XANTENNA_1060 u_core.u_top.u_core.r_off[0] VSS VSS VDD VDD sky130_fd_sc_hd__diode_2
XANTENNA_1061 u_core.u_top.u_core.r_off[0] VSS VSS VDD VDD sky130_fd_sc_hd__diode_2
XANTENNA_1062 u_core.u_top.u_core.r_pdata[1] VSS VSS VDD VDD sky130_fd_sc_hd__diode_2
XANTENNA_1063 u_core.u_top.u_core.r_pdata[24] VSS VSS VDD VDD sky130_fd_sc_hd__diode_2
XANTENNA_1064 u_core.u_top.u_core.r_pdata[28] VSS VSS VDD VDD sky130_fd_sc_hd__diode_2
XANTENNA_1065 u_core.u_top.u_core.r_pdata[29] VSS VSS VDD VDD sky130_fd_sc_hd__diode_2
XANTENNA_1066 u_core.u_top.u_core.r_pdata[29] VSS VSS VDD VDD sky130_fd_sc_hd__diode_2
XANTENNA_1067 u_core.u_top.u_core.r_pdata[2] VSS VSS VDD VDD sky130_fd_sc_hd__diode_2
XANTENNA_1068 u_core.u_top.u_core.r_pdata[7] VSS VSS VDD VDD sky130_fd_sc_hd__diode_2
XANTENNA_1069 u_core.u_top.u_core.r_prow[6] VSS VSS VDD VDD sky130_fd_sc_hd__diode_2
XANTENNA_107 _03483_ VSS VSS VDD VDD sky130_fd_sc_hd__diode_2
XANTENNA_1070 u_core.u_top.u_core.r_x[14] VSS VSS VDD VDD sky130_fd_sc_hd__diode_2
XANTENNA_1071 u_core.u_top.u_core.r_x[22] VSS VSS VDD VDD sky130_fd_sc_hd__diode_2
XANTENNA_1072 u_core.u_top.u_core.r_x[25] VSS VSS VDD VDD sky130_fd_sc_hd__diode_2
XANTENNA_1073 u_core.u_top.u_core.r_x[4] VSS VSS VDD VDD sky130_fd_sc_hd__diode_2
XANTENNA_1074 u_core.u_top.u_core.r_x[54] VSS VSS VDD VDD sky130_fd_sc_hd__diode_2
XANTENNA_1075 u_core.u_top.u_core.r_x[82] VSS VSS VDD VDD sky130_fd_sc_hd__diode_2
XANTENNA_1076 u_core.u_top.u_core.r_x[82] VSS VSS VDD VDD sky130_fd_sc_hd__diode_2
XANTENNA_1077 u_core.u_top.u_core.r_x[89] VSS VSS VDD VDD sky130_fd_sc_hd__diode_2
XANTENNA_1078 u_core.u_top.u_core.r_x[9] VSS VSS VDD VDD sky130_fd_sc_hd__diode_2
XANTENNA_1079 u_core.u_top.u_core.state[1] VSS VSS VDD VDD sky130_fd_sc_hd__diode_2
XANTENNA_108 _03483_ VSS VSS VDD VDD sky130_fd_sc_hd__diode_2
XANTENNA_1080 u_core.u_top.u_spi.cmd[6] VSS VSS VDD VDD sky130_fd_sc_hd__diode_2
XANTENNA_1081 u_core.u_top.u_spi.shift_in[32] VSS VSS VDD VDD sky130_fd_sc_hd__diode_2
XANTENNA_1082 u_core.u_top.u_spi.shift_in[32] VSS VSS VDD VDD sky130_fd_sc_hd__diode_2
XANTENNA_1083 u_core.u_top.u_spi.shift_out[33] VSS VSS VDD VDD sky130_fd_sc_hd__diode_2
XANTENNA_1084 u_core.u_top.u_spi.shift_out[33] VSS VSS VDD VDD sky130_fd_sc_hd__diode_2
XANTENNA_1085 u_core.u_top.u_spi.shift_out[33] VSS VSS VDD VDD sky130_fd_sc_hd__diode_2
XANTENNA_1086 u_core.u_top.u_spi.shift_out[33] VSS VSS VDD VDD sky130_fd_sc_hd__diode_2
XANTENNA_1087 u_core.u_top.u_spi.shift_out[33] VSS VSS VDD VDD sky130_fd_sc_hd__diode_2
XANTENNA_1088 u_core.u_top.u_spi.shift_out[33] VSS VSS VDD VDD sky130_fd_sc_hd__diode_2
XANTENNA_1089 net231 VSS VSS VDD VDD sky130_fd_sc_hd__diode_2
XANTENNA_109 _03483_ VSS VSS VDD VDD sky130_fd_sc_hd__diode_2
XANTENNA_1090 sa_n[14] VSS VSS VDD VDD sky130_fd_sc_hd__diode_2
XANTENNA_1091 sa_n[11] VSS VSS VDD VDD sky130_fd_sc_hd__diode_2
XANTENNA_1092 mosi VSS VSS VDD VDD sky130_fd_sc_hd__diode_2
XANTENNA_1093 cfg_ts[2] VSS VSS VDD VDD sky130_fd_sc_hd__diode_2
XANTENNA_1094 cfg_ts[1] VSS VSS VDD VDD sky130_fd_sc_hd__diode_2
XANTENNA_1095 cfg_tr[1] VSS VSS VDD VDD sky130_fd_sc_hd__diode_2
XANTENNA_1096 cfg_tr[0] VSS VSS VDD VDD sky130_fd_sc_hd__diode_2
XANTENNA_1097 cfg_tp[0] VSS VSS VDD VDD sky130_fd_sc_hd__diode_2
XANTENNA_1098 sa_n[23] VSS VSS VDD VDD sky130_fd_sc_hd__diode_2
XANTENNA_1099 sa_n[21] VSS VSS VDD VDD sky130_fd_sc_hd__diode_2
XANTENNA_11 net840 VSS VSS VDD VDD sky130_fd_sc_hd__diode_2
XANTENNA_110 _03483_ VSS VSS VDD VDD sky130_fd_sc_hd__diode_2
XANTENNA_1100 net35 VSS VSS VDD VDD sky130_fd_sc_hd__diode_2
XANTENNA_1101 clknet_2_2__leaf__11361_ VSS VSS VDD VDD sky130_fd_sc_hd__diode_2
XANTENNA_1102 clknet_2_2__leaf__11361_ VSS VSS VDD VDD sky130_fd_sc_hd__diode_2
XANTENNA_1103 clknet_1_1__leaf__11355_ VSS VSS VDD VDD sky130_fd_sc_hd__diode_2
XANTENNA_1104 delaynet_3_clk VSS VSS VDD VDD sky130_fd_sc_hd__diode_2
XANTENNA_1105 delaynet_8_clk VSS VSS VDD VDD sky130_fd_sc_hd__diode_2
XANTENNA_1106 delaynet_20_clk VSS VSS VDD VDD sky130_fd_sc_hd__diode_2
XANTENNA_1107 net1039 VSS VSS VDD VDD sky130_fd_sc_hd__diode_2
XANTENNA_1108 net1039 VSS VSS VDD VDD sky130_fd_sc_hd__diode_2
XANTENNA_1109 net966 VSS VSS VDD VDD sky130_fd_sc_hd__diode_2
XANTENNA_111 _03484_ VSS VSS VDD VDD sky130_fd_sc_hd__diode_2
XANTENNA_1110 net835 VSS VSS VDD VDD sky130_fd_sc_hd__diode_2
XANTENNA_1111 net835 VSS VSS VDD VDD sky130_fd_sc_hd__diode_2
XANTENNA_1112 _11243_ VSS VSS VDD VDD sky130_fd_sc_hd__diode_2
XANTENNA_1113 _11259_ VSS VSS VDD VDD sky130_fd_sc_hd__diode_2
XANTENNA_1114 u_core.u_top.u_core.r_pdata[33] VSS VSS VDD VDD sky130_fd_sc_hd__diode_2
XANTENNA_1115 u_core.u_top.u_core.r_pdata[33] VSS VSS VDD VDD sky130_fd_sc_hd__diode_2
XANTENNA_1116 u_core.u_top.u_core.r_x[136] VSS VSS VDD VDD sky130_fd_sc_hd__diode_2
XANTENNA_1117 u_core.u_top.u_core.r_x[136] VSS VSS VDD VDD sky130_fd_sc_hd__diode_2
XANTENNA_1118 u_core.u_top.u_core.r_x[136] VSS VSS VDD VDD sky130_fd_sc_hd__diode_2
XANTENNA_1119 u_core.u_top.u_core.r_x[67] VSS VSS VDD VDD sky130_fd_sc_hd__diode_2
XANTENNA_112 _03485_ VSS VSS VDD VDD sky130_fd_sc_hd__diode_2
XANTENNA_1120 _06865_ VSS VSS VDD VDD sky130_fd_sc_hd__diode_2
XANTENNA_1121 net843 VSS VSS VDD VDD sky130_fd_sc_hd__diode_2
XANTENNA_1122 net826 VSS VSS VDD VDD sky130_fd_sc_hd__diode_2
XANTENNA_1123 net966 VSS VSS VDD VDD sky130_fd_sc_hd__diode_2
XANTENNA_113 _03485_ VSS VSS VDD VDD sky130_fd_sc_hd__diode_2
XANTENNA_114 _03485_ VSS VSS VDD VDD sky130_fd_sc_hd__diode_2
XANTENNA_115 _03485_ VSS VSS VDD VDD sky130_fd_sc_hd__diode_2
XANTENNA_116 _03485_ VSS VSS VDD VDD sky130_fd_sc_hd__diode_2
XANTENNA_117 _03485_ VSS VSS VDD VDD sky130_fd_sc_hd__diode_2
XANTENNA_118 _03485_ VSS VSS VDD VDD sky130_fd_sc_hd__diode_2
XANTENNA_119 _03485_ VSS VSS VDD VDD sky130_fd_sc_hd__diode_2
XANTENNA_12 net837 VSS VSS VDD VDD sky130_fd_sc_hd__diode_2
XANTENNA_120 _03485_ VSS VSS VDD VDD sky130_fd_sc_hd__diode_2
XANTENNA_121 _03485_ VSS VSS VDD VDD sky130_fd_sc_hd__diode_2
XANTENNA_122 _03485_ VSS VSS VDD VDD sky130_fd_sc_hd__diode_2
XANTENNA_123 _03486_ VSS VSS VDD VDD sky130_fd_sc_hd__diode_2
XANTENNA_124 _03486_ VSS VSS VDD VDD sky130_fd_sc_hd__diode_2
XANTENNA_125 _03486_ VSS VSS VDD VDD sky130_fd_sc_hd__diode_2
XANTENNA_126 _03486_ VSS VSS VDD VDD sky130_fd_sc_hd__diode_2
XANTENNA_127 _03486_ VSS VSS VDD VDD sky130_fd_sc_hd__diode_2
XANTENNA_128 _03488_ VSS VSS VDD VDD sky130_fd_sc_hd__diode_2
XANTENNA_129 _03488_ VSS VSS VDD VDD sky130_fd_sc_hd__diode_2
XANTENNA_13 net837 VSS VSS VDD VDD sky130_fd_sc_hd__diode_2
XANTENNA_130 _03488_ VSS VSS VDD VDD sky130_fd_sc_hd__diode_2
XANTENNA_131 _03488_ VSS VSS VDD VDD sky130_fd_sc_hd__diode_2
XANTENNA_132 _03488_ VSS VSS VDD VDD sky130_fd_sc_hd__diode_2
XANTENNA_133 _03488_ VSS VSS VDD VDD sky130_fd_sc_hd__diode_2
XANTENNA_134 _03488_ VSS VSS VDD VDD sky130_fd_sc_hd__diode_2
XANTENNA_135 _03488_ VSS VSS VDD VDD sky130_fd_sc_hd__diode_2
XANTENNA_136 _03488_ VSS VSS VDD VDD sky130_fd_sc_hd__diode_2
XANTENNA_137 _03488_ VSS VSS VDD VDD sky130_fd_sc_hd__diode_2
XANTENNA_138 _03488_ VSS VSS VDD VDD sky130_fd_sc_hd__diode_2
XANTENNA_139 _03489_ VSS VSS VDD VDD sky130_fd_sc_hd__diode_2
XANTENNA_14 net837 VSS VSS VDD VDD sky130_fd_sc_hd__diode_2
XANTENNA_140 _03492_ VSS VSS VDD VDD sky130_fd_sc_hd__diode_2
XANTENNA_141 _03492_ VSS VSS VDD VDD sky130_fd_sc_hd__diode_2
XANTENNA_142 _03492_ VSS VSS VDD VDD sky130_fd_sc_hd__diode_2
XANTENNA_143 _03492_ VSS VSS VDD VDD sky130_fd_sc_hd__diode_2
XANTENNA_144 _03492_ VSS VSS VDD VDD sky130_fd_sc_hd__diode_2
XANTENNA_145 _03492_ VSS VSS VDD VDD sky130_fd_sc_hd__diode_2
XANTENNA_146 _03493_ VSS VSS VDD VDD sky130_fd_sc_hd__diode_2
XANTENNA_147 _03493_ VSS VSS VDD VDD sky130_fd_sc_hd__diode_2
XANTENNA_148 _03504_ VSS VSS VDD VDD sky130_fd_sc_hd__diode_2
XANTENNA_149 _03504_ VSS VSS VDD VDD sky130_fd_sc_hd__diode_2
XANTENNA_15 net837 VSS VSS VDD VDD sky130_fd_sc_hd__diode_2
XANTENNA_150 _03519_ VSS VSS VDD VDD sky130_fd_sc_hd__diode_2
XANTENNA_151 _03519_ VSS VSS VDD VDD sky130_fd_sc_hd__diode_2
XANTENNA_152 _03519_ VSS VSS VDD VDD sky130_fd_sc_hd__diode_2
XANTENNA_153 _03519_ VSS VSS VDD VDD sky130_fd_sc_hd__diode_2
XANTENNA_154 _03519_ VSS VSS VDD VDD sky130_fd_sc_hd__diode_2
XANTENNA_155 _03519_ VSS VSS VDD VDD sky130_fd_sc_hd__diode_2
XANTENNA_156 _03519_ VSS VSS VDD VDD sky130_fd_sc_hd__diode_2
XANTENNA_157 _03519_ VSS VSS VDD VDD sky130_fd_sc_hd__diode_2
XANTENNA_158 _03519_ VSS VSS VDD VDD sky130_fd_sc_hd__diode_2
XANTENNA_159 _03519_ VSS VSS VDD VDD sky130_fd_sc_hd__diode_2
XANTENNA_16 net988 VSS VSS VDD VDD sky130_fd_sc_hd__diode_2
XANTENNA_160 _03519_ VSS VSS VDD VDD sky130_fd_sc_hd__diode_2
XANTENNA_161 _03520_ VSS VSS VDD VDD sky130_fd_sc_hd__diode_2
XANTENNA_162 _03520_ VSS VSS VDD VDD sky130_fd_sc_hd__diode_2
XANTENNA_163 _03520_ VSS VSS VDD VDD sky130_fd_sc_hd__diode_2
XANTENNA_164 _03520_ VSS VSS VDD VDD sky130_fd_sc_hd__diode_2
XANTENNA_165 _03520_ VSS VSS VDD VDD sky130_fd_sc_hd__diode_2
XANTENNA_166 _03520_ VSS VSS VDD VDD sky130_fd_sc_hd__diode_2
XANTENNA_167 _03520_ VSS VSS VDD VDD sky130_fd_sc_hd__diode_2
XANTENNA_168 _03520_ VSS VSS VDD VDD sky130_fd_sc_hd__diode_2
XANTENNA_169 _03520_ VSS VSS VDD VDD sky130_fd_sc_hd__diode_2
XANTENNA_17 net838 VSS VSS VDD VDD sky130_fd_sc_hd__diode_2
XANTENNA_170 _03520_ VSS VSS VDD VDD sky130_fd_sc_hd__diode_2
XANTENNA_171 _03520_ VSS VSS VDD VDD sky130_fd_sc_hd__diode_2
XANTENNA_172 _03728_ VSS VSS VDD VDD sky130_fd_sc_hd__diode_2
XANTENNA_173 _0390_ VSS VSS VDD VDD sky130_fd_sc_hd__diode_2
XANTENNA_174 _0390_ VSS VSS VDD VDD sky130_fd_sc_hd__diode_2
XANTENNA_175 _0390_ VSS VSS VDD VDD sky130_fd_sc_hd__diode_2
XANTENNA_176 _0390_ VSS VSS VDD VDD sky130_fd_sc_hd__diode_2
XANTENNA_177 _04086_ VSS VSS VDD VDD sky130_fd_sc_hd__diode_2
XANTENNA_178 _0422_ VSS VSS VDD VDD sky130_fd_sc_hd__diode_2
XANTENNA_179 _0430_ VSS VSS VDD VDD sky130_fd_sc_hd__diode_2
XANTENNA_18 net838 VSS VSS VDD VDD sky130_fd_sc_hd__diode_2
XANTENNA_180 _0430_ VSS VSS VDD VDD sky130_fd_sc_hd__diode_2
XANTENNA_181 _0430_ VSS VSS VDD VDD sky130_fd_sc_hd__diode_2
XANTENNA_182 _0430_ VSS VSS VDD VDD sky130_fd_sc_hd__diode_2
XANTENNA_183 _0430_ VSS VSS VDD VDD sky130_fd_sc_hd__diode_2
XANTENNA_184 _0430_ VSS VSS VDD VDD sky130_fd_sc_hd__diode_2
XANTENNA_185 _0430_ VSS VSS VDD VDD sky130_fd_sc_hd__diode_2
XANTENNA_186 _0430_ VSS VSS VDD VDD sky130_fd_sc_hd__diode_2
XANTENNA_187 _0430_ VSS VSS VDD VDD sky130_fd_sc_hd__diode_2
XANTENNA_188 _0430_ VSS VSS VDD VDD sky130_fd_sc_hd__diode_2
XANTENNA_189 _0430_ VSS VSS VDD VDD sky130_fd_sc_hd__diode_2
XANTENNA_19 net838 VSS VSS VDD VDD sky130_fd_sc_hd__diode_2
XANTENNA_190 _04697_ VSS VSS VDD VDD sky130_fd_sc_hd__diode_2
XANTENNA_191 _04697_ VSS VSS VDD VDD sky130_fd_sc_hd__diode_2
XANTENNA_192 _04697_ VSS VSS VDD VDD sky130_fd_sc_hd__diode_2
XANTENNA_193 _04718_ VSS VSS VDD VDD sky130_fd_sc_hd__diode_2
XANTENNA_194 _04722_ VSS VSS VDD VDD sky130_fd_sc_hd__diode_2
XANTENNA_195 _04731_ VSS VSS VDD VDD sky130_fd_sc_hd__diode_2
XANTENNA_196 _04912_ VSS VSS VDD VDD sky130_fd_sc_hd__diode_2
XANTENNA_197 _04912_ VSS VSS VDD VDD sky130_fd_sc_hd__diode_2
XANTENNA_198 _04962_ VSS VSS VDD VDD sky130_fd_sc_hd__diode_2
XANTENNA_199 _05007_ VSS VSS VDD VDD sky130_fd_sc_hd__diode_2
XANTENNA_2 clknet_leaf_14_clk VSS VSS VDD VDD sky130_fd_sc_hd__diode_2
XANTENNA_20 net878 VSS VSS VDD VDD sky130_fd_sc_hd__diode_2
XANTENNA_200 _05148_ VSS VSS VDD VDD sky130_fd_sc_hd__diode_2
XANTENNA_201 _05169_ VSS VSS VDD VDD sky130_fd_sc_hd__diode_2
XANTENNA_202 _05185_ VSS VSS VDD VDD sky130_fd_sc_hd__diode_2
XANTENNA_203 _05189_ VSS VSS VDD VDD sky130_fd_sc_hd__diode_2
XANTENNA_204 _05211_ VSS VSS VDD VDD sky130_fd_sc_hd__diode_2
XANTENNA_205 _05211_ VSS VSS VDD VDD sky130_fd_sc_hd__diode_2
XANTENNA_206 _05231_ VSS VSS VDD VDD sky130_fd_sc_hd__diode_2
XANTENNA_207 _05231_ VSS VSS VDD VDD sky130_fd_sc_hd__diode_2
XANTENNA_208 _05238_ VSS VSS VDD VDD sky130_fd_sc_hd__diode_2
XANTENNA_209 _05238_ VSS VSS VDD VDD sky130_fd_sc_hd__diode_2
XANTENNA_21 net878 VSS VSS VDD VDD sky130_fd_sc_hd__diode_2
XANTENNA_210 _05254_ VSS VSS VDD VDD sky130_fd_sc_hd__diode_2
XANTENNA_211 _05254_ VSS VSS VDD VDD sky130_fd_sc_hd__diode_2
XANTENNA_212 _05313_ VSS VSS VDD VDD sky130_fd_sc_hd__diode_2
XANTENNA_213 _05317_ VSS VSS VDD VDD sky130_fd_sc_hd__diode_2
XANTENNA_214 _05317_ VSS VSS VDD VDD sky130_fd_sc_hd__diode_2
XANTENNA_215 _05317_ VSS VSS VDD VDD sky130_fd_sc_hd__diode_2
XANTENNA_216 _05323_ VSS VSS VDD VDD sky130_fd_sc_hd__diode_2
XANTENNA_217 _05378_ VSS VSS VDD VDD sky130_fd_sc_hd__diode_2
XANTENNA_218 _05459_ VSS VSS VDD VDD sky130_fd_sc_hd__diode_2
XANTENNA_219 _05459_ VSS VSS VDD VDD sky130_fd_sc_hd__diode_2
XANTENNA_22 _11237_ VSS VSS VDD VDD sky130_fd_sc_hd__diode_2
XANTENNA_220 _05459_ VSS VSS VDD VDD sky130_fd_sc_hd__diode_2
XANTENNA_221 _05464_ VSS VSS VDD VDD sky130_fd_sc_hd__diode_2
XANTENNA_222 _05468_ VSS VSS VDD VDD sky130_fd_sc_hd__diode_2
XANTENNA_223 sa_p[6] VSS VSS VDD VDD sky130_fd_sc_hd__diode_2
XANTENNA_224 sa_p[5] VSS VSS VDD VDD sky130_fd_sc_hd__diode_2
XANTENNA_225 sa_p[23] VSS VSS VDD VDD sky130_fd_sc_hd__diode_2
XANTENNA_226 _05568_ VSS VSS VDD VDD sky130_fd_sc_hd__diode_2
XANTENNA_227 sa_p[14] VSS VSS VDD VDD sky130_fd_sc_hd__diode_2
XANTENNA_228 _05947_ VSS VSS VDD VDD sky130_fd_sc_hd__diode_2
XANTENNA_229 _05947_ VSS VSS VDD VDD sky130_fd_sc_hd__diode_2
XANTENNA_23 _1334_ VSS VSS VDD VDD sky130_fd_sc_hd__diode_2
XANTENNA_230 _05947_ VSS VSS VDD VDD sky130_fd_sc_hd__diode_2
XANTENNA_231 _05947_ VSS VSS VDD VDD sky130_fd_sc_hd__diode_2
XANTENNA_232 _05947_ VSS VSS VDD VDD sky130_fd_sc_hd__diode_2
XANTENNA_233 _05947_ VSS VSS VDD VDD sky130_fd_sc_hd__diode_2
XANTENNA_234 _05947_ VSS VSS VDD VDD sky130_fd_sc_hd__diode_2
XANTENNA_235 _05947_ VSS VSS VDD VDD sky130_fd_sc_hd__diode_2
XANTENNA_236 _05947_ VSS VSS VDD VDD sky130_fd_sc_hd__diode_2
XANTENNA_237 _05947_ VSS VSS VDD VDD sky130_fd_sc_hd__diode_2
XANTENNA_238 _05958_ VSS VSS VDD VDD sky130_fd_sc_hd__diode_2
XANTENNA_239 _06006_ VSS VSS VDD VDD sky130_fd_sc_hd__diode_2
XANTENNA_24 u_core.u_top.u_core.r_pdata[21] VSS VSS VDD VDD sky130_fd_sc_hd__diode_2
XANTENNA_240 _06040_ VSS VSS VDD VDD sky130_fd_sc_hd__diode_2
XANTENNA_241 _06076_ VSS VSS VDD VDD sky130_fd_sc_hd__diode_2
XANTENNA_242 _06081_ VSS VSS VDD VDD sky130_fd_sc_hd__diode_2
XANTENNA_243 _06088_ VSS VSS VDD VDD sky130_fd_sc_hd__diode_2
XANTENNA_244 _06100_ VSS VSS VDD VDD sky130_fd_sc_hd__diode_2
XANTENNA_245 _06102_ VSS VSS VDD VDD sky130_fd_sc_hd__diode_2
XANTENNA_246 _06143_ VSS VSS VDD VDD sky130_fd_sc_hd__diode_2
XANTENNA_247 _06143_ VSS VSS VDD VDD sky130_fd_sc_hd__diode_2
XANTENNA_248 _06143_ VSS VSS VDD VDD sky130_fd_sc_hd__diode_2
XANTENNA_249 _06143_ VSS VSS VDD VDD sky130_fd_sc_hd__diode_2
XANTENNA_25 net971 VSS VSS VDD VDD sky130_fd_sc_hd__diode_2
XANTENNA_250 _06143_ VSS VSS VDD VDD sky130_fd_sc_hd__diode_2
XANTENNA_251 _06143_ VSS VSS VDD VDD sky130_fd_sc_hd__diode_2
XANTENNA_252 _06143_ VSS VSS VDD VDD sky130_fd_sc_hd__diode_2
XANTENNA_253 _06143_ VSS VSS VDD VDD sky130_fd_sc_hd__diode_2
XANTENNA_254 _06143_ VSS VSS VDD VDD sky130_fd_sc_hd__diode_2
XANTENNA_255 _06143_ VSS VSS VDD VDD sky130_fd_sc_hd__diode_2
XANTENNA_256 _06163_ VSS VSS VDD VDD sky130_fd_sc_hd__diode_2
XANTENNA_257 _06163_ VSS VSS VDD VDD sky130_fd_sc_hd__diode_2
XANTENNA_258 clknet_2_2__leaf__11398_ VSS VSS VDD VDD sky130_fd_sc_hd__diode_2
XANTENNA_259 clknet_2_0__leaf__11398_ VSS VSS VDD VDD sky130_fd_sc_hd__diode_2
XANTENNA_26 net664 VSS VSS VDD VDD sky130_fd_sc_hd__diode_2
XANTENNA_260 clknet_2_0__leaf__11398_ VSS VSS VDD VDD sky130_fd_sc_hd__diode_2
XANTENNA_261 clknet_1_0__leaf__11416_ VSS VSS VDD VDD sky130_fd_sc_hd__diode_2
XANTENNA_262 clknet_2_3__leaf__11419_ VSS VSS VDD VDD sky130_fd_sc_hd__diode_2
XANTENNA_263 clknet_2_2__leaf__11419_ VSS VSS VDD VDD sky130_fd_sc_hd__diode_2
XANTENNA_264 _0634_ VSS VSS VDD VDD sky130_fd_sc_hd__diode_2
XANTENNA_265 _06357_ VSS VSS VDD VDD sky130_fd_sc_hd__diode_2
XANTENNA_266 _06391_ VSS VSS VDD VDD sky130_fd_sc_hd__diode_2
XANTENNA_267 _06393_ VSS VSS VDD VDD sky130_fd_sc_hd__diode_2
XANTENNA_268 _06393_ VSS VSS VDD VDD sky130_fd_sc_hd__diode_2
XANTENNA_269 _06425_ VSS VSS VDD VDD sky130_fd_sc_hd__diode_2
XANTENNA_27 net664 VSS VSS VDD VDD sky130_fd_sc_hd__diode_2
XANTENNA_270 _06459_ VSS VSS VDD VDD sky130_fd_sc_hd__diode_2
XANTENNA_271 _06459_ VSS VSS VDD VDD sky130_fd_sc_hd__diode_2
XANTENNA_272 _06459_ VSS VSS VDD VDD sky130_fd_sc_hd__diode_2
XANTENNA_273 _06459_ VSS VSS VDD VDD sky130_fd_sc_hd__diode_2
XANTENNA_274 _06459_ VSS VSS VDD VDD sky130_fd_sc_hd__diode_2
XANTENNA_275 _06459_ VSS VSS VDD VDD sky130_fd_sc_hd__diode_2
XANTENNA_276 _06459_ VSS VSS VDD VDD sky130_fd_sc_hd__diode_2
XANTENNA_277 _06459_ VSS VSS VDD VDD sky130_fd_sc_hd__diode_2
XANTENNA_278 _06459_ VSS VSS VDD VDD sky130_fd_sc_hd__diode_2
XANTENNA_279 _06459_ VSS VSS VDD VDD sky130_fd_sc_hd__diode_2
XANTENNA_28 net664 VSS VSS VDD VDD sky130_fd_sc_hd__diode_2
XANTENNA_280 _06459_ VSS VSS VDD VDD sky130_fd_sc_hd__diode_2
XANTENNA_281 _06466_ VSS VSS VDD VDD sky130_fd_sc_hd__diode_2
XANTENNA_282 _06466_ VSS VSS VDD VDD sky130_fd_sc_hd__diode_2
XANTENNA_283 _06466_ VSS VSS VDD VDD sky130_fd_sc_hd__diode_2
XANTENNA_284 _06466_ VSS VSS VDD VDD sky130_fd_sc_hd__diode_2
XANTENNA_285 _06466_ VSS VSS VDD VDD sky130_fd_sc_hd__diode_2
XANTENNA_286 _06469_ VSS VSS VDD VDD sky130_fd_sc_hd__diode_2
XANTENNA_287 clknet_4_13_0__11423_ VSS VSS VDD VDD sky130_fd_sc_hd__diode_2
XANTENNA_288 clknet_4_12_0__11423_ VSS VSS VDD VDD sky130_fd_sc_hd__diode_2
XANTENNA_289 clknet_4_5_0__11423_ VSS VSS VDD VDD sky130_fd_sc_hd__diode_2
XANTENNA_29 u_core.u_top.u_spi.shift_in[20] VSS VSS VDD VDD sky130_fd_sc_hd__diode_2
XANTENNA_290 clknet_4_4_0__11423_ VSS VSS VDD VDD sky130_fd_sc_hd__diode_2
XANTENNA_291 _06590_ VSS VSS VDD VDD sky130_fd_sc_hd__diode_2
XANTENNA_292 clknet_2_1__leaf__11425_ VSS VSS VDD VDD sky130_fd_sc_hd__diode_2
XANTENNA_293 clknet_2_1__leaf__11428_ VSS VSS VDD VDD sky130_fd_sc_hd__diode_2
XANTENNA_294 clknet_2_0__leaf__11428_ VSS VSS VDD VDD sky130_fd_sc_hd__diode_2
XANTENNA_295 clknet_2_0__leaf__11428_ VSS VSS VDD VDD sky130_fd_sc_hd__diode_2
XANTENNA_296 clknet_2_0__leaf__11428_ VSS VSS VDD VDD sky130_fd_sc_hd__diode_2
XANTENNA_297 _06635_ VSS VSS VDD VDD sky130_fd_sc_hd__diode_2
XANTENNA_298 clknet_3_3__leaf__11429_ VSS VSS VDD VDD sky130_fd_sc_hd__diode_2
XANTENNA_299 _06668_ VSS VSS VDD VDD sky130_fd_sc_hd__diode_2
XANTENNA_3 _11259_ VSS VSS VDD VDD sky130_fd_sc_hd__diode_2
XANTENNA_30 net853 VSS VSS VDD VDD sky130_fd_sc_hd__diode_2
XANTENNA_300 _06683_ VSS VSS VDD VDD sky130_fd_sc_hd__diode_2
XANTENNA_301 _06700_ VSS VSS VDD VDD sky130_fd_sc_hd__diode_2
XANTENNA_302 _0670_ VSS VSS VDD VDD sky130_fd_sc_hd__diode_2
XANTENNA_303 _0670_ VSS VSS VDD VDD sky130_fd_sc_hd__diode_2
XANTENNA_304 _0670_ VSS VSS VDD VDD sky130_fd_sc_hd__diode_2
XANTENNA_305 _0670_ VSS VSS VDD VDD sky130_fd_sc_hd__diode_2
XANTENNA_306 _0670_ VSS VSS VDD VDD sky130_fd_sc_hd__diode_2
XANTENNA_307 _0670_ VSS VSS VDD VDD sky130_fd_sc_hd__diode_2
XANTENNA_308 _0670_ VSS VSS VDD VDD sky130_fd_sc_hd__diode_2
XANTENNA_309 _0670_ VSS VSS VDD VDD sky130_fd_sc_hd__diode_2
XANTENNA_31 net853 VSS VSS VDD VDD sky130_fd_sc_hd__diode_2
XANTENNA_310 _0670_ VSS VSS VDD VDD sky130_fd_sc_hd__diode_2
XANTENNA_311 _0670_ VSS VSS VDD VDD sky130_fd_sc_hd__diode_2
XANTENNA_312 _0670_ VSS VSS VDD VDD sky130_fd_sc_hd__diode_2
XANTENNA_313 _06711_ VSS VSS VDD VDD sky130_fd_sc_hd__diode_2
XANTENNA_314 _06711_ VSS VSS VDD VDD sky130_fd_sc_hd__diode_2
XANTENNA_315 _06711_ VSS VSS VDD VDD sky130_fd_sc_hd__diode_2
XANTENNA_316 _06711_ VSS VSS VDD VDD sky130_fd_sc_hd__diode_2
XANTENNA_317 _06711_ VSS VSS VDD VDD sky130_fd_sc_hd__diode_2
XANTENNA_318 _06711_ VSS VSS VDD VDD sky130_fd_sc_hd__diode_2
XANTENNA_319 _06711_ VSS VSS VDD VDD sky130_fd_sc_hd__diode_2
XANTENNA_32 net853 VSS VSS VDD VDD sky130_fd_sc_hd__diode_2
XANTENNA_320 _06711_ VSS VSS VDD VDD sky130_fd_sc_hd__diode_2
XANTENNA_321 _06711_ VSS VSS VDD VDD sky130_fd_sc_hd__diode_2
XANTENNA_322 _06711_ VSS VSS VDD VDD sky130_fd_sc_hd__diode_2
XANTENNA_323 _06711_ VSS VSS VDD VDD sky130_fd_sc_hd__diode_2
XANTENNA_324 _06745_ VSS VSS VDD VDD sky130_fd_sc_hd__diode_2
XANTENNA_325 _06767_ VSS VSS VDD VDD sky130_fd_sc_hd__diode_2
XANTENNA_326 _06767_ VSS VSS VDD VDD sky130_fd_sc_hd__diode_2
XANTENNA_327 _06767_ VSS VSS VDD VDD sky130_fd_sc_hd__diode_2
XANTENNA_328 _06767_ VSS VSS VDD VDD sky130_fd_sc_hd__diode_2
XANTENNA_329 _06810_ VSS VSS VDD VDD sky130_fd_sc_hd__diode_2
XANTENNA_33 net853 VSS VSS VDD VDD sky130_fd_sc_hd__diode_2
XANTENNA_330 _06833_ VSS VSS VDD VDD sky130_fd_sc_hd__diode_2
XANTENNA_331 _06833_ VSS VSS VDD VDD sky130_fd_sc_hd__diode_2
XANTENNA_332 _06833_ VSS VSS VDD VDD sky130_fd_sc_hd__diode_2
XANTENNA_333 _06837_ VSS VSS VDD VDD sky130_fd_sc_hd__diode_2
XANTENNA_334 _06837_ VSS VSS VDD VDD sky130_fd_sc_hd__diode_2
XANTENNA_335 _06837_ VSS VSS VDD VDD sky130_fd_sc_hd__diode_2
XANTENNA_336 _06837_ VSS VSS VDD VDD sky130_fd_sc_hd__diode_2
XANTENNA_337 _06848_ VSS VSS VDD VDD sky130_fd_sc_hd__diode_2
XANTENNA_338 _06864_ VSS VSS VDD VDD sky130_fd_sc_hd__diode_2
XANTENNA_339 _06864_ VSS VSS VDD VDD sky130_fd_sc_hd__diode_2
XANTENNA_34 _0012_ VSS VSS VDD VDD sky130_fd_sc_hd__diode_2
XANTENNA_340 _06864_ VSS VSS VDD VDD sky130_fd_sc_hd__diode_2
XANTENNA_341 _06903_ VSS VSS VDD VDD sky130_fd_sc_hd__diode_2
XANTENNA_342 net992 VSS VSS VDD VDD sky130_fd_sc_hd__diode_2
XANTENNA_343 net981 VSS VSS VDD VDD sky130_fd_sc_hd__diode_2
XANTENNA_344 net972 VSS VSS VDD VDD sky130_fd_sc_hd__diode_2
XANTENNA_345 net972 VSS VSS VDD VDD sky130_fd_sc_hd__diode_2
XANTENNA_346 net969 VSS VSS VDD VDD sky130_fd_sc_hd__diode_2
XANTENNA_347 net967 VSS VSS VDD VDD sky130_fd_sc_hd__diode_2
XANTENNA_348 net966 VSS VSS VDD VDD sky130_fd_sc_hd__diode_2
XANTENNA_349 net960 VSS VSS VDD VDD sky130_fd_sc_hd__diode_2
XANTENNA_35 _0012_ VSS VSS VDD VDD sky130_fd_sc_hd__diode_2
XANTENNA_350 net959 VSS VSS VDD VDD sky130_fd_sc_hd__diode_2
XANTENNA_351 net950 VSS VSS VDD VDD sky130_fd_sc_hd__diode_2
XANTENNA_352 net948 VSS VSS VDD VDD sky130_fd_sc_hd__diode_2
XANTENNA_353 _06978_ VSS VSS VDD VDD sky130_fd_sc_hd__diode_2
XANTENNA_354 _06978_ VSS VSS VDD VDD sky130_fd_sc_hd__diode_2
XANTENNA_355 net945 VSS VSS VDD VDD sky130_fd_sc_hd__diode_2
XANTENNA_356 net936 VSS VSS VDD VDD sky130_fd_sc_hd__diode_2
XANTENNA_357 _06996_ VSS VSS VDD VDD sky130_fd_sc_hd__diode_2
XANTENNA_358 net934 VSS VSS VDD VDD sky130_fd_sc_hd__diode_2
XANTENNA_359 net934 VSS VSS VDD VDD sky130_fd_sc_hd__diode_2
XANTENNA_36 _0012_ VSS VSS VDD VDD sky130_fd_sc_hd__diode_2
XANTENNA_360 net929 VSS VSS VDD VDD sky130_fd_sc_hd__diode_2
XANTENNA_361 net925 VSS VSS VDD VDD sky130_fd_sc_hd__diode_2
XANTENNA_362 net925 VSS VSS VDD VDD sky130_fd_sc_hd__diode_2
XANTENNA_363 net925 VSS VSS VDD VDD sky130_fd_sc_hd__diode_2
XANTENNA_364 net925 VSS VSS VDD VDD sky130_fd_sc_hd__diode_2
XANTENNA_365 net924 VSS VSS VDD VDD sky130_fd_sc_hd__diode_2
XANTENNA_366 net923 VSS VSS VDD VDD sky130_fd_sc_hd__diode_2
XANTENNA_367 net921 VSS VSS VDD VDD sky130_fd_sc_hd__diode_2
XANTENNA_368 net921 VSS VSS VDD VDD sky130_fd_sc_hd__diode_2
XANTENNA_369 net921 VSS VSS VDD VDD sky130_fd_sc_hd__diode_2
XANTENNA_37 _0012_ VSS VSS VDD VDD sky130_fd_sc_hd__diode_2
XANTENNA_370 net921 VSS VSS VDD VDD sky130_fd_sc_hd__diode_2
XANTENNA_371 net920 VSS VSS VDD VDD sky130_fd_sc_hd__diode_2
XANTENNA_372 _07021_ VSS VSS VDD VDD sky130_fd_sc_hd__diode_2
XANTENNA_373 _07021_ VSS VSS VDD VDD sky130_fd_sc_hd__diode_2
XANTENNA_374 net917 VSS VSS VDD VDD sky130_fd_sc_hd__diode_2
XANTENNA_375 net917 VSS VSS VDD VDD sky130_fd_sc_hd__diode_2
XANTENNA_376 _07030_ VSS VSS VDD VDD sky130_fd_sc_hd__diode_2
XANTENNA_377 _07030_ VSS VSS VDD VDD sky130_fd_sc_hd__diode_2
XANTENNA_378 _07030_ VSS VSS VDD VDD sky130_fd_sc_hd__diode_2
XANTENNA_379 _07030_ VSS VSS VDD VDD sky130_fd_sc_hd__diode_2
XANTENNA_38 _0020_ VSS VSS VDD VDD sky130_fd_sc_hd__diode_2
XANTENNA_380 _07030_ VSS VSS VDD VDD sky130_fd_sc_hd__diode_2
XANTENNA_381 _07030_ VSS VSS VDD VDD sky130_fd_sc_hd__diode_2
XANTENNA_382 _07030_ VSS VSS VDD VDD sky130_fd_sc_hd__diode_2
XANTENNA_383 _07030_ VSS VSS VDD VDD sky130_fd_sc_hd__diode_2
XANTENNA_384 _07030_ VSS VSS VDD VDD sky130_fd_sc_hd__diode_2
XANTENNA_385 _07030_ VSS VSS VDD VDD sky130_fd_sc_hd__diode_2
XANTENNA_386 _07030_ VSS VSS VDD VDD sky130_fd_sc_hd__diode_2
XANTENNA_387 _07039_ VSS VSS VDD VDD sky130_fd_sc_hd__diode_2
XANTENNA_388 _07044_ VSS VSS VDD VDD sky130_fd_sc_hd__diode_2
XANTENNA_389 net908 VSS VSS VDD VDD sky130_fd_sc_hd__diode_2
XANTENNA_39 _0020_ VSS VSS VDD VDD sky130_fd_sc_hd__diode_2
XANTENNA_390 _07064_ VSS VSS VDD VDD sky130_fd_sc_hd__diode_2
XANTENNA_391 net903 VSS VSS VDD VDD sky130_fd_sc_hd__diode_2
XANTENNA_392 net902 VSS VSS VDD VDD sky130_fd_sc_hd__diode_2
XANTENNA_393 net902 VSS VSS VDD VDD sky130_fd_sc_hd__diode_2
XANTENNA_394 _07071_ VSS VSS VDD VDD sky130_fd_sc_hd__diode_2
XANTENNA_395 _07071_ VSS VSS VDD VDD sky130_fd_sc_hd__diode_2
XANTENNA_396 _07071_ VSS VSS VDD VDD sky130_fd_sc_hd__diode_2
XANTENNA_397 _07071_ VSS VSS VDD VDD sky130_fd_sc_hd__diode_2
XANTENNA_398 _07071_ VSS VSS VDD VDD sky130_fd_sc_hd__diode_2
XANTENNA_399 _07071_ VSS VSS VDD VDD sky130_fd_sc_hd__diode_2
XANTENNA_4 clk VSS VSS VDD VDD sky130_fd_sc_hd__diode_2
XANTENNA_40 _0020_ VSS VSS VDD VDD sky130_fd_sc_hd__diode_2
XANTENNA_400 _07071_ VSS VSS VDD VDD sky130_fd_sc_hd__diode_2
XANTENNA_401 _07071_ VSS VSS VDD VDD sky130_fd_sc_hd__diode_2
XANTENNA_402 _07071_ VSS VSS VDD VDD sky130_fd_sc_hd__diode_2
XANTENNA_403 _07071_ VSS VSS VDD VDD sky130_fd_sc_hd__diode_2
XANTENNA_404 _07071_ VSS VSS VDD VDD sky130_fd_sc_hd__diode_2
XANTENNA_405 net897 VSS VSS VDD VDD sky130_fd_sc_hd__diode_2
XANTENNA_406 _07079_ VSS VSS VDD VDD sky130_fd_sc_hd__diode_2
XANTENNA_407 _07081_ VSS VSS VDD VDD sky130_fd_sc_hd__diode_2
XANTENNA_408 _07085_ VSS VSS VDD VDD sky130_fd_sc_hd__diode_2
XANTENNA_409 _07085_ VSS VSS VDD VDD sky130_fd_sc_hd__diode_2
XANTENNA_41 _0020_ VSS VSS VDD VDD sky130_fd_sc_hd__diode_2
XANTENNA_410 _07085_ VSS VSS VDD VDD sky130_fd_sc_hd__diode_2
XANTENNA_411 _07085_ VSS VSS VDD VDD sky130_fd_sc_hd__diode_2
XANTENNA_412 _07085_ VSS VSS VDD VDD sky130_fd_sc_hd__diode_2
XANTENNA_413 _07085_ VSS VSS VDD VDD sky130_fd_sc_hd__diode_2
XANTENNA_414 _07085_ VSS VSS VDD VDD sky130_fd_sc_hd__diode_2
XANTENNA_415 _07085_ VSS VSS VDD VDD sky130_fd_sc_hd__diode_2
XANTENNA_416 _07085_ VSS VSS VDD VDD sky130_fd_sc_hd__diode_2
XANTENNA_417 _07085_ VSS VSS VDD VDD sky130_fd_sc_hd__diode_2
XANTENNA_418 _07085_ VSS VSS VDD VDD sky130_fd_sc_hd__diode_2
XANTENNA_419 net853 VSS VSS VDD VDD sky130_fd_sc_hd__diode_2
XANTENNA_42 _0020_ VSS VSS VDD VDD sky130_fd_sc_hd__diode_2
XANTENNA_420 net849 VSS VSS VDD VDD sky130_fd_sc_hd__diode_2
XANTENNA_421 net849 VSS VSS VDD VDD sky130_fd_sc_hd__diode_2
XANTENNA_422 net849 VSS VSS VDD VDD sky130_fd_sc_hd__diode_2
XANTENNA_423 net849 VSS VSS VDD VDD sky130_fd_sc_hd__diode_2
XANTENNA_424 net849 VSS VSS VDD VDD sky130_fd_sc_hd__diode_2
XANTENNA_425 net849 VSS VSS VDD VDD sky130_fd_sc_hd__diode_2
XANTENNA_426 net849 VSS VSS VDD VDD sky130_fd_sc_hd__diode_2
XANTENNA_427 net849 VSS VSS VDD VDD sky130_fd_sc_hd__diode_2
XANTENNA_428 net849 VSS VSS VDD VDD sky130_fd_sc_hd__diode_2
XANTENNA_429 net849 VSS VSS VDD VDD sky130_fd_sc_hd__diode_2
XANTENNA_43 _0020_ VSS VSS VDD VDD sky130_fd_sc_hd__diode_2
XANTENNA_430 net847 VSS VSS VDD VDD sky130_fd_sc_hd__diode_2
XANTENNA_431 net847 VSS VSS VDD VDD sky130_fd_sc_hd__diode_2
XANTENNA_432 net847 VSS VSS VDD VDD sky130_fd_sc_hd__diode_2
XANTENNA_433 net847 VSS VSS VDD VDD sky130_fd_sc_hd__diode_2
XANTENNA_434 net847 VSS VSS VDD VDD sky130_fd_sc_hd__diode_2
XANTENNA_435 net845 VSS VSS VDD VDD sky130_fd_sc_hd__diode_2
XANTENNA_436 net845 VSS VSS VDD VDD sky130_fd_sc_hd__diode_2
XANTENNA_437 net845 VSS VSS VDD VDD sky130_fd_sc_hd__diode_2
XANTENNA_438 net845 VSS VSS VDD VDD sky130_fd_sc_hd__diode_2
XANTENNA_439 net844 VSS VSS VDD VDD sky130_fd_sc_hd__diode_2
XANTENNA_44 _0020_ VSS VSS VDD VDD sky130_fd_sc_hd__diode_2
XANTENNA_440 net844 VSS VSS VDD VDD sky130_fd_sc_hd__diode_2
XANTENNA_441 net844 VSS VSS VDD VDD sky130_fd_sc_hd__diode_2
XANTENNA_442 net844 VSS VSS VDD VDD sky130_fd_sc_hd__diode_2
XANTENNA_443 net844 VSS VSS VDD VDD sky130_fd_sc_hd__diode_2
XANTENNA_444 net844 VSS VSS VDD VDD sky130_fd_sc_hd__diode_2
XANTENNA_445 net844 VSS VSS VDD VDD sky130_fd_sc_hd__diode_2
XANTENNA_446 net844 VSS VSS VDD VDD sky130_fd_sc_hd__diode_2
XANTENNA_447 net844 VSS VSS VDD VDD sky130_fd_sc_hd__diode_2
XANTENNA_448 net844 VSS VSS VDD VDD sky130_fd_sc_hd__diode_2
XANTENNA_449 net844 VSS VSS VDD VDD sky130_fd_sc_hd__diode_2
XANTENNA_45 _0020_ VSS VSS VDD VDD sky130_fd_sc_hd__diode_2
XANTENNA_450 net844 VSS VSS VDD VDD sky130_fd_sc_hd__diode_2
XANTENNA_451 net843 VSS VSS VDD VDD sky130_fd_sc_hd__diode_2
XANTENNA_452 net843 VSS VSS VDD VDD sky130_fd_sc_hd__diode_2
XANTENNA_453 net843 VSS VSS VDD VDD sky130_fd_sc_hd__diode_2
XANTENNA_454 net843 VSS VSS VDD VDD sky130_fd_sc_hd__diode_2
XANTENNA_455 net843 VSS VSS VDD VDD sky130_fd_sc_hd__diode_2
XANTENNA_456 net842 VSS VSS VDD VDD sky130_fd_sc_hd__diode_2
XANTENNA_457 net842 VSS VSS VDD VDD sky130_fd_sc_hd__diode_2
XANTENNA_458 net842 VSS VSS VDD VDD sky130_fd_sc_hd__diode_2
XANTENNA_459 net842 VSS VSS VDD VDD sky130_fd_sc_hd__diode_2
XANTENNA_46 _0031_ VSS VSS VDD VDD sky130_fd_sc_hd__diode_2
XANTENNA_460 net839 VSS VSS VDD VDD sky130_fd_sc_hd__diode_2
XANTENNA_461 net839 VSS VSS VDD VDD sky130_fd_sc_hd__diode_2
XANTENNA_462 net831 VSS VSS VDD VDD sky130_fd_sc_hd__diode_2
XANTENNA_463 net831 VSS VSS VDD VDD sky130_fd_sc_hd__diode_2
XANTENNA_464 net831 VSS VSS VDD VDD sky130_fd_sc_hd__diode_2
XANTENNA_465 net831 VSS VSS VDD VDD sky130_fd_sc_hd__diode_2
XANTENNA_466 net831 VSS VSS VDD VDD sky130_fd_sc_hd__diode_2
XANTENNA_467 net831 VSS VSS VDD VDD sky130_fd_sc_hd__diode_2
XANTENNA_468 net824 VSS VSS VDD VDD sky130_fd_sc_hd__diode_2
XANTENNA_469 net822 VSS VSS VDD VDD sky130_fd_sc_hd__diode_2
XANTENNA_47 _0031_ VSS VSS VDD VDD sky130_fd_sc_hd__diode_2
XANTENNA_470 net819 VSS VSS VDD VDD sky130_fd_sc_hd__diode_2
XANTENNA_471 net810 VSS VSS VDD VDD sky130_fd_sc_hd__diode_2
XANTENNA_472 net807 VSS VSS VDD VDD sky130_fd_sc_hd__diode_2
XANTENNA_473 net787 VSS VSS VDD VDD sky130_fd_sc_hd__diode_2
XANTENNA_474 net787 VSS VSS VDD VDD sky130_fd_sc_hd__diode_2
XANTENNA_475 _07146_ VSS VSS VDD VDD sky130_fd_sc_hd__diode_2
XANTENNA_476 net784 VSS VSS VDD VDD sky130_fd_sc_hd__diode_2
XANTENNA_477 _07153_ VSS VSS VDD VDD sky130_fd_sc_hd__diode_2
XANTENNA_478 net776 VSS VSS VDD VDD sky130_fd_sc_hd__diode_2
XANTENNA_479 net776 VSS VSS VDD VDD sky130_fd_sc_hd__diode_2
XANTENNA_48 _0031_ VSS VSS VDD VDD sky130_fd_sc_hd__diode_2
XANTENNA_480 net776 VSS VSS VDD VDD sky130_fd_sc_hd__diode_2
XANTENNA_481 net776 VSS VSS VDD VDD sky130_fd_sc_hd__diode_2
XANTENNA_482 net776 VSS VSS VDD VDD sky130_fd_sc_hd__diode_2
XANTENNA_483 net776 VSS VSS VDD VDD sky130_fd_sc_hd__diode_2
XANTENNA_484 net776 VSS VSS VDD VDD sky130_fd_sc_hd__diode_2
XANTENNA_485 net776 VSS VSS VDD VDD sky130_fd_sc_hd__diode_2
XANTENNA_486 net776 VSS VSS VDD VDD sky130_fd_sc_hd__diode_2
XANTENNA_487 net776 VSS VSS VDD VDD sky130_fd_sc_hd__diode_2
XANTENNA_488 net776 VSS VSS VDD VDD sky130_fd_sc_hd__diode_2
XANTENNA_489 net776 VSS VSS VDD VDD sky130_fd_sc_hd__diode_2
XANTENNA_49 _0031_ VSS VSS VDD VDD sky130_fd_sc_hd__diode_2
XANTENNA_490 net776 VSS VSS VDD VDD sky130_fd_sc_hd__diode_2
XANTENNA_491 net776 VSS VSS VDD VDD sky130_fd_sc_hd__diode_2
XANTENNA_492 net776 VSS VSS VDD VDD sky130_fd_sc_hd__diode_2
XANTENNA_493 net776 VSS VSS VDD VDD sky130_fd_sc_hd__diode_2
XANTENNA_494 net761 VSS VSS VDD VDD sky130_fd_sc_hd__diode_2
XANTENNA_495 _07171_ VSS VSS VDD VDD sky130_fd_sc_hd__diode_2
XANTENNA_496 _07171_ VSS VSS VDD VDD sky130_fd_sc_hd__diode_2
XANTENNA_497 _07171_ VSS VSS VDD VDD sky130_fd_sc_hd__diode_2
XANTENNA_498 _07171_ VSS VSS VDD VDD sky130_fd_sc_hd__diode_2
XANTENNA_499 _07171_ VSS VSS VDD VDD sky130_fd_sc_hd__diode_2
XANTENNA_5 _0012_ VSS VSS VDD VDD sky130_fd_sc_hd__diode_2
XANTENNA_50 _0031_ VSS VSS VDD VDD sky130_fd_sc_hd__diode_2
XANTENNA_500 _07171_ VSS VSS VDD VDD sky130_fd_sc_hd__diode_2
XANTENNA_501 _07208_ VSS VSS VDD VDD sky130_fd_sc_hd__diode_2
XANTENNA_502 _07208_ VSS VSS VDD VDD sky130_fd_sc_hd__diode_2
XANTENNA_503 _07208_ VSS VSS VDD VDD sky130_fd_sc_hd__diode_2
XANTENNA_504 _07208_ VSS VSS VDD VDD sky130_fd_sc_hd__diode_2
XANTENNA_505 _07208_ VSS VSS VDD VDD sky130_fd_sc_hd__diode_2
XANTENNA_506 _07208_ VSS VSS VDD VDD sky130_fd_sc_hd__diode_2
XANTENNA_507 net743 VSS VSS VDD VDD sky130_fd_sc_hd__diode_2
XANTENNA_508 net743 VSS VSS VDD VDD sky130_fd_sc_hd__diode_2
XANTENNA_509 net743 VSS VSS VDD VDD sky130_fd_sc_hd__diode_2
XANTENNA_51 _0031_ VSS VSS VDD VDD sky130_fd_sc_hd__diode_2
XANTENNA_510 net743 VSS VSS VDD VDD sky130_fd_sc_hd__diode_2
XANTENNA_511 net743 VSS VSS VDD VDD sky130_fd_sc_hd__diode_2
XANTENNA_512 net743 VSS VSS VDD VDD sky130_fd_sc_hd__diode_2
XANTENNA_513 net743 VSS VSS VDD VDD sky130_fd_sc_hd__diode_2
XANTENNA_514 net732 VSS VSS VDD VDD sky130_fd_sc_hd__diode_2
XANTENNA_515 net732 VSS VSS VDD VDD sky130_fd_sc_hd__diode_2
XANTENNA_516 net721 VSS VSS VDD VDD sky130_fd_sc_hd__diode_2
XANTENNA_517 net721 VSS VSS VDD VDD sky130_fd_sc_hd__diode_2
XANTENNA_518 net720 VSS VSS VDD VDD sky130_fd_sc_hd__diode_2
XANTENNA_519 net720 VSS VSS VDD VDD sky130_fd_sc_hd__diode_2
XANTENNA_52 _0031_ VSS VSS VDD VDD sky130_fd_sc_hd__diode_2
XANTENNA_520 net711 VSS VSS VDD VDD sky130_fd_sc_hd__diode_2
XANTENNA_521 _0725_[2] VSS VSS VDD VDD sky130_fd_sc_hd__diode_2
XANTENNA_522 _07275_ VSS VSS VDD VDD sky130_fd_sc_hd__diode_2
XANTENNA_523 net698 VSS VSS VDD VDD sky130_fd_sc_hd__diode_2
XANTENNA_524 _07289_ VSS VSS VDD VDD sky130_fd_sc_hd__diode_2
XANTENNA_525 _07289_ VSS VSS VDD VDD sky130_fd_sc_hd__diode_2
XANTENNA_526 _07289_ VSS VSS VDD VDD sky130_fd_sc_hd__diode_2
XANTENNA_527 _07289_ VSS VSS VDD VDD sky130_fd_sc_hd__diode_2
XANTENNA_528 _07289_ VSS VSS VDD VDD sky130_fd_sc_hd__diode_2
XANTENNA_529 _07289_ VSS VSS VDD VDD sky130_fd_sc_hd__diode_2
XANTENNA_53 _0031_ VSS VSS VDD VDD sky130_fd_sc_hd__diode_2
XANTENNA_530 _07289_ VSS VSS VDD VDD sky130_fd_sc_hd__diode_2
XANTENNA_531 _07289_ VSS VSS VDD VDD sky130_fd_sc_hd__diode_2
XANTENNA_532 _07289_ VSS VSS VDD VDD sky130_fd_sc_hd__diode_2
XANTENNA_533 _07289_ VSS VSS VDD VDD sky130_fd_sc_hd__diode_2
XANTENNA_534 _07289_ VSS VSS VDD VDD sky130_fd_sc_hd__diode_2
XANTENNA_535 _07414_ VSS VSS VDD VDD sky130_fd_sc_hd__diode_2
XANTENNA_536 _07414_ VSS VSS VDD VDD sky130_fd_sc_hd__diode_2
XANTENNA_537 _07414_ VSS VSS VDD VDD sky130_fd_sc_hd__diode_2
XANTENNA_538 _07414_ VSS VSS VDD VDD sky130_fd_sc_hd__diode_2
XANTENNA_539 _07414_ VSS VSS VDD VDD sky130_fd_sc_hd__diode_2
XANTENNA_54 _0031_ VSS VSS VDD VDD sky130_fd_sc_hd__diode_2
XANTENNA_540 _07414_ VSS VSS VDD VDD sky130_fd_sc_hd__diode_2
XANTENNA_541 _07414_ VSS VSS VDD VDD sky130_fd_sc_hd__diode_2
XANTENNA_542 _07414_ VSS VSS VDD VDD sky130_fd_sc_hd__diode_2
XANTENNA_543 _07414_ VSS VSS VDD VDD sky130_fd_sc_hd__diode_2
XANTENNA_544 _07414_ VSS VSS VDD VDD sky130_fd_sc_hd__diode_2
XANTENNA_545 _07414_ VSS VSS VDD VDD sky130_fd_sc_hd__diode_2
XANTENNA_546 _07417_ VSS VSS VDD VDD sky130_fd_sc_hd__diode_2
XANTENNA_547 _07417_ VSS VSS VDD VDD sky130_fd_sc_hd__diode_2
XANTENNA_548 _07417_ VSS VSS VDD VDD sky130_fd_sc_hd__diode_2
XANTENNA_549 _07417_ VSS VSS VDD VDD sky130_fd_sc_hd__diode_2
XANTENNA_55 _0031_ VSS VSS VDD VDD sky130_fd_sc_hd__diode_2
XANTENNA_550 _07417_ VSS VSS VDD VDD sky130_fd_sc_hd__diode_2
XANTENNA_551 _07417_ VSS VSS VDD VDD sky130_fd_sc_hd__diode_2
XANTENNA_552 _07417_ VSS VSS VDD VDD sky130_fd_sc_hd__diode_2
XANTENNA_553 _07417_ VSS VSS VDD VDD sky130_fd_sc_hd__diode_2
XANTENNA_554 _07417_ VSS VSS VDD VDD sky130_fd_sc_hd__diode_2
XANTENNA_555 _07417_ VSS VSS VDD VDD sky130_fd_sc_hd__diode_2
XANTENNA_556 _07417_ VSS VSS VDD VDD sky130_fd_sc_hd__diode_2
XANTENNA_557 _07487_ VSS VSS VDD VDD sky130_fd_sc_hd__diode_2
XANTENNA_558 _07523_ VSS VSS VDD VDD sky130_fd_sc_hd__diode_2
XANTENNA_559 _07573_ VSS VSS VDD VDD sky130_fd_sc_hd__diode_2
XANTENNA_56 _0065_ VSS VSS VDD VDD sky130_fd_sc_hd__diode_2
XANTENNA_560 _07573_ VSS VSS VDD VDD sky130_fd_sc_hd__diode_2
XANTENNA_561 _07573_ VSS VSS VDD VDD sky130_fd_sc_hd__diode_2
XANTENNA_562 _07573_ VSS VSS VDD VDD sky130_fd_sc_hd__diode_2
XANTENNA_563 _07573_ VSS VSS VDD VDD sky130_fd_sc_hd__diode_2
XANTENNA_564 _07578_ VSS VSS VDD VDD sky130_fd_sc_hd__diode_2
XANTENNA_565 _07582_ VSS VSS VDD VDD sky130_fd_sc_hd__diode_2
XANTENNA_566 clknet_leaf_3_clk VSS VSS VDD VDD sky130_fd_sc_hd__diode_2
XANTENNA_567 clknet_leaf_2_clk VSS VSS VDD VDD sky130_fd_sc_hd__diode_2
XANTENNA_568 _07590_ VSS VSS VDD VDD sky130_fd_sc_hd__diode_2
XANTENNA_569 _07668_ VSS VSS VDD VDD sky130_fd_sc_hd__diode_2
XANTENNA_57 _0070_ VSS VSS VDD VDD sky130_fd_sc_hd__diode_2
XANTENNA_570 _07668_ VSS VSS VDD VDD sky130_fd_sc_hd__diode_2
XANTENNA_571 _07668_ VSS VSS VDD VDD sky130_fd_sc_hd__diode_2
XANTENNA_572 clknet_leaf_1_clk VSS VSS VDD VDD sky130_fd_sc_hd__diode_2
XANTENNA_573 _07689_ VSS VSS VDD VDD sky130_fd_sc_hd__diode_2
XANTENNA_574 _07725_ VSS VSS VDD VDD sky130_fd_sc_hd__diode_2
XANTENNA_575 _07814_ VSS VSS VDD VDD sky130_fd_sc_hd__diode_2
XANTENNA_576 clknet_leaf_9_clk VSS VSS VDD VDD sky130_fd_sc_hd__diode_2
XANTENNA_577 _08109_ VSS VSS VDD VDD sky130_fd_sc_hd__diode_2
XANTENNA_578 clknet_leaf_6_clk VSS VSS VDD VDD sky130_fd_sc_hd__diode_2
XANTENNA_579 clknet_leaf_5_clk VSS VSS VDD VDD sky130_fd_sc_hd__diode_2
XANTENNA_58 _0070_ VSS VSS VDD VDD sky130_fd_sc_hd__diode_2
XANTENNA_580 clknet_leaf_5_clk VSS VSS VDD VDD sky130_fd_sc_hd__diode_2
XANTENNA_581 clknet_leaf_8_clk VSS VSS VDD VDD sky130_fd_sc_hd__diode_2
XANTENNA_582 clknet_leaf_11_clk VSS VSS VDD VDD sky130_fd_sc_hd__diode_2
XANTENNA_583 clknet_leaf_12_clk VSS VSS VDD VDD sky130_fd_sc_hd__diode_2
XANTENNA_584 clknet_3_4__leaf_clk_regs VSS VSS VDD VDD sky130_fd_sc_hd__diode_2
XANTENNA_585 clknet_3_3__leaf_clk_regs VSS VSS VDD VDD sky130_fd_sc_hd__diode_2
XANTENNA_586 clknet_1_0__leaf_clk VSS VSS VDD VDD sky130_fd_sc_hd__diode_2
XANTENNA_587 clknet_0_clk VSS VSS VDD VDD sky130_fd_sc_hd__diode_2
XANTENNA_588 clknet_0_clk VSS VSS VDD VDD sky130_fd_sc_hd__diode_2
XANTENNA_589 clknet_leaf_20_clk VSS VSS VDD VDD sky130_fd_sc_hd__diode_2
XANTENNA_59 _0070_ VSS VSS VDD VDD sky130_fd_sc_hd__diode_2
XANTENNA_590 clknet_leaf_20_clk VSS VSS VDD VDD sky130_fd_sc_hd__diode_2
XANTENNA_591 clknet_leaf_20_clk VSS VSS VDD VDD sky130_fd_sc_hd__diode_2
XANTENNA_592 clknet_leaf_19_clk VSS VSS VDD VDD sky130_fd_sc_hd__diode_2
XANTENNA_593 clknet_3_2__leaf_clk_regs VSS VSS VDD VDD sky130_fd_sc_hd__diode_2
XANTENNA_594 clknet_3_2__leaf_clk_regs VSS VSS VDD VDD sky130_fd_sc_hd__diode_2
XANTENNA_595 clknet_3_2__leaf_clk_regs VSS VSS VDD VDD sky130_fd_sc_hd__diode_2
XANTENNA_596 clknet_3_2__leaf_clk_regs VSS VSS VDD VDD sky130_fd_sc_hd__diode_2
XANTENNA_597 clknet_3_2__leaf_clk_regs VSS VSS VDD VDD sky130_fd_sc_hd__diode_2
XANTENNA_598 clknet_3_2__leaf_clk_regs VSS VSS VDD VDD sky130_fd_sc_hd__diode_2
XANTENNA_599 clknet_3_0__leaf_clk_regs VSS VSS VDD VDD sky130_fd_sc_hd__diode_2
XANTENNA_6 _0012_ VSS VSS VDD VDD sky130_fd_sc_hd__diode_2
XANTENNA_60 _0070_ VSS VSS VDD VDD sky130_fd_sc_hd__diode_2
XANTENNA_600 clknet_0_clk_regs VSS VSS VDD VDD sky130_fd_sc_hd__diode_2
XANTENNA_601 clknet_0_clk_regs VSS VSS VDD VDD sky130_fd_sc_hd__diode_2
XANTENNA_602 clknet_0_clk_regs VSS VSS VDD VDD sky130_fd_sc_hd__diode_2
XANTENNA_603 clknet_0_clk_regs VSS VSS VDD VDD sky130_fd_sc_hd__diode_2
XANTENNA_604 clknet_3_0__leaf__11429_ VSS VSS VDD VDD sky130_fd_sc_hd__diode_2
XANTENNA_605 net993 VSS VSS VDD VDD sky130_fd_sc_hd__diode_2
XANTENNA_606 net980 VSS VSS VDD VDD sky130_fd_sc_hd__diode_2
XANTENNA_607 net980 VSS VSS VDD VDD sky130_fd_sc_hd__diode_2
XANTENNA_608 net980 VSS VSS VDD VDD sky130_fd_sc_hd__diode_2
XANTENNA_609 net980 VSS VSS VDD VDD sky130_fd_sc_hd__diode_2
XANTENNA_61 _0070_ VSS VSS VDD VDD sky130_fd_sc_hd__diode_2
XANTENNA_610 net980 VSS VSS VDD VDD sky130_fd_sc_hd__diode_2
XANTENNA_611 net980 VSS VSS VDD VDD sky130_fd_sc_hd__diode_2
XANTENNA_612 net980 VSS VSS VDD VDD sky130_fd_sc_hd__diode_2
XANTENNA_613 net957 VSS VSS VDD VDD sky130_fd_sc_hd__diode_2
XANTENNA_614 _08519_ VSS VSS VDD VDD sky130_fd_sc_hd__diode_2
XANTENNA_615 net889 VSS VSS VDD VDD sky130_fd_sc_hd__diode_2
XANTENNA_616 net889 VSS VSS VDD VDD sky130_fd_sc_hd__diode_2
XANTENNA_617 net891 VSS VSS VDD VDD sky130_fd_sc_hd__diode_2
XANTENNA_618 net891 VSS VSS VDD VDD sky130_fd_sc_hd__diode_2
XANTENNA_619 net838 VSS VSS VDD VDD sky130_fd_sc_hd__diode_2
XANTENNA_62 _0070_ VSS VSS VDD VDD sky130_fd_sc_hd__diode_2
XANTENNA_620 net838 VSS VSS VDD VDD sky130_fd_sc_hd__diode_2
XANTENNA_621 net838 VSS VSS VDD VDD sky130_fd_sc_hd__diode_2
XANTENNA_622 net838 VSS VSS VDD VDD sky130_fd_sc_hd__diode_2
XANTENNA_623 net797 VSS VSS VDD VDD sky130_fd_sc_hd__diode_2
XANTENNA_624 net797 VSS VSS VDD VDD sky130_fd_sc_hd__diode_2
XANTENNA_625 net791 VSS VSS VDD VDD sky130_fd_sc_hd__diode_2
XANTENNA_626 net712 VSS VSS VDD VDD sky130_fd_sc_hd__diode_2
XANTENNA_627 net774 VSS VSS VDD VDD sky130_fd_sc_hd__diode_2
XANTENNA_628 net774 VSS VSS VDD VDD sky130_fd_sc_hd__diode_2
XANTENNA_629 net774 VSS VSS VDD VDD sky130_fd_sc_hd__diode_2
XANTENNA_63 _0070_ VSS VSS VDD VDD sky130_fd_sc_hd__diode_2
XANTENNA_630 net646 VSS VSS VDD VDD sky130_fd_sc_hd__diode_2
XANTENNA_631 net647 VSS VSS VDD VDD sky130_fd_sc_hd__diode_2
XANTENNA_632 net752 VSS VSS VDD VDD sky130_fd_sc_hd__diode_2
XANTENNA_633 net752 VSS VSS VDD VDD sky130_fd_sc_hd__diode_2
XANTENNA_634 net752 VSS VSS VDD VDD sky130_fd_sc_hd__diode_2
XANTENNA_635 net752 VSS VSS VDD VDD sky130_fd_sc_hd__diode_2
XANTENNA_636 net752 VSS VSS VDD VDD sky130_fd_sc_hd__diode_2
XANTENNA_637 net752 VSS VSS VDD VDD sky130_fd_sc_hd__diode_2
XANTENNA_638 net752 VSS VSS VDD VDD sky130_fd_sc_hd__diode_2
XANTENNA_639 net752 VSS VSS VDD VDD sky130_fd_sc_hd__diode_2
XANTENNA_64 _0070_ VSS VSS VDD VDD sky130_fd_sc_hd__diode_2
XANTENNA_640 net752 VSS VSS VDD VDD sky130_fd_sc_hd__diode_2
XANTENNA_641 net752 VSS VSS VDD VDD sky130_fd_sc_hd__diode_2
XANTENNA_642 net752 VSS VSS VDD VDD sky130_fd_sc_hd__diode_2
XANTENNA_643 net652 VSS VSS VDD VDD sky130_fd_sc_hd__diode_2
XANTENNA_644 net652 VSS VSS VDD VDD sky130_fd_sc_hd__diode_2
XANTENNA_645 net652 VSS VSS VDD VDD sky130_fd_sc_hd__diode_2
XANTENNA_646 net652 VSS VSS VDD VDD sky130_fd_sc_hd__diode_2
XANTENNA_647 net652 VSS VSS VDD VDD sky130_fd_sc_hd__diode_2
XANTENNA_648 net652 VSS VSS VDD VDD sky130_fd_sc_hd__diode_2
XANTENNA_649 net653 VSS VSS VDD VDD sky130_fd_sc_hd__diode_2
XANTENNA_65 _0097_ VSS VSS VDD VDD sky130_fd_sc_hd__diode_2
XANTENNA_650 _09479_ VSS VSS VDD VDD sky130_fd_sc_hd__diode_2
XANTENNA_651 net741 VSS VSS VDD VDD sky130_fd_sc_hd__diode_2
XANTENNA_652 net741 VSS VSS VDD VDD sky130_fd_sc_hd__diode_2
XANTENNA_653 net741 VSS VSS VDD VDD sky130_fd_sc_hd__diode_2
XANTENNA_654 net741 VSS VSS VDD VDD sky130_fd_sc_hd__diode_2
XANTENNA_655 net741 VSS VSS VDD VDD sky130_fd_sc_hd__diode_2
XANTENNA_656 net741 VSS VSS VDD VDD sky130_fd_sc_hd__diode_2
XANTENNA_657 net741 VSS VSS VDD VDD sky130_fd_sc_hd__diode_2
XANTENNA_658 net741 VSS VSS VDD VDD sky130_fd_sc_hd__diode_2
XANTENNA_659 net741 VSS VSS VDD VDD sky130_fd_sc_hd__diode_2
XANTENNA_66 _0097_ VSS VSS VDD VDD sky130_fd_sc_hd__diode_2
XANTENNA_660 net741 VSS VSS VDD VDD sky130_fd_sc_hd__diode_2
XANTENNA_661 net741 VSS VSS VDD VDD sky130_fd_sc_hd__diode_2
XANTENNA_662 net640 VSS VSS VDD VDD sky130_fd_sc_hd__diode_2
XANTENNA_663 net875 VSS VSS VDD VDD sky130_fd_sc_hd__diode_2
XANTENNA_664 net875 VSS VSS VDD VDD sky130_fd_sc_hd__diode_2
XANTENNA_665 net875 VSS VSS VDD VDD sky130_fd_sc_hd__diode_2
XANTENNA_666 net875 VSS VSS VDD VDD sky130_fd_sc_hd__diode_2
XANTENNA_667 net629 VSS VSS VDD VDD sky130_fd_sc_hd__diode_2
XANTENNA_668 net629 VSS VSS VDD VDD sky130_fd_sc_hd__diode_2
XANTENNA_669 net629 VSS VSS VDD VDD sky130_fd_sc_hd__diode_2
XANTENNA_67 _0097_ VSS VSS VDD VDD sky130_fd_sc_hd__diode_2
XANTENNA_670 net629 VSS VSS VDD VDD sky130_fd_sc_hd__diode_2
XANTENNA_671 net629 VSS VSS VDD VDD sky130_fd_sc_hd__diode_2
XANTENNA_672 net629 VSS VSS VDD VDD sky130_fd_sc_hd__diode_2
XANTENNA_673 net629 VSS VSS VDD VDD sky130_fd_sc_hd__diode_2
XANTENNA_674 net629 VSS VSS VDD VDD sky130_fd_sc_hd__diode_2
XANTENNA_675 clknet_leaf_0_clk VSS VSS VDD VDD sky130_fd_sc_hd__diode_2
XANTENNA_676 clknet_0__11429_ VSS VSS VDD VDD sky130_fd_sc_hd__diode_2
XANTENNA_677 net1000 VSS VSS VDD VDD sky130_fd_sc_hd__diode_2
XANTENNA_678 net894 VSS VSS VDD VDD sky130_fd_sc_hd__diode_2
XANTENNA_679 net894 VSS VSS VDD VDD sky130_fd_sc_hd__diode_2
XANTENNA_68 _0097_ VSS VSS VDD VDD sky130_fd_sc_hd__diode_2
XANTENNA_680 _09816_ VSS VSS VDD VDD sky130_fd_sc_hd__diode_2
XANTENNA_681 _09816_ VSS VSS VDD VDD sky130_fd_sc_hd__diode_2
XANTENNA_682 _09837_ VSS VSS VDD VDD sky130_fd_sc_hd__diode_2
XANTENNA_683 _09866_ VSS VSS VDD VDD sky130_fd_sc_hd__diode_2
XANTENNA_684 _09866_ VSS VSS VDD VDD sky130_fd_sc_hd__diode_2
XANTENNA_685 _09866_ VSS VSS VDD VDD sky130_fd_sc_hd__diode_2
XANTENNA_686 _09866_ VSS VSS VDD VDD sky130_fd_sc_hd__diode_2
XANTENNA_687 _09874_ VSS VSS VDD VDD sky130_fd_sc_hd__diode_2
XANTENNA_688 _09881_ VSS VSS VDD VDD sky130_fd_sc_hd__diode_2
XANTENNA_689 _09884_ VSS VSS VDD VDD sky130_fd_sc_hd__diode_2
XANTENNA_69 _0097_ VSS VSS VDD VDD sky130_fd_sc_hd__diode_2
XANTENNA_690 _09913_ VSS VSS VDD VDD sky130_fd_sc_hd__diode_2
XANTENNA_691 net877 VSS VSS VDD VDD sky130_fd_sc_hd__diode_2
XANTENNA_692 net877 VSS VSS VDD VDD sky130_fd_sc_hd__diode_2
XANTENNA_693 net877 VSS VSS VDD VDD sky130_fd_sc_hd__diode_2
XANTENNA_694 net876 VSS VSS VDD VDD sky130_fd_sc_hd__diode_2
XANTENNA_695 net876 VSS VSS VDD VDD sky130_fd_sc_hd__diode_2
XANTENNA_696 net876 VSS VSS VDD VDD sky130_fd_sc_hd__diode_2
XANTENNA_697 net876 VSS VSS VDD VDD sky130_fd_sc_hd__diode_2
XANTENNA_698 net876 VSS VSS VDD VDD sky130_fd_sc_hd__diode_2
XANTENNA_699 net876 VSS VSS VDD VDD sky130_fd_sc_hd__diode_2
XANTENNA_7 _06859_ VSS VSS VDD VDD sky130_fd_sc_hd__diode_2
XANTENNA_70 _0097_ VSS VSS VDD VDD sky130_fd_sc_hd__diode_2
XANTENNA_700 net876 VSS VSS VDD VDD sky130_fd_sc_hd__diode_2
XANTENNA_701 net876 VSS VSS VDD VDD sky130_fd_sc_hd__diode_2
XANTENNA_702 net876 VSS VSS VDD VDD sky130_fd_sc_hd__diode_2
XANTENNA_703 net876 VSS VSS VDD VDD sky130_fd_sc_hd__diode_2
XANTENNA_704 net876 VSS VSS VDD VDD sky130_fd_sc_hd__diode_2
XANTENNA_705 net876 VSS VSS VDD VDD sky130_fd_sc_hd__diode_2
XANTENNA_706 net876 VSS VSS VDD VDD sky130_fd_sc_hd__diode_2
XANTENNA_707 _09975_ VSS VSS VDD VDD sky130_fd_sc_hd__diode_2
XANTENNA_708 _1019_[3] VSS VSS VDD VDD sky130_fd_sc_hd__diode_2
XANTENNA_709 _10206_ VSS VSS VDD VDD sky130_fd_sc_hd__diode_2
XANTENNA_71 _0097_ VSS VSS VDD VDD sky130_fd_sc_hd__diode_2
XANTENNA_710 _10217_ VSS VSS VDD VDD sky130_fd_sc_hd__diode_2
XANTENNA_711 _10222_ VSS VSS VDD VDD sky130_fd_sc_hd__diode_2
XANTENNA_712 _1022_[17] VSS VSS VDD VDD sky130_fd_sc_hd__diode_2
XANTENNA_713 _1022_[18] VSS VSS VDD VDD sky130_fd_sc_hd__diode_2
XANTENNA_714 _1022_[18] VSS VSS VDD VDD sky130_fd_sc_hd__diode_2
XANTENNA_715 _1022_[18] VSS VSS VDD VDD sky130_fd_sc_hd__diode_2
XANTENNA_716 _1022_[18] VSS VSS VDD VDD sky130_fd_sc_hd__diode_2
XANTENNA_717 _1022_[18] VSS VSS VDD VDD sky130_fd_sc_hd__diode_2
XANTENNA_718 _1022_[18] VSS VSS VDD VDD sky130_fd_sc_hd__diode_2
XANTENNA_719 _1022_[3] VSS VSS VDD VDD sky130_fd_sc_hd__diode_2
XANTENNA_72 _0097_ VSS VSS VDD VDD sky130_fd_sc_hd__diode_2
XANTENNA_720 _1022_[3] VSS VSS VDD VDD sky130_fd_sc_hd__diode_2
XANTENNA_721 _1022_[3] VSS VSS VDD VDD sky130_fd_sc_hd__diode_2
XANTENNA_722 _1022_[3] VSS VSS VDD VDD sky130_fd_sc_hd__diode_2
XANTENNA_723 _1022_[3] VSS VSS VDD VDD sky130_fd_sc_hd__diode_2
XANTENNA_724 _1022_[3] VSS VSS VDD VDD sky130_fd_sc_hd__diode_2
XANTENNA_725 _1022_[3] VSS VSS VDD VDD sky130_fd_sc_hd__diode_2
XANTENNA_726 _1022_[3] VSS VSS VDD VDD sky130_fd_sc_hd__diode_2
XANTENNA_727 _1022_[3] VSS VSS VDD VDD sky130_fd_sc_hd__diode_2
XANTENNA_728 _1022_[3] VSS VSS VDD VDD sky130_fd_sc_hd__diode_2
XANTENNA_729 _10230_ VSS VSS VDD VDD sky130_fd_sc_hd__diode_2
XANTENNA_73 _0097_ VSS VSS VDD VDD sky130_fd_sc_hd__diode_2
XANTENNA_730 _1025_[10] VSS VSS VDD VDD sky130_fd_sc_hd__diode_2
XANTENNA_731 _1025_[12] VSS VSS VDD VDD sky130_fd_sc_hd__diode_2
XANTENNA_732 net820 VSS VSS VDD VDD sky130_fd_sc_hd__diode_2
XANTENNA_733 net820 VSS VSS VDD VDD sky130_fd_sc_hd__diode_2
XANTENNA_734 net820 VSS VSS VDD VDD sky130_fd_sc_hd__diode_2
XANTENNA_735 net820 VSS VSS VDD VDD sky130_fd_sc_hd__diode_2
XANTENNA_736 net820 VSS VSS VDD VDD sky130_fd_sc_hd__diode_2
XANTENNA_737 net811 VSS VSS VDD VDD sky130_fd_sc_hd__diode_2
XANTENNA_738 net812 VSS VSS VDD VDD sky130_fd_sc_hd__diode_2
XANTENNA_739 net789 VSS VSS VDD VDD sky130_fd_sc_hd__diode_2
XANTENNA_74 _0097_ VSS VSS VDD VDD sky130_fd_sc_hd__diode_2
XANTENNA_740 net789 VSS VSS VDD VDD sky130_fd_sc_hd__diode_2
XANTENNA_741 net789 VSS VSS VDD VDD sky130_fd_sc_hd__diode_2
XANTENNA_742 net789 VSS VSS VDD VDD sky130_fd_sc_hd__diode_2
XANTENNA_743 _1038_ VSS VSS VDD VDD sky130_fd_sc_hd__diode_2
XANTENNA_744 _1038_ VSS VSS VDD VDD sky130_fd_sc_hd__diode_2
XANTENNA_745 _1038_ VSS VSS VDD VDD sky130_fd_sc_hd__diode_2
XANTENNA_746 _1038_ VSS VSS VDD VDD sky130_fd_sc_hd__diode_2
XANTENNA_747 _1038_ VSS VSS VDD VDD sky130_fd_sc_hd__diode_2
XANTENNA_748 _1038_ VSS VSS VDD VDD sky130_fd_sc_hd__diode_2
XANTENNA_749 _1038_ VSS VSS VDD VDD sky130_fd_sc_hd__diode_2
XANTENNA_75 _0097_ VSS VSS VDD VDD sky130_fd_sc_hd__diode_2
XANTENNA_750 _1038_ VSS VSS VDD VDD sky130_fd_sc_hd__diode_2
XANTENNA_751 _1038_ VSS VSS VDD VDD sky130_fd_sc_hd__diode_2
XANTENNA_752 _1038_ VSS VSS VDD VDD sky130_fd_sc_hd__diode_2
XANTENNA_753 _1038_ VSS VSS VDD VDD sky130_fd_sc_hd__diode_2
XANTENNA_754 net775 VSS VSS VDD VDD sky130_fd_sc_hd__diode_2
XANTENNA_755 net773 VSS VSS VDD VDD sky130_fd_sc_hd__diode_2
XANTENNA_756 net773 VSS VSS VDD VDD sky130_fd_sc_hd__diode_2
XANTENNA_757 net773 VSS VSS VDD VDD sky130_fd_sc_hd__diode_2
XANTENNA_758 net773 VSS VSS VDD VDD sky130_fd_sc_hd__diode_2
XANTENNA_759 _1042_[101] VSS VSS VDD VDD sky130_fd_sc_hd__diode_2
XANTENNA_76 _0113_ VSS VSS VDD VDD sky130_fd_sc_hd__diode_2
XANTENNA_760 _1042_[74] VSS VSS VDD VDD sky130_fd_sc_hd__diode_2
XANTENNA_761 _10532_ VSS VSS VDD VDD sky130_fd_sc_hd__diode_2
XANTENNA_762 _10560_ VSS VSS VDD VDD sky130_fd_sc_hd__diode_2
XANTENNA_763 _10569_ VSS VSS VDD VDD sky130_fd_sc_hd__diode_2
XANTENNA_764 _10573_ VSS VSS VDD VDD sky130_fd_sc_hd__diode_2
XANTENNA_765 _10573_ VSS VSS VDD VDD sky130_fd_sc_hd__diode_2
XANTENNA_766 net740 VSS VSS VDD VDD sky130_fd_sc_hd__diode_2
XANTENNA_767 net740 VSS VSS VDD VDD sky130_fd_sc_hd__diode_2
XANTENNA_768 net740 VSS VSS VDD VDD sky130_fd_sc_hd__diode_2
XANTENNA_769 net740 VSS VSS VDD VDD sky130_fd_sc_hd__diode_2
XANTENNA_77 _0113_ VSS VSS VDD VDD sky130_fd_sc_hd__diode_2
XANTENNA_770 net740 VSS VSS VDD VDD sky130_fd_sc_hd__diode_2
XANTENNA_771 net740 VSS VSS VDD VDD sky130_fd_sc_hd__diode_2
XANTENNA_772 net684 VSS VSS VDD VDD sky130_fd_sc_hd__diode_2
XANTENNA_773 net684 VSS VSS VDD VDD sky130_fd_sc_hd__diode_2
XANTENNA_774 net684 VSS VSS VDD VDD sky130_fd_sc_hd__diode_2
XANTENNA_775 net684 VSS VSS VDD VDD sky130_fd_sc_hd__diode_2
XANTENNA_776 net684 VSS VSS VDD VDD sky130_fd_sc_hd__diode_2
XANTENNA_777 net684 VSS VSS VDD VDD sky130_fd_sc_hd__diode_2
XANTENNA_778 net681 VSS VSS VDD VDD sky130_fd_sc_hd__diode_2
XANTENNA_779 net681 VSS VSS VDD VDD sky130_fd_sc_hd__diode_2
XANTENNA_78 _0113_ VSS VSS VDD VDD sky130_fd_sc_hd__diode_2
XANTENNA_780 _10734_ VSS VSS VDD VDD sky130_fd_sc_hd__diode_2
XANTENNA_781 net680 VSS VSS VDD VDD sky130_fd_sc_hd__diode_2
XANTENNA_782 _10754_ VSS VSS VDD VDD sky130_fd_sc_hd__diode_2
XANTENNA_783 net658 VSS VSS VDD VDD sky130_fd_sc_hd__diode_2
XANTENNA_784 net655 VSS VSS VDD VDD sky130_fd_sc_hd__diode_2
XANTENNA_785 net655 VSS VSS VDD VDD sky130_fd_sc_hd__diode_2
XANTENNA_786 net655 VSS VSS VDD VDD sky130_fd_sc_hd__diode_2
XANTENNA_787 _10912_ VSS VSS VDD VDD sky130_fd_sc_hd__diode_2
XANTENNA_788 _1091_[23] VSS VSS VDD VDD sky130_fd_sc_hd__diode_2
XANTENNA_789 _1093_[31] VSS VSS VDD VDD sky130_fd_sc_hd__diode_2
XANTENNA_79 _0113_ VSS VSS VDD VDD sky130_fd_sc_hd__diode_2
XANTENNA_790 _1093_[39] VSS VSS VDD VDD sky130_fd_sc_hd__diode_2
XANTENNA_791 net665 VSS VSS VDD VDD sky130_fd_sc_hd__diode_2
XANTENNA_792 net649 VSS VSS VDD VDD sky130_fd_sc_hd__diode_2
XANTENNA_793 _11145_ VSS VSS VDD VDD sky130_fd_sc_hd__diode_2
XANTENNA_794 _11217_ VSS VSS VDD VDD sky130_fd_sc_hd__diode_2
XANTENNA_795 _11220_ VSS VSS VDD VDD sky130_fd_sc_hd__diode_2
XANTENNA_796 _11240_ VSS VSS VDD VDD sky130_fd_sc_hd__diode_2
XANTENNA_797 _11240_ VSS VSS VDD VDD sky130_fd_sc_hd__diode_2
XANTENNA_798 net677 VSS VSS VDD VDD sky130_fd_sc_hd__diode_2
XANTENNA_799 _11249_ VSS VSS VDD VDD sky130_fd_sc_hd__diode_2
XANTENNA_8 net971 VSS VSS VDD VDD sky130_fd_sc_hd__diode_2
XANTENNA_80 _0113_ VSS VSS VDD VDD sky130_fd_sc_hd__diode_2
XANTENNA_800 _11249_ VSS VSS VDD VDD sky130_fd_sc_hd__diode_2
XANTENNA_801 net679 VSS VSS VDD VDD sky130_fd_sc_hd__diode_2
XANTENNA_802 net679 VSS VSS VDD VDD sky130_fd_sc_hd__diode_2
XANTENNA_803 _11254_ VSS VSS VDD VDD sky130_fd_sc_hd__diode_2
XANTENNA_804 _11254_ VSS VSS VDD VDD sky130_fd_sc_hd__diode_2
XANTENNA_805 _11254_ VSS VSS VDD VDD sky130_fd_sc_hd__diode_2
XANTENNA_806 _11254_ VSS VSS VDD VDD sky130_fd_sc_hd__diode_2
XANTENNA_807 _11254_ VSS VSS VDD VDD sky130_fd_sc_hd__diode_2
XANTENNA_808 _11254_ VSS VSS VDD VDD sky130_fd_sc_hd__diode_2
XANTENNA_809 _11254_ VSS VSS VDD VDD sky130_fd_sc_hd__diode_2
XANTENNA_81 _0118_ VSS VSS VDD VDD sky130_fd_sc_hd__diode_2
XANTENNA_810 _11254_ VSS VSS VDD VDD sky130_fd_sc_hd__diode_2
XANTENNA_811 _11254_ VSS VSS VDD VDD sky130_fd_sc_hd__diode_2
XANTENNA_812 _11254_ VSS VSS VDD VDD sky130_fd_sc_hd__diode_2
XANTENNA_813 _11254_ VSS VSS VDD VDD sky130_fd_sc_hd__diode_2
XANTENNA_814 _11256_ VSS VSS VDD VDD sky130_fd_sc_hd__diode_2
XANTENNA_815 _11256_ VSS VSS VDD VDD sky130_fd_sc_hd__diode_2
XANTENNA_816 _11256_ VSS VSS VDD VDD sky130_fd_sc_hd__diode_2
XANTENNA_817 _11256_ VSS VSS VDD VDD sky130_fd_sc_hd__diode_2
XANTENNA_818 _11256_ VSS VSS VDD VDD sky130_fd_sc_hd__diode_2
XANTENNA_819 _11256_ VSS VSS VDD VDD sky130_fd_sc_hd__diode_2
XANTENNA_82 _0180_ VSS VSS VDD VDD sky130_fd_sc_hd__diode_2
XANTENNA_820 _11256_ VSS VSS VDD VDD sky130_fd_sc_hd__diode_2
XANTENNA_821 _11256_ VSS VSS VDD VDD sky130_fd_sc_hd__diode_2
XANTENNA_822 _11256_ VSS VSS VDD VDD sky130_fd_sc_hd__diode_2
XANTENNA_823 _11256_ VSS VSS VDD VDD sky130_fd_sc_hd__diode_2
XANTENNA_824 _11256_ VSS VSS VDD VDD sky130_fd_sc_hd__diode_2
XANTENNA_825 _11256_ VSS VSS VDD VDD sky130_fd_sc_hd__diode_2
XANTENNA_826 _11256_ VSS VSS VDD VDD sky130_fd_sc_hd__diode_2
XANTENNA_827 net633 VSS VSS VDD VDD sky130_fd_sc_hd__diode_2
XANTENNA_828 net633 VSS VSS VDD VDD sky130_fd_sc_hd__diode_2
XANTENNA_829 net633 VSS VSS VDD VDD sky130_fd_sc_hd__diode_2
XANTENNA_83 _0180_ VSS VSS VDD VDD sky130_fd_sc_hd__diode_2
XANTENNA_830 net633 VSS VSS VDD VDD sky130_fd_sc_hd__diode_2
XANTENNA_831 net632 VSS VSS VDD VDD sky130_fd_sc_hd__diode_2
XANTENNA_832 net632 VSS VSS VDD VDD sky130_fd_sc_hd__diode_2
XANTENNA_833 net632 VSS VSS VDD VDD sky130_fd_sc_hd__diode_2
XANTENNA_834 net631 VSS VSS VDD VDD sky130_fd_sc_hd__diode_2
XANTENNA_835 net631 VSS VSS VDD VDD sky130_fd_sc_hd__diode_2
XANTENNA_836 net631 VSS VSS VDD VDD sky130_fd_sc_hd__diode_2
XANTENNA_837 net631 VSS VSS VDD VDD sky130_fd_sc_hd__diode_2
XANTENNA_838 net631 VSS VSS VDD VDD sky130_fd_sc_hd__diode_2
XANTENNA_839 net631 VSS VSS VDD VDD sky130_fd_sc_hd__diode_2
XANTENNA_84 _0192_ VSS VSS VDD VDD sky130_fd_sc_hd__diode_2
XANTENNA_840 net631 VSS VSS VDD VDD sky130_fd_sc_hd__diode_2
XANTENNA_841 net631 VSS VSS VDD VDD sky130_fd_sc_hd__diode_2
XANTENNA_842 net631 VSS VSS VDD VDD sky130_fd_sc_hd__diode_2
XANTENNA_843 _11268_ VSS VSS VDD VDD sky130_fd_sc_hd__diode_2
XANTENNA_844 _11268_ VSS VSS VDD VDD sky130_fd_sc_hd__diode_2
XANTENNA_845 _11268_ VSS VSS VDD VDD sky130_fd_sc_hd__diode_2
XANTENNA_846 _11268_ VSS VSS VDD VDD sky130_fd_sc_hd__diode_2
XANTENNA_847 _11268_ VSS VSS VDD VDD sky130_fd_sc_hd__diode_2
XANTENNA_848 _11268_ VSS VSS VDD VDD sky130_fd_sc_hd__diode_2
XANTENNA_849 _11268_ VSS VSS VDD VDD sky130_fd_sc_hd__diode_2
XANTENNA_85 _0210_ VSS VSS VDD VDD sky130_fd_sc_hd__diode_2
XANTENNA_850 _11268_ VSS VSS VDD VDD sky130_fd_sc_hd__diode_2
XANTENNA_851 _11268_ VSS VSS VDD VDD sky130_fd_sc_hd__diode_2
XANTENNA_852 _11268_ VSS VSS VDD VDD sky130_fd_sc_hd__diode_2
XANTENNA_853 _11268_ VSS VSS VDD VDD sky130_fd_sc_hd__diode_2
XANTENNA_854 _11268_ VSS VSS VDD VDD sky130_fd_sc_hd__diode_2
XANTENNA_855 _11268_ VSS VSS VDD VDD sky130_fd_sc_hd__diode_2
XANTENNA_856 _11268_ VSS VSS VDD VDD sky130_fd_sc_hd__diode_2
XANTENNA_857 _11268_ VSS VSS VDD VDD sky130_fd_sc_hd__diode_2
XANTENNA_858 _11268_ VSS VSS VDD VDD sky130_fd_sc_hd__diode_2
XANTENNA_859 _11268_ VSS VSS VDD VDD sky130_fd_sc_hd__diode_2
XANTENNA_86 _0215_ VSS VSS VDD VDD sky130_fd_sc_hd__diode_2
XANTENNA_860 _11268_ VSS VSS VDD VDD sky130_fd_sc_hd__diode_2
XANTENNA_861 _11268_ VSS VSS VDD VDD sky130_fd_sc_hd__diode_2
XANTENNA_862 _11268_ VSS VSS VDD VDD sky130_fd_sc_hd__diode_2
XANTENNA_863 net630 VSS VSS VDD VDD sky130_fd_sc_hd__diode_2
XANTENNA_864 net630 VSS VSS VDD VDD sky130_fd_sc_hd__diode_2
XANTENNA_865 net630 VSS VSS VDD VDD sky130_fd_sc_hd__diode_2
XANTENNA_866 net630 VSS VSS VDD VDD sky130_fd_sc_hd__diode_2
XANTENNA_867 net630 VSS VSS VDD VDD sky130_fd_sc_hd__diode_2
XANTENNA_868 net630 VSS VSS VDD VDD sky130_fd_sc_hd__diode_2
XANTENNA_869 _1263_ VSS VSS VDD VDD sky130_fd_sc_hd__diode_2
XANTENNA_87 _0215_ VSS VSS VDD VDD sky130_fd_sc_hd__diode_2
XANTENNA_870 _1263_ VSS VSS VDD VDD sky130_fd_sc_hd__diode_2
XANTENNA_871 _1263_ VSS VSS VDD VDD sky130_fd_sc_hd__diode_2
XANTENNA_872 _1263_ VSS VSS VDD VDD sky130_fd_sc_hd__diode_2
XANTENNA_873 _1263_ VSS VSS VDD VDD sky130_fd_sc_hd__diode_2
XANTENNA_874 _1263_ VSS VSS VDD VDD sky130_fd_sc_hd__diode_2
XANTENNA_875 _1263_ VSS VSS VDD VDD sky130_fd_sc_hd__diode_2
XANTENNA_876 _1263_ VSS VSS VDD VDD sky130_fd_sc_hd__diode_2
XANTENNA_877 _1311_ VSS VSS VDD VDD sky130_fd_sc_hd__diode_2
XANTENNA_878 _1311_ VSS VSS VDD VDD sky130_fd_sc_hd__diode_2
XANTENNA_879 _1311_ VSS VSS VDD VDD sky130_fd_sc_hd__diode_2
XANTENNA_88 _0215_ VSS VSS VDD VDD sky130_fd_sc_hd__diode_2
XANTENNA_880 _1311_ VSS VSS VDD VDD sky130_fd_sc_hd__diode_2
XANTENNA_881 _1311_ VSS VSS VDD VDD sky130_fd_sc_hd__diode_2
XANTENNA_882 _1311_ VSS VSS VDD VDD sky130_fd_sc_hd__diode_2
XANTENNA_883 _1311_ VSS VSS VDD VDD sky130_fd_sc_hd__diode_2
XANTENNA_884 _1311_ VSS VSS VDD VDD sky130_fd_sc_hd__diode_2
XANTENNA_885 _1311_ VSS VSS VDD VDD sky130_fd_sc_hd__diode_2
XANTENNA_886 _1311_ VSS VSS VDD VDD sky130_fd_sc_hd__diode_2
XANTENNA_887 _1312_ VSS VSS VDD VDD sky130_fd_sc_hd__diode_2
XANTENNA_888 _1316_ VSS VSS VDD VDD sky130_fd_sc_hd__diode_2
XANTENNA_889 _1318_ VSS VSS VDD VDD sky130_fd_sc_hd__diode_2
XANTENNA_89 _0215_ VSS VSS VDD VDD sky130_fd_sc_hd__diode_2
XANTENNA_890 _1318_ VSS VSS VDD VDD sky130_fd_sc_hd__diode_2
XANTENNA_891 _1318_ VSS VSS VDD VDD sky130_fd_sc_hd__diode_2
XANTENNA_892 _1318_ VSS VSS VDD VDD sky130_fd_sc_hd__diode_2
XANTENNA_893 _1318_ VSS VSS VDD VDD sky130_fd_sc_hd__diode_2
XANTENNA_894 _1324_ VSS VSS VDD VDD sky130_fd_sc_hd__diode_2
XANTENNA_895 _1324_ VSS VSS VDD VDD sky130_fd_sc_hd__diode_2
XANTENNA_896 _1324_ VSS VSS VDD VDD sky130_fd_sc_hd__diode_2
XANTENNA_897 _1324_ VSS VSS VDD VDD sky130_fd_sc_hd__diode_2
XANTENNA_898 _1324_ VSS VSS VDD VDD sky130_fd_sc_hd__diode_2
XANTENNA_899 _1324_ VSS VSS VDD VDD sky130_fd_sc_hd__diode_2
XANTENNA_9 net840 VSS VSS VDD VDD sky130_fd_sc_hd__diode_2
XANTENNA_90 _0215_ VSS VSS VDD VDD sky130_fd_sc_hd__diode_2
XANTENNA_900 _1324_ VSS VSS VDD VDD sky130_fd_sc_hd__diode_2
XANTENNA_901 _1324_ VSS VSS VDD VDD sky130_fd_sc_hd__diode_2
XANTENNA_902 _1324_ VSS VSS VDD VDD sky130_fd_sc_hd__diode_2
XANTENNA_903 _1324_ VSS VSS VDD VDD sky130_fd_sc_hd__diode_2
XANTENNA_904 _1324_ VSS VSS VDD VDD sky130_fd_sc_hd__diode_2
XANTENNA_905 _1331_ VSS VSS VDD VDD sky130_fd_sc_hd__diode_2
XANTENNA_906 _1332_ VSS VSS VDD VDD sky130_fd_sc_hd__diode_2
XANTENNA_907 _1332_ VSS VSS VDD VDD sky130_fd_sc_hd__diode_2
XANTENNA_908 _1333_ VSS VSS VDD VDD sky130_fd_sc_hd__diode_2
XANTENNA_909 _1333_ VSS VSS VDD VDD sky130_fd_sc_hd__diode_2
XANTENNA_91 _02485_ VSS VSS VDD VDD sky130_fd_sc_hd__diode_2
XANTENNA_910 _1333_ VSS VSS VDD VDD sky130_fd_sc_hd__diode_2
XANTENNA_911 _1333_ VSS VSS VDD VDD sky130_fd_sc_hd__diode_2
XANTENNA_912 _1333_ VSS VSS VDD VDD sky130_fd_sc_hd__diode_2
XANTENNA_913 _1333_ VSS VSS VDD VDD sky130_fd_sc_hd__diode_2
XANTENNA_914 _1333_ VSS VSS VDD VDD sky130_fd_sc_hd__diode_2
XANTENNA_915 _1334_ VSS VSS VDD VDD sky130_fd_sc_hd__diode_2
XANTENNA_916 _1334_ VSS VSS VDD VDD sky130_fd_sc_hd__diode_2
XANTENNA_917 _1334_ VSS VSS VDD VDD sky130_fd_sc_hd__diode_2
XANTENNA_918 _1334_ VSS VSS VDD VDD sky130_fd_sc_hd__diode_2
XANTENNA_919 _1334_ VSS VSS VDD VDD sky130_fd_sc_hd__diode_2
XANTENNA_92 _02485_ VSS VSS VDD VDD sky130_fd_sc_hd__diode_2
XANTENNA_920 _1334_ VSS VSS VDD VDD sky130_fd_sc_hd__diode_2
XANTENNA_921 _1334_ VSS VSS VDD VDD sky130_fd_sc_hd__diode_2
XANTENNA_922 _1334_ VSS VSS VDD VDD sky130_fd_sc_hd__diode_2
XANTENNA_923 _1334_ VSS VSS VDD VDD sky130_fd_sc_hd__diode_2
XANTENNA_924 _1334_ VSS VSS VDD VDD sky130_fd_sc_hd__diode_2
XANTENNA_925 _1334_ VSS VSS VDD VDD sky130_fd_sc_hd__diode_2
XANTENNA_926 _1335_ VSS VSS VDD VDD sky130_fd_sc_hd__diode_2
XANTENNA_927 _1336_ VSS VSS VDD VDD sky130_fd_sc_hd__diode_2
XANTENNA_928 _1336_ VSS VSS VDD VDD sky130_fd_sc_hd__diode_2
XANTENNA_929 _1336_ VSS VSS VDD VDD sky130_fd_sc_hd__diode_2
XANTENNA_93 _02485_ VSS VSS VDD VDD sky130_fd_sc_hd__diode_2
XANTENNA_930 _1336_ VSS VSS VDD VDD sky130_fd_sc_hd__diode_2
XANTENNA_931 _1336_ VSS VSS VDD VDD sky130_fd_sc_hd__diode_2
XANTENNA_932 _1336_ VSS VSS VDD VDD sky130_fd_sc_hd__diode_2
XANTENNA_933 _1336_ VSS VSS VDD VDD sky130_fd_sc_hd__diode_2
XANTENNA_934 _1336_ VSS VSS VDD VDD sky130_fd_sc_hd__diode_2
XANTENNA_935 _1336_ VSS VSS VDD VDD sky130_fd_sc_hd__diode_2
XANTENNA_936 _1336_ VSS VSS VDD VDD sky130_fd_sc_hd__diode_2
XANTENNA_937 _1336_ VSS VSS VDD VDD sky130_fd_sc_hd__diode_2
XANTENNA_938 _1337_ VSS VSS VDD VDD sky130_fd_sc_hd__diode_2
XANTENNA_939 _1337_ VSS VSS VDD VDD sky130_fd_sc_hd__diode_2
XANTENNA_94 _02485_ VSS VSS VDD VDD sky130_fd_sc_hd__diode_2
XANTENNA_940 _1337_ VSS VSS VDD VDD sky130_fd_sc_hd__diode_2
XANTENNA_941 _1337_ VSS VSS VDD VDD sky130_fd_sc_hd__diode_2
XANTENNA_942 _1337_ VSS VSS VDD VDD sky130_fd_sc_hd__diode_2
XANTENNA_943 _1337_ VSS VSS VDD VDD sky130_fd_sc_hd__diode_2
XANTENNA_944 _1337_ VSS VSS VDD VDD sky130_fd_sc_hd__diode_2
XANTENNA_945 _1337_ VSS VSS VDD VDD sky130_fd_sc_hd__diode_2
XANTENNA_946 _1337_ VSS VSS VDD VDD sky130_fd_sc_hd__diode_2
XANTENNA_947 _1337_ VSS VSS VDD VDD sky130_fd_sc_hd__diode_2
XANTENNA_948 _1337_ VSS VSS VDD VDD sky130_fd_sc_hd__diode_2
XANTENNA_949 _1338_ VSS VSS VDD VDD sky130_fd_sc_hd__diode_2
XANTENNA_95 _02485_ VSS VSS VDD VDD sky130_fd_sc_hd__diode_2
XANTENNA_950 _1338_ VSS VSS VDD VDD sky130_fd_sc_hd__diode_2
XANTENNA_951 _1338_ VSS VSS VDD VDD sky130_fd_sc_hd__diode_2
XANTENNA_952 _1338_ VSS VSS VDD VDD sky130_fd_sc_hd__diode_2
XANTENNA_953 _1338_ VSS VSS VDD VDD sky130_fd_sc_hd__diode_2
XANTENNA_954 _1338_ VSS VSS VDD VDD sky130_fd_sc_hd__diode_2
XANTENNA_955 _1339_ VSS VSS VDD VDD sky130_fd_sc_hd__diode_2
XANTENNA_956 _1339_ VSS VSS VDD VDD sky130_fd_sc_hd__diode_2
XANTENNA_957 _1339_ VSS VSS VDD VDD sky130_fd_sc_hd__diode_2
XANTENNA_958 _1339_ VSS VSS VDD VDD sky130_fd_sc_hd__diode_2
XANTENNA_959 _1339_ VSS VSS VDD VDD sky130_fd_sc_hd__diode_2
XANTENNA_96 _02485_ VSS VSS VDD VDD sky130_fd_sc_hd__diode_2
XANTENNA_960 _1339_ VSS VSS VDD VDD sky130_fd_sc_hd__diode_2
XANTENNA_961 _1339_ VSS VSS VDD VDD sky130_fd_sc_hd__diode_2
XANTENNA_962 _1339_ VSS VSS VDD VDD sky130_fd_sc_hd__diode_2
XANTENNA_963 _1339_ VSS VSS VDD VDD sky130_fd_sc_hd__diode_2
XANTENNA_964 _1339_ VSS VSS VDD VDD sky130_fd_sc_hd__diode_2
XANTENNA_965 _1339_ VSS VSS VDD VDD sky130_fd_sc_hd__diode_2
XANTENNA_966 _1340_ VSS VSS VDD VDD sky130_fd_sc_hd__diode_2
XANTENNA_967 _1340_ VSS VSS VDD VDD sky130_fd_sc_hd__diode_2
XANTENNA_968 _1340_ VSS VSS VDD VDD sky130_fd_sc_hd__diode_2
XANTENNA_969 _1340_ VSS VSS VDD VDD sky130_fd_sc_hd__diode_2
XANTENNA_97 _02490_ VSS VSS VDD VDD sky130_fd_sc_hd__diode_2
XANTENNA_970 _1340_ VSS VSS VDD VDD sky130_fd_sc_hd__diode_2
XANTENNA_971 _1340_ VSS VSS VDD VDD sky130_fd_sc_hd__diode_2
XANTENNA_972 _1340_ VSS VSS VDD VDD sky130_fd_sc_hd__diode_2
XANTENNA_973 _1340_ VSS VSS VDD VDD sky130_fd_sc_hd__diode_2
XANTENNA_974 _1340_ VSS VSS VDD VDD sky130_fd_sc_hd__diode_2
XANTENNA_975 _1340_ VSS VSS VDD VDD sky130_fd_sc_hd__diode_2
XANTENNA_976 _1340_ VSS VSS VDD VDD sky130_fd_sc_hd__diode_2
XANTENNA_977 _1346_ VSS VSS VDD VDD sky130_fd_sc_hd__diode_2
XANTENNA_978 _1346_ VSS VSS VDD VDD sky130_fd_sc_hd__diode_2
XANTENNA_979 _1346_ VSS VSS VDD VDD sky130_fd_sc_hd__diode_2
XANTENNA_98 _02490_ VSS VSS VDD VDD sky130_fd_sc_hd__diode_2
XANTENNA_980 _1349_ VSS VSS VDD VDD sky130_fd_sc_hd__diode_2
XANTENNA_981 _1350_ VSS VSS VDD VDD sky130_fd_sc_hd__diode_2
XANTENNA_982 _1352_ VSS VSS VDD VDD sky130_fd_sc_hd__diode_2
XANTENNA_983 _1352_ VSS VSS VDD VDD sky130_fd_sc_hd__diode_2
XANTENNA_984 _1352_ VSS VSS VDD VDD sky130_fd_sc_hd__diode_2
XANTENNA_985 _1352_ VSS VSS VDD VDD sky130_fd_sc_hd__diode_2
XANTENNA_986 _1352_ VSS VSS VDD VDD sky130_fd_sc_hd__diode_2
XANTENNA_987 _1352_ VSS VSS VDD VDD sky130_fd_sc_hd__diode_2
XANTENNA_988 _1359_ VSS VSS VDD VDD sky130_fd_sc_hd__diode_2
XANTENNA_989 _2033_[1] VSS VSS VDD VDD sky130_fd_sc_hd__diode_2
XANTENNA_99 _02490_ VSS VSS VDD VDD sky130_fd_sc_hd__diode_2
XANTENNA_990 net96 VSS VSS VDD VDD sky130_fd_sc_hd__diode_2
XANTENNA_991 clk VSS VSS VDD VDD sky130_fd_sc_hd__diode_2
XANTENNA_992 clk VSS VSS VDD VDD sky130_fd_sc_hd__diode_2
XANTENNA_993 clk VSS VSS VDD VDD sky130_fd_sc_hd__diode_2
XANTENNA_994 clk VSS VSS VDD VDD sky130_fd_sc_hd__diode_2
XANTENNA_995 clk VSS VSS VDD VDD sky130_fd_sc_hd__diode_2
XANTENNA_996 clk VSS VSS VDD VDD sky130_fd_sc_hd__diode_2
XANTENNA_997 clk VSS VSS VDD VDD sky130_fd_sc_hd__diode_2
XANTENNA_998 clk VSS VSS VDD VDD sky130_fd_sc_hd__diode_2
XANTENNA_999 clk VSS VSS VDD VDD sky130_fd_sc_hd__diode_2
.ends
.subckt tc2t2r wl blp bln sl vss
XMp dp wl sl vss sky130_fd_pr__nfet_g5v0d10v5 w=1 l=0.5
XRp blp dp sky130_fd_pr_reram__reram_cell area_ox=0.0676
XMn dn wl sl vss sky130_fd_pr__nfet_g5v0d10v5 w=1 l=0.5
XRn bln dn sky130_fd_pr_reram__reram_cell area_ox=0.0676
.ends
.subckt user_analog_project_wrapper gpio_analog[0] gpio_analog[10] gpio_analog[11] gpio_analog[12] gpio_analog[13] gpio_analog[14] gpio_analog[15] gpio_analog[16] gpio_analog[17] gpio_analog[1] gpio_analog[2] gpio_analog[3] gpio_analog[4] gpio_analog[5] gpio_analog[6] gpio_analog[7] gpio_analog[8] gpio_analog[9] gpio_noesd[0] gpio_noesd[10] gpio_noesd[11] gpio_noesd[12] gpio_noesd[13] gpio_noesd[14] gpio_noesd[15] gpio_noesd[16] gpio_noesd[17] gpio_noesd[1] gpio_noesd[2] gpio_noesd[3] gpio_noesd[4] gpio_noesd[5] gpio_noesd[6] gpio_noesd[7] gpio_noesd[8] gpio_noesd[9] io_analog[0] io_analog[10] io_analog[1] io_analog[2] io_analog[3] io_analog[4] io_analog[7] io_analog[8] io_analog[9] io_analog[5] io_analog[6] io_clamp_high[0] io_clamp_high[1] io_clamp_high[2] io_clamp_low[0] io_clamp_low[1] io_clamp_low[2] io_in[0] io_in[10] io_in[11] io_in[12] io_in[13] io_in[14] io_in[15] io_in[16] io_in[17] io_in[18] io_in[19] io_in[1] io_in[20] io_in[21] io_in[22] io_in[23] io_in[24] io_in[25] io_in[26] io_in[2] io_in[3] io_in[4] io_in[5] io_in[6] io_in[7] io_in[8] io_in[9] io_in_3v3[0] io_in_3v3[10] io_in_3v3[11] io_in_3v3[12] io_in_3v3[13] io_in_3v3[14] io_in_3v3[15] io_in_3v3[16] io_in_3v3[17] io_in_3v3[18] io_in_3v3[19] io_in_3v3[1] io_in_3v3[20] io_in_3v3[21] io_in_3v3[22] io_in_3v3[23] io_in_3v3[24] io_in_3v3[25] io_in_3v3[26] io_in_3v3[2] io_in_3v3[3] io_in_3v3[4] io_in_3v3[5] io_in_3v3[6] io_in_3v3[7] io_in_3v3[8] io_in_3v3[9] io_oeb[0] io_oeb[10] io_oeb[11] io_oeb[12] io_oeb[13] io_oeb[14] io_oeb[15] io_oeb[16] io_oeb[17] io_oeb[18] io_oeb[19] io_oeb[1] io_oeb[20] io_oeb[21] io_oeb[22] io_oeb[23] io_oeb[24] io_oeb[25] io_oeb[26] io_oeb[2] io_oeb[3] io_oeb[4] io_oeb[5] io_oeb[6] io_oeb[7] io_oeb[8] io_oeb[9] io_out[0] io_out[10] io_out[11] io_out[12] io_out[13] io_out[14] io_out[15] io_out[16] io_out[17] io_out[18] io_out[19] io_out[1] io_out[20] io_out[21] io_out[22] io_out[23] io_out[24] io_out[25] io_out[26] io_out[2] io_out[3] io_out[4] io_out[5] io_out[6] io_out[7] io_out[8] io_out[9] la_data_in[0] la_data_in[100] la_data_in[101] la_data_in[102] la_data_in[103] la_data_in[104] la_data_in[105] la_data_in[106] la_data_in[107] la_data_in[108] la_data_in[109] la_data_in[10] la_data_in[110] la_data_in[111] la_data_in[112] la_data_in[113] la_data_in[114] la_data_in[115] la_data_in[116] la_data_in[117] la_data_in[118] la_data_in[119] la_data_in[11] la_data_in[120] la_data_in[121] la_data_in[122] la_data_in[123] la_data_in[124] la_data_in[125] la_data_in[126] la_data_in[127] la_data_in[12] la_data_in[13] la_data_in[14] la_data_in[15] la_data_in[16] la_data_in[17] la_data_in[18] la_data_in[19] la_data_in[1] la_data_in[20] la_data_in[21] la_data_in[22] la_data_in[23] la_data_in[24] la_data_in[25] la_data_in[26] la_data_in[27] la_data_in[28] la_data_in[29] la_data_in[2] la_data_in[30] la_data_in[31] la_data_in[32] la_data_in[33] la_data_in[34] la_data_in[35] la_data_in[36] la_data_in[37] la_data_in[38] la_data_in[39] la_data_in[3] la_data_in[40] la_data_in[41] la_data_in[42] la_data_in[43] la_data_in[44] la_data_in[45] la_data_in[46] la_data_in[47] la_data_in[48] la_data_in[49] la_data_in[4] la_data_in[50] la_data_in[51] la_data_in[52] la_data_in[53] la_data_in[54] la_data_in[55] la_data_in[56] la_data_in[57] la_data_in[58] la_data_in[59] la_data_in[5] la_data_in[60] la_data_in[61] la_data_in[62] la_data_in[63] la_data_in[64] la_data_in[65] la_data_in[66] la_data_in[67] la_data_in[68] la_data_in[69] la_data_in[6] la_data_in[70] la_data_in[71] la_data_in[72] la_data_in[73] la_data_in[74] la_data_in[75] la_data_in[76] la_data_in[77] la_data_in[78] la_data_in[79] la_data_in[7] la_data_in[80] la_data_in[81] la_data_in[82] la_data_in[83] la_data_in[84] la_data_in[85] la_data_in[86] la_data_in[87] la_data_in[88] la_data_in[89] la_data_in[8] la_data_in[90] la_data_in[91] la_data_in[92] la_data_in[93] la_data_in[94] la_data_in[95] la_data_in[96] la_data_in[97] la_data_in[98] la_data_in[99] la_data_in[9] la_data_out[0] la_data_out[100] la_data_out[101] la_data_out[102] la_data_out[103] la_data_out[104] la_data_out[105] la_data_out[106] la_data_out[107] la_data_out[108] la_data_out[109] la_data_out[10] la_data_out[110] la_data_out[111] la_data_out[112] la_data_out[113] la_data_out[114] la_data_out[115] la_data_out[116] la_data_out[117] la_data_out[118] la_data_out[119] la_data_out[11] la_data_out[120] la_data_out[121] la_data_out[122] la_data_out[123] la_data_out[124] la_data_out[125] la_data_out[126] la_data_out[127] la_data_out[12] la_data_out[13] la_data_out[14] la_data_out[15] la_data_out[16] la_data_out[17] la_data_out[18] la_data_out[19] la_data_out[1] la_data_out[20] la_data_out[21] la_data_out[22] la_data_out[23] la_data_out[24] la_data_out[25] la_data_out[26] la_data_out[27] la_data_out[28] la_data_out[29] la_data_out[2] la_data_out[30] la_data_out[31] la_data_out[32] la_data_out[33] la_data_out[34] la_data_out[35] la_data_out[36] la_data_out[37] la_data_out[38] la_data_out[39] la_data_out[3] la_data_out[40] la_data_out[41] la_data_out[42] la_data_out[43] la_data_out[44] la_data_out[45] la_data_out[46] la_data_out[47] la_data_out[48] la_data_out[49] la_data_out[4] la_data_out[50] la_data_out[51] la_data_out[52] la_data_out[53] la_data_out[54] la_data_out[55] la_data_out[56] la_data_out[57] la_data_out[58] la_data_out[59] la_data_out[5] la_data_out[60] la_data_out[61] la_data_out[62] la_data_out[63] la_data_out[64] la_data_out[65] la_data_out[66] la_data_out[67] la_data_out[68] la_data_out[69] la_data_out[6] la_data_out[70] la_data_out[71] la_data_out[72] la_data_out[73] la_data_out[74] la_data_out[75] la_data_out[76] la_data_out[77] la_data_out[78] la_data_out[79] la_data_out[7] la_data_out[80] la_data_out[81] la_data_out[82] la_data_out[83] la_data_out[84] la_data_out[85] la_data_out[86] la_data_out[87] la_data_out[88] la_data_out[89] la_data_out[8] la_data_out[90] la_data_out[91] la_data_out[92] la_data_out[93] la_data_out[94] la_data_out[95] la_data_out[96] la_data_out[97] la_data_out[98] la_data_out[99] la_data_out[9] la_oenb[0] la_oenb[100] la_oenb[101] la_oenb[102] la_oenb[103] la_oenb[104] la_oenb[105] la_oenb[106] la_oenb[107] la_oenb[108] la_oenb[109] la_oenb[10] la_oenb[110] la_oenb[111] la_oenb[112] la_oenb[113] la_oenb[114] la_oenb[115] la_oenb[116] la_oenb[117] la_oenb[118] la_oenb[119] la_oenb[11] la_oenb[120] la_oenb[121] la_oenb[122] la_oenb[123] la_oenb[124] la_oenb[125] la_oenb[126] la_oenb[127] la_oenb[12] la_oenb[13] la_oenb[14] la_oenb[15] la_oenb[16] la_oenb[17] la_oenb[18] la_oenb[19] la_oenb[1] la_oenb[20] la_oenb[21] la_oenb[22] la_oenb[23] la_oenb[24] la_oenb[25] la_oenb[26] la_oenb[27] la_oenb[28] la_oenb[29] la_oenb[2] la_oenb[30] la_oenb[31] la_oenb[32] la_oenb[33] la_oenb[34] la_oenb[35] la_oenb[36] la_oenb[37] la_oenb[38] la_oenb[39] la_oenb[3] la_oenb[40] la_oenb[41] la_oenb[42] la_oenb[43] la_oenb[44] la_oenb[45] la_oenb[46] la_oenb[47] la_oenb[48] la_oenb[49] la_oenb[4] la_oenb[50] la_oenb[51] la_oenb[52] la_oenb[53] la_oenb[54] la_oenb[55] la_oenb[56] la_oenb[57] la_oenb[58] la_oenb[59] la_oenb[5] la_oenb[60] la_oenb[61] la_oenb[62] la_oenb[63] la_oenb[64] la_oenb[65] la_oenb[66] la_oenb[67] la_oenb[68] la_oenb[69] la_oenb[6] la_oenb[70] la_oenb[71] la_oenb[72] la_oenb[73] la_oenb[74] la_oenb[75] la_oenb[76] la_oenb[77] la_oenb[78] la_oenb[79] la_oenb[7] la_oenb[80] la_oenb[81] la_oenb[82] la_oenb[83] la_oenb[84] la_oenb[85] la_oenb[86] la_oenb[87] la_oenb[88] la_oenb[89] la_oenb[8] la_oenb[90] la_oenb[91] la_oenb[92] la_oenb[93] la_oenb[94] la_oenb[95] la_oenb[96] la_oenb[97] la_oenb[98] la_oenb[99] la_oenb[9] user_clock2 user_irq[0] user_irq[1] user_irq[2] vccd1 vccd2 vdda1 vdda2 vssa1 vssa2 vssd1 vssd2 wb_clk_i wb_rst_i wbs_ack_o wbs_adr_i[0] wbs_adr_i[10] wbs_adr_i[11] wbs_adr_i[12] wbs_adr_i[13] wbs_adr_i[14] wbs_adr_i[15] wbs_adr_i[16] wbs_adr_i[17] wbs_adr_i[18] wbs_adr_i[19] wbs_adr_i[1] wbs_adr_i[20] wbs_adr_i[21] wbs_adr_i[22] wbs_adr_i[23] wbs_adr_i[24] wbs_adr_i[25] wbs_adr_i[26] wbs_adr_i[27] wbs_adr_i[28] wbs_adr_i[29] wbs_adr_i[2] wbs_adr_i[30] wbs_adr_i[31] wbs_adr_i[3] wbs_adr_i[4] wbs_adr_i[5] wbs_adr_i[6] wbs_adr_i[7] wbs_adr_i[8] wbs_adr_i[9] wbs_cyc_i wbs_dat_i[0] wbs_dat_i[10] wbs_dat_i[11] wbs_dat_i[12] wbs_dat_i[13] wbs_dat_i[14] wbs_dat_i[15] wbs_dat_i[16] wbs_dat_i[17] wbs_dat_i[18] wbs_dat_i[19] wbs_dat_i[1] wbs_dat_i[20] wbs_dat_i[21] wbs_dat_i[22] wbs_dat_i[23] wbs_dat_i[24] wbs_dat_i[25] wbs_dat_i[26] wbs_dat_i[27] wbs_dat_i[28] wbs_dat_i[29] wbs_dat_i[2] wbs_dat_i[30] wbs_dat_i[31] wbs_dat_i[3] wbs_dat_i[4] wbs_dat_i[5] wbs_dat_i[6] wbs_dat_i[7] wbs_dat_i[8] wbs_dat_i[9] wbs_dat_o[0] wbs_dat_o[10] wbs_dat_o[11] wbs_dat_o[12] wbs_dat_o[13] wbs_dat_o[14] wbs_dat_o[15] wbs_dat_o[16] wbs_dat_o[17] wbs_dat_o[18] wbs_dat_o[19] wbs_dat_o[1] wbs_dat_o[20] wbs_dat_o[21] wbs_dat_o[22] wbs_dat_o[23] wbs_dat_o[24] wbs_dat_o[25] wbs_dat_o[26] wbs_dat_o[27] wbs_dat_o[28] wbs_dat_o[29] wbs_dat_o[2] wbs_dat_o[30] wbs_dat_o[31] wbs_dat_o[3] wbs_dat_o[4] wbs_dat_o[5] wbs_dat_o[6] wbs_dat_o[7] wbs_dat_o[8] wbs_dat_o[9] wbs_sel_i[0] wbs_sel_i[1] wbs_sel_i[2] wbs_sel_i[3] wbs_stb_i wbs_we_i
Xmacro io_analog[6] io_analog[5] io_analog[1] io_analog[0] vssa1 vdda1 vccd1 io_analog[4] lv_wl_on[35] lv_wl_on[34] lv_wl_on[33] lv_wl_on[32] lv_wl_on[31] lv_wl_on[30] lv_wl_on[29] lv_wl_on[28] lv_wl_on[27] lv_wl_on[26] lv_wl_on[25] lv_wl_on[24] lv_wl_on[23] lv_wl_on[22] lv_wl_on[21] lv_wl_on[20] lv_wl_on[19] lv_wl_on[18] lv_wl_on[17] lv_wl_on[16] lv_wl_on[15] lv_wl_on[14] lv_wl_on[13] lv_wl_on[12] lv_wl_on[11] lv_wl_on[10] lv_wl_on[9] lv_wl_on[8] lv_wl_on[7] lv_wl_on[6] lv_wl_on[5] lv_wl_on[4] lv_wl_on[3] lv_wl_on[2] lv_wl_on[1] lv_wl_on[0] lv_wl_on[71] lv_wl_on[70] lv_wl_on[69] lv_wl_on[68] lv_wl_on[67] lv_wl_on[66] lv_wl_on[65] lv_wl_on[64] lv_wl_on[63] lv_wl_on[62] lv_wl_on[61] lv_wl_on[60] lv_wl_on[59] lv_wl_on[58] lv_wl_on[57] lv_wl_on[56] lv_wl_on[55] lv_wl_on[54] lv_wl_on[53] lv_wl_on[52] lv_wl_on[51] lv_wl_on[50] lv_wl_on[49] lv_wl_on[48] lv_wl_on[47] lv_wl_on[46] lv_wl_on[45] lv_wl_on[44] lv_wl_on[43] lv_wl_on[42] lv_wl_on[41] lv_wl_on[40] lv_wl_on[39] lv_wl_on[38] lv_wl_on[37] lv_wl_on[36] lv_blp_prg[0] lv_sa_p[0] lv_bln_prg[0] lv_sa_n[0] lv_blp_prg[1] lv_sa_p[1] lv_bln_prg[1] lv_sa_n[1] lv_blp_prg[2] lv_sa_p[2] lv_bln_prg[2] lv_sa_n[2] lv_blp_prg[3] lv_sa_p[3] lv_bln_prg[3] lv_sa_n[3] lv_blp_prg[4] lv_sa_p[4] lv_bln_prg[4] lv_sa_n[4] lv_blp_prg[5] lv_sa_p[5] lv_bln_prg[5] lv_sa_n[5] lv_blp_prg[6] lv_sa_p[6] lv_bln_prg[6] lv_sa_n[6] lv_blp_prg[7] lv_sa_p[7] lv_bln_prg[7] lv_sa_n[7] lv_blp_prg[8] lv_sa_p[8] lv_bln_prg[8] lv_sa_n[8] lv_blp_prg[9] lv_sa_p[9] lv_bln_prg[9] lv_sa_n[9] lv_blp_prg[10] lv_sa_p[10] lv_bln_prg[10] lv_sa_n[10] lv_blp_prg[11] lv_sa_p[11] lv_bln_prg[11] lv_sa_n[11] lv_blp_prg[12] lv_sa_p[12] lv_bln_prg[12] lv_sa_n[12] lv_blp_prg[13] lv_sa_p[13] lv_bln_prg[13] lv_sa_n[13] lv_blp_prg[14] lv_sa_p[14] lv_bln_prg[14] lv_sa_n[14] lv_blp_prg[15] lv_sa_p[15] lv_bln_prg[15] lv_sa_n[15] lv_blp_prg[16] lv_sa_p[16] lv_bln_prg[16] lv_sa_n[16] lv_blp_prg[17] lv_sa_p[17] lv_bln_prg[17] lv_sa_n[17] lv_blp_prg[18] lv_sa_p[18] lv_bln_prg[18] lv_sa_n[18] lv_blp_prg[19] lv_sa_p[19] lv_bln_prg[19] lv_sa_n[19] lv_blp_prg[20] lv_sa_p[20] lv_bln_prg[20] lv_sa_n[20] lv_blp_prg[21] lv_sa_p[21] lv_bln_prg[21] lv_sa_n[21] lv_blp_prg[22] lv_sa_p[22] lv_bln_prg[22] lv_sa_n[22] lv_blp_prg[23] lv_sa_p[23] lv_bln_prg[23] lv_sa_n[23] lv_bl_sen lv_flt lv_sl_prg lv_wl_prog lv_ref_sel[0] lv_ref_sel[1] lv_ref_sel[2] tcim_macro
Xdig lv_bl_sen io_in[5] io_in[8] lv_flt io_out[11] io_out[10] io_in[9] io_out[13] io_out[12] io_in[6] io_in[7] lv_sl_prg lv_wl_prog lv_bln_prg[0] lv_bln_prg[1] lv_bln_prg[2] lv_bln_prg[3] lv_bln_prg[4] lv_bln_prg[5] lv_bln_prg[6] lv_bln_prg[7] lv_bln_prg[8] lv_bln_prg[9] lv_bln_prg[10] lv_bln_prg[11] lv_bln_prg[12] lv_bln_prg[13] lv_bln_prg[14] lv_bln_prg[15] lv_bln_prg[16] lv_bln_prg[17] lv_bln_prg[18] lv_bln_prg[19] lv_bln_prg[20] lv_bln_prg[21] lv_bln_prg[22] lv_bln_prg[23] lv_blp_prg[0] lv_blp_prg[1] lv_blp_prg[2] lv_blp_prg[3] lv_blp_prg[4] lv_blp_prg[5] lv_blp_prg[6] lv_blp_prg[7] lv_blp_prg[8] lv_blp_prg[9] lv_blp_prg[10] lv_blp_prg[11] lv_blp_prg[12] lv_blp_prg[13] lv_blp_prg[14] lv_blp_prg[15] lv_blp_prg[16] lv_blp_prg[17] lv_blp_prg[18] lv_blp_prg[19] lv_blp_prg[20] lv_blp_prg[21] lv_blp_prg[22] lv_blp_prg[23] io_in[24] io_in[23] io_in[22] io_in[26] io_in[25] io_in[21] io_in[20] io_in[19] io_out[18] io_out[17] io_out[16] io_out[15] io_out[14] lv_ref_sel[0] lv_ref_sel[1] lv_ref_sel[2] lv_sa_n[0] lv_sa_n[1] lv_sa_n[2] lv_sa_n[3] lv_sa_n[4] lv_sa_n[5] lv_sa_n[6] lv_sa_n[7] lv_sa_n[8] lv_sa_n[9] lv_sa_n[10] lv_sa_n[11] lv_sa_n[12] lv_sa_n[13] lv_sa_n[14] lv_sa_n[15] lv_sa_n[16] lv_sa_n[17] lv_sa_n[18] lv_sa_n[19] lv_sa_n[20] lv_sa_n[21] lv_sa_n[22] lv_sa_n[23] lv_sa_p[0] lv_sa_p[1] lv_sa_p[2] lv_sa_p[3] lv_sa_p[4] lv_sa_p[5] lv_sa_p[6] lv_sa_p[7] lv_sa_p[8] lv_sa_p[9] lv_sa_p[10] lv_sa_p[11] lv_sa_p[12] lv_sa_p[13] lv_sa_p[14] lv_sa_p[15] lv_sa_p[16] lv_sa_p[17] lv_sa_p[18] lv_sa_p[19] lv_sa_p[20] lv_sa_p[21] lv_sa_p[22] lv_sa_p[23] io_oeb[5] io_oeb[6] io_oeb[7] io_oeb[8] io_oeb[9] io_oeb[19] io_oeb[20] io_oeb[21] io_oeb[22] io_oeb[23] io_oeb[24] io_oeb[25] io_oeb[26] io_out[5] io_out[6] io_out[7] io_out[8] io_out[9] io_out[19] io_out[20] io_out[21] io_out[22] io_out[23] io_out[24] io_out[25] io_out[26] io_oeb[10] io_oeb[11] io_oeb[12] io_oeb[13] io_oeb[14] io_oeb[15] io_oeb[16] io_oeb[17] io_oeb[18] lv_wl_on[0] lv_wl_on[1] lv_wl_on[2] lv_wl_on[3] lv_wl_on[4] lv_wl_on[5] lv_wl_on[6] lv_wl_on[7] lv_wl_on[8] lv_wl_on[9] lv_wl_on[10] lv_wl_on[11] lv_wl_on[12] lv_wl_on[13] lv_wl_on[14] lv_wl_on[15] lv_wl_on[16] lv_wl_on[17] lv_wl_on[18] lv_wl_on[19] lv_wl_on[20] lv_wl_on[21] lv_wl_on[22] lv_wl_on[23] lv_wl_on[24] lv_wl_on[25] lv_wl_on[26] lv_wl_on[27] lv_wl_on[28] lv_wl_on[29] lv_wl_on[30] lv_wl_on[31] lv_wl_on[32] lv_wl_on[33] lv_wl_on[34] lv_wl_on[35] lv_wl_on[36] lv_wl_on[37] lv_wl_on[38] lv_wl_on[39] lv_wl_on[40] lv_wl_on[41] lv_wl_on[42] lv_wl_on[43] lv_wl_on[44] lv_wl_on[45] lv_wl_on[46] lv_wl_on[47] lv_wl_on[48] lv_wl_on[49] lv_wl_on[50] lv_wl_on[51] lv_wl_on[52] lv_wl_on[53] lv_wl_on[54] lv_wl_on[55] lv_wl_on[56] lv_wl_on[57] lv_wl_on[58] lv_wl_on[59] lv_wl_on[60] lv_wl_on[61] lv_wl_on[62] lv_wl_on[63] lv_wl_on[64] lv_wl_on[65] lv_wl_on[66] lv_wl_on[67] lv_wl_on[68] lv_wl_on[69] lv_wl_on[70] lv_wl_on[71] vccd1 vssa1 tcim_chip_digital
Xtc io_analog[2] io_analog[3] io_analog[7] io_analog[8] vssa1 tc2t2r
Xd_lv_sa_p[0] vssa1 lv_sa_p[0] sky130_fd_pr__diode_pw2nd_05v5 perim=1.2e+07 area=9e+12
Xd_lv_sa_n[0] vssa1 lv_sa_n[0] sky130_fd_pr__diode_pw2nd_05v5 perim=1.2e+07 area=9e+12
Xd_lv_sa_p[1] vssa1 lv_sa_p[1] sky130_fd_pr__diode_pw2nd_05v5 perim=1.2e+07 area=9e+12
Xd_lv_sa_n[1] vssa1 lv_sa_n[1] sky130_fd_pr__diode_pw2nd_05v5 perim=1.2e+07 area=9e+12
Xd_lv_sa_p[2] vssa1 lv_sa_p[2] sky130_fd_pr__diode_pw2nd_05v5 perim=1.2e+07 area=9e+12
Xd_lv_sa_n[2] vssa1 lv_sa_n[2] sky130_fd_pr__diode_pw2nd_05v5 perim=1.2e+07 area=9e+12
Xd_lv_sa_p[3] vssa1 lv_sa_p[3] sky130_fd_pr__diode_pw2nd_05v5 perim=1.2e+07 area=9e+12
Xd_lv_sa_n[3] vssa1 lv_sa_n[3] sky130_fd_pr__diode_pw2nd_05v5 perim=1.2e+07 area=9e+12
Xd_lv_sa_p[4] vssa1 lv_sa_p[4] sky130_fd_pr__diode_pw2nd_05v5 perim=1.2e+07 area=9e+12
Xd_lv_sa_n[4] vssa1 lv_sa_n[4] sky130_fd_pr__diode_pw2nd_05v5 perim=1.2e+07 area=9e+12
Xd_lv_sa_p[5] vssa1 lv_sa_p[5] sky130_fd_pr__diode_pw2nd_05v5 perim=1.2e+07 area=9e+12
Xd_lv_sa_n[5] vssa1 lv_sa_n[5] sky130_fd_pr__diode_pw2nd_05v5 perim=1.2e+07 area=9e+12
Xd_lv_sa_p[6] vssa1 lv_sa_p[6] sky130_fd_pr__diode_pw2nd_05v5 perim=1.2e+07 area=9e+12
Xd_lv_sa_n[6] vssa1 lv_sa_n[6] sky130_fd_pr__diode_pw2nd_05v5 perim=1.2e+07 area=9e+12
Xd_lv_sa_p[7] vssa1 lv_sa_p[7] sky130_fd_pr__diode_pw2nd_05v5 perim=1.2e+07 area=9e+12
Xd_lv_sa_n[7] vssa1 lv_sa_n[7] sky130_fd_pr__diode_pw2nd_05v5 perim=1.2e+07 area=9e+12
Xd_lv_sa_p[8] vssa1 lv_sa_p[8] sky130_fd_pr__diode_pw2nd_05v5 perim=1.2e+07 area=9e+12
Xd_lv_sa_n[8] vssa1 lv_sa_n[8] sky130_fd_pr__diode_pw2nd_05v5 perim=1.2e+07 area=9e+12
Xd_lv_sa_p[9] vssa1 lv_sa_p[9] sky130_fd_pr__diode_pw2nd_05v5 perim=1.2e+07 area=9e+12
Xd_lv_sa_n[9] vssa1 lv_sa_n[9] sky130_fd_pr__diode_pw2nd_05v5 perim=1.2e+07 area=9e+12
Xd_lv_sa_p[10] vssa1 lv_sa_p[10] sky130_fd_pr__diode_pw2nd_05v5 perim=1.2e+07 area=9e+12
Xd_lv_sa_n[10] vssa1 lv_sa_n[10] sky130_fd_pr__diode_pw2nd_05v5 perim=1.2e+07 area=9e+12
Xd_lv_sa_p[11] vssa1 lv_sa_p[11] sky130_fd_pr__diode_pw2nd_05v5 perim=1.2e+07 area=9e+12
Xd_lv_sa_n[11] vssa1 lv_sa_n[11] sky130_fd_pr__diode_pw2nd_05v5 perim=1.2e+07 area=9e+12
Xd_lv_sa_p[12] vssa1 lv_sa_p[12] sky130_fd_pr__diode_pw2nd_05v5 perim=1.2e+07 area=9e+12
Xd_lv_sa_n[12] vssa1 lv_sa_n[12] sky130_fd_pr__diode_pw2nd_05v5 perim=1.2e+07 area=9e+12
Xd_lv_sa_p[13] vssa1 lv_sa_p[13] sky130_fd_pr__diode_pw2nd_05v5 perim=1.2e+07 area=9e+12
Xd_lv_sa_n[13] vssa1 lv_sa_n[13] sky130_fd_pr__diode_pw2nd_05v5 perim=1.2e+07 area=9e+12
Xd_lv_sa_p[14] vssa1 lv_sa_p[14] sky130_fd_pr__diode_pw2nd_05v5 perim=1.2e+07 area=9e+12
Xd_lv_sa_n[14] vssa1 lv_sa_n[14] sky130_fd_pr__diode_pw2nd_05v5 perim=1.2e+07 area=9e+12
Xd_lv_sa_p[15] vssa1 lv_sa_p[15] sky130_fd_pr__diode_pw2nd_05v5 perim=1.2e+07 area=9e+12
Xd_lv_sa_n[15] vssa1 lv_sa_n[15] sky130_fd_pr__diode_pw2nd_05v5 perim=1.2e+07 area=9e+12
Xd_lv_sa_p[16] vssa1 lv_sa_p[16] sky130_fd_pr__diode_pw2nd_05v5 perim=1.2e+07 area=9e+12
Xd_lv_sa_n[16] vssa1 lv_sa_n[16] sky130_fd_pr__diode_pw2nd_05v5 perim=1.2e+07 area=9e+12
Xd_lv_sa_p[17] vssa1 lv_sa_p[17] sky130_fd_pr__diode_pw2nd_05v5 perim=1.2e+07 area=9e+12
Xd_lv_sa_n[17] vssa1 lv_sa_n[17] sky130_fd_pr__diode_pw2nd_05v5 perim=1.2e+07 area=9e+12
Xd_lv_sa_p[18] vssa1 lv_sa_p[18] sky130_fd_pr__diode_pw2nd_05v5 perim=1.2e+07 area=9e+12
Xd_lv_sa_n[18] vssa1 lv_sa_n[18] sky130_fd_pr__diode_pw2nd_05v5 perim=1.2e+07 area=9e+12
Xd_lv_sa_p[19] vssa1 lv_sa_p[19] sky130_fd_pr__diode_pw2nd_05v5 perim=1.2e+07 area=9e+12
Xd_lv_sa_n[19] vssa1 lv_sa_n[19] sky130_fd_pr__diode_pw2nd_05v5 perim=1.2e+07 area=9e+12
Xd_lv_sa_p[20] vssa1 lv_sa_p[20] sky130_fd_pr__diode_pw2nd_05v5 perim=1.2e+07 area=9e+12
Xd_lv_sa_n[20] vssa1 lv_sa_n[20] sky130_fd_pr__diode_pw2nd_05v5 perim=1.2e+07 area=9e+12
Xd_lv_sa_p[21] vssa1 lv_sa_p[21] sky130_fd_pr__diode_pw2nd_05v5 perim=1.2e+07 area=9e+12
Xd_lv_sa_n[21] vssa1 lv_sa_n[21] sky130_fd_pr__diode_pw2nd_05v5 perim=1.2e+07 area=9e+12
Xd_lv_sa_p[22] vssa1 lv_sa_p[22] sky130_fd_pr__diode_pw2nd_05v5 perim=1.2e+07 area=9e+12
Xd_lv_sa_n[22] vssa1 lv_sa_n[22] sky130_fd_pr__diode_pw2nd_05v5 perim=1.2e+07 area=9e+12
Xd_lv_sa_p[23] vssa1 lv_sa_p[23] sky130_fd_pr__diode_pw2nd_05v5 perim=1.2e+07 area=9e+12
Xd_lv_sa_n[23] vssa1 lv_sa_n[23] sky130_fd_pr__diode_pw2nd_05v5 perim=1.2e+07 area=9e+12
Xd_io_in[5] vssa1 io_in[5] sky130_fd_pr__diode_pw2nd_05v5 perim=1.2e+07 area=9e+12
Xd_io_in[6] vssa1 io_in[6] sky130_fd_pr__diode_pw2nd_05v5 perim=1.2e+07 area=9e+12
Xd_io_in[9] vssa1 io_in[9] sky130_fd_pr__diode_pw2nd_05v5 perim=1.2e+07 area=9e+12
Xd_io_in[8] vssa1 io_in[8] sky130_fd_pr__diode_pw2nd_05v5 perim=1.2e+07 area=9e+12
Xd_io_in[7] vssa1 io_in[7] sky130_fd_pr__diode_pw2nd_05v5 perim=1.2e+07 area=9e+12
Xd_io_in[26] vssa1 io_in[26] sky130_fd_pr__diode_pw2nd_05v5 perim=1.2e+07 area=9e+12
Xd_io_in[25] vssa1 io_in[25] sky130_fd_pr__diode_pw2nd_05v5 perim=1.2e+07 area=9e+12
Xd_io_in[24] vssa1 io_in[24] sky130_fd_pr__diode_pw2nd_05v5 perim=1.2e+07 area=9e+12
Xd_io_in[21] vssa1 io_in[21] sky130_fd_pr__diode_pw2nd_05v5 perim=1.2e+07 area=9e+12
Xd_io_in[23] vssa1 io_in[23] sky130_fd_pr__diode_pw2nd_05v5 perim=1.2e+07 area=9e+12
Xd_io_in[22] vssa1 io_in[22] sky130_fd_pr__diode_pw2nd_05v5 perim=1.2e+07 area=9e+12
Xd_io_in[20] vssa1 io_in[20] sky130_fd_pr__diode_pw2nd_05v5 perim=1.2e+07 area=9e+12
Xd_io_in[19] vssa1 io_in[19] sky130_fd_pr__diode_pw2nd_05v5 perim=1.2e+07 area=9e+12
.ends
