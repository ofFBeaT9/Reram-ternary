* Extracted by KLayout with SG13G2 LVS runset on : 09/10/2026 14:24

.SUBCKT tcim_ls in out vdd vddh vss
M$1 vss in \$6 vss sg13_lv_nmos L=0.13u W=0.3u AS=0.102p AD=0.102p PS=1.28u
+ PD=1.28u rfmode=0
M$2 vss in \$8 vss sg13_hv_nmos L=0.45u W=1u AS=0.34p AD=0.34p PS=2.68u
+ PD=2.68u rfmode=0
M$3 vss \$6 \$2 vss sg13_hv_nmos L=0.45u W=1u AS=0.34p AD=0.34p PS=2.68u
+ PD=2.68u rfmode=0
M$4 vss \$8 out vss sg13_hv_nmos L=0.45u W=1u AS=0.34p AD=0.34p PS=2.68u
+ PD=2.68u rfmode=0
M$5 vdd in \$6 vdd sg13_lv_pmos L=0.13u W=0.6u AS=0.204p AD=0.204p PS=1.88u
+ PD=1.88u rfmode=0
M$6 vddh \$2 \$8 vddh sg13_hv_pmos L=0.45u W=0.3u AS=0.102p AD=0.102p PS=1.28u
+ PD=1.28u rfmode=0
M$7 vddh \$8 \$2 vddh sg13_hv_pmos L=0.45u W=0.3u AS=0.102p AD=0.102p PS=1.28u
+ PD=1.28u rfmode=0
M$8 vddh \$8 out vddh sg13_hv_pmos L=0.45u W=2u AS=0.68p AD=0.68p PS=4.68u
+ PD=4.68u rfmode=0
.ENDS tcim_ls
