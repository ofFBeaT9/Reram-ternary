* ReRAM cell alone: 1 us pulses of 1.0, 1.1, 1.2 V (SET from 1.8 nm), then RESET pulse -1.2 V
.include ../../model/reram_stanford_ihp.lib
Vte te 0 PWL(0 0 10n 1.0 1.01u 1.0 1.02u 0 2u 0 2.01u 1.1 3.01u 1.1 3.02u 0 4u 0 4.01u 1.2 5.01u 1.2 5.02u 0 6u 0 6.01u -1.2 7.01u -1.2 7.02u 0 8u 0)
X1 te 0 gap reram_stanford_ihp gap_min=0.10 gap_ini=1.8
.options reltol=1e-4 abstol=1e-13 vntol=1e-7 method=gear
.tran 1n 8u 0 2n uic
.control
run
meas tran g1 find v(gap) at=1.5u
meas tran g2 find v(gap) at=3.5u
meas tran g3 find v(gap) at=5.5u
meas tran g4 find v(gap) at=7.5u
.endc
.end
