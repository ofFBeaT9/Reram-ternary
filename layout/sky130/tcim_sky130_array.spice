* NGSPICE file created from tcim_sky130_array.ext - technology: sky130B

.subckt tcim_sky130_array WL0 WL1 WL2 WL3 WL4 WL5 WL6 WL7 WL8 WL9 WL10 WL11 WL12 WL13
+ WL14 WL15 WL16 WL17 WL18 WL19 WL20 WL21 WL22 WL23 WL24 WL25 WL26 WL27 WL28 WL29
+ WL30 WL31 WL32 WL33 WL34 WL35 WL36 WL37 WL38 WL39 WL40 WL41 WL42 WL43 WL44 WL45
+ WL46 WL47 WL48 WL49 WL50 WL51 WL52 WL53 WL54 WL55 WL56 WL57 WL58 WL59 WL60 WL61
+ WL62 WL63 WL64 WL65 WL66 WL67 WL68 WL69 WL70 WL71 BLP0 BLP1 BLP2 BLP3 BLP4 BLP5
+ BLP6 BLP7 BLP8 BLP9 BLP10 BLP11 BLP12 BLP13 BLP14 BLP15 BLP16 BLP17 BLP18 BLP19
+ BLP20 BLP21 BLP22 BLP23 BLN0 BLN1 BLN2 BLN3 BLN4 BLN5 BLN6 BLN7 BLN8 BLN9 BLN10
+ BLN11 BLN12 BLN13 BLN14 BLN15 BLN16 BLN17 BLN18 BLN19 BLN20 BLN21 BLN22 BLN23 SL0
+ SL1 SL2 SL3 SL4 SL5 SL6 SL7 SL8 SL9 SL10 SL11 SL12 SL13 SL14 SL15 SL16 SL17 SL18
+ SL19 SL20 SL21 SL22 SL23 VSS
X0 rr2t2r_0[0|0]/a_460_290# WL0 SL0 VSS sky130_fd_pr__nfet_g5v0d10v5 ad=0.65 pd=3.3 as=0.75 ps=3.5 w=1 l=0.5
X1 BLP0 rr2t2r_0[0|0]/a_60_290# sky130_fd_pr_reram__reram_cell area_ox=0.0676
X2 BLN0 rr2t2r_0[0|0]/a_460_290# sky130_fd_pr_reram__reram_cell area_ox=0.0676
X3 rr2t2r_0[0|0]/a_60_290# WL0 SL0 VSS sky130_fd_pr__nfet_g5v0d10v5 ad=0.65 pd=3.3 as=0.75 ps=3.5 w=1 l=0.5
X4 rr2t2r_0[1|0]/a_460_290# WL1 SL0 VSS sky130_fd_pr__nfet_g5v0d10v5 ad=0.65 pd=3.3 as=108 ps=504 w=1 l=0.5
X5 BLP0 rr2t2r_0[1|0]/a_60_290# sky130_fd_pr_reram__reram_cell area_ox=0.0676
X6 BLN0 rr2t2r_0[1|0]/a_460_290# sky130_fd_pr_reram__reram_cell area_ox=0.0676
X7 rr2t2r_0[1|0]/a_60_290# WL1 SL0 VSS sky130_fd_pr__nfet_g5v0d10v5 ad=0.65 pd=3.3 as=0 ps=0 w=1 l=0.5
X8 rr2t2r_0[2|0]/a_460_290# WL2 SL0 VSS sky130_fd_pr__nfet_g5v0d10v5 ad=0.65 pd=3.3 as=0 ps=0 w=1 l=0.5
X9 BLP0 rr2t2r_0[2|0]/a_60_290# sky130_fd_pr_reram__reram_cell area_ox=0.0676
X10 BLN0 rr2t2r_0[2|0]/a_460_290# sky130_fd_pr_reram__reram_cell area_ox=0.0676
X11 rr2t2r_0[2|0]/a_60_290# WL2 SL0 VSS sky130_fd_pr__nfet_g5v0d10v5 ad=0.65 pd=3.3 as=0 ps=0 w=1 l=0.5
X12 rr2t2r_0[3|0]/a_460_290# WL3 SL0 VSS sky130_fd_pr__nfet_g5v0d10v5 ad=0.65 pd=3.3 as=0 ps=0 w=1 l=0.5
X13 BLP0 rr2t2r_0[3|0]/a_60_290# sky130_fd_pr_reram__reram_cell area_ox=0.0676
X14 BLN0 rr2t2r_0[3|0]/a_460_290# sky130_fd_pr_reram__reram_cell area_ox=0.0676
X15 rr2t2r_0[3|0]/a_60_290# WL3 SL0 VSS sky130_fd_pr__nfet_g5v0d10v5 ad=0.65 pd=3.3 as=0 ps=0 w=1 l=0.5
X16 rr2t2r_0[4|0]/a_460_290# WL4 SL0 VSS sky130_fd_pr__nfet_g5v0d10v5 ad=0.65 pd=3.3 as=0 ps=0 w=1 l=0.5
X17 BLP0 rr2t2r_0[4|0]/a_60_290# sky130_fd_pr_reram__reram_cell area_ox=0.0676
X18 BLN0 rr2t2r_0[4|0]/a_460_290# sky130_fd_pr_reram__reram_cell area_ox=0.0676
X19 rr2t2r_0[4|0]/a_60_290# WL4 SL0 VSS sky130_fd_pr__nfet_g5v0d10v5 ad=0.65 pd=3.3 as=0 ps=0 w=1 l=0.5
X20 rr2t2r_0[5|0]/a_460_290# WL5 SL0 VSS sky130_fd_pr__nfet_g5v0d10v5 ad=0.65 pd=3.3 as=0 ps=0 w=1 l=0.5
X21 BLP0 rr2t2r_0[5|0]/a_60_290# sky130_fd_pr_reram__reram_cell area_ox=0.0676
X22 BLN0 rr2t2r_0[5|0]/a_460_290# sky130_fd_pr_reram__reram_cell area_ox=0.0676
X23 rr2t2r_0[5|0]/a_60_290# WL5 SL0 VSS sky130_fd_pr__nfet_g5v0d10v5 ad=0.65 pd=3.3 as=0 ps=0 w=1 l=0.5
X24 rr2t2r_0[6|0]/a_460_290# WL6 SL0 VSS sky130_fd_pr__nfet_g5v0d10v5 ad=0.65 pd=3.3 as=0 ps=0 w=1 l=0.5
X25 BLP0 rr2t2r_0[6|0]/a_60_290# sky130_fd_pr_reram__reram_cell area_ox=0.0676
X26 BLN0 rr2t2r_0[6|0]/a_460_290# sky130_fd_pr_reram__reram_cell area_ox=0.0676
X27 rr2t2r_0[6|0]/a_60_290# WL6 SL0 VSS sky130_fd_pr__nfet_g5v0d10v5 ad=0.65 pd=3.3 as=0 ps=0 w=1 l=0.5
X28 rr2t2r_0[7|0]/a_460_290# WL7 SL0 VSS sky130_fd_pr__nfet_g5v0d10v5 ad=0.65 pd=3.3 as=0 ps=0 w=1 l=0.5
X29 BLP0 rr2t2r_0[7|0]/a_60_290# sky130_fd_pr_reram__reram_cell area_ox=0.0676
X30 BLN0 rr2t2r_0[7|0]/a_460_290# sky130_fd_pr_reram__reram_cell area_ox=0.0676
X31 rr2t2r_0[7|0]/a_60_290# WL7 SL0 VSS sky130_fd_pr__nfet_g5v0d10v5 ad=0.65 pd=3.3 as=0 ps=0 w=1 l=0.5
X32 rr2t2r_0[8|0]/a_460_290# WL8 SL0 VSS sky130_fd_pr__nfet_g5v0d10v5 ad=0.65 pd=3.3 as=0 ps=0 w=1 l=0.5
X33 BLP0 rr2t2r_0[8|0]/a_60_290# sky130_fd_pr_reram__reram_cell area_ox=0.0676
X34 BLN0 rr2t2r_0[8|0]/a_460_290# sky130_fd_pr_reram__reram_cell area_ox=0.0676
X35 rr2t2r_0[8|0]/a_60_290# WL8 SL0 VSS sky130_fd_pr__nfet_g5v0d10v5 ad=0.65 pd=3.3 as=0 ps=0 w=1 l=0.5
X36 rr2t2r_0[9|0]/a_460_290# WL9 SL0 VSS sky130_fd_pr__nfet_g5v0d10v5 ad=0.65 pd=3.3 as=0 ps=0 w=1 l=0.5
X37 BLP0 rr2t2r_0[9|0]/a_60_290# sky130_fd_pr_reram__reram_cell area_ox=0.0676
X38 BLN0 rr2t2r_0[9|0]/a_460_290# sky130_fd_pr_reram__reram_cell area_ox=0.0676
X39 rr2t2r_0[9|0]/a_60_290# WL9 SL0 VSS sky130_fd_pr__nfet_g5v0d10v5 ad=0.65 pd=3.3 as=0 ps=0 w=1 l=0.5
X40 rr2t2r_0[10|0]/a_460_290# WL10 SL0 VSS sky130_fd_pr__nfet_g5v0d10v5 ad=0.65 pd=3.3 as=0 ps=0 w=1 l=0.5
X41 BLP0 rr2t2r_0[10|0]/a_60_290# sky130_fd_pr_reram__reram_cell area_ox=0.0676
X42 BLN0 rr2t2r_0[10|0]/a_460_290# sky130_fd_pr_reram__reram_cell area_ox=0.0676
X43 rr2t2r_0[10|0]/a_60_290# WL10 SL0 VSS sky130_fd_pr__nfet_g5v0d10v5 ad=0.65 pd=3.3 as=0 ps=0 w=1 l=0.5
X44 rr2t2r_0[11|0]/a_460_290# WL11 SL0 VSS sky130_fd_pr__nfet_g5v0d10v5 ad=0.65 pd=3.3 as=0 ps=0 w=1 l=0.5
X45 BLP0 rr2t2r_0[11|0]/a_60_290# sky130_fd_pr_reram__reram_cell area_ox=0.0676
X46 BLN0 rr2t2r_0[11|0]/a_460_290# sky130_fd_pr_reram__reram_cell area_ox=0.0676
X47 rr2t2r_0[11|0]/a_60_290# WL11 SL0 VSS sky130_fd_pr__nfet_g5v0d10v5 ad=0.65 pd=3.3 as=0 ps=0 w=1 l=0.5
X48 rr2t2r_0[12|0]/a_460_290# WL12 SL0 VSS sky130_fd_pr__nfet_g5v0d10v5 ad=0.65 pd=3.3 as=0 ps=0 w=1 l=0.5
X49 BLP0 rr2t2r_0[12|0]/a_60_290# sky130_fd_pr_reram__reram_cell area_ox=0.0676
X50 BLN0 rr2t2r_0[12|0]/a_460_290# sky130_fd_pr_reram__reram_cell area_ox=0.0676
X51 rr2t2r_0[12|0]/a_60_290# WL12 SL0 VSS sky130_fd_pr__nfet_g5v0d10v5 ad=0.65 pd=3.3 as=0 ps=0 w=1 l=0.5
X52 rr2t2r_0[13|0]/a_460_290# WL13 SL0 VSS sky130_fd_pr__nfet_g5v0d10v5 ad=0.65 pd=3.3 as=0 ps=0 w=1 l=0.5
X53 BLP0 rr2t2r_0[13|0]/a_60_290# sky130_fd_pr_reram__reram_cell area_ox=0.0676
X54 BLN0 rr2t2r_0[13|0]/a_460_290# sky130_fd_pr_reram__reram_cell area_ox=0.0676
X55 rr2t2r_0[13|0]/a_60_290# WL13 SL0 VSS sky130_fd_pr__nfet_g5v0d10v5 ad=0.65 pd=3.3 as=0 ps=0 w=1 l=0.5
X56 rr2t2r_0[14|0]/a_460_290# WL14 SL0 VSS sky130_fd_pr__nfet_g5v0d10v5 ad=0.65 pd=3.3 as=0 ps=0 w=1 l=0.5
X57 BLP0 rr2t2r_0[14|0]/a_60_290# sky130_fd_pr_reram__reram_cell area_ox=0.0676
X58 BLN0 rr2t2r_0[14|0]/a_460_290# sky130_fd_pr_reram__reram_cell area_ox=0.0676
X59 rr2t2r_0[14|0]/a_60_290# WL14 SL0 VSS sky130_fd_pr__nfet_g5v0d10v5 ad=0.65 pd=3.3 as=0 ps=0 w=1 l=0.5
X60 rr2t2r_0[15|0]/a_460_290# WL15 SL0 VSS sky130_fd_pr__nfet_g5v0d10v5 ad=0.65 pd=3.3 as=0 ps=0 w=1 l=0.5
X61 BLP0 rr2t2r_0[15|0]/a_60_290# sky130_fd_pr_reram__reram_cell area_ox=0.0676
X62 BLN0 rr2t2r_0[15|0]/a_460_290# sky130_fd_pr_reram__reram_cell area_ox=0.0676
X63 rr2t2r_0[15|0]/a_60_290# WL15 SL0 VSS sky130_fd_pr__nfet_g5v0d10v5 ad=0.65 pd=3.3 as=0 ps=0 w=1 l=0.5
X64 rr2t2r_0[16|0]/a_460_290# WL16 SL0 VSS sky130_fd_pr__nfet_g5v0d10v5 ad=0.65 pd=3.3 as=0 ps=0 w=1 l=0.5
X65 BLP0 rr2t2r_0[16|0]/a_60_290# sky130_fd_pr_reram__reram_cell area_ox=0.0676
X66 BLN0 rr2t2r_0[16|0]/a_460_290# sky130_fd_pr_reram__reram_cell area_ox=0.0676
X67 rr2t2r_0[16|0]/a_60_290# WL16 SL0 VSS sky130_fd_pr__nfet_g5v0d10v5 ad=0.65 pd=3.3 as=0 ps=0 w=1 l=0.5
X68 rr2t2r_0[17|0]/a_460_290# WL17 SL0 VSS sky130_fd_pr__nfet_g5v0d10v5 ad=0.65 pd=3.3 as=0 ps=0 w=1 l=0.5
X69 BLP0 rr2t2r_0[17|0]/a_60_290# sky130_fd_pr_reram__reram_cell area_ox=0.0676
X70 BLN0 rr2t2r_0[17|0]/a_460_290# sky130_fd_pr_reram__reram_cell area_ox=0.0676
X71 rr2t2r_0[17|0]/a_60_290# WL17 SL0 VSS sky130_fd_pr__nfet_g5v0d10v5 ad=0.65 pd=3.3 as=0 ps=0 w=1 l=0.5
X72 rr2t2r_0[18|0]/a_460_290# WL18 SL0 VSS sky130_fd_pr__nfet_g5v0d10v5 ad=0.65 pd=3.3 as=0 ps=0 w=1 l=0.5
X73 BLP0 rr2t2r_0[18|0]/a_60_290# sky130_fd_pr_reram__reram_cell area_ox=0.0676
X74 BLN0 rr2t2r_0[18|0]/a_460_290# sky130_fd_pr_reram__reram_cell area_ox=0.0676
X75 rr2t2r_0[18|0]/a_60_290# WL18 SL0 VSS sky130_fd_pr__nfet_g5v0d10v5 ad=0.65 pd=3.3 as=0 ps=0 w=1 l=0.5
X76 rr2t2r_0[19|0]/a_460_290# WL19 SL0 VSS sky130_fd_pr__nfet_g5v0d10v5 ad=0.65 pd=3.3 as=0 ps=0 w=1 l=0.5
X77 BLP0 rr2t2r_0[19|0]/a_60_290# sky130_fd_pr_reram__reram_cell area_ox=0.0676
X78 BLN0 rr2t2r_0[19|0]/a_460_290# sky130_fd_pr_reram__reram_cell area_ox=0.0676
X79 rr2t2r_0[19|0]/a_60_290# WL19 SL0 VSS sky130_fd_pr__nfet_g5v0d10v5 ad=0.65 pd=3.3 as=0 ps=0 w=1 l=0.5
X80 rr2t2r_0[20|0]/a_460_290# WL20 SL0 VSS sky130_fd_pr__nfet_g5v0d10v5 ad=0.65 pd=3.3 as=0 ps=0 w=1 l=0.5
X81 BLP0 rr2t2r_0[20|0]/a_60_290# sky130_fd_pr_reram__reram_cell area_ox=0.0676
X82 BLN0 rr2t2r_0[20|0]/a_460_290# sky130_fd_pr_reram__reram_cell area_ox=0.0676
X83 rr2t2r_0[20|0]/a_60_290# WL20 SL0 VSS sky130_fd_pr__nfet_g5v0d10v5 ad=0.65 pd=3.3 as=0 ps=0 w=1 l=0.5
X84 rr2t2r_0[21|0]/a_460_290# WL21 SL0 VSS sky130_fd_pr__nfet_g5v0d10v5 ad=0.65 pd=3.3 as=0 ps=0 w=1 l=0.5
X85 BLP0 rr2t2r_0[21|0]/a_60_290# sky130_fd_pr_reram__reram_cell area_ox=0.0676
X86 BLN0 rr2t2r_0[21|0]/a_460_290# sky130_fd_pr_reram__reram_cell area_ox=0.0676
X87 rr2t2r_0[21|0]/a_60_290# WL21 SL0 VSS sky130_fd_pr__nfet_g5v0d10v5 ad=0.65 pd=3.3 as=0 ps=0 w=1 l=0.5
X88 rr2t2r_0[22|0]/a_460_290# WL22 SL0 VSS sky130_fd_pr__nfet_g5v0d10v5 ad=0.65 pd=3.3 as=0 ps=0 w=1 l=0.5
X89 BLP0 rr2t2r_0[22|0]/a_60_290# sky130_fd_pr_reram__reram_cell area_ox=0.0676
X90 BLN0 rr2t2r_0[22|0]/a_460_290# sky130_fd_pr_reram__reram_cell area_ox=0.0676
X91 rr2t2r_0[22|0]/a_60_290# WL22 SL0 VSS sky130_fd_pr__nfet_g5v0d10v5 ad=0.65 pd=3.3 as=0 ps=0 w=1 l=0.5
X92 rr2t2r_0[23|0]/a_460_290# WL23 SL0 VSS sky130_fd_pr__nfet_g5v0d10v5 ad=0.65 pd=3.3 as=0 ps=0 w=1 l=0.5
X93 BLP0 rr2t2r_0[23|0]/a_60_290# sky130_fd_pr_reram__reram_cell area_ox=0.0676
X94 BLN0 rr2t2r_0[23|0]/a_460_290# sky130_fd_pr_reram__reram_cell area_ox=0.0676
X95 rr2t2r_0[23|0]/a_60_290# WL23 SL0 VSS sky130_fd_pr__nfet_g5v0d10v5 ad=0.65 pd=3.3 as=0 ps=0 w=1 l=0.5
X96 rr2t2r_0[24|0]/a_460_290# WL24 SL0 VSS sky130_fd_pr__nfet_g5v0d10v5 ad=0.65 pd=3.3 as=0 ps=0 w=1 l=0.5
X97 BLP0 rr2t2r_0[24|0]/a_60_290# sky130_fd_pr_reram__reram_cell area_ox=0.0676
X98 BLN0 rr2t2r_0[24|0]/a_460_290# sky130_fd_pr_reram__reram_cell area_ox=0.0676
X99 rr2t2r_0[24|0]/a_60_290# WL24 SL0 VSS sky130_fd_pr__nfet_g5v0d10v5 ad=0.65 pd=3.3 as=0 ps=0 w=1 l=0.5
X100 rr2t2r_0[25|0]/a_460_290# WL25 SL0 VSS sky130_fd_pr__nfet_g5v0d10v5 ad=0.65 pd=3.3 as=0 ps=0 w=1 l=0.5
X101 BLP0 rr2t2r_0[25|0]/a_60_290# sky130_fd_pr_reram__reram_cell area_ox=0.0676
X102 BLN0 rr2t2r_0[25|0]/a_460_290# sky130_fd_pr_reram__reram_cell area_ox=0.0676
X103 rr2t2r_0[25|0]/a_60_290# WL25 SL0 VSS sky130_fd_pr__nfet_g5v0d10v5 ad=0.65 pd=3.3 as=0 ps=0 w=1 l=0.5
X104 rr2t2r_0[26|0]/a_460_290# WL26 SL0 VSS sky130_fd_pr__nfet_g5v0d10v5 ad=0.65 pd=3.3 as=0 ps=0 w=1 l=0.5
X105 BLP0 rr2t2r_0[26|0]/a_60_290# sky130_fd_pr_reram__reram_cell area_ox=0.0676
X106 BLN0 rr2t2r_0[26|0]/a_460_290# sky130_fd_pr_reram__reram_cell area_ox=0.0676
X107 rr2t2r_0[26|0]/a_60_290# WL26 SL0 VSS sky130_fd_pr__nfet_g5v0d10v5 ad=0.65 pd=3.3 as=0 ps=0 w=1 l=0.5
X108 rr2t2r_0[27|0]/a_460_290# WL27 SL0 VSS sky130_fd_pr__nfet_g5v0d10v5 ad=0.65 pd=3.3 as=0 ps=0 w=1 l=0.5
X109 BLP0 rr2t2r_0[27|0]/a_60_290# sky130_fd_pr_reram__reram_cell area_ox=0.0676
X110 BLN0 rr2t2r_0[27|0]/a_460_290# sky130_fd_pr_reram__reram_cell area_ox=0.0676
X111 rr2t2r_0[27|0]/a_60_290# WL27 SL0 VSS sky130_fd_pr__nfet_g5v0d10v5 ad=0.65 pd=3.3 as=0 ps=0 w=1 l=0.5
X112 rr2t2r_0[28|0]/a_460_290# WL28 SL0 VSS sky130_fd_pr__nfet_g5v0d10v5 ad=0.65 pd=3.3 as=0 ps=0 w=1 l=0.5
X113 BLP0 rr2t2r_0[28|0]/a_60_290# sky130_fd_pr_reram__reram_cell area_ox=0.0676
X114 BLN0 rr2t2r_0[28|0]/a_460_290# sky130_fd_pr_reram__reram_cell area_ox=0.0676
X115 rr2t2r_0[28|0]/a_60_290# WL28 SL0 VSS sky130_fd_pr__nfet_g5v0d10v5 ad=0.65 pd=3.3 as=0 ps=0 w=1 l=0.5
X116 rr2t2r_0[29|0]/a_460_290# WL29 SL0 VSS sky130_fd_pr__nfet_g5v0d10v5 ad=0.65 pd=3.3 as=0 ps=0 w=1 l=0.5
X117 BLP0 rr2t2r_0[29|0]/a_60_290# sky130_fd_pr_reram__reram_cell area_ox=0.0676
X118 BLN0 rr2t2r_0[29|0]/a_460_290# sky130_fd_pr_reram__reram_cell area_ox=0.0676
X119 rr2t2r_0[29|0]/a_60_290# WL29 SL0 VSS sky130_fd_pr__nfet_g5v0d10v5 ad=0.65 pd=3.3 as=0 ps=0 w=1 l=0.5
X120 rr2t2r_0[30|0]/a_460_290# WL30 SL0 VSS sky130_fd_pr__nfet_g5v0d10v5 ad=0.65 pd=3.3 as=0 ps=0 w=1 l=0.5
X121 BLP0 rr2t2r_0[30|0]/a_60_290# sky130_fd_pr_reram__reram_cell area_ox=0.0676
X122 BLN0 rr2t2r_0[30|0]/a_460_290# sky130_fd_pr_reram__reram_cell area_ox=0.0676
X123 rr2t2r_0[30|0]/a_60_290# WL30 SL0 VSS sky130_fd_pr__nfet_g5v0d10v5 ad=0.65 pd=3.3 as=0 ps=0 w=1 l=0.5
X124 rr2t2r_0[31|0]/a_460_290# WL31 SL0 VSS sky130_fd_pr__nfet_g5v0d10v5 ad=0.65 pd=3.3 as=0 ps=0 w=1 l=0.5
X125 BLP0 rr2t2r_0[31|0]/a_60_290# sky130_fd_pr_reram__reram_cell area_ox=0.0676
X126 BLN0 rr2t2r_0[31|0]/a_460_290# sky130_fd_pr_reram__reram_cell area_ox=0.0676
X127 rr2t2r_0[31|0]/a_60_290# WL31 SL0 VSS sky130_fd_pr__nfet_g5v0d10v5 ad=0.65 pd=3.3 as=0 ps=0 w=1 l=0.5
X128 rr2t2r_0[32|0]/a_460_290# WL32 SL0 VSS sky130_fd_pr__nfet_g5v0d10v5 ad=0.65 pd=3.3 as=0 ps=0 w=1 l=0.5
X129 BLP0 rr2t2r_0[32|0]/a_60_290# sky130_fd_pr_reram__reram_cell area_ox=0.0676
X130 BLN0 rr2t2r_0[32|0]/a_460_290# sky130_fd_pr_reram__reram_cell area_ox=0.0676
X131 rr2t2r_0[32|0]/a_60_290# WL32 SL0 VSS sky130_fd_pr__nfet_g5v0d10v5 ad=0.65 pd=3.3 as=0 ps=0 w=1 l=0.5
X132 rr2t2r_0[33|0]/a_460_290# WL33 SL0 VSS sky130_fd_pr__nfet_g5v0d10v5 ad=0.65 pd=3.3 as=0 ps=0 w=1 l=0.5
X133 BLP0 rr2t2r_0[33|0]/a_60_290# sky130_fd_pr_reram__reram_cell area_ox=0.0676
X134 BLN0 rr2t2r_0[33|0]/a_460_290# sky130_fd_pr_reram__reram_cell area_ox=0.0676
X135 rr2t2r_0[33|0]/a_60_290# WL33 SL0 VSS sky130_fd_pr__nfet_g5v0d10v5 ad=0.65 pd=3.3 as=0 ps=0 w=1 l=0.5
X136 rr2t2r_0[34|0]/a_460_290# WL34 SL0 VSS sky130_fd_pr__nfet_g5v0d10v5 ad=0.65 pd=3.3 as=0 ps=0 w=1 l=0.5
X137 BLP0 rr2t2r_0[34|0]/a_60_290# sky130_fd_pr_reram__reram_cell area_ox=0.0676
X138 BLN0 rr2t2r_0[34|0]/a_460_290# sky130_fd_pr_reram__reram_cell area_ox=0.0676
X139 rr2t2r_0[34|0]/a_60_290# WL34 SL0 VSS sky130_fd_pr__nfet_g5v0d10v5 ad=0.65 pd=3.3 as=0 ps=0 w=1 l=0.5
X140 rr2t2r_0[35|0]/a_460_290# WL35 SL0 VSS sky130_fd_pr__nfet_g5v0d10v5 ad=0.65 pd=3.3 as=0 ps=0 w=1 l=0.5
X141 BLP0 rr2t2r_0[35|0]/a_60_290# sky130_fd_pr_reram__reram_cell area_ox=0.0676
X142 BLN0 rr2t2r_0[35|0]/a_460_290# sky130_fd_pr_reram__reram_cell area_ox=0.0676
X143 rr2t2r_0[35|0]/a_60_290# WL35 SL0 VSS sky130_fd_pr__nfet_g5v0d10v5 ad=0.65 pd=3.3 as=0 ps=0 w=1 l=0.5
X144 rr2t2r_0[36|0]/a_460_290# WL36 SL0 VSS sky130_fd_pr__nfet_g5v0d10v5 ad=0.65 pd=3.3 as=0 ps=0 w=1 l=0.5
X145 BLP0 rr2t2r_0[36|0]/a_60_290# sky130_fd_pr_reram__reram_cell area_ox=0.0676
X146 BLN0 rr2t2r_0[36|0]/a_460_290# sky130_fd_pr_reram__reram_cell area_ox=0.0676
X147 rr2t2r_0[36|0]/a_60_290# WL36 SL0 VSS sky130_fd_pr__nfet_g5v0d10v5 ad=0.65 pd=3.3 as=0 ps=0 w=1 l=0.5
X148 rr2t2r_0[37|0]/a_460_290# WL37 SL0 VSS sky130_fd_pr__nfet_g5v0d10v5 ad=0.65 pd=3.3 as=0 ps=0 w=1 l=0.5
X149 BLP0 rr2t2r_0[37|0]/a_60_290# sky130_fd_pr_reram__reram_cell area_ox=0.0676
X150 BLN0 rr2t2r_0[37|0]/a_460_290# sky130_fd_pr_reram__reram_cell area_ox=0.0676
X151 rr2t2r_0[37|0]/a_60_290# WL37 SL0 VSS sky130_fd_pr__nfet_g5v0d10v5 ad=0.65 pd=3.3 as=0 ps=0 w=1 l=0.5
X152 rr2t2r_0[38|0]/a_460_290# WL38 SL0 VSS sky130_fd_pr__nfet_g5v0d10v5 ad=0.65 pd=3.3 as=0 ps=0 w=1 l=0.5
X153 BLP0 rr2t2r_0[38|0]/a_60_290# sky130_fd_pr_reram__reram_cell area_ox=0.0676
X154 BLN0 rr2t2r_0[38|0]/a_460_290# sky130_fd_pr_reram__reram_cell area_ox=0.0676
X155 rr2t2r_0[38|0]/a_60_290# WL38 SL0 VSS sky130_fd_pr__nfet_g5v0d10v5 ad=0.65 pd=3.3 as=0 ps=0 w=1 l=0.5
X156 rr2t2r_0[39|0]/a_460_290# WL39 SL0 VSS sky130_fd_pr__nfet_g5v0d10v5 ad=0.65 pd=3.3 as=0 ps=0 w=1 l=0.5
X157 BLP0 rr2t2r_0[39|0]/a_60_290# sky130_fd_pr_reram__reram_cell area_ox=0.0676
X158 BLN0 rr2t2r_0[39|0]/a_460_290# sky130_fd_pr_reram__reram_cell area_ox=0.0676
X159 rr2t2r_0[39|0]/a_60_290# WL39 SL0 VSS sky130_fd_pr__nfet_g5v0d10v5 ad=0.65 pd=3.3 as=0 ps=0 w=1 l=0.5
X160 rr2t2r_0[40|0]/a_460_290# WL40 SL0 VSS sky130_fd_pr__nfet_g5v0d10v5 ad=0.65 pd=3.3 as=0 ps=0 w=1 l=0.5
X161 BLP0 rr2t2r_0[40|0]/a_60_290# sky130_fd_pr_reram__reram_cell area_ox=0.0676
X162 BLN0 rr2t2r_0[40|0]/a_460_290# sky130_fd_pr_reram__reram_cell area_ox=0.0676
X163 rr2t2r_0[40|0]/a_60_290# WL40 SL0 VSS sky130_fd_pr__nfet_g5v0d10v5 ad=0.65 pd=3.3 as=0 ps=0 w=1 l=0.5
X164 rr2t2r_0[41|0]/a_460_290# WL41 SL0 VSS sky130_fd_pr__nfet_g5v0d10v5 ad=0.65 pd=3.3 as=0 ps=0 w=1 l=0.5
X165 BLP0 rr2t2r_0[41|0]/a_60_290# sky130_fd_pr_reram__reram_cell area_ox=0.0676
X166 BLN0 rr2t2r_0[41|0]/a_460_290# sky130_fd_pr_reram__reram_cell area_ox=0.0676
X167 rr2t2r_0[41|0]/a_60_290# WL41 SL0 VSS sky130_fd_pr__nfet_g5v0d10v5 ad=0.65 pd=3.3 as=0 ps=0 w=1 l=0.5
X168 rr2t2r_0[42|0]/a_460_290# WL42 SL0 VSS sky130_fd_pr__nfet_g5v0d10v5 ad=0.65 pd=3.3 as=0 ps=0 w=1 l=0.5
X169 BLP0 rr2t2r_0[42|0]/a_60_290# sky130_fd_pr_reram__reram_cell area_ox=0.0676
X170 BLN0 rr2t2r_0[42|0]/a_460_290# sky130_fd_pr_reram__reram_cell area_ox=0.0676
X171 rr2t2r_0[42|0]/a_60_290# WL42 SL0 VSS sky130_fd_pr__nfet_g5v0d10v5 ad=0.65 pd=3.3 as=0 ps=0 w=1 l=0.5
X172 rr2t2r_0[43|0]/a_460_290# WL43 SL0 VSS sky130_fd_pr__nfet_g5v0d10v5 ad=0.65 pd=3.3 as=0 ps=0 w=1 l=0.5
X173 BLP0 rr2t2r_0[43|0]/a_60_290# sky130_fd_pr_reram__reram_cell area_ox=0.0676
X174 BLN0 rr2t2r_0[43|0]/a_460_290# sky130_fd_pr_reram__reram_cell area_ox=0.0676
X175 rr2t2r_0[43|0]/a_60_290# WL43 SL0 VSS sky130_fd_pr__nfet_g5v0d10v5 ad=0.65 pd=3.3 as=0 ps=0 w=1 l=0.5
X176 rr2t2r_0[44|0]/a_460_290# WL44 SL0 VSS sky130_fd_pr__nfet_g5v0d10v5 ad=0.65 pd=3.3 as=0 ps=0 w=1 l=0.5
X177 BLP0 rr2t2r_0[44|0]/a_60_290# sky130_fd_pr_reram__reram_cell area_ox=0.0676
X178 BLN0 rr2t2r_0[44|0]/a_460_290# sky130_fd_pr_reram__reram_cell area_ox=0.0676
X179 rr2t2r_0[44|0]/a_60_290# WL44 SL0 VSS sky130_fd_pr__nfet_g5v0d10v5 ad=0.65 pd=3.3 as=0 ps=0 w=1 l=0.5
X180 rr2t2r_0[45|0]/a_460_290# WL45 SL0 VSS sky130_fd_pr__nfet_g5v0d10v5 ad=0.65 pd=3.3 as=0 ps=0 w=1 l=0.5
X181 BLP0 rr2t2r_0[45|0]/a_60_290# sky130_fd_pr_reram__reram_cell area_ox=0.0676
X182 BLN0 rr2t2r_0[45|0]/a_460_290# sky130_fd_pr_reram__reram_cell area_ox=0.0676
X183 rr2t2r_0[45|0]/a_60_290# WL45 SL0 VSS sky130_fd_pr__nfet_g5v0d10v5 ad=0.65 pd=3.3 as=0 ps=0 w=1 l=0.5
X184 rr2t2r_0[46|0]/a_460_290# WL46 SL0 VSS sky130_fd_pr__nfet_g5v0d10v5 ad=0.65 pd=3.3 as=0 ps=0 w=1 l=0.5
X185 BLP0 rr2t2r_0[46|0]/a_60_290# sky130_fd_pr_reram__reram_cell area_ox=0.0676
X186 BLN0 rr2t2r_0[46|0]/a_460_290# sky130_fd_pr_reram__reram_cell area_ox=0.0676
X187 rr2t2r_0[46|0]/a_60_290# WL46 SL0 VSS sky130_fd_pr__nfet_g5v0d10v5 ad=0.65 pd=3.3 as=0 ps=0 w=1 l=0.5
X188 rr2t2r_0[47|0]/a_460_290# WL47 SL0 VSS sky130_fd_pr__nfet_g5v0d10v5 ad=0.65 pd=3.3 as=0 ps=0 w=1 l=0.5
X189 BLP0 rr2t2r_0[47|0]/a_60_290# sky130_fd_pr_reram__reram_cell area_ox=0.0676
X190 BLN0 rr2t2r_0[47|0]/a_460_290# sky130_fd_pr_reram__reram_cell area_ox=0.0676
X191 rr2t2r_0[47|0]/a_60_290# WL47 SL0 VSS sky130_fd_pr__nfet_g5v0d10v5 ad=0.65 pd=3.3 as=0 ps=0 w=1 l=0.5
X192 rr2t2r_0[48|0]/a_460_290# WL48 SL0 VSS sky130_fd_pr__nfet_g5v0d10v5 ad=0.65 pd=3.3 as=0 ps=0 w=1 l=0.5
X193 BLP0 rr2t2r_0[48|0]/a_60_290# sky130_fd_pr_reram__reram_cell area_ox=0.0676
X194 BLN0 rr2t2r_0[48|0]/a_460_290# sky130_fd_pr_reram__reram_cell area_ox=0.0676
X195 rr2t2r_0[48|0]/a_60_290# WL48 SL0 VSS sky130_fd_pr__nfet_g5v0d10v5 ad=0.65 pd=3.3 as=0 ps=0 w=1 l=0.5
X196 rr2t2r_0[49|0]/a_460_290# WL49 SL0 VSS sky130_fd_pr__nfet_g5v0d10v5 ad=0.65 pd=3.3 as=0 ps=0 w=1 l=0.5
X197 BLP0 rr2t2r_0[49|0]/a_60_290# sky130_fd_pr_reram__reram_cell area_ox=0.0676
X198 BLN0 rr2t2r_0[49|0]/a_460_290# sky130_fd_pr_reram__reram_cell area_ox=0.0676
X199 rr2t2r_0[49|0]/a_60_290# WL49 SL0 VSS sky130_fd_pr__nfet_g5v0d10v5 ad=0.65 pd=3.3 as=0 ps=0 w=1 l=0.5
X200 rr2t2r_0[50|0]/a_460_290# WL50 SL0 VSS sky130_fd_pr__nfet_g5v0d10v5 ad=0.65 pd=3.3 as=0 ps=0 w=1 l=0.5
X201 BLP0 rr2t2r_0[50|0]/a_60_290# sky130_fd_pr_reram__reram_cell area_ox=0.0676
X202 BLN0 rr2t2r_0[50|0]/a_460_290# sky130_fd_pr_reram__reram_cell area_ox=0.0676
X203 rr2t2r_0[50|0]/a_60_290# WL50 SL0 VSS sky130_fd_pr__nfet_g5v0d10v5 ad=0.65 pd=3.3 as=0 ps=0 w=1 l=0.5
X204 rr2t2r_0[51|0]/a_460_290# WL51 SL0 VSS sky130_fd_pr__nfet_g5v0d10v5 ad=0.65 pd=3.3 as=0 ps=0 w=1 l=0.5
X205 BLP0 rr2t2r_0[51|0]/a_60_290# sky130_fd_pr_reram__reram_cell area_ox=0.0676
X206 BLN0 rr2t2r_0[51|0]/a_460_290# sky130_fd_pr_reram__reram_cell area_ox=0.0676
X207 rr2t2r_0[51|0]/a_60_290# WL51 SL0 VSS sky130_fd_pr__nfet_g5v0d10v5 ad=0.65 pd=3.3 as=0 ps=0 w=1 l=0.5
X208 rr2t2r_0[52|0]/a_460_290# WL52 SL0 VSS sky130_fd_pr__nfet_g5v0d10v5 ad=0.65 pd=3.3 as=0 ps=0 w=1 l=0.5
X209 BLP0 rr2t2r_0[52|0]/a_60_290# sky130_fd_pr_reram__reram_cell area_ox=0.0676
X210 BLN0 rr2t2r_0[52|0]/a_460_290# sky130_fd_pr_reram__reram_cell area_ox=0.0676
X211 rr2t2r_0[52|0]/a_60_290# WL52 SL0 VSS sky130_fd_pr__nfet_g5v0d10v5 ad=0.65 pd=3.3 as=0 ps=0 w=1 l=0.5
X212 rr2t2r_0[53|0]/a_460_290# WL53 SL0 VSS sky130_fd_pr__nfet_g5v0d10v5 ad=0.65 pd=3.3 as=0 ps=0 w=1 l=0.5
X213 BLP0 rr2t2r_0[53|0]/a_60_290# sky130_fd_pr_reram__reram_cell area_ox=0.0676
X214 BLN0 rr2t2r_0[53|0]/a_460_290# sky130_fd_pr_reram__reram_cell area_ox=0.0676
X215 rr2t2r_0[53|0]/a_60_290# WL53 SL0 VSS sky130_fd_pr__nfet_g5v0d10v5 ad=0.65 pd=3.3 as=0 ps=0 w=1 l=0.5
X216 rr2t2r_0[54|0]/a_460_290# WL54 SL0 VSS sky130_fd_pr__nfet_g5v0d10v5 ad=0.65 pd=3.3 as=0 ps=0 w=1 l=0.5
X217 BLP0 rr2t2r_0[54|0]/a_60_290# sky130_fd_pr_reram__reram_cell area_ox=0.0676
X218 BLN0 rr2t2r_0[54|0]/a_460_290# sky130_fd_pr_reram__reram_cell area_ox=0.0676
X219 rr2t2r_0[54|0]/a_60_290# WL54 SL0 VSS sky130_fd_pr__nfet_g5v0d10v5 ad=0.65 pd=3.3 as=0 ps=0 w=1 l=0.5
X220 rr2t2r_0[55|0]/a_460_290# WL55 SL0 VSS sky130_fd_pr__nfet_g5v0d10v5 ad=0.65 pd=3.3 as=0 ps=0 w=1 l=0.5
X221 BLP0 rr2t2r_0[55|0]/a_60_290# sky130_fd_pr_reram__reram_cell area_ox=0.0676
X222 BLN0 rr2t2r_0[55|0]/a_460_290# sky130_fd_pr_reram__reram_cell area_ox=0.0676
X223 rr2t2r_0[55|0]/a_60_290# WL55 SL0 VSS sky130_fd_pr__nfet_g5v0d10v5 ad=0.65 pd=3.3 as=0 ps=0 w=1 l=0.5
X224 rr2t2r_0[56|0]/a_460_290# WL56 SL0 VSS sky130_fd_pr__nfet_g5v0d10v5 ad=0.65 pd=3.3 as=0 ps=0 w=1 l=0.5
X225 BLP0 rr2t2r_0[56|0]/a_60_290# sky130_fd_pr_reram__reram_cell area_ox=0.0676
X226 BLN0 rr2t2r_0[56|0]/a_460_290# sky130_fd_pr_reram__reram_cell area_ox=0.0676
X227 rr2t2r_0[56|0]/a_60_290# WL56 SL0 VSS sky130_fd_pr__nfet_g5v0d10v5 ad=0.65 pd=3.3 as=0 ps=0 w=1 l=0.5
X228 rr2t2r_0[57|0]/a_460_290# WL57 SL0 VSS sky130_fd_pr__nfet_g5v0d10v5 ad=0.65 pd=3.3 as=0 ps=0 w=1 l=0.5
X229 BLP0 rr2t2r_0[57|0]/a_60_290# sky130_fd_pr_reram__reram_cell area_ox=0.0676
X230 BLN0 rr2t2r_0[57|0]/a_460_290# sky130_fd_pr_reram__reram_cell area_ox=0.0676
X231 rr2t2r_0[57|0]/a_60_290# WL57 SL0 VSS sky130_fd_pr__nfet_g5v0d10v5 ad=0.65 pd=3.3 as=0 ps=0 w=1 l=0.5
X232 rr2t2r_0[58|0]/a_460_290# WL58 SL0 VSS sky130_fd_pr__nfet_g5v0d10v5 ad=0.65 pd=3.3 as=0 ps=0 w=1 l=0.5
X233 BLP0 rr2t2r_0[58|0]/a_60_290# sky130_fd_pr_reram__reram_cell area_ox=0.0676
X234 BLN0 rr2t2r_0[58|0]/a_460_290# sky130_fd_pr_reram__reram_cell area_ox=0.0676
X235 rr2t2r_0[58|0]/a_60_290# WL58 SL0 VSS sky130_fd_pr__nfet_g5v0d10v5 ad=0.65 pd=3.3 as=0 ps=0 w=1 l=0.5
X236 rr2t2r_0[59|0]/a_460_290# WL59 SL0 VSS sky130_fd_pr__nfet_g5v0d10v5 ad=0.65 pd=3.3 as=0 ps=0 w=1 l=0.5
X237 BLP0 rr2t2r_0[59|0]/a_60_290# sky130_fd_pr_reram__reram_cell area_ox=0.0676
X238 BLN0 rr2t2r_0[59|0]/a_460_290# sky130_fd_pr_reram__reram_cell area_ox=0.0676
X239 rr2t2r_0[59|0]/a_60_290# WL59 SL0 VSS sky130_fd_pr__nfet_g5v0d10v5 ad=0.65 pd=3.3 as=0 ps=0 w=1 l=0.5
X240 rr2t2r_0[60|0]/a_460_290# WL60 SL0 VSS sky130_fd_pr__nfet_g5v0d10v5 ad=0.65 pd=3.3 as=0 ps=0 w=1 l=0.5
X241 BLP0 rr2t2r_0[60|0]/a_60_290# sky130_fd_pr_reram__reram_cell area_ox=0.0676
X242 BLN0 rr2t2r_0[60|0]/a_460_290# sky130_fd_pr_reram__reram_cell area_ox=0.0676
X243 rr2t2r_0[60|0]/a_60_290# WL60 SL0 VSS sky130_fd_pr__nfet_g5v0d10v5 ad=0.65 pd=3.3 as=0 ps=0 w=1 l=0.5
X244 rr2t2r_0[61|0]/a_460_290# WL61 SL0 VSS sky130_fd_pr__nfet_g5v0d10v5 ad=0.65 pd=3.3 as=0 ps=0 w=1 l=0.5
X245 BLP0 rr2t2r_0[61|0]/a_60_290# sky130_fd_pr_reram__reram_cell area_ox=0.0676
X246 BLN0 rr2t2r_0[61|0]/a_460_290# sky130_fd_pr_reram__reram_cell area_ox=0.0676
X247 rr2t2r_0[61|0]/a_60_290# WL61 SL0 VSS sky130_fd_pr__nfet_g5v0d10v5 ad=0.65 pd=3.3 as=0 ps=0 w=1 l=0.5
X248 rr2t2r_0[62|0]/a_460_290# WL62 SL0 VSS sky130_fd_pr__nfet_g5v0d10v5 ad=0.65 pd=3.3 as=0 ps=0 w=1 l=0.5
X249 BLP0 rr2t2r_0[62|0]/a_60_290# sky130_fd_pr_reram__reram_cell area_ox=0.0676
X250 BLN0 rr2t2r_0[62|0]/a_460_290# sky130_fd_pr_reram__reram_cell area_ox=0.0676
X251 rr2t2r_0[62|0]/a_60_290# WL62 SL0 VSS sky130_fd_pr__nfet_g5v0d10v5 ad=0.65 pd=3.3 as=0 ps=0 w=1 l=0.5
X252 rr2t2r_0[63|0]/a_460_290# WL63 SL0 VSS sky130_fd_pr__nfet_g5v0d10v5 ad=0.65 pd=3.3 as=0 ps=0 w=1 l=0.5
X253 BLP0 rr2t2r_0[63|0]/a_60_290# sky130_fd_pr_reram__reram_cell area_ox=0.0676
X254 BLN0 rr2t2r_0[63|0]/a_460_290# sky130_fd_pr_reram__reram_cell area_ox=0.0676
X255 rr2t2r_0[63|0]/a_60_290# WL63 SL0 VSS sky130_fd_pr__nfet_g5v0d10v5 ad=0.65 pd=3.3 as=0 ps=0 w=1 l=0.5
X256 rr2t2r_0[64|0]/a_460_290# WL64 SL0 VSS sky130_fd_pr__nfet_g5v0d10v5 ad=0.65 pd=3.3 as=0 ps=0 w=1 l=0.5
X257 BLP0 rr2t2r_0[64|0]/a_60_290# sky130_fd_pr_reram__reram_cell area_ox=0.0676
X258 BLN0 rr2t2r_0[64|0]/a_460_290# sky130_fd_pr_reram__reram_cell area_ox=0.0676
X259 rr2t2r_0[64|0]/a_60_290# WL64 SL0 VSS sky130_fd_pr__nfet_g5v0d10v5 ad=0.65 pd=3.3 as=0 ps=0 w=1 l=0.5
X260 rr2t2r_0[65|0]/a_460_290# WL65 SL0 VSS sky130_fd_pr__nfet_g5v0d10v5 ad=0.65 pd=3.3 as=0 ps=0 w=1 l=0.5
X261 BLP0 rr2t2r_0[65|0]/a_60_290# sky130_fd_pr_reram__reram_cell area_ox=0.0676
X262 BLN0 rr2t2r_0[65|0]/a_460_290# sky130_fd_pr_reram__reram_cell area_ox=0.0676
X263 rr2t2r_0[65|0]/a_60_290# WL65 SL0 VSS sky130_fd_pr__nfet_g5v0d10v5 ad=0.65 pd=3.3 as=0 ps=0 w=1 l=0.5
X264 rr2t2r_0[66|0]/a_460_290# WL66 SL0 VSS sky130_fd_pr__nfet_g5v0d10v5 ad=0.65 pd=3.3 as=0 ps=0 w=1 l=0.5
X265 BLP0 rr2t2r_0[66|0]/a_60_290# sky130_fd_pr_reram__reram_cell area_ox=0.0676
X266 BLN0 rr2t2r_0[66|0]/a_460_290# sky130_fd_pr_reram__reram_cell area_ox=0.0676
X267 rr2t2r_0[66|0]/a_60_290# WL66 SL0 VSS sky130_fd_pr__nfet_g5v0d10v5 ad=0.65 pd=3.3 as=0 ps=0 w=1 l=0.5
X268 rr2t2r_0[67|0]/a_460_290# WL67 SL0 VSS sky130_fd_pr__nfet_g5v0d10v5 ad=0.65 pd=3.3 as=0 ps=0 w=1 l=0.5
X269 BLP0 rr2t2r_0[67|0]/a_60_290# sky130_fd_pr_reram__reram_cell area_ox=0.0676
X270 BLN0 rr2t2r_0[67|0]/a_460_290# sky130_fd_pr_reram__reram_cell area_ox=0.0676
X271 rr2t2r_0[67|0]/a_60_290# WL67 SL0 VSS sky130_fd_pr__nfet_g5v0d10v5 ad=0.65 pd=3.3 as=0 ps=0 w=1 l=0.5
X272 rr2t2r_0[68|0]/a_460_290# WL68 SL0 VSS sky130_fd_pr__nfet_g5v0d10v5 ad=0.65 pd=3.3 as=0 ps=0 w=1 l=0.5
X273 BLP0 rr2t2r_0[68|0]/a_60_290# sky130_fd_pr_reram__reram_cell area_ox=0.0676
X274 BLN0 rr2t2r_0[68|0]/a_460_290# sky130_fd_pr_reram__reram_cell area_ox=0.0676
X275 rr2t2r_0[68|0]/a_60_290# WL68 SL0 VSS sky130_fd_pr__nfet_g5v0d10v5 ad=0.65 pd=3.3 as=0 ps=0 w=1 l=0.5
X276 rr2t2r_0[69|0]/a_460_290# WL69 SL0 VSS sky130_fd_pr__nfet_g5v0d10v5 ad=0.65 pd=3.3 as=0 ps=0 w=1 l=0.5
X277 BLP0 rr2t2r_0[69|0]/a_60_290# sky130_fd_pr_reram__reram_cell area_ox=0.0676
X278 BLN0 rr2t2r_0[69|0]/a_460_290# sky130_fd_pr_reram__reram_cell area_ox=0.0676
X279 rr2t2r_0[69|0]/a_60_290# WL69 SL0 VSS sky130_fd_pr__nfet_g5v0d10v5 ad=0.65 pd=3.3 as=0 ps=0 w=1 l=0.5
X280 rr2t2r_0[70|0]/a_460_290# WL70 SL0 VSS sky130_fd_pr__nfet_g5v0d10v5 ad=0.65 pd=3.3 as=0 ps=0 w=1 l=0.5
X281 BLP0 rr2t2r_0[70|0]/a_60_290# sky130_fd_pr_reram__reram_cell area_ox=0.0676
X282 BLN0 rr2t2r_0[70|0]/a_460_290# sky130_fd_pr_reram__reram_cell area_ox=0.0676
X283 rr2t2r_0[70|0]/a_60_290# WL70 SL0 VSS sky130_fd_pr__nfet_g5v0d10v5 ad=0.65 pd=3.3 as=0 ps=0 w=1 l=0.5
X284 rr2t2r_0[71|0]/a_460_290# WL71 SL0 VSS sky130_fd_pr__nfet_g5v0d10v5 ad=0.65 pd=3.3 as=0 ps=0 w=1 l=0.5
X285 BLP0 rr2t2r_0[71|0]/a_60_290# sky130_fd_pr_reram__reram_cell area_ox=0.0676
X286 BLN0 rr2t2r_0[71|0]/a_460_290# sky130_fd_pr_reram__reram_cell area_ox=0.0676
X287 rr2t2r_0[71|0]/a_60_290# WL71 SL0 VSS sky130_fd_pr__nfet_g5v0d10v5 ad=0.65 pd=3.3 as=0 ps=0 w=1 l=0.5
X288 rr2t2r_0[0|1]/a_460_290# WL0 SL1 VSS sky130_fd_pr__nfet_g5v0d10v5 ad=0.65 pd=3.3 as=108 ps=504 w=1 l=0.5
X289 BLP1 rr2t2r_0[0|1]/a_60_290# sky130_fd_pr_reram__reram_cell area_ox=0.0676
X290 BLN1 rr2t2r_0[0|1]/a_460_290# sky130_fd_pr_reram__reram_cell area_ox=0.0676
X291 rr2t2r_0[0|1]/a_60_290# WL0 SL1 VSS sky130_fd_pr__nfet_g5v0d10v5 ad=0.65 pd=3.3 as=0 ps=0 w=1 l=0.5
X292 rr2t2r_0[1|1]/a_460_290# WL1 SL1 VSS sky130_fd_pr__nfet_g5v0d10v5 ad=0.65 pd=3.3 as=0 ps=0 w=1 l=0.5
X293 BLP1 rr2t2r_0[1|1]/a_60_290# sky130_fd_pr_reram__reram_cell area_ox=0.0676
X294 BLN1 rr2t2r_0[1|1]/a_460_290# sky130_fd_pr_reram__reram_cell area_ox=0.0676
X295 rr2t2r_0[1|1]/a_60_290# WL1 SL1 VSS sky130_fd_pr__nfet_g5v0d10v5 ad=0.65 pd=3.3 as=0 ps=0 w=1 l=0.5
X296 rr2t2r_0[2|1]/a_460_290# WL2 SL1 VSS sky130_fd_pr__nfet_g5v0d10v5 ad=0.65 pd=3.3 as=0 ps=0 w=1 l=0.5
X297 BLP1 rr2t2r_0[2|1]/a_60_290# sky130_fd_pr_reram__reram_cell area_ox=0.0676
X298 BLN1 rr2t2r_0[2|1]/a_460_290# sky130_fd_pr_reram__reram_cell area_ox=0.0676
X299 rr2t2r_0[2|1]/a_60_290# WL2 SL1 VSS sky130_fd_pr__nfet_g5v0d10v5 ad=0.65 pd=3.3 as=0 ps=0 w=1 l=0.5
X300 rr2t2r_0[3|1]/a_460_290# WL3 SL1 VSS sky130_fd_pr__nfet_g5v0d10v5 ad=0.65 pd=3.3 as=0 ps=0 w=1 l=0.5
X301 BLP1 rr2t2r_0[3|1]/a_60_290# sky130_fd_pr_reram__reram_cell area_ox=0.0676
X302 BLN1 rr2t2r_0[3|1]/a_460_290# sky130_fd_pr_reram__reram_cell area_ox=0.0676
X303 rr2t2r_0[3|1]/a_60_290# WL3 SL1 VSS sky130_fd_pr__nfet_g5v0d10v5 ad=0.65 pd=3.3 as=0 ps=0 w=1 l=0.5
X304 rr2t2r_0[4|1]/a_460_290# WL4 SL1 VSS sky130_fd_pr__nfet_g5v0d10v5 ad=0.65 pd=3.3 as=0 ps=0 w=1 l=0.5
X305 BLP1 rr2t2r_0[4|1]/a_60_290# sky130_fd_pr_reram__reram_cell area_ox=0.0676
X306 BLN1 rr2t2r_0[4|1]/a_460_290# sky130_fd_pr_reram__reram_cell area_ox=0.0676
X307 rr2t2r_0[4|1]/a_60_290# WL4 SL1 VSS sky130_fd_pr__nfet_g5v0d10v5 ad=0.65 pd=3.3 as=0 ps=0 w=1 l=0.5
X308 rr2t2r_0[5|1]/a_460_290# WL5 SL1 VSS sky130_fd_pr__nfet_g5v0d10v5 ad=0.65 pd=3.3 as=0 ps=0 w=1 l=0.5
X309 BLP1 rr2t2r_0[5|1]/a_60_290# sky130_fd_pr_reram__reram_cell area_ox=0.0676
X310 BLN1 rr2t2r_0[5|1]/a_460_290# sky130_fd_pr_reram__reram_cell area_ox=0.0676
X311 rr2t2r_0[5|1]/a_60_290# WL5 SL1 VSS sky130_fd_pr__nfet_g5v0d10v5 ad=0.65 pd=3.3 as=0 ps=0 w=1 l=0.5
X312 rr2t2r_0[6|1]/a_460_290# WL6 SL1 VSS sky130_fd_pr__nfet_g5v0d10v5 ad=0.65 pd=3.3 as=0 ps=0 w=1 l=0.5
X313 BLP1 rr2t2r_0[6|1]/a_60_290# sky130_fd_pr_reram__reram_cell area_ox=0.0676
X314 BLN1 rr2t2r_0[6|1]/a_460_290# sky130_fd_pr_reram__reram_cell area_ox=0.0676
X315 rr2t2r_0[6|1]/a_60_290# WL6 SL1 VSS sky130_fd_pr__nfet_g5v0d10v5 ad=0.65 pd=3.3 as=0 ps=0 w=1 l=0.5
X316 rr2t2r_0[7|1]/a_460_290# WL7 SL1 VSS sky130_fd_pr__nfet_g5v0d10v5 ad=0.65 pd=3.3 as=0 ps=0 w=1 l=0.5
X317 BLP1 rr2t2r_0[7|1]/a_60_290# sky130_fd_pr_reram__reram_cell area_ox=0.0676
X318 BLN1 rr2t2r_0[7|1]/a_460_290# sky130_fd_pr_reram__reram_cell area_ox=0.0676
X319 rr2t2r_0[7|1]/a_60_290# WL7 SL1 VSS sky130_fd_pr__nfet_g5v0d10v5 ad=0.65 pd=3.3 as=0 ps=0 w=1 l=0.5
X320 rr2t2r_0[8|1]/a_460_290# WL8 SL1 VSS sky130_fd_pr__nfet_g5v0d10v5 ad=0.65 pd=3.3 as=0 ps=0 w=1 l=0.5
X321 BLP1 rr2t2r_0[8|1]/a_60_290# sky130_fd_pr_reram__reram_cell area_ox=0.0676
X322 BLN1 rr2t2r_0[8|1]/a_460_290# sky130_fd_pr_reram__reram_cell area_ox=0.0676
X323 rr2t2r_0[8|1]/a_60_290# WL8 SL1 VSS sky130_fd_pr__nfet_g5v0d10v5 ad=0.65 pd=3.3 as=0 ps=0 w=1 l=0.5
X324 rr2t2r_0[9|1]/a_460_290# WL9 SL1 VSS sky130_fd_pr__nfet_g5v0d10v5 ad=0.65 pd=3.3 as=0 ps=0 w=1 l=0.5
X325 BLP1 rr2t2r_0[9|1]/a_60_290# sky130_fd_pr_reram__reram_cell area_ox=0.0676
X326 BLN1 rr2t2r_0[9|1]/a_460_290# sky130_fd_pr_reram__reram_cell area_ox=0.0676
X327 rr2t2r_0[9|1]/a_60_290# WL9 SL1 VSS sky130_fd_pr__nfet_g5v0d10v5 ad=0.65 pd=3.3 as=0 ps=0 w=1 l=0.5
X328 rr2t2r_0[10|1]/a_460_290# WL10 SL1 VSS sky130_fd_pr__nfet_g5v0d10v5 ad=0.65 pd=3.3 as=0 ps=0 w=1 l=0.5
X329 BLP1 rr2t2r_0[10|1]/a_60_290# sky130_fd_pr_reram__reram_cell area_ox=0.0676
X330 BLN1 rr2t2r_0[10|1]/a_460_290# sky130_fd_pr_reram__reram_cell area_ox=0.0676
X331 rr2t2r_0[10|1]/a_60_290# WL10 SL1 VSS sky130_fd_pr__nfet_g5v0d10v5 ad=0.65 pd=3.3 as=0 ps=0 w=1 l=0.5
X332 rr2t2r_0[11|1]/a_460_290# WL11 SL1 VSS sky130_fd_pr__nfet_g5v0d10v5 ad=0.65 pd=3.3 as=0 ps=0 w=1 l=0.5
X333 BLP1 rr2t2r_0[11|1]/a_60_290# sky130_fd_pr_reram__reram_cell area_ox=0.0676
X334 BLN1 rr2t2r_0[11|1]/a_460_290# sky130_fd_pr_reram__reram_cell area_ox=0.0676
X335 rr2t2r_0[11|1]/a_60_290# WL11 SL1 VSS sky130_fd_pr__nfet_g5v0d10v5 ad=0.65 pd=3.3 as=0 ps=0 w=1 l=0.5
X336 rr2t2r_0[12|1]/a_460_290# WL12 SL1 VSS sky130_fd_pr__nfet_g5v0d10v5 ad=0.65 pd=3.3 as=0 ps=0 w=1 l=0.5
X337 BLP1 rr2t2r_0[12|1]/a_60_290# sky130_fd_pr_reram__reram_cell area_ox=0.0676
X338 BLN1 rr2t2r_0[12|1]/a_460_290# sky130_fd_pr_reram__reram_cell area_ox=0.0676
X339 rr2t2r_0[12|1]/a_60_290# WL12 SL1 VSS sky130_fd_pr__nfet_g5v0d10v5 ad=0.65 pd=3.3 as=0 ps=0 w=1 l=0.5
X340 rr2t2r_0[13|1]/a_460_290# WL13 SL1 VSS sky130_fd_pr__nfet_g5v0d10v5 ad=0.65 pd=3.3 as=0 ps=0 w=1 l=0.5
X341 BLP1 rr2t2r_0[13|1]/a_60_290# sky130_fd_pr_reram__reram_cell area_ox=0.0676
X342 BLN1 rr2t2r_0[13|1]/a_460_290# sky130_fd_pr_reram__reram_cell area_ox=0.0676
X343 rr2t2r_0[13|1]/a_60_290# WL13 SL1 VSS sky130_fd_pr__nfet_g5v0d10v5 ad=0.65 pd=3.3 as=0 ps=0 w=1 l=0.5
X344 rr2t2r_0[14|1]/a_460_290# WL14 SL1 VSS sky130_fd_pr__nfet_g5v0d10v5 ad=0.65 pd=3.3 as=0 ps=0 w=1 l=0.5
X345 BLP1 rr2t2r_0[14|1]/a_60_290# sky130_fd_pr_reram__reram_cell area_ox=0.0676
X346 BLN1 rr2t2r_0[14|1]/a_460_290# sky130_fd_pr_reram__reram_cell area_ox=0.0676
X347 rr2t2r_0[14|1]/a_60_290# WL14 SL1 VSS sky130_fd_pr__nfet_g5v0d10v5 ad=0.65 pd=3.3 as=0 ps=0 w=1 l=0.5
X348 rr2t2r_0[15|1]/a_460_290# WL15 SL1 VSS sky130_fd_pr__nfet_g5v0d10v5 ad=0.65 pd=3.3 as=0 ps=0 w=1 l=0.5
X349 BLP1 rr2t2r_0[15|1]/a_60_290# sky130_fd_pr_reram__reram_cell area_ox=0.0676
X350 BLN1 rr2t2r_0[15|1]/a_460_290# sky130_fd_pr_reram__reram_cell area_ox=0.0676
X351 rr2t2r_0[15|1]/a_60_290# WL15 SL1 VSS sky130_fd_pr__nfet_g5v0d10v5 ad=0.65 pd=3.3 as=0 ps=0 w=1 l=0.5
X352 rr2t2r_0[16|1]/a_460_290# WL16 SL1 VSS sky130_fd_pr__nfet_g5v0d10v5 ad=0.65 pd=3.3 as=0 ps=0 w=1 l=0.5
X353 BLP1 rr2t2r_0[16|1]/a_60_290# sky130_fd_pr_reram__reram_cell area_ox=0.0676
X354 BLN1 rr2t2r_0[16|1]/a_460_290# sky130_fd_pr_reram__reram_cell area_ox=0.0676
X355 rr2t2r_0[16|1]/a_60_290# WL16 SL1 VSS sky130_fd_pr__nfet_g5v0d10v5 ad=0.65 pd=3.3 as=0 ps=0 w=1 l=0.5
X356 rr2t2r_0[17|1]/a_460_290# WL17 SL1 VSS sky130_fd_pr__nfet_g5v0d10v5 ad=0.65 pd=3.3 as=0 ps=0 w=1 l=0.5
X357 BLP1 rr2t2r_0[17|1]/a_60_290# sky130_fd_pr_reram__reram_cell area_ox=0.0676
X358 BLN1 rr2t2r_0[17|1]/a_460_290# sky130_fd_pr_reram__reram_cell area_ox=0.0676
X359 rr2t2r_0[17|1]/a_60_290# WL17 SL1 VSS sky130_fd_pr__nfet_g5v0d10v5 ad=0.65 pd=3.3 as=0 ps=0 w=1 l=0.5
X360 rr2t2r_0[18|1]/a_460_290# WL18 SL1 VSS sky130_fd_pr__nfet_g5v0d10v5 ad=0.65 pd=3.3 as=0 ps=0 w=1 l=0.5
X361 BLP1 rr2t2r_0[18|1]/a_60_290# sky130_fd_pr_reram__reram_cell area_ox=0.0676
X362 BLN1 rr2t2r_0[18|1]/a_460_290# sky130_fd_pr_reram__reram_cell area_ox=0.0676
X363 rr2t2r_0[18|1]/a_60_290# WL18 SL1 VSS sky130_fd_pr__nfet_g5v0d10v5 ad=0.65 pd=3.3 as=0 ps=0 w=1 l=0.5
X364 rr2t2r_0[19|1]/a_460_290# WL19 SL1 VSS sky130_fd_pr__nfet_g5v0d10v5 ad=0.65 pd=3.3 as=0 ps=0 w=1 l=0.5
X365 BLP1 rr2t2r_0[19|1]/a_60_290# sky130_fd_pr_reram__reram_cell area_ox=0.0676
X366 BLN1 rr2t2r_0[19|1]/a_460_290# sky130_fd_pr_reram__reram_cell area_ox=0.0676
X367 rr2t2r_0[19|1]/a_60_290# WL19 SL1 VSS sky130_fd_pr__nfet_g5v0d10v5 ad=0.65 pd=3.3 as=0 ps=0 w=1 l=0.5
X368 rr2t2r_0[20|1]/a_460_290# WL20 SL1 VSS sky130_fd_pr__nfet_g5v0d10v5 ad=0.65 pd=3.3 as=0 ps=0 w=1 l=0.5
X369 BLP1 rr2t2r_0[20|1]/a_60_290# sky130_fd_pr_reram__reram_cell area_ox=0.0676
X370 BLN1 rr2t2r_0[20|1]/a_460_290# sky130_fd_pr_reram__reram_cell area_ox=0.0676
X371 rr2t2r_0[20|1]/a_60_290# WL20 SL1 VSS sky130_fd_pr__nfet_g5v0d10v5 ad=0.65 pd=3.3 as=0 ps=0 w=1 l=0.5
X372 rr2t2r_0[21|1]/a_460_290# WL21 SL1 VSS sky130_fd_pr__nfet_g5v0d10v5 ad=0.65 pd=3.3 as=0 ps=0 w=1 l=0.5
X373 BLP1 rr2t2r_0[21|1]/a_60_290# sky130_fd_pr_reram__reram_cell area_ox=0.0676
X374 BLN1 rr2t2r_0[21|1]/a_460_290# sky130_fd_pr_reram__reram_cell area_ox=0.0676
X375 rr2t2r_0[21|1]/a_60_290# WL21 SL1 VSS sky130_fd_pr__nfet_g5v0d10v5 ad=0.65 pd=3.3 as=0 ps=0 w=1 l=0.5
X376 rr2t2r_0[22|1]/a_460_290# WL22 SL1 VSS sky130_fd_pr__nfet_g5v0d10v5 ad=0.65 pd=3.3 as=0 ps=0 w=1 l=0.5
X377 BLP1 rr2t2r_0[22|1]/a_60_290# sky130_fd_pr_reram__reram_cell area_ox=0.0676
X378 BLN1 rr2t2r_0[22|1]/a_460_290# sky130_fd_pr_reram__reram_cell area_ox=0.0676
X379 rr2t2r_0[22|1]/a_60_290# WL22 SL1 VSS sky130_fd_pr__nfet_g5v0d10v5 ad=0.65 pd=3.3 as=0 ps=0 w=1 l=0.5
X380 rr2t2r_0[23|1]/a_460_290# WL23 SL1 VSS sky130_fd_pr__nfet_g5v0d10v5 ad=0.65 pd=3.3 as=0 ps=0 w=1 l=0.5
X381 BLP1 rr2t2r_0[23|1]/a_60_290# sky130_fd_pr_reram__reram_cell area_ox=0.0676
X382 BLN1 rr2t2r_0[23|1]/a_460_290# sky130_fd_pr_reram__reram_cell area_ox=0.0676
X383 rr2t2r_0[23|1]/a_60_290# WL23 SL1 VSS sky130_fd_pr__nfet_g5v0d10v5 ad=0.65 pd=3.3 as=0 ps=0 w=1 l=0.5
X384 rr2t2r_0[24|1]/a_460_290# WL24 SL1 VSS sky130_fd_pr__nfet_g5v0d10v5 ad=0.65 pd=3.3 as=0 ps=0 w=1 l=0.5
X385 BLP1 rr2t2r_0[24|1]/a_60_290# sky130_fd_pr_reram__reram_cell area_ox=0.0676
X386 BLN1 rr2t2r_0[24|1]/a_460_290# sky130_fd_pr_reram__reram_cell area_ox=0.0676
X387 rr2t2r_0[24|1]/a_60_290# WL24 SL1 VSS sky130_fd_pr__nfet_g5v0d10v5 ad=0.65 pd=3.3 as=0 ps=0 w=1 l=0.5
X388 rr2t2r_0[25|1]/a_460_290# WL25 SL1 VSS sky130_fd_pr__nfet_g5v0d10v5 ad=0.65 pd=3.3 as=0 ps=0 w=1 l=0.5
X389 BLP1 rr2t2r_0[25|1]/a_60_290# sky130_fd_pr_reram__reram_cell area_ox=0.0676
X390 BLN1 rr2t2r_0[25|1]/a_460_290# sky130_fd_pr_reram__reram_cell area_ox=0.0676
X391 rr2t2r_0[25|1]/a_60_290# WL25 SL1 VSS sky130_fd_pr__nfet_g5v0d10v5 ad=0.65 pd=3.3 as=0 ps=0 w=1 l=0.5
X392 rr2t2r_0[26|1]/a_460_290# WL26 SL1 VSS sky130_fd_pr__nfet_g5v0d10v5 ad=0.65 pd=3.3 as=0 ps=0 w=1 l=0.5
X393 BLP1 rr2t2r_0[26|1]/a_60_290# sky130_fd_pr_reram__reram_cell area_ox=0.0676
X394 BLN1 rr2t2r_0[26|1]/a_460_290# sky130_fd_pr_reram__reram_cell area_ox=0.0676
X395 rr2t2r_0[26|1]/a_60_290# WL26 SL1 VSS sky130_fd_pr__nfet_g5v0d10v5 ad=0.65 pd=3.3 as=0 ps=0 w=1 l=0.5
X396 rr2t2r_0[27|1]/a_460_290# WL27 SL1 VSS sky130_fd_pr__nfet_g5v0d10v5 ad=0.65 pd=3.3 as=0 ps=0 w=1 l=0.5
X397 BLP1 rr2t2r_0[27|1]/a_60_290# sky130_fd_pr_reram__reram_cell area_ox=0.0676
X398 BLN1 rr2t2r_0[27|1]/a_460_290# sky130_fd_pr_reram__reram_cell area_ox=0.0676
X399 rr2t2r_0[27|1]/a_60_290# WL27 SL1 VSS sky130_fd_pr__nfet_g5v0d10v5 ad=0.65 pd=3.3 as=0 ps=0 w=1 l=0.5
X400 rr2t2r_0[28|1]/a_460_290# WL28 SL1 VSS sky130_fd_pr__nfet_g5v0d10v5 ad=0.65 pd=3.3 as=0 ps=0 w=1 l=0.5
X401 BLP1 rr2t2r_0[28|1]/a_60_290# sky130_fd_pr_reram__reram_cell area_ox=0.0676
X402 BLN1 rr2t2r_0[28|1]/a_460_290# sky130_fd_pr_reram__reram_cell area_ox=0.0676
X403 rr2t2r_0[28|1]/a_60_290# WL28 SL1 VSS sky130_fd_pr__nfet_g5v0d10v5 ad=0.65 pd=3.3 as=0 ps=0 w=1 l=0.5
X404 rr2t2r_0[29|1]/a_460_290# WL29 SL1 VSS sky130_fd_pr__nfet_g5v0d10v5 ad=0.65 pd=3.3 as=0 ps=0 w=1 l=0.5
X405 BLP1 rr2t2r_0[29|1]/a_60_290# sky130_fd_pr_reram__reram_cell area_ox=0.0676
X406 BLN1 rr2t2r_0[29|1]/a_460_290# sky130_fd_pr_reram__reram_cell area_ox=0.0676
X407 rr2t2r_0[29|1]/a_60_290# WL29 SL1 VSS sky130_fd_pr__nfet_g5v0d10v5 ad=0.65 pd=3.3 as=0 ps=0 w=1 l=0.5
X408 rr2t2r_0[30|1]/a_460_290# WL30 SL1 VSS sky130_fd_pr__nfet_g5v0d10v5 ad=0.65 pd=3.3 as=0 ps=0 w=1 l=0.5
X409 BLP1 rr2t2r_0[30|1]/a_60_290# sky130_fd_pr_reram__reram_cell area_ox=0.0676
X410 BLN1 rr2t2r_0[30|1]/a_460_290# sky130_fd_pr_reram__reram_cell area_ox=0.0676
X411 rr2t2r_0[30|1]/a_60_290# WL30 SL1 VSS sky130_fd_pr__nfet_g5v0d10v5 ad=0.65 pd=3.3 as=0 ps=0 w=1 l=0.5
X412 rr2t2r_0[31|1]/a_460_290# WL31 SL1 VSS sky130_fd_pr__nfet_g5v0d10v5 ad=0.65 pd=3.3 as=0 ps=0 w=1 l=0.5
X413 BLP1 rr2t2r_0[31|1]/a_60_290# sky130_fd_pr_reram__reram_cell area_ox=0.0676
X414 BLN1 rr2t2r_0[31|1]/a_460_290# sky130_fd_pr_reram__reram_cell area_ox=0.0676
X415 rr2t2r_0[31|1]/a_60_290# WL31 SL1 VSS sky130_fd_pr__nfet_g5v0d10v5 ad=0.65 pd=3.3 as=0 ps=0 w=1 l=0.5
X416 rr2t2r_0[32|1]/a_460_290# WL32 SL1 VSS sky130_fd_pr__nfet_g5v0d10v5 ad=0.65 pd=3.3 as=0 ps=0 w=1 l=0.5
X417 BLP1 rr2t2r_0[32|1]/a_60_290# sky130_fd_pr_reram__reram_cell area_ox=0.0676
X418 BLN1 rr2t2r_0[32|1]/a_460_290# sky130_fd_pr_reram__reram_cell area_ox=0.0676
X419 rr2t2r_0[32|1]/a_60_290# WL32 SL1 VSS sky130_fd_pr__nfet_g5v0d10v5 ad=0.65 pd=3.3 as=0 ps=0 w=1 l=0.5
X420 rr2t2r_0[33|1]/a_460_290# WL33 SL1 VSS sky130_fd_pr__nfet_g5v0d10v5 ad=0.65 pd=3.3 as=0 ps=0 w=1 l=0.5
X421 BLP1 rr2t2r_0[33|1]/a_60_290# sky130_fd_pr_reram__reram_cell area_ox=0.0676
X422 BLN1 rr2t2r_0[33|1]/a_460_290# sky130_fd_pr_reram__reram_cell area_ox=0.0676
X423 rr2t2r_0[33|1]/a_60_290# WL33 SL1 VSS sky130_fd_pr__nfet_g5v0d10v5 ad=0.65 pd=3.3 as=0 ps=0 w=1 l=0.5
X424 rr2t2r_0[34|1]/a_460_290# WL34 SL1 VSS sky130_fd_pr__nfet_g5v0d10v5 ad=0.65 pd=3.3 as=0 ps=0 w=1 l=0.5
X425 BLP1 rr2t2r_0[34|1]/a_60_290# sky130_fd_pr_reram__reram_cell area_ox=0.0676
X426 BLN1 rr2t2r_0[34|1]/a_460_290# sky130_fd_pr_reram__reram_cell area_ox=0.0676
X427 rr2t2r_0[34|1]/a_60_290# WL34 SL1 VSS sky130_fd_pr__nfet_g5v0d10v5 ad=0.65 pd=3.3 as=0 ps=0 w=1 l=0.5
X428 rr2t2r_0[35|1]/a_460_290# WL35 SL1 VSS sky130_fd_pr__nfet_g5v0d10v5 ad=0.65 pd=3.3 as=0 ps=0 w=1 l=0.5
X429 BLP1 rr2t2r_0[35|1]/a_60_290# sky130_fd_pr_reram__reram_cell area_ox=0.0676
X430 BLN1 rr2t2r_0[35|1]/a_460_290# sky130_fd_pr_reram__reram_cell area_ox=0.0676
X431 rr2t2r_0[35|1]/a_60_290# WL35 SL1 VSS sky130_fd_pr__nfet_g5v0d10v5 ad=0.65 pd=3.3 as=0 ps=0 w=1 l=0.5
X432 rr2t2r_0[36|1]/a_460_290# WL36 SL1 VSS sky130_fd_pr__nfet_g5v0d10v5 ad=0.65 pd=3.3 as=0 ps=0 w=1 l=0.5
X433 BLP1 rr2t2r_0[36|1]/a_60_290# sky130_fd_pr_reram__reram_cell area_ox=0.0676
X434 BLN1 rr2t2r_0[36|1]/a_460_290# sky130_fd_pr_reram__reram_cell area_ox=0.0676
X435 rr2t2r_0[36|1]/a_60_290# WL36 SL1 VSS sky130_fd_pr__nfet_g5v0d10v5 ad=0.65 pd=3.3 as=0 ps=0 w=1 l=0.5
X436 rr2t2r_0[37|1]/a_460_290# WL37 SL1 VSS sky130_fd_pr__nfet_g5v0d10v5 ad=0.65 pd=3.3 as=0 ps=0 w=1 l=0.5
X437 BLP1 rr2t2r_0[37|1]/a_60_290# sky130_fd_pr_reram__reram_cell area_ox=0.0676
X438 BLN1 rr2t2r_0[37|1]/a_460_290# sky130_fd_pr_reram__reram_cell area_ox=0.0676
X439 rr2t2r_0[37|1]/a_60_290# WL37 SL1 VSS sky130_fd_pr__nfet_g5v0d10v5 ad=0.65 pd=3.3 as=0 ps=0 w=1 l=0.5
X440 rr2t2r_0[38|1]/a_460_290# WL38 SL1 VSS sky130_fd_pr__nfet_g5v0d10v5 ad=0.65 pd=3.3 as=0 ps=0 w=1 l=0.5
X441 BLP1 rr2t2r_0[38|1]/a_60_290# sky130_fd_pr_reram__reram_cell area_ox=0.0676
X442 BLN1 rr2t2r_0[38|1]/a_460_290# sky130_fd_pr_reram__reram_cell area_ox=0.0676
X443 rr2t2r_0[38|1]/a_60_290# WL38 SL1 VSS sky130_fd_pr__nfet_g5v0d10v5 ad=0.65 pd=3.3 as=0 ps=0 w=1 l=0.5
X444 rr2t2r_0[39|1]/a_460_290# WL39 SL1 VSS sky130_fd_pr__nfet_g5v0d10v5 ad=0.65 pd=3.3 as=0 ps=0 w=1 l=0.5
X445 BLP1 rr2t2r_0[39|1]/a_60_290# sky130_fd_pr_reram__reram_cell area_ox=0.0676
X446 BLN1 rr2t2r_0[39|1]/a_460_290# sky130_fd_pr_reram__reram_cell area_ox=0.0676
X447 rr2t2r_0[39|1]/a_60_290# WL39 SL1 VSS sky130_fd_pr__nfet_g5v0d10v5 ad=0.65 pd=3.3 as=0 ps=0 w=1 l=0.5
X448 rr2t2r_0[40|1]/a_460_290# WL40 SL1 VSS sky130_fd_pr__nfet_g5v0d10v5 ad=0.65 pd=3.3 as=0 ps=0 w=1 l=0.5
X449 BLP1 rr2t2r_0[40|1]/a_60_290# sky130_fd_pr_reram__reram_cell area_ox=0.0676
X450 BLN1 rr2t2r_0[40|1]/a_460_290# sky130_fd_pr_reram__reram_cell area_ox=0.0676
X451 rr2t2r_0[40|1]/a_60_290# WL40 SL1 VSS sky130_fd_pr__nfet_g5v0d10v5 ad=0.65 pd=3.3 as=0 ps=0 w=1 l=0.5
X452 rr2t2r_0[41|1]/a_460_290# WL41 SL1 VSS sky130_fd_pr__nfet_g5v0d10v5 ad=0.65 pd=3.3 as=0 ps=0 w=1 l=0.5
X453 BLP1 rr2t2r_0[41|1]/a_60_290# sky130_fd_pr_reram__reram_cell area_ox=0.0676
X454 BLN1 rr2t2r_0[41|1]/a_460_290# sky130_fd_pr_reram__reram_cell area_ox=0.0676
X455 rr2t2r_0[41|1]/a_60_290# WL41 SL1 VSS sky130_fd_pr__nfet_g5v0d10v5 ad=0.65 pd=3.3 as=0 ps=0 w=1 l=0.5
X456 rr2t2r_0[42|1]/a_460_290# WL42 SL1 VSS sky130_fd_pr__nfet_g5v0d10v5 ad=0.65 pd=3.3 as=0 ps=0 w=1 l=0.5
X457 BLP1 rr2t2r_0[42|1]/a_60_290# sky130_fd_pr_reram__reram_cell area_ox=0.0676
X458 BLN1 rr2t2r_0[42|1]/a_460_290# sky130_fd_pr_reram__reram_cell area_ox=0.0676
X459 rr2t2r_0[42|1]/a_60_290# WL42 SL1 VSS sky130_fd_pr__nfet_g5v0d10v5 ad=0.65 pd=3.3 as=0 ps=0 w=1 l=0.5
X460 rr2t2r_0[43|1]/a_460_290# WL43 SL1 VSS sky130_fd_pr__nfet_g5v0d10v5 ad=0.65 pd=3.3 as=0 ps=0 w=1 l=0.5
X461 BLP1 rr2t2r_0[43|1]/a_60_290# sky130_fd_pr_reram__reram_cell area_ox=0.0676
X462 BLN1 rr2t2r_0[43|1]/a_460_290# sky130_fd_pr_reram__reram_cell area_ox=0.0676
X463 rr2t2r_0[43|1]/a_60_290# WL43 SL1 VSS sky130_fd_pr__nfet_g5v0d10v5 ad=0.65 pd=3.3 as=0 ps=0 w=1 l=0.5
X464 rr2t2r_0[44|1]/a_460_290# WL44 SL1 VSS sky130_fd_pr__nfet_g5v0d10v5 ad=0.65 pd=3.3 as=0 ps=0 w=1 l=0.5
X465 BLP1 rr2t2r_0[44|1]/a_60_290# sky130_fd_pr_reram__reram_cell area_ox=0.0676
X466 BLN1 rr2t2r_0[44|1]/a_460_290# sky130_fd_pr_reram__reram_cell area_ox=0.0676
X467 rr2t2r_0[44|1]/a_60_290# WL44 SL1 VSS sky130_fd_pr__nfet_g5v0d10v5 ad=0.65 pd=3.3 as=0 ps=0 w=1 l=0.5
X468 rr2t2r_0[45|1]/a_460_290# WL45 SL1 VSS sky130_fd_pr__nfet_g5v0d10v5 ad=0.65 pd=3.3 as=0 ps=0 w=1 l=0.5
X469 BLP1 rr2t2r_0[45|1]/a_60_290# sky130_fd_pr_reram__reram_cell area_ox=0.0676
X470 BLN1 rr2t2r_0[45|1]/a_460_290# sky130_fd_pr_reram__reram_cell area_ox=0.0676
X471 rr2t2r_0[45|1]/a_60_290# WL45 SL1 VSS sky130_fd_pr__nfet_g5v0d10v5 ad=0.65 pd=3.3 as=0 ps=0 w=1 l=0.5
X472 rr2t2r_0[46|1]/a_460_290# WL46 SL1 VSS sky130_fd_pr__nfet_g5v0d10v5 ad=0.65 pd=3.3 as=0 ps=0 w=1 l=0.5
X473 BLP1 rr2t2r_0[46|1]/a_60_290# sky130_fd_pr_reram__reram_cell area_ox=0.0676
X474 BLN1 rr2t2r_0[46|1]/a_460_290# sky130_fd_pr_reram__reram_cell area_ox=0.0676
X475 rr2t2r_0[46|1]/a_60_290# WL46 SL1 VSS sky130_fd_pr__nfet_g5v0d10v5 ad=0.65 pd=3.3 as=0 ps=0 w=1 l=0.5
X476 rr2t2r_0[47|1]/a_460_290# WL47 SL1 VSS sky130_fd_pr__nfet_g5v0d10v5 ad=0.65 pd=3.3 as=0 ps=0 w=1 l=0.5
X477 BLP1 rr2t2r_0[47|1]/a_60_290# sky130_fd_pr_reram__reram_cell area_ox=0.0676
X478 BLN1 rr2t2r_0[47|1]/a_460_290# sky130_fd_pr_reram__reram_cell area_ox=0.0676
X479 rr2t2r_0[47|1]/a_60_290# WL47 SL1 VSS sky130_fd_pr__nfet_g5v0d10v5 ad=0.65 pd=3.3 as=0 ps=0 w=1 l=0.5
X480 rr2t2r_0[48|1]/a_460_290# WL48 SL1 VSS sky130_fd_pr__nfet_g5v0d10v5 ad=0.65 pd=3.3 as=0 ps=0 w=1 l=0.5
X481 BLP1 rr2t2r_0[48|1]/a_60_290# sky130_fd_pr_reram__reram_cell area_ox=0.0676
X482 BLN1 rr2t2r_0[48|1]/a_460_290# sky130_fd_pr_reram__reram_cell area_ox=0.0676
X483 rr2t2r_0[48|1]/a_60_290# WL48 SL1 VSS sky130_fd_pr__nfet_g5v0d10v5 ad=0.65 pd=3.3 as=0 ps=0 w=1 l=0.5
X484 rr2t2r_0[49|1]/a_460_290# WL49 SL1 VSS sky130_fd_pr__nfet_g5v0d10v5 ad=0.65 pd=3.3 as=0 ps=0 w=1 l=0.5
X485 BLP1 rr2t2r_0[49|1]/a_60_290# sky130_fd_pr_reram__reram_cell area_ox=0.0676
X486 BLN1 rr2t2r_0[49|1]/a_460_290# sky130_fd_pr_reram__reram_cell area_ox=0.0676
X487 rr2t2r_0[49|1]/a_60_290# WL49 SL1 VSS sky130_fd_pr__nfet_g5v0d10v5 ad=0.65 pd=3.3 as=0 ps=0 w=1 l=0.5
X488 rr2t2r_0[50|1]/a_460_290# WL50 SL1 VSS sky130_fd_pr__nfet_g5v0d10v5 ad=0.65 pd=3.3 as=0 ps=0 w=1 l=0.5
X489 BLP1 rr2t2r_0[50|1]/a_60_290# sky130_fd_pr_reram__reram_cell area_ox=0.0676
X490 BLN1 rr2t2r_0[50|1]/a_460_290# sky130_fd_pr_reram__reram_cell area_ox=0.0676
X491 rr2t2r_0[50|1]/a_60_290# WL50 SL1 VSS sky130_fd_pr__nfet_g5v0d10v5 ad=0.65 pd=3.3 as=0 ps=0 w=1 l=0.5
X492 rr2t2r_0[51|1]/a_460_290# WL51 SL1 VSS sky130_fd_pr__nfet_g5v0d10v5 ad=0.65 pd=3.3 as=0 ps=0 w=1 l=0.5
X493 BLP1 rr2t2r_0[51|1]/a_60_290# sky130_fd_pr_reram__reram_cell area_ox=0.0676
X494 BLN1 rr2t2r_0[51|1]/a_460_290# sky130_fd_pr_reram__reram_cell area_ox=0.0676
X495 rr2t2r_0[51|1]/a_60_290# WL51 SL1 VSS sky130_fd_pr__nfet_g5v0d10v5 ad=0.65 pd=3.3 as=0 ps=0 w=1 l=0.5
X496 rr2t2r_0[52|1]/a_460_290# WL52 SL1 VSS sky130_fd_pr__nfet_g5v0d10v5 ad=0.65 pd=3.3 as=0 ps=0 w=1 l=0.5
X497 BLP1 rr2t2r_0[52|1]/a_60_290# sky130_fd_pr_reram__reram_cell area_ox=0.0676
X498 BLN1 rr2t2r_0[52|1]/a_460_290# sky130_fd_pr_reram__reram_cell area_ox=0.0676
X499 rr2t2r_0[52|1]/a_60_290# WL52 SL1 VSS sky130_fd_pr__nfet_g5v0d10v5 ad=0.65 pd=3.3 as=0 ps=0 w=1 l=0.5
X500 rr2t2r_0[53|1]/a_460_290# WL53 SL1 VSS sky130_fd_pr__nfet_g5v0d10v5 ad=0.65 pd=3.3 as=0 ps=0 w=1 l=0.5
X501 BLP1 rr2t2r_0[53|1]/a_60_290# sky130_fd_pr_reram__reram_cell area_ox=0.0676
X502 BLN1 rr2t2r_0[53|1]/a_460_290# sky130_fd_pr_reram__reram_cell area_ox=0.0676
X503 rr2t2r_0[53|1]/a_60_290# WL53 SL1 VSS sky130_fd_pr__nfet_g5v0d10v5 ad=0.65 pd=3.3 as=0 ps=0 w=1 l=0.5
X504 rr2t2r_0[54|1]/a_460_290# WL54 SL1 VSS sky130_fd_pr__nfet_g5v0d10v5 ad=0.65 pd=3.3 as=0 ps=0 w=1 l=0.5
X505 BLP1 rr2t2r_0[54|1]/a_60_290# sky130_fd_pr_reram__reram_cell area_ox=0.0676
X506 BLN1 rr2t2r_0[54|1]/a_460_290# sky130_fd_pr_reram__reram_cell area_ox=0.0676
X507 rr2t2r_0[54|1]/a_60_290# WL54 SL1 VSS sky130_fd_pr__nfet_g5v0d10v5 ad=0.65 pd=3.3 as=0 ps=0 w=1 l=0.5
X508 rr2t2r_0[55|1]/a_460_290# WL55 SL1 VSS sky130_fd_pr__nfet_g5v0d10v5 ad=0.65 pd=3.3 as=0 ps=0 w=1 l=0.5
X509 BLP1 rr2t2r_0[55|1]/a_60_290# sky130_fd_pr_reram__reram_cell area_ox=0.0676
X510 BLN1 rr2t2r_0[55|1]/a_460_290# sky130_fd_pr_reram__reram_cell area_ox=0.0676
X511 rr2t2r_0[55|1]/a_60_290# WL55 SL1 VSS sky130_fd_pr__nfet_g5v0d10v5 ad=0.65 pd=3.3 as=0 ps=0 w=1 l=0.5
X512 rr2t2r_0[56|1]/a_460_290# WL56 SL1 VSS sky130_fd_pr__nfet_g5v0d10v5 ad=0.65 pd=3.3 as=0 ps=0 w=1 l=0.5
X513 BLP1 rr2t2r_0[56|1]/a_60_290# sky130_fd_pr_reram__reram_cell area_ox=0.0676
X514 BLN1 rr2t2r_0[56|1]/a_460_290# sky130_fd_pr_reram__reram_cell area_ox=0.0676
X515 rr2t2r_0[56|1]/a_60_290# WL56 SL1 VSS sky130_fd_pr__nfet_g5v0d10v5 ad=0.65 pd=3.3 as=0 ps=0 w=1 l=0.5
X516 rr2t2r_0[57|1]/a_460_290# WL57 SL1 VSS sky130_fd_pr__nfet_g5v0d10v5 ad=0.65 pd=3.3 as=0 ps=0 w=1 l=0.5
X517 BLP1 rr2t2r_0[57|1]/a_60_290# sky130_fd_pr_reram__reram_cell area_ox=0.0676
X518 BLN1 rr2t2r_0[57|1]/a_460_290# sky130_fd_pr_reram__reram_cell area_ox=0.0676
X519 rr2t2r_0[57|1]/a_60_290# WL57 SL1 VSS sky130_fd_pr__nfet_g5v0d10v5 ad=0.65 pd=3.3 as=0 ps=0 w=1 l=0.5
X520 rr2t2r_0[58|1]/a_460_290# WL58 SL1 VSS sky130_fd_pr__nfet_g5v0d10v5 ad=0.65 pd=3.3 as=0 ps=0 w=1 l=0.5
X521 BLP1 rr2t2r_0[58|1]/a_60_290# sky130_fd_pr_reram__reram_cell area_ox=0.0676
X522 BLN1 rr2t2r_0[58|1]/a_460_290# sky130_fd_pr_reram__reram_cell area_ox=0.0676
X523 rr2t2r_0[58|1]/a_60_290# WL58 SL1 VSS sky130_fd_pr__nfet_g5v0d10v5 ad=0.65 pd=3.3 as=0 ps=0 w=1 l=0.5
X524 rr2t2r_0[59|1]/a_460_290# WL59 SL1 VSS sky130_fd_pr__nfet_g5v0d10v5 ad=0.65 pd=3.3 as=0 ps=0 w=1 l=0.5
X525 BLP1 rr2t2r_0[59|1]/a_60_290# sky130_fd_pr_reram__reram_cell area_ox=0.0676
X526 BLN1 rr2t2r_0[59|1]/a_460_290# sky130_fd_pr_reram__reram_cell area_ox=0.0676
X527 rr2t2r_0[59|1]/a_60_290# WL59 SL1 VSS sky130_fd_pr__nfet_g5v0d10v5 ad=0.65 pd=3.3 as=0 ps=0 w=1 l=0.5
X528 rr2t2r_0[60|1]/a_460_290# WL60 SL1 VSS sky130_fd_pr__nfet_g5v0d10v5 ad=0.65 pd=3.3 as=0 ps=0 w=1 l=0.5
X529 BLP1 rr2t2r_0[60|1]/a_60_290# sky130_fd_pr_reram__reram_cell area_ox=0.0676
X530 BLN1 rr2t2r_0[60|1]/a_460_290# sky130_fd_pr_reram__reram_cell area_ox=0.0676
X531 rr2t2r_0[60|1]/a_60_290# WL60 SL1 VSS sky130_fd_pr__nfet_g5v0d10v5 ad=0.65 pd=3.3 as=0 ps=0 w=1 l=0.5
X532 rr2t2r_0[61|1]/a_460_290# WL61 SL1 VSS sky130_fd_pr__nfet_g5v0d10v5 ad=0.65 pd=3.3 as=0 ps=0 w=1 l=0.5
X533 BLP1 rr2t2r_0[61|1]/a_60_290# sky130_fd_pr_reram__reram_cell area_ox=0.0676
X534 BLN1 rr2t2r_0[61|1]/a_460_290# sky130_fd_pr_reram__reram_cell area_ox=0.0676
X535 rr2t2r_0[61|1]/a_60_290# WL61 SL1 VSS sky130_fd_pr__nfet_g5v0d10v5 ad=0.65 pd=3.3 as=0 ps=0 w=1 l=0.5
X536 rr2t2r_0[62|1]/a_460_290# WL62 SL1 VSS sky130_fd_pr__nfet_g5v0d10v5 ad=0.65 pd=3.3 as=0 ps=0 w=1 l=0.5
X537 BLP1 rr2t2r_0[62|1]/a_60_290# sky130_fd_pr_reram__reram_cell area_ox=0.0676
X538 BLN1 rr2t2r_0[62|1]/a_460_290# sky130_fd_pr_reram__reram_cell area_ox=0.0676
X539 rr2t2r_0[62|1]/a_60_290# WL62 SL1 VSS sky130_fd_pr__nfet_g5v0d10v5 ad=0.65 pd=3.3 as=0 ps=0 w=1 l=0.5
X540 rr2t2r_0[63|1]/a_460_290# WL63 SL1 VSS sky130_fd_pr__nfet_g5v0d10v5 ad=0.65 pd=3.3 as=0 ps=0 w=1 l=0.5
X541 BLP1 rr2t2r_0[63|1]/a_60_290# sky130_fd_pr_reram__reram_cell area_ox=0.0676
X542 BLN1 rr2t2r_0[63|1]/a_460_290# sky130_fd_pr_reram__reram_cell area_ox=0.0676
X543 rr2t2r_0[63|1]/a_60_290# WL63 SL1 VSS sky130_fd_pr__nfet_g5v0d10v5 ad=0.65 pd=3.3 as=0 ps=0 w=1 l=0.5
X544 rr2t2r_0[64|1]/a_460_290# WL64 SL1 VSS sky130_fd_pr__nfet_g5v0d10v5 ad=0.65 pd=3.3 as=0 ps=0 w=1 l=0.5
X545 BLP1 rr2t2r_0[64|1]/a_60_290# sky130_fd_pr_reram__reram_cell area_ox=0.0676
X546 BLN1 rr2t2r_0[64|1]/a_460_290# sky130_fd_pr_reram__reram_cell area_ox=0.0676
X547 rr2t2r_0[64|1]/a_60_290# WL64 SL1 VSS sky130_fd_pr__nfet_g5v0d10v5 ad=0.65 pd=3.3 as=0 ps=0 w=1 l=0.5
X548 rr2t2r_0[65|1]/a_460_290# WL65 SL1 VSS sky130_fd_pr__nfet_g5v0d10v5 ad=0.65 pd=3.3 as=0 ps=0 w=1 l=0.5
X549 BLP1 rr2t2r_0[65|1]/a_60_290# sky130_fd_pr_reram__reram_cell area_ox=0.0676
X550 BLN1 rr2t2r_0[65|1]/a_460_290# sky130_fd_pr_reram__reram_cell area_ox=0.0676
X551 rr2t2r_0[65|1]/a_60_290# WL65 SL1 VSS sky130_fd_pr__nfet_g5v0d10v5 ad=0.65 pd=3.3 as=0 ps=0 w=1 l=0.5
X552 rr2t2r_0[66|1]/a_460_290# WL66 SL1 VSS sky130_fd_pr__nfet_g5v0d10v5 ad=0.65 pd=3.3 as=0 ps=0 w=1 l=0.5
X553 BLP1 rr2t2r_0[66|1]/a_60_290# sky130_fd_pr_reram__reram_cell area_ox=0.0676
X554 BLN1 rr2t2r_0[66|1]/a_460_290# sky130_fd_pr_reram__reram_cell area_ox=0.0676
X555 rr2t2r_0[66|1]/a_60_290# WL66 SL1 VSS sky130_fd_pr__nfet_g5v0d10v5 ad=0.65 pd=3.3 as=0 ps=0 w=1 l=0.5
X556 rr2t2r_0[67|1]/a_460_290# WL67 SL1 VSS sky130_fd_pr__nfet_g5v0d10v5 ad=0.65 pd=3.3 as=0 ps=0 w=1 l=0.5
X557 BLP1 rr2t2r_0[67|1]/a_60_290# sky130_fd_pr_reram__reram_cell area_ox=0.0676
X558 BLN1 rr2t2r_0[67|1]/a_460_290# sky130_fd_pr_reram__reram_cell area_ox=0.0676
X559 rr2t2r_0[67|1]/a_60_290# WL67 SL1 VSS sky130_fd_pr__nfet_g5v0d10v5 ad=0.65 pd=3.3 as=0 ps=0 w=1 l=0.5
X560 rr2t2r_0[68|1]/a_460_290# WL68 SL1 VSS sky130_fd_pr__nfet_g5v0d10v5 ad=0.65 pd=3.3 as=0 ps=0 w=1 l=0.5
X561 BLP1 rr2t2r_0[68|1]/a_60_290# sky130_fd_pr_reram__reram_cell area_ox=0.0676
X562 BLN1 rr2t2r_0[68|1]/a_460_290# sky130_fd_pr_reram__reram_cell area_ox=0.0676
X563 rr2t2r_0[68|1]/a_60_290# WL68 SL1 VSS sky130_fd_pr__nfet_g5v0d10v5 ad=0.65 pd=3.3 as=0 ps=0 w=1 l=0.5
X564 rr2t2r_0[69|1]/a_460_290# WL69 SL1 VSS sky130_fd_pr__nfet_g5v0d10v5 ad=0.65 pd=3.3 as=0 ps=0 w=1 l=0.5
X565 BLP1 rr2t2r_0[69|1]/a_60_290# sky130_fd_pr_reram__reram_cell area_ox=0.0676
X566 BLN1 rr2t2r_0[69|1]/a_460_290# sky130_fd_pr_reram__reram_cell area_ox=0.0676
X567 rr2t2r_0[69|1]/a_60_290# WL69 SL1 VSS sky130_fd_pr__nfet_g5v0d10v5 ad=0.65 pd=3.3 as=0 ps=0 w=1 l=0.5
X568 rr2t2r_0[70|1]/a_460_290# WL70 SL1 VSS sky130_fd_pr__nfet_g5v0d10v5 ad=0.65 pd=3.3 as=0 ps=0 w=1 l=0.5
X569 BLP1 rr2t2r_0[70|1]/a_60_290# sky130_fd_pr_reram__reram_cell area_ox=0.0676
X570 BLN1 rr2t2r_0[70|1]/a_460_290# sky130_fd_pr_reram__reram_cell area_ox=0.0676
X571 rr2t2r_0[70|1]/a_60_290# WL70 SL1 VSS sky130_fd_pr__nfet_g5v0d10v5 ad=0.65 pd=3.3 as=0 ps=0 w=1 l=0.5
X572 rr2t2r_0[71|1]/a_460_290# WL71 SL1 VSS sky130_fd_pr__nfet_g5v0d10v5 ad=0.65 pd=3.3 as=0 ps=0 w=1 l=0.5
X573 BLP1 rr2t2r_0[71|1]/a_60_290# sky130_fd_pr_reram__reram_cell area_ox=0.0676
X574 BLN1 rr2t2r_0[71|1]/a_460_290# sky130_fd_pr_reram__reram_cell area_ox=0.0676
X575 rr2t2r_0[71|1]/a_60_290# WL71 SL1 VSS sky130_fd_pr__nfet_g5v0d10v5 ad=0.65 pd=3.3 as=0 ps=0 w=1 l=0.5
X576 rr2t2r_0[0|2]/a_460_290# WL0 SL2 VSS sky130_fd_pr__nfet_g5v0d10v5 ad=0.65 pd=3.3 as=108 ps=504 w=1 l=0.5
X577 BLP2 rr2t2r_0[0|2]/a_60_290# sky130_fd_pr_reram__reram_cell area_ox=0.0676
X578 BLN2 rr2t2r_0[0|2]/a_460_290# sky130_fd_pr_reram__reram_cell area_ox=0.0676
X579 rr2t2r_0[0|2]/a_60_290# WL0 SL2 VSS sky130_fd_pr__nfet_g5v0d10v5 ad=0.65 pd=3.3 as=0 ps=0 w=1 l=0.5
X580 rr2t2r_0[1|2]/a_460_290# WL1 SL2 VSS sky130_fd_pr__nfet_g5v0d10v5 ad=0.65 pd=3.3 as=0 ps=0 w=1 l=0.5
X581 BLP2 rr2t2r_0[1|2]/a_60_290# sky130_fd_pr_reram__reram_cell area_ox=0.0676
X582 BLN2 rr2t2r_0[1|2]/a_460_290# sky130_fd_pr_reram__reram_cell area_ox=0.0676
X583 rr2t2r_0[1|2]/a_60_290# WL1 SL2 VSS sky130_fd_pr__nfet_g5v0d10v5 ad=0.65 pd=3.3 as=0 ps=0 w=1 l=0.5
X584 rr2t2r_0[2|2]/a_460_290# WL2 SL2 VSS sky130_fd_pr__nfet_g5v0d10v5 ad=0.65 pd=3.3 as=0 ps=0 w=1 l=0.5
X585 BLP2 rr2t2r_0[2|2]/a_60_290# sky130_fd_pr_reram__reram_cell area_ox=0.0676
X586 BLN2 rr2t2r_0[2|2]/a_460_290# sky130_fd_pr_reram__reram_cell area_ox=0.0676
X587 rr2t2r_0[2|2]/a_60_290# WL2 SL2 VSS sky130_fd_pr__nfet_g5v0d10v5 ad=0.65 pd=3.3 as=0 ps=0 w=1 l=0.5
X588 rr2t2r_0[3|2]/a_460_290# WL3 SL2 VSS sky130_fd_pr__nfet_g5v0d10v5 ad=0.65 pd=3.3 as=0 ps=0 w=1 l=0.5
X589 BLP2 rr2t2r_0[3|2]/a_60_290# sky130_fd_pr_reram__reram_cell area_ox=0.0676
X590 BLN2 rr2t2r_0[3|2]/a_460_290# sky130_fd_pr_reram__reram_cell area_ox=0.0676
X591 rr2t2r_0[3|2]/a_60_290# WL3 SL2 VSS sky130_fd_pr__nfet_g5v0d10v5 ad=0.65 pd=3.3 as=0 ps=0 w=1 l=0.5
X592 rr2t2r_0[4|2]/a_460_290# WL4 SL2 VSS sky130_fd_pr__nfet_g5v0d10v5 ad=0.65 pd=3.3 as=0 ps=0 w=1 l=0.5
X593 BLP2 rr2t2r_0[4|2]/a_60_290# sky130_fd_pr_reram__reram_cell area_ox=0.0676
X594 BLN2 rr2t2r_0[4|2]/a_460_290# sky130_fd_pr_reram__reram_cell area_ox=0.0676
X595 rr2t2r_0[4|2]/a_60_290# WL4 SL2 VSS sky130_fd_pr__nfet_g5v0d10v5 ad=0.65 pd=3.3 as=0 ps=0 w=1 l=0.5
X596 rr2t2r_0[5|2]/a_460_290# WL5 SL2 VSS sky130_fd_pr__nfet_g5v0d10v5 ad=0.65 pd=3.3 as=0 ps=0 w=1 l=0.5
X597 BLP2 rr2t2r_0[5|2]/a_60_290# sky130_fd_pr_reram__reram_cell area_ox=0.0676
X598 BLN2 rr2t2r_0[5|2]/a_460_290# sky130_fd_pr_reram__reram_cell area_ox=0.0676
X599 rr2t2r_0[5|2]/a_60_290# WL5 SL2 VSS sky130_fd_pr__nfet_g5v0d10v5 ad=0.65 pd=3.3 as=0 ps=0 w=1 l=0.5
X600 rr2t2r_0[6|2]/a_460_290# WL6 SL2 VSS sky130_fd_pr__nfet_g5v0d10v5 ad=0.65 pd=3.3 as=0 ps=0 w=1 l=0.5
X601 BLP2 rr2t2r_0[6|2]/a_60_290# sky130_fd_pr_reram__reram_cell area_ox=0.0676
X602 BLN2 rr2t2r_0[6|2]/a_460_290# sky130_fd_pr_reram__reram_cell area_ox=0.0676
X603 rr2t2r_0[6|2]/a_60_290# WL6 SL2 VSS sky130_fd_pr__nfet_g5v0d10v5 ad=0.65 pd=3.3 as=0 ps=0 w=1 l=0.5
X604 rr2t2r_0[7|2]/a_460_290# WL7 SL2 VSS sky130_fd_pr__nfet_g5v0d10v5 ad=0.65 pd=3.3 as=0 ps=0 w=1 l=0.5
X605 BLP2 rr2t2r_0[7|2]/a_60_290# sky130_fd_pr_reram__reram_cell area_ox=0.0676
X606 BLN2 rr2t2r_0[7|2]/a_460_290# sky130_fd_pr_reram__reram_cell area_ox=0.0676
X607 rr2t2r_0[7|2]/a_60_290# WL7 SL2 VSS sky130_fd_pr__nfet_g5v0d10v5 ad=0.65 pd=3.3 as=0 ps=0 w=1 l=0.5
X608 rr2t2r_0[8|2]/a_460_290# WL8 SL2 VSS sky130_fd_pr__nfet_g5v0d10v5 ad=0.65 pd=3.3 as=0 ps=0 w=1 l=0.5
X609 BLP2 rr2t2r_0[8|2]/a_60_290# sky130_fd_pr_reram__reram_cell area_ox=0.0676
X610 BLN2 rr2t2r_0[8|2]/a_460_290# sky130_fd_pr_reram__reram_cell area_ox=0.0676
X611 rr2t2r_0[8|2]/a_60_290# WL8 SL2 VSS sky130_fd_pr__nfet_g5v0d10v5 ad=0.65 pd=3.3 as=0 ps=0 w=1 l=0.5
X612 rr2t2r_0[9|2]/a_460_290# WL9 SL2 VSS sky130_fd_pr__nfet_g5v0d10v5 ad=0.65 pd=3.3 as=0 ps=0 w=1 l=0.5
X613 BLP2 rr2t2r_0[9|2]/a_60_290# sky130_fd_pr_reram__reram_cell area_ox=0.0676
X614 BLN2 rr2t2r_0[9|2]/a_460_290# sky130_fd_pr_reram__reram_cell area_ox=0.0676
X615 rr2t2r_0[9|2]/a_60_290# WL9 SL2 VSS sky130_fd_pr__nfet_g5v0d10v5 ad=0.65 pd=3.3 as=0 ps=0 w=1 l=0.5
X616 rr2t2r_0[10|2]/a_460_290# WL10 SL2 VSS sky130_fd_pr__nfet_g5v0d10v5 ad=0.65 pd=3.3 as=0 ps=0 w=1 l=0.5
X617 BLP2 rr2t2r_0[10|2]/a_60_290# sky130_fd_pr_reram__reram_cell area_ox=0.0676
X618 BLN2 rr2t2r_0[10|2]/a_460_290# sky130_fd_pr_reram__reram_cell area_ox=0.0676
X619 rr2t2r_0[10|2]/a_60_290# WL10 SL2 VSS sky130_fd_pr__nfet_g5v0d10v5 ad=0.65 pd=3.3 as=0 ps=0 w=1 l=0.5
X620 rr2t2r_0[11|2]/a_460_290# WL11 SL2 VSS sky130_fd_pr__nfet_g5v0d10v5 ad=0.65 pd=3.3 as=0 ps=0 w=1 l=0.5
X621 BLP2 rr2t2r_0[11|2]/a_60_290# sky130_fd_pr_reram__reram_cell area_ox=0.0676
X622 BLN2 rr2t2r_0[11|2]/a_460_290# sky130_fd_pr_reram__reram_cell area_ox=0.0676
X623 rr2t2r_0[11|2]/a_60_290# WL11 SL2 VSS sky130_fd_pr__nfet_g5v0d10v5 ad=0.65 pd=3.3 as=0 ps=0 w=1 l=0.5
X624 rr2t2r_0[12|2]/a_460_290# WL12 SL2 VSS sky130_fd_pr__nfet_g5v0d10v5 ad=0.65 pd=3.3 as=0 ps=0 w=1 l=0.5
X625 BLP2 rr2t2r_0[12|2]/a_60_290# sky130_fd_pr_reram__reram_cell area_ox=0.0676
X626 BLN2 rr2t2r_0[12|2]/a_460_290# sky130_fd_pr_reram__reram_cell area_ox=0.0676
X627 rr2t2r_0[12|2]/a_60_290# WL12 SL2 VSS sky130_fd_pr__nfet_g5v0d10v5 ad=0.65 pd=3.3 as=0 ps=0 w=1 l=0.5
X628 rr2t2r_0[13|2]/a_460_290# WL13 SL2 VSS sky130_fd_pr__nfet_g5v0d10v5 ad=0.65 pd=3.3 as=0 ps=0 w=1 l=0.5
X629 BLP2 rr2t2r_0[13|2]/a_60_290# sky130_fd_pr_reram__reram_cell area_ox=0.0676
X630 BLN2 rr2t2r_0[13|2]/a_460_290# sky130_fd_pr_reram__reram_cell area_ox=0.0676
X631 rr2t2r_0[13|2]/a_60_290# WL13 SL2 VSS sky130_fd_pr__nfet_g5v0d10v5 ad=0.65 pd=3.3 as=0 ps=0 w=1 l=0.5
X632 rr2t2r_0[14|2]/a_460_290# WL14 SL2 VSS sky130_fd_pr__nfet_g5v0d10v5 ad=0.65 pd=3.3 as=0 ps=0 w=1 l=0.5
X633 BLP2 rr2t2r_0[14|2]/a_60_290# sky130_fd_pr_reram__reram_cell area_ox=0.0676
X634 BLN2 rr2t2r_0[14|2]/a_460_290# sky130_fd_pr_reram__reram_cell area_ox=0.0676
X635 rr2t2r_0[14|2]/a_60_290# WL14 SL2 VSS sky130_fd_pr__nfet_g5v0d10v5 ad=0.65 pd=3.3 as=0 ps=0 w=1 l=0.5
X636 rr2t2r_0[15|2]/a_460_290# WL15 SL2 VSS sky130_fd_pr__nfet_g5v0d10v5 ad=0.65 pd=3.3 as=0 ps=0 w=1 l=0.5
X637 BLP2 rr2t2r_0[15|2]/a_60_290# sky130_fd_pr_reram__reram_cell area_ox=0.0676
X638 BLN2 rr2t2r_0[15|2]/a_460_290# sky130_fd_pr_reram__reram_cell area_ox=0.0676
X639 rr2t2r_0[15|2]/a_60_290# WL15 SL2 VSS sky130_fd_pr__nfet_g5v0d10v5 ad=0.65 pd=3.3 as=0 ps=0 w=1 l=0.5
X640 rr2t2r_0[16|2]/a_460_290# WL16 SL2 VSS sky130_fd_pr__nfet_g5v0d10v5 ad=0.65 pd=3.3 as=0 ps=0 w=1 l=0.5
X641 BLP2 rr2t2r_0[16|2]/a_60_290# sky130_fd_pr_reram__reram_cell area_ox=0.0676
X642 BLN2 rr2t2r_0[16|2]/a_460_290# sky130_fd_pr_reram__reram_cell area_ox=0.0676
X643 rr2t2r_0[16|2]/a_60_290# WL16 SL2 VSS sky130_fd_pr__nfet_g5v0d10v5 ad=0.65 pd=3.3 as=0 ps=0 w=1 l=0.5
X644 rr2t2r_0[17|2]/a_460_290# WL17 SL2 VSS sky130_fd_pr__nfet_g5v0d10v5 ad=0.65 pd=3.3 as=0 ps=0 w=1 l=0.5
X645 BLP2 rr2t2r_0[17|2]/a_60_290# sky130_fd_pr_reram__reram_cell area_ox=0.0676
X646 BLN2 rr2t2r_0[17|2]/a_460_290# sky130_fd_pr_reram__reram_cell area_ox=0.0676
X647 rr2t2r_0[17|2]/a_60_290# WL17 SL2 VSS sky130_fd_pr__nfet_g5v0d10v5 ad=0.65 pd=3.3 as=0 ps=0 w=1 l=0.5
X648 rr2t2r_0[18|2]/a_460_290# WL18 SL2 VSS sky130_fd_pr__nfet_g5v0d10v5 ad=0.65 pd=3.3 as=0 ps=0 w=1 l=0.5
X649 BLP2 rr2t2r_0[18|2]/a_60_290# sky130_fd_pr_reram__reram_cell area_ox=0.0676
X650 BLN2 rr2t2r_0[18|2]/a_460_290# sky130_fd_pr_reram__reram_cell area_ox=0.0676
X651 rr2t2r_0[18|2]/a_60_290# WL18 SL2 VSS sky130_fd_pr__nfet_g5v0d10v5 ad=0.65 pd=3.3 as=0 ps=0 w=1 l=0.5
X652 rr2t2r_0[19|2]/a_460_290# WL19 SL2 VSS sky130_fd_pr__nfet_g5v0d10v5 ad=0.65 pd=3.3 as=0 ps=0 w=1 l=0.5
X653 BLP2 rr2t2r_0[19|2]/a_60_290# sky130_fd_pr_reram__reram_cell area_ox=0.0676
X654 BLN2 rr2t2r_0[19|2]/a_460_290# sky130_fd_pr_reram__reram_cell area_ox=0.0676
X655 rr2t2r_0[19|2]/a_60_290# WL19 SL2 VSS sky130_fd_pr__nfet_g5v0d10v5 ad=0.65 pd=3.3 as=0 ps=0 w=1 l=0.5
X656 rr2t2r_0[20|2]/a_460_290# WL20 SL2 VSS sky130_fd_pr__nfet_g5v0d10v5 ad=0.65 pd=3.3 as=0 ps=0 w=1 l=0.5
X657 BLP2 rr2t2r_0[20|2]/a_60_290# sky130_fd_pr_reram__reram_cell area_ox=0.0676
X658 BLN2 rr2t2r_0[20|2]/a_460_290# sky130_fd_pr_reram__reram_cell area_ox=0.0676
X659 rr2t2r_0[20|2]/a_60_290# WL20 SL2 VSS sky130_fd_pr__nfet_g5v0d10v5 ad=0.65 pd=3.3 as=0 ps=0 w=1 l=0.5
X660 rr2t2r_0[21|2]/a_460_290# WL21 SL2 VSS sky130_fd_pr__nfet_g5v0d10v5 ad=0.65 pd=3.3 as=0 ps=0 w=1 l=0.5
X661 BLP2 rr2t2r_0[21|2]/a_60_290# sky130_fd_pr_reram__reram_cell area_ox=0.0676
X662 BLN2 rr2t2r_0[21|2]/a_460_290# sky130_fd_pr_reram__reram_cell area_ox=0.0676
X663 rr2t2r_0[21|2]/a_60_290# WL21 SL2 VSS sky130_fd_pr__nfet_g5v0d10v5 ad=0.65 pd=3.3 as=0 ps=0 w=1 l=0.5
X664 rr2t2r_0[22|2]/a_460_290# WL22 SL2 VSS sky130_fd_pr__nfet_g5v0d10v5 ad=0.65 pd=3.3 as=0 ps=0 w=1 l=0.5
X665 BLP2 rr2t2r_0[22|2]/a_60_290# sky130_fd_pr_reram__reram_cell area_ox=0.0676
X666 BLN2 rr2t2r_0[22|2]/a_460_290# sky130_fd_pr_reram__reram_cell area_ox=0.0676
X667 rr2t2r_0[22|2]/a_60_290# WL22 SL2 VSS sky130_fd_pr__nfet_g5v0d10v5 ad=0.65 pd=3.3 as=0 ps=0 w=1 l=0.5
X668 rr2t2r_0[23|2]/a_460_290# WL23 SL2 VSS sky130_fd_pr__nfet_g5v0d10v5 ad=0.65 pd=3.3 as=0 ps=0 w=1 l=0.5
X669 BLP2 rr2t2r_0[23|2]/a_60_290# sky130_fd_pr_reram__reram_cell area_ox=0.0676
X670 BLN2 rr2t2r_0[23|2]/a_460_290# sky130_fd_pr_reram__reram_cell area_ox=0.0676
X671 rr2t2r_0[23|2]/a_60_290# WL23 SL2 VSS sky130_fd_pr__nfet_g5v0d10v5 ad=0.65 pd=3.3 as=0 ps=0 w=1 l=0.5
X672 rr2t2r_0[24|2]/a_460_290# WL24 SL2 VSS sky130_fd_pr__nfet_g5v0d10v5 ad=0.65 pd=3.3 as=0 ps=0 w=1 l=0.5
X673 BLP2 rr2t2r_0[24|2]/a_60_290# sky130_fd_pr_reram__reram_cell area_ox=0.0676
X674 BLN2 rr2t2r_0[24|2]/a_460_290# sky130_fd_pr_reram__reram_cell area_ox=0.0676
X675 rr2t2r_0[24|2]/a_60_290# WL24 SL2 VSS sky130_fd_pr__nfet_g5v0d10v5 ad=0.65 pd=3.3 as=0 ps=0 w=1 l=0.5
X676 rr2t2r_0[25|2]/a_460_290# WL25 SL2 VSS sky130_fd_pr__nfet_g5v0d10v5 ad=0.65 pd=3.3 as=0 ps=0 w=1 l=0.5
X677 BLP2 rr2t2r_0[25|2]/a_60_290# sky130_fd_pr_reram__reram_cell area_ox=0.0676
X678 BLN2 rr2t2r_0[25|2]/a_460_290# sky130_fd_pr_reram__reram_cell area_ox=0.0676
X679 rr2t2r_0[25|2]/a_60_290# WL25 SL2 VSS sky130_fd_pr__nfet_g5v0d10v5 ad=0.65 pd=3.3 as=0 ps=0 w=1 l=0.5
X680 rr2t2r_0[26|2]/a_460_290# WL26 SL2 VSS sky130_fd_pr__nfet_g5v0d10v5 ad=0.65 pd=3.3 as=0 ps=0 w=1 l=0.5
X681 BLP2 rr2t2r_0[26|2]/a_60_290# sky130_fd_pr_reram__reram_cell area_ox=0.0676
X682 BLN2 rr2t2r_0[26|2]/a_460_290# sky130_fd_pr_reram__reram_cell area_ox=0.0676
X683 rr2t2r_0[26|2]/a_60_290# WL26 SL2 VSS sky130_fd_pr__nfet_g5v0d10v5 ad=0.65 pd=3.3 as=0 ps=0 w=1 l=0.5
X684 rr2t2r_0[27|2]/a_460_290# WL27 SL2 VSS sky130_fd_pr__nfet_g5v0d10v5 ad=0.65 pd=3.3 as=0 ps=0 w=1 l=0.5
X685 BLP2 rr2t2r_0[27|2]/a_60_290# sky130_fd_pr_reram__reram_cell area_ox=0.0676
X686 BLN2 rr2t2r_0[27|2]/a_460_290# sky130_fd_pr_reram__reram_cell area_ox=0.0676
X687 rr2t2r_0[27|2]/a_60_290# WL27 SL2 VSS sky130_fd_pr__nfet_g5v0d10v5 ad=0.65 pd=3.3 as=0 ps=0 w=1 l=0.5
X688 rr2t2r_0[28|2]/a_460_290# WL28 SL2 VSS sky130_fd_pr__nfet_g5v0d10v5 ad=0.65 pd=3.3 as=0 ps=0 w=1 l=0.5
X689 BLP2 rr2t2r_0[28|2]/a_60_290# sky130_fd_pr_reram__reram_cell area_ox=0.0676
X690 BLN2 rr2t2r_0[28|2]/a_460_290# sky130_fd_pr_reram__reram_cell area_ox=0.0676
X691 rr2t2r_0[28|2]/a_60_290# WL28 SL2 VSS sky130_fd_pr__nfet_g5v0d10v5 ad=0.65 pd=3.3 as=0 ps=0 w=1 l=0.5
X692 rr2t2r_0[29|2]/a_460_290# WL29 SL2 VSS sky130_fd_pr__nfet_g5v0d10v5 ad=0.65 pd=3.3 as=0 ps=0 w=1 l=0.5
X693 BLP2 rr2t2r_0[29|2]/a_60_290# sky130_fd_pr_reram__reram_cell area_ox=0.0676
X694 BLN2 rr2t2r_0[29|2]/a_460_290# sky130_fd_pr_reram__reram_cell area_ox=0.0676
X695 rr2t2r_0[29|2]/a_60_290# WL29 SL2 VSS sky130_fd_pr__nfet_g5v0d10v5 ad=0.65 pd=3.3 as=0 ps=0 w=1 l=0.5
X696 rr2t2r_0[30|2]/a_460_290# WL30 SL2 VSS sky130_fd_pr__nfet_g5v0d10v5 ad=0.65 pd=3.3 as=0 ps=0 w=1 l=0.5
X697 BLP2 rr2t2r_0[30|2]/a_60_290# sky130_fd_pr_reram__reram_cell area_ox=0.0676
X698 BLN2 rr2t2r_0[30|2]/a_460_290# sky130_fd_pr_reram__reram_cell area_ox=0.0676
X699 rr2t2r_0[30|2]/a_60_290# WL30 SL2 VSS sky130_fd_pr__nfet_g5v0d10v5 ad=0.65 pd=3.3 as=0 ps=0 w=1 l=0.5
X700 rr2t2r_0[31|2]/a_460_290# WL31 SL2 VSS sky130_fd_pr__nfet_g5v0d10v5 ad=0.65 pd=3.3 as=0 ps=0 w=1 l=0.5
X701 BLP2 rr2t2r_0[31|2]/a_60_290# sky130_fd_pr_reram__reram_cell area_ox=0.0676
X702 BLN2 rr2t2r_0[31|2]/a_460_290# sky130_fd_pr_reram__reram_cell area_ox=0.0676
X703 rr2t2r_0[31|2]/a_60_290# WL31 SL2 VSS sky130_fd_pr__nfet_g5v0d10v5 ad=0.65 pd=3.3 as=0 ps=0 w=1 l=0.5
X704 rr2t2r_0[32|2]/a_460_290# WL32 SL2 VSS sky130_fd_pr__nfet_g5v0d10v5 ad=0.65 pd=3.3 as=0 ps=0 w=1 l=0.5
X705 BLP2 rr2t2r_0[32|2]/a_60_290# sky130_fd_pr_reram__reram_cell area_ox=0.0676
X706 BLN2 rr2t2r_0[32|2]/a_460_290# sky130_fd_pr_reram__reram_cell area_ox=0.0676
X707 rr2t2r_0[32|2]/a_60_290# WL32 SL2 VSS sky130_fd_pr__nfet_g5v0d10v5 ad=0.65 pd=3.3 as=0 ps=0 w=1 l=0.5
X708 rr2t2r_0[33|2]/a_460_290# WL33 SL2 VSS sky130_fd_pr__nfet_g5v0d10v5 ad=0.65 pd=3.3 as=0 ps=0 w=1 l=0.5
X709 BLP2 rr2t2r_0[33|2]/a_60_290# sky130_fd_pr_reram__reram_cell area_ox=0.0676
X710 BLN2 rr2t2r_0[33|2]/a_460_290# sky130_fd_pr_reram__reram_cell area_ox=0.0676
X711 rr2t2r_0[33|2]/a_60_290# WL33 SL2 VSS sky130_fd_pr__nfet_g5v0d10v5 ad=0.65 pd=3.3 as=0 ps=0 w=1 l=0.5
X712 rr2t2r_0[34|2]/a_460_290# WL34 SL2 VSS sky130_fd_pr__nfet_g5v0d10v5 ad=0.65 pd=3.3 as=0 ps=0 w=1 l=0.5
X713 BLP2 rr2t2r_0[34|2]/a_60_290# sky130_fd_pr_reram__reram_cell area_ox=0.0676
X714 BLN2 rr2t2r_0[34|2]/a_460_290# sky130_fd_pr_reram__reram_cell area_ox=0.0676
X715 rr2t2r_0[34|2]/a_60_290# WL34 SL2 VSS sky130_fd_pr__nfet_g5v0d10v5 ad=0.65 pd=3.3 as=0 ps=0 w=1 l=0.5
X716 rr2t2r_0[35|2]/a_460_290# WL35 SL2 VSS sky130_fd_pr__nfet_g5v0d10v5 ad=0.65 pd=3.3 as=0 ps=0 w=1 l=0.5
X717 BLP2 rr2t2r_0[35|2]/a_60_290# sky130_fd_pr_reram__reram_cell area_ox=0.0676
X718 BLN2 rr2t2r_0[35|2]/a_460_290# sky130_fd_pr_reram__reram_cell area_ox=0.0676
X719 rr2t2r_0[35|2]/a_60_290# WL35 SL2 VSS sky130_fd_pr__nfet_g5v0d10v5 ad=0.65 pd=3.3 as=0 ps=0 w=1 l=0.5
X720 rr2t2r_0[36|2]/a_460_290# WL36 SL2 VSS sky130_fd_pr__nfet_g5v0d10v5 ad=0.65 pd=3.3 as=0 ps=0 w=1 l=0.5
X721 BLP2 rr2t2r_0[36|2]/a_60_290# sky130_fd_pr_reram__reram_cell area_ox=0.0676
X722 BLN2 rr2t2r_0[36|2]/a_460_290# sky130_fd_pr_reram__reram_cell area_ox=0.0676
X723 rr2t2r_0[36|2]/a_60_290# WL36 SL2 VSS sky130_fd_pr__nfet_g5v0d10v5 ad=0.65 pd=3.3 as=0 ps=0 w=1 l=0.5
X724 rr2t2r_0[37|2]/a_460_290# WL37 SL2 VSS sky130_fd_pr__nfet_g5v0d10v5 ad=0.65 pd=3.3 as=0 ps=0 w=1 l=0.5
X725 BLP2 rr2t2r_0[37|2]/a_60_290# sky130_fd_pr_reram__reram_cell area_ox=0.0676
X726 BLN2 rr2t2r_0[37|2]/a_460_290# sky130_fd_pr_reram__reram_cell area_ox=0.0676
X727 rr2t2r_0[37|2]/a_60_290# WL37 SL2 VSS sky130_fd_pr__nfet_g5v0d10v5 ad=0.65 pd=3.3 as=0 ps=0 w=1 l=0.5
X728 rr2t2r_0[38|2]/a_460_290# WL38 SL2 VSS sky130_fd_pr__nfet_g5v0d10v5 ad=0.65 pd=3.3 as=0 ps=0 w=1 l=0.5
X729 BLP2 rr2t2r_0[38|2]/a_60_290# sky130_fd_pr_reram__reram_cell area_ox=0.0676
X730 BLN2 rr2t2r_0[38|2]/a_460_290# sky130_fd_pr_reram__reram_cell area_ox=0.0676
X731 rr2t2r_0[38|2]/a_60_290# WL38 SL2 VSS sky130_fd_pr__nfet_g5v0d10v5 ad=0.65 pd=3.3 as=0 ps=0 w=1 l=0.5
X732 rr2t2r_0[39|2]/a_460_290# WL39 SL2 VSS sky130_fd_pr__nfet_g5v0d10v5 ad=0.65 pd=3.3 as=0 ps=0 w=1 l=0.5
X733 BLP2 rr2t2r_0[39|2]/a_60_290# sky130_fd_pr_reram__reram_cell area_ox=0.0676
X734 BLN2 rr2t2r_0[39|2]/a_460_290# sky130_fd_pr_reram__reram_cell area_ox=0.0676
X735 rr2t2r_0[39|2]/a_60_290# WL39 SL2 VSS sky130_fd_pr__nfet_g5v0d10v5 ad=0.65 pd=3.3 as=0 ps=0 w=1 l=0.5
X736 rr2t2r_0[40|2]/a_460_290# WL40 SL2 VSS sky130_fd_pr__nfet_g5v0d10v5 ad=0.65 pd=3.3 as=0 ps=0 w=1 l=0.5
X737 BLP2 rr2t2r_0[40|2]/a_60_290# sky130_fd_pr_reram__reram_cell area_ox=0.0676
X738 BLN2 rr2t2r_0[40|2]/a_460_290# sky130_fd_pr_reram__reram_cell area_ox=0.0676
X739 rr2t2r_0[40|2]/a_60_290# WL40 SL2 VSS sky130_fd_pr__nfet_g5v0d10v5 ad=0.65 pd=3.3 as=0 ps=0 w=1 l=0.5
X740 rr2t2r_0[41|2]/a_460_290# WL41 SL2 VSS sky130_fd_pr__nfet_g5v0d10v5 ad=0.65 pd=3.3 as=0 ps=0 w=1 l=0.5
X741 BLP2 rr2t2r_0[41|2]/a_60_290# sky130_fd_pr_reram__reram_cell area_ox=0.0676
X742 BLN2 rr2t2r_0[41|2]/a_460_290# sky130_fd_pr_reram__reram_cell area_ox=0.0676
X743 rr2t2r_0[41|2]/a_60_290# WL41 SL2 VSS sky130_fd_pr__nfet_g5v0d10v5 ad=0.65 pd=3.3 as=0 ps=0 w=1 l=0.5
X744 rr2t2r_0[42|2]/a_460_290# WL42 SL2 VSS sky130_fd_pr__nfet_g5v0d10v5 ad=0.65 pd=3.3 as=0 ps=0 w=1 l=0.5
X745 BLP2 rr2t2r_0[42|2]/a_60_290# sky130_fd_pr_reram__reram_cell area_ox=0.0676
X746 BLN2 rr2t2r_0[42|2]/a_460_290# sky130_fd_pr_reram__reram_cell area_ox=0.0676
X747 rr2t2r_0[42|2]/a_60_290# WL42 SL2 VSS sky130_fd_pr__nfet_g5v0d10v5 ad=0.65 pd=3.3 as=0 ps=0 w=1 l=0.5
X748 rr2t2r_0[43|2]/a_460_290# WL43 SL2 VSS sky130_fd_pr__nfet_g5v0d10v5 ad=0.65 pd=3.3 as=0 ps=0 w=1 l=0.5
X749 BLP2 rr2t2r_0[43|2]/a_60_290# sky130_fd_pr_reram__reram_cell area_ox=0.0676
X750 BLN2 rr2t2r_0[43|2]/a_460_290# sky130_fd_pr_reram__reram_cell area_ox=0.0676
X751 rr2t2r_0[43|2]/a_60_290# WL43 SL2 VSS sky130_fd_pr__nfet_g5v0d10v5 ad=0.65 pd=3.3 as=0 ps=0 w=1 l=0.5
X752 rr2t2r_0[44|2]/a_460_290# WL44 SL2 VSS sky130_fd_pr__nfet_g5v0d10v5 ad=0.65 pd=3.3 as=0 ps=0 w=1 l=0.5
X753 BLP2 rr2t2r_0[44|2]/a_60_290# sky130_fd_pr_reram__reram_cell area_ox=0.0676
X754 BLN2 rr2t2r_0[44|2]/a_460_290# sky130_fd_pr_reram__reram_cell area_ox=0.0676
X755 rr2t2r_0[44|2]/a_60_290# WL44 SL2 VSS sky130_fd_pr__nfet_g5v0d10v5 ad=0.65 pd=3.3 as=0 ps=0 w=1 l=0.5
X756 rr2t2r_0[45|2]/a_460_290# WL45 SL2 VSS sky130_fd_pr__nfet_g5v0d10v5 ad=0.65 pd=3.3 as=0 ps=0 w=1 l=0.5
X757 BLP2 rr2t2r_0[45|2]/a_60_290# sky130_fd_pr_reram__reram_cell area_ox=0.0676
X758 BLN2 rr2t2r_0[45|2]/a_460_290# sky130_fd_pr_reram__reram_cell area_ox=0.0676
X759 rr2t2r_0[45|2]/a_60_290# WL45 SL2 VSS sky130_fd_pr__nfet_g5v0d10v5 ad=0.65 pd=3.3 as=0 ps=0 w=1 l=0.5
X760 rr2t2r_0[46|2]/a_460_290# WL46 SL2 VSS sky130_fd_pr__nfet_g5v0d10v5 ad=0.65 pd=3.3 as=0 ps=0 w=1 l=0.5
X761 BLP2 rr2t2r_0[46|2]/a_60_290# sky130_fd_pr_reram__reram_cell area_ox=0.0676
X762 BLN2 rr2t2r_0[46|2]/a_460_290# sky130_fd_pr_reram__reram_cell area_ox=0.0676
X763 rr2t2r_0[46|2]/a_60_290# WL46 SL2 VSS sky130_fd_pr__nfet_g5v0d10v5 ad=0.65 pd=3.3 as=0 ps=0 w=1 l=0.5
X764 rr2t2r_0[47|2]/a_460_290# WL47 SL2 VSS sky130_fd_pr__nfet_g5v0d10v5 ad=0.65 pd=3.3 as=0 ps=0 w=1 l=0.5
X765 BLP2 rr2t2r_0[47|2]/a_60_290# sky130_fd_pr_reram__reram_cell area_ox=0.0676
X766 BLN2 rr2t2r_0[47|2]/a_460_290# sky130_fd_pr_reram__reram_cell area_ox=0.0676
X767 rr2t2r_0[47|2]/a_60_290# WL47 SL2 VSS sky130_fd_pr__nfet_g5v0d10v5 ad=0.65 pd=3.3 as=0 ps=0 w=1 l=0.5
X768 rr2t2r_0[48|2]/a_460_290# WL48 SL2 VSS sky130_fd_pr__nfet_g5v0d10v5 ad=0.65 pd=3.3 as=0 ps=0 w=1 l=0.5
X769 BLP2 rr2t2r_0[48|2]/a_60_290# sky130_fd_pr_reram__reram_cell area_ox=0.0676
X770 BLN2 rr2t2r_0[48|2]/a_460_290# sky130_fd_pr_reram__reram_cell area_ox=0.0676
X771 rr2t2r_0[48|2]/a_60_290# WL48 SL2 VSS sky130_fd_pr__nfet_g5v0d10v5 ad=0.65 pd=3.3 as=0 ps=0 w=1 l=0.5
X772 rr2t2r_0[49|2]/a_460_290# WL49 SL2 VSS sky130_fd_pr__nfet_g5v0d10v5 ad=0.65 pd=3.3 as=0 ps=0 w=1 l=0.5
X773 BLP2 rr2t2r_0[49|2]/a_60_290# sky130_fd_pr_reram__reram_cell area_ox=0.0676
X774 BLN2 rr2t2r_0[49|2]/a_460_290# sky130_fd_pr_reram__reram_cell area_ox=0.0676
X775 rr2t2r_0[49|2]/a_60_290# WL49 SL2 VSS sky130_fd_pr__nfet_g5v0d10v5 ad=0.65 pd=3.3 as=0 ps=0 w=1 l=0.5
X776 rr2t2r_0[50|2]/a_460_290# WL50 SL2 VSS sky130_fd_pr__nfet_g5v0d10v5 ad=0.65 pd=3.3 as=0 ps=0 w=1 l=0.5
X777 BLP2 rr2t2r_0[50|2]/a_60_290# sky130_fd_pr_reram__reram_cell area_ox=0.0676
X778 BLN2 rr2t2r_0[50|2]/a_460_290# sky130_fd_pr_reram__reram_cell area_ox=0.0676
X779 rr2t2r_0[50|2]/a_60_290# WL50 SL2 VSS sky130_fd_pr__nfet_g5v0d10v5 ad=0.65 pd=3.3 as=0 ps=0 w=1 l=0.5
X780 rr2t2r_0[51|2]/a_460_290# WL51 SL2 VSS sky130_fd_pr__nfet_g5v0d10v5 ad=0.65 pd=3.3 as=0 ps=0 w=1 l=0.5
X781 BLP2 rr2t2r_0[51|2]/a_60_290# sky130_fd_pr_reram__reram_cell area_ox=0.0676
X782 BLN2 rr2t2r_0[51|2]/a_460_290# sky130_fd_pr_reram__reram_cell area_ox=0.0676
X783 rr2t2r_0[51|2]/a_60_290# WL51 SL2 VSS sky130_fd_pr__nfet_g5v0d10v5 ad=0.65 pd=3.3 as=0 ps=0 w=1 l=0.5
X784 rr2t2r_0[52|2]/a_460_290# WL52 SL2 VSS sky130_fd_pr__nfet_g5v0d10v5 ad=0.65 pd=3.3 as=0 ps=0 w=1 l=0.5
X785 BLP2 rr2t2r_0[52|2]/a_60_290# sky130_fd_pr_reram__reram_cell area_ox=0.0676
X786 BLN2 rr2t2r_0[52|2]/a_460_290# sky130_fd_pr_reram__reram_cell area_ox=0.0676
X787 rr2t2r_0[52|2]/a_60_290# WL52 SL2 VSS sky130_fd_pr__nfet_g5v0d10v5 ad=0.65 pd=3.3 as=0 ps=0 w=1 l=0.5
X788 rr2t2r_0[53|2]/a_460_290# WL53 SL2 VSS sky130_fd_pr__nfet_g5v0d10v5 ad=0.65 pd=3.3 as=0 ps=0 w=1 l=0.5
X789 BLP2 rr2t2r_0[53|2]/a_60_290# sky130_fd_pr_reram__reram_cell area_ox=0.0676
X790 BLN2 rr2t2r_0[53|2]/a_460_290# sky130_fd_pr_reram__reram_cell area_ox=0.0676
X791 rr2t2r_0[53|2]/a_60_290# WL53 SL2 VSS sky130_fd_pr__nfet_g5v0d10v5 ad=0.65 pd=3.3 as=0 ps=0 w=1 l=0.5
X792 rr2t2r_0[54|2]/a_460_290# WL54 SL2 VSS sky130_fd_pr__nfet_g5v0d10v5 ad=0.65 pd=3.3 as=0 ps=0 w=1 l=0.5
X793 BLP2 rr2t2r_0[54|2]/a_60_290# sky130_fd_pr_reram__reram_cell area_ox=0.0676
X794 BLN2 rr2t2r_0[54|2]/a_460_290# sky130_fd_pr_reram__reram_cell area_ox=0.0676
X795 rr2t2r_0[54|2]/a_60_290# WL54 SL2 VSS sky130_fd_pr__nfet_g5v0d10v5 ad=0.65 pd=3.3 as=0 ps=0 w=1 l=0.5
X796 rr2t2r_0[55|2]/a_460_290# WL55 SL2 VSS sky130_fd_pr__nfet_g5v0d10v5 ad=0.65 pd=3.3 as=0 ps=0 w=1 l=0.5
X797 BLP2 rr2t2r_0[55|2]/a_60_290# sky130_fd_pr_reram__reram_cell area_ox=0.0676
X798 BLN2 rr2t2r_0[55|2]/a_460_290# sky130_fd_pr_reram__reram_cell area_ox=0.0676
X799 rr2t2r_0[55|2]/a_60_290# WL55 SL2 VSS sky130_fd_pr__nfet_g5v0d10v5 ad=0.65 pd=3.3 as=0 ps=0 w=1 l=0.5
X800 rr2t2r_0[56|2]/a_460_290# WL56 SL2 VSS sky130_fd_pr__nfet_g5v0d10v5 ad=0.65 pd=3.3 as=0 ps=0 w=1 l=0.5
X801 BLP2 rr2t2r_0[56|2]/a_60_290# sky130_fd_pr_reram__reram_cell area_ox=0.0676
X802 BLN2 rr2t2r_0[56|2]/a_460_290# sky130_fd_pr_reram__reram_cell area_ox=0.0676
X803 rr2t2r_0[56|2]/a_60_290# WL56 SL2 VSS sky130_fd_pr__nfet_g5v0d10v5 ad=0.65 pd=3.3 as=0 ps=0 w=1 l=0.5
X804 rr2t2r_0[57|2]/a_460_290# WL57 SL2 VSS sky130_fd_pr__nfet_g5v0d10v5 ad=0.65 pd=3.3 as=0 ps=0 w=1 l=0.5
X805 BLP2 rr2t2r_0[57|2]/a_60_290# sky130_fd_pr_reram__reram_cell area_ox=0.0676
X806 BLN2 rr2t2r_0[57|2]/a_460_290# sky130_fd_pr_reram__reram_cell area_ox=0.0676
X807 rr2t2r_0[57|2]/a_60_290# WL57 SL2 VSS sky130_fd_pr__nfet_g5v0d10v5 ad=0.65 pd=3.3 as=0 ps=0 w=1 l=0.5
X808 rr2t2r_0[58|2]/a_460_290# WL58 SL2 VSS sky130_fd_pr__nfet_g5v0d10v5 ad=0.65 pd=3.3 as=0 ps=0 w=1 l=0.5
X809 BLP2 rr2t2r_0[58|2]/a_60_290# sky130_fd_pr_reram__reram_cell area_ox=0.0676
X810 BLN2 rr2t2r_0[58|2]/a_460_290# sky130_fd_pr_reram__reram_cell area_ox=0.0676
X811 rr2t2r_0[58|2]/a_60_290# WL58 SL2 VSS sky130_fd_pr__nfet_g5v0d10v5 ad=0.65 pd=3.3 as=0 ps=0 w=1 l=0.5
X812 rr2t2r_0[59|2]/a_460_290# WL59 SL2 VSS sky130_fd_pr__nfet_g5v0d10v5 ad=0.65 pd=3.3 as=0 ps=0 w=1 l=0.5
X813 BLP2 rr2t2r_0[59|2]/a_60_290# sky130_fd_pr_reram__reram_cell area_ox=0.0676
X814 BLN2 rr2t2r_0[59|2]/a_460_290# sky130_fd_pr_reram__reram_cell area_ox=0.0676
X815 rr2t2r_0[59|2]/a_60_290# WL59 SL2 VSS sky130_fd_pr__nfet_g5v0d10v5 ad=0.65 pd=3.3 as=0 ps=0 w=1 l=0.5
X816 rr2t2r_0[60|2]/a_460_290# WL60 SL2 VSS sky130_fd_pr__nfet_g5v0d10v5 ad=0.65 pd=3.3 as=0 ps=0 w=1 l=0.5
X817 BLP2 rr2t2r_0[60|2]/a_60_290# sky130_fd_pr_reram__reram_cell area_ox=0.0676
X818 BLN2 rr2t2r_0[60|2]/a_460_290# sky130_fd_pr_reram__reram_cell area_ox=0.0676
X819 rr2t2r_0[60|2]/a_60_290# WL60 SL2 VSS sky130_fd_pr__nfet_g5v0d10v5 ad=0.65 pd=3.3 as=0 ps=0 w=1 l=0.5
X820 rr2t2r_0[61|2]/a_460_290# WL61 SL2 VSS sky130_fd_pr__nfet_g5v0d10v5 ad=0.65 pd=3.3 as=0 ps=0 w=1 l=0.5
X821 BLP2 rr2t2r_0[61|2]/a_60_290# sky130_fd_pr_reram__reram_cell area_ox=0.0676
X822 BLN2 rr2t2r_0[61|2]/a_460_290# sky130_fd_pr_reram__reram_cell area_ox=0.0676
X823 rr2t2r_0[61|2]/a_60_290# WL61 SL2 VSS sky130_fd_pr__nfet_g5v0d10v5 ad=0.65 pd=3.3 as=0 ps=0 w=1 l=0.5
X824 rr2t2r_0[62|2]/a_460_290# WL62 SL2 VSS sky130_fd_pr__nfet_g5v0d10v5 ad=0.65 pd=3.3 as=0 ps=0 w=1 l=0.5
X825 BLP2 rr2t2r_0[62|2]/a_60_290# sky130_fd_pr_reram__reram_cell area_ox=0.0676
X826 BLN2 rr2t2r_0[62|2]/a_460_290# sky130_fd_pr_reram__reram_cell area_ox=0.0676
X827 rr2t2r_0[62|2]/a_60_290# WL62 SL2 VSS sky130_fd_pr__nfet_g5v0d10v5 ad=0.65 pd=3.3 as=0 ps=0 w=1 l=0.5
X828 rr2t2r_0[63|2]/a_460_290# WL63 SL2 VSS sky130_fd_pr__nfet_g5v0d10v5 ad=0.65 pd=3.3 as=0 ps=0 w=1 l=0.5
X829 BLP2 rr2t2r_0[63|2]/a_60_290# sky130_fd_pr_reram__reram_cell area_ox=0.0676
X830 BLN2 rr2t2r_0[63|2]/a_460_290# sky130_fd_pr_reram__reram_cell area_ox=0.0676
X831 rr2t2r_0[63|2]/a_60_290# WL63 SL2 VSS sky130_fd_pr__nfet_g5v0d10v5 ad=0.65 pd=3.3 as=0 ps=0 w=1 l=0.5
X832 rr2t2r_0[64|2]/a_460_290# WL64 SL2 VSS sky130_fd_pr__nfet_g5v0d10v5 ad=0.65 pd=3.3 as=0 ps=0 w=1 l=0.5
X833 BLP2 rr2t2r_0[64|2]/a_60_290# sky130_fd_pr_reram__reram_cell area_ox=0.0676
X834 BLN2 rr2t2r_0[64|2]/a_460_290# sky130_fd_pr_reram__reram_cell area_ox=0.0676
X835 rr2t2r_0[64|2]/a_60_290# WL64 SL2 VSS sky130_fd_pr__nfet_g5v0d10v5 ad=0.65 pd=3.3 as=0 ps=0 w=1 l=0.5
X836 rr2t2r_0[65|2]/a_460_290# WL65 SL2 VSS sky130_fd_pr__nfet_g5v0d10v5 ad=0.65 pd=3.3 as=0 ps=0 w=1 l=0.5
X837 BLP2 rr2t2r_0[65|2]/a_60_290# sky130_fd_pr_reram__reram_cell area_ox=0.0676
X838 BLN2 rr2t2r_0[65|2]/a_460_290# sky130_fd_pr_reram__reram_cell area_ox=0.0676
X839 rr2t2r_0[65|2]/a_60_290# WL65 SL2 VSS sky130_fd_pr__nfet_g5v0d10v5 ad=0.65 pd=3.3 as=0 ps=0 w=1 l=0.5
X840 rr2t2r_0[66|2]/a_460_290# WL66 SL2 VSS sky130_fd_pr__nfet_g5v0d10v5 ad=0.65 pd=3.3 as=0 ps=0 w=1 l=0.5
X841 BLP2 rr2t2r_0[66|2]/a_60_290# sky130_fd_pr_reram__reram_cell area_ox=0.0676
X842 BLN2 rr2t2r_0[66|2]/a_460_290# sky130_fd_pr_reram__reram_cell area_ox=0.0676
X843 rr2t2r_0[66|2]/a_60_290# WL66 SL2 VSS sky130_fd_pr__nfet_g5v0d10v5 ad=0.65 pd=3.3 as=0 ps=0 w=1 l=0.5
X844 rr2t2r_0[67|2]/a_460_290# WL67 SL2 VSS sky130_fd_pr__nfet_g5v0d10v5 ad=0.65 pd=3.3 as=0 ps=0 w=1 l=0.5
X845 BLP2 rr2t2r_0[67|2]/a_60_290# sky130_fd_pr_reram__reram_cell area_ox=0.0676
X846 BLN2 rr2t2r_0[67|2]/a_460_290# sky130_fd_pr_reram__reram_cell area_ox=0.0676
X847 rr2t2r_0[67|2]/a_60_290# WL67 SL2 VSS sky130_fd_pr__nfet_g5v0d10v5 ad=0.65 pd=3.3 as=0 ps=0 w=1 l=0.5
X848 rr2t2r_0[68|2]/a_460_290# WL68 SL2 VSS sky130_fd_pr__nfet_g5v0d10v5 ad=0.65 pd=3.3 as=0 ps=0 w=1 l=0.5
X849 BLP2 rr2t2r_0[68|2]/a_60_290# sky130_fd_pr_reram__reram_cell area_ox=0.0676
X850 BLN2 rr2t2r_0[68|2]/a_460_290# sky130_fd_pr_reram__reram_cell area_ox=0.0676
X851 rr2t2r_0[68|2]/a_60_290# WL68 SL2 VSS sky130_fd_pr__nfet_g5v0d10v5 ad=0.65 pd=3.3 as=0 ps=0 w=1 l=0.5
X852 rr2t2r_0[69|2]/a_460_290# WL69 SL2 VSS sky130_fd_pr__nfet_g5v0d10v5 ad=0.65 pd=3.3 as=0 ps=0 w=1 l=0.5
X853 BLP2 rr2t2r_0[69|2]/a_60_290# sky130_fd_pr_reram__reram_cell area_ox=0.0676
X854 BLN2 rr2t2r_0[69|2]/a_460_290# sky130_fd_pr_reram__reram_cell area_ox=0.0676
X855 rr2t2r_0[69|2]/a_60_290# WL69 SL2 VSS sky130_fd_pr__nfet_g5v0d10v5 ad=0.65 pd=3.3 as=0 ps=0 w=1 l=0.5
X856 rr2t2r_0[70|2]/a_460_290# WL70 SL2 VSS sky130_fd_pr__nfet_g5v0d10v5 ad=0.65 pd=3.3 as=0 ps=0 w=1 l=0.5
X857 BLP2 rr2t2r_0[70|2]/a_60_290# sky130_fd_pr_reram__reram_cell area_ox=0.0676
X858 BLN2 rr2t2r_0[70|2]/a_460_290# sky130_fd_pr_reram__reram_cell area_ox=0.0676
X859 rr2t2r_0[70|2]/a_60_290# WL70 SL2 VSS sky130_fd_pr__nfet_g5v0d10v5 ad=0.65 pd=3.3 as=0 ps=0 w=1 l=0.5
X860 rr2t2r_0[71|2]/a_460_290# WL71 SL2 VSS sky130_fd_pr__nfet_g5v0d10v5 ad=0.65 pd=3.3 as=0 ps=0 w=1 l=0.5
X861 BLP2 rr2t2r_0[71|2]/a_60_290# sky130_fd_pr_reram__reram_cell area_ox=0.0676
X862 BLN2 rr2t2r_0[71|2]/a_460_290# sky130_fd_pr_reram__reram_cell area_ox=0.0676
X863 rr2t2r_0[71|2]/a_60_290# WL71 SL2 VSS sky130_fd_pr__nfet_g5v0d10v5 ad=0.65 pd=3.3 as=0 ps=0 w=1 l=0.5
X864 rr2t2r_0[0|3]/a_460_290# WL0 SL3 VSS sky130_fd_pr__nfet_g5v0d10v5 ad=0.65 pd=3.3 as=108 ps=504 w=1 l=0.5
X865 BLP3 rr2t2r_0[0|3]/a_60_290# sky130_fd_pr_reram__reram_cell area_ox=0.0676
X866 BLN3 rr2t2r_0[0|3]/a_460_290# sky130_fd_pr_reram__reram_cell area_ox=0.0676
X867 rr2t2r_0[0|3]/a_60_290# WL0 SL3 VSS sky130_fd_pr__nfet_g5v0d10v5 ad=0.65 pd=3.3 as=0 ps=0 w=1 l=0.5
X868 rr2t2r_0[1|3]/a_460_290# WL1 SL3 VSS sky130_fd_pr__nfet_g5v0d10v5 ad=0.65 pd=3.3 as=0 ps=0 w=1 l=0.5
X869 BLP3 rr2t2r_0[1|3]/a_60_290# sky130_fd_pr_reram__reram_cell area_ox=0.0676
X870 BLN3 rr2t2r_0[1|3]/a_460_290# sky130_fd_pr_reram__reram_cell area_ox=0.0676
X871 rr2t2r_0[1|3]/a_60_290# WL1 SL3 VSS sky130_fd_pr__nfet_g5v0d10v5 ad=0.65 pd=3.3 as=0 ps=0 w=1 l=0.5
X872 rr2t2r_0[2|3]/a_460_290# WL2 SL3 VSS sky130_fd_pr__nfet_g5v0d10v5 ad=0.65 pd=3.3 as=0 ps=0 w=1 l=0.5
X873 BLP3 rr2t2r_0[2|3]/a_60_290# sky130_fd_pr_reram__reram_cell area_ox=0.0676
X874 BLN3 rr2t2r_0[2|3]/a_460_290# sky130_fd_pr_reram__reram_cell area_ox=0.0676
X875 rr2t2r_0[2|3]/a_60_290# WL2 SL3 VSS sky130_fd_pr__nfet_g5v0d10v5 ad=0.65 pd=3.3 as=0 ps=0 w=1 l=0.5
X876 rr2t2r_0[3|3]/a_460_290# WL3 SL3 VSS sky130_fd_pr__nfet_g5v0d10v5 ad=0.65 pd=3.3 as=0 ps=0 w=1 l=0.5
X877 BLP3 rr2t2r_0[3|3]/a_60_290# sky130_fd_pr_reram__reram_cell area_ox=0.0676
X878 BLN3 rr2t2r_0[3|3]/a_460_290# sky130_fd_pr_reram__reram_cell area_ox=0.0676
X879 rr2t2r_0[3|3]/a_60_290# WL3 SL3 VSS sky130_fd_pr__nfet_g5v0d10v5 ad=0.65 pd=3.3 as=0 ps=0 w=1 l=0.5
X880 rr2t2r_0[4|3]/a_460_290# WL4 SL3 VSS sky130_fd_pr__nfet_g5v0d10v5 ad=0.65 pd=3.3 as=0 ps=0 w=1 l=0.5
X881 BLP3 rr2t2r_0[4|3]/a_60_290# sky130_fd_pr_reram__reram_cell area_ox=0.0676
X882 BLN3 rr2t2r_0[4|3]/a_460_290# sky130_fd_pr_reram__reram_cell area_ox=0.0676
X883 rr2t2r_0[4|3]/a_60_290# WL4 SL3 VSS sky130_fd_pr__nfet_g5v0d10v5 ad=0.65 pd=3.3 as=0 ps=0 w=1 l=0.5
X884 rr2t2r_0[5|3]/a_460_290# WL5 SL3 VSS sky130_fd_pr__nfet_g5v0d10v5 ad=0.65 pd=3.3 as=0 ps=0 w=1 l=0.5
X885 BLP3 rr2t2r_0[5|3]/a_60_290# sky130_fd_pr_reram__reram_cell area_ox=0.0676
X886 BLN3 rr2t2r_0[5|3]/a_460_290# sky130_fd_pr_reram__reram_cell area_ox=0.0676
X887 rr2t2r_0[5|3]/a_60_290# WL5 SL3 VSS sky130_fd_pr__nfet_g5v0d10v5 ad=0.65 pd=3.3 as=0 ps=0 w=1 l=0.5
X888 rr2t2r_0[6|3]/a_460_290# WL6 SL3 VSS sky130_fd_pr__nfet_g5v0d10v5 ad=0.65 pd=3.3 as=0 ps=0 w=1 l=0.5
X889 BLP3 rr2t2r_0[6|3]/a_60_290# sky130_fd_pr_reram__reram_cell area_ox=0.0676
X890 BLN3 rr2t2r_0[6|3]/a_460_290# sky130_fd_pr_reram__reram_cell area_ox=0.0676
X891 rr2t2r_0[6|3]/a_60_290# WL6 SL3 VSS sky130_fd_pr__nfet_g5v0d10v5 ad=0.65 pd=3.3 as=0 ps=0 w=1 l=0.5
X892 rr2t2r_0[7|3]/a_460_290# WL7 SL3 VSS sky130_fd_pr__nfet_g5v0d10v5 ad=0.65 pd=3.3 as=0 ps=0 w=1 l=0.5
X893 BLP3 rr2t2r_0[7|3]/a_60_290# sky130_fd_pr_reram__reram_cell area_ox=0.0676
X894 BLN3 rr2t2r_0[7|3]/a_460_290# sky130_fd_pr_reram__reram_cell area_ox=0.0676
X895 rr2t2r_0[7|3]/a_60_290# WL7 SL3 VSS sky130_fd_pr__nfet_g5v0d10v5 ad=0.65 pd=3.3 as=0 ps=0 w=1 l=0.5
X896 rr2t2r_0[8|3]/a_460_290# WL8 SL3 VSS sky130_fd_pr__nfet_g5v0d10v5 ad=0.65 pd=3.3 as=0 ps=0 w=1 l=0.5
X897 BLP3 rr2t2r_0[8|3]/a_60_290# sky130_fd_pr_reram__reram_cell area_ox=0.0676
X898 BLN3 rr2t2r_0[8|3]/a_460_290# sky130_fd_pr_reram__reram_cell area_ox=0.0676
X899 rr2t2r_0[8|3]/a_60_290# WL8 SL3 VSS sky130_fd_pr__nfet_g5v0d10v5 ad=0.65 pd=3.3 as=0 ps=0 w=1 l=0.5
X900 rr2t2r_0[9|3]/a_460_290# WL9 SL3 VSS sky130_fd_pr__nfet_g5v0d10v5 ad=0.65 pd=3.3 as=0 ps=0 w=1 l=0.5
X901 BLP3 rr2t2r_0[9|3]/a_60_290# sky130_fd_pr_reram__reram_cell area_ox=0.0676
X902 BLN3 rr2t2r_0[9|3]/a_460_290# sky130_fd_pr_reram__reram_cell area_ox=0.0676
X903 rr2t2r_0[9|3]/a_60_290# WL9 SL3 VSS sky130_fd_pr__nfet_g5v0d10v5 ad=0.65 pd=3.3 as=0 ps=0 w=1 l=0.5
X904 rr2t2r_0[10|3]/a_460_290# WL10 SL3 VSS sky130_fd_pr__nfet_g5v0d10v5 ad=0.65 pd=3.3 as=0 ps=0 w=1 l=0.5
X905 BLP3 rr2t2r_0[10|3]/a_60_290# sky130_fd_pr_reram__reram_cell area_ox=0.0676
X906 BLN3 rr2t2r_0[10|3]/a_460_290# sky130_fd_pr_reram__reram_cell area_ox=0.0676
X907 rr2t2r_0[10|3]/a_60_290# WL10 SL3 VSS sky130_fd_pr__nfet_g5v0d10v5 ad=0.65 pd=3.3 as=0 ps=0 w=1 l=0.5
X908 rr2t2r_0[11|3]/a_460_290# WL11 SL3 VSS sky130_fd_pr__nfet_g5v0d10v5 ad=0.65 pd=3.3 as=0 ps=0 w=1 l=0.5
X909 BLP3 rr2t2r_0[11|3]/a_60_290# sky130_fd_pr_reram__reram_cell area_ox=0.0676
X910 BLN3 rr2t2r_0[11|3]/a_460_290# sky130_fd_pr_reram__reram_cell area_ox=0.0676
X911 rr2t2r_0[11|3]/a_60_290# WL11 SL3 VSS sky130_fd_pr__nfet_g5v0d10v5 ad=0.65 pd=3.3 as=0 ps=0 w=1 l=0.5
X912 rr2t2r_0[12|3]/a_460_290# WL12 SL3 VSS sky130_fd_pr__nfet_g5v0d10v5 ad=0.65 pd=3.3 as=0 ps=0 w=1 l=0.5
X913 BLP3 rr2t2r_0[12|3]/a_60_290# sky130_fd_pr_reram__reram_cell area_ox=0.0676
X914 BLN3 rr2t2r_0[12|3]/a_460_290# sky130_fd_pr_reram__reram_cell area_ox=0.0676
X915 rr2t2r_0[12|3]/a_60_290# WL12 SL3 VSS sky130_fd_pr__nfet_g5v0d10v5 ad=0.65 pd=3.3 as=0 ps=0 w=1 l=0.5
X916 rr2t2r_0[13|3]/a_460_290# WL13 SL3 VSS sky130_fd_pr__nfet_g5v0d10v5 ad=0.65 pd=3.3 as=0 ps=0 w=1 l=0.5
X917 BLP3 rr2t2r_0[13|3]/a_60_290# sky130_fd_pr_reram__reram_cell area_ox=0.0676
X918 BLN3 rr2t2r_0[13|3]/a_460_290# sky130_fd_pr_reram__reram_cell area_ox=0.0676
X919 rr2t2r_0[13|3]/a_60_290# WL13 SL3 VSS sky130_fd_pr__nfet_g5v0d10v5 ad=0.65 pd=3.3 as=0 ps=0 w=1 l=0.5
X920 rr2t2r_0[14|3]/a_460_290# WL14 SL3 VSS sky130_fd_pr__nfet_g5v0d10v5 ad=0.65 pd=3.3 as=0 ps=0 w=1 l=0.5
X921 BLP3 rr2t2r_0[14|3]/a_60_290# sky130_fd_pr_reram__reram_cell area_ox=0.0676
X922 BLN3 rr2t2r_0[14|3]/a_460_290# sky130_fd_pr_reram__reram_cell area_ox=0.0676
X923 rr2t2r_0[14|3]/a_60_290# WL14 SL3 VSS sky130_fd_pr__nfet_g5v0d10v5 ad=0.65 pd=3.3 as=0 ps=0 w=1 l=0.5
X924 rr2t2r_0[15|3]/a_460_290# WL15 SL3 VSS sky130_fd_pr__nfet_g5v0d10v5 ad=0.65 pd=3.3 as=0 ps=0 w=1 l=0.5
X925 BLP3 rr2t2r_0[15|3]/a_60_290# sky130_fd_pr_reram__reram_cell area_ox=0.0676
X926 BLN3 rr2t2r_0[15|3]/a_460_290# sky130_fd_pr_reram__reram_cell area_ox=0.0676
X927 rr2t2r_0[15|3]/a_60_290# WL15 SL3 VSS sky130_fd_pr__nfet_g5v0d10v5 ad=0.65 pd=3.3 as=0 ps=0 w=1 l=0.5
X928 rr2t2r_0[16|3]/a_460_290# WL16 SL3 VSS sky130_fd_pr__nfet_g5v0d10v5 ad=0.65 pd=3.3 as=0 ps=0 w=1 l=0.5
X929 BLP3 rr2t2r_0[16|3]/a_60_290# sky130_fd_pr_reram__reram_cell area_ox=0.0676
X930 BLN3 rr2t2r_0[16|3]/a_460_290# sky130_fd_pr_reram__reram_cell area_ox=0.0676
X931 rr2t2r_0[16|3]/a_60_290# WL16 SL3 VSS sky130_fd_pr__nfet_g5v0d10v5 ad=0.65 pd=3.3 as=0 ps=0 w=1 l=0.5
X932 rr2t2r_0[17|3]/a_460_290# WL17 SL3 VSS sky130_fd_pr__nfet_g5v0d10v5 ad=0.65 pd=3.3 as=0 ps=0 w=1 l=0.5
X933 BLP3 rr2t2r_0[17|3]/a_60_290# sky130_fd_pr_reram__reram_cell area_ox=0.0676
X934 BLN3 rr2t2r_0[17|3]/a_460_290# sky130_fd_pr_reram__reram_cell area_ox=0.0676
X935 rr2t2r_0[17|3]/a_60_290# WL17 SL3 VSS sky130_fd_pr__nfet_g5v0d10v5 ad=0.65 pd=3.3 as=0 ps=0 w=1 l=0.5
X936 rr2t2r_0[18|3]/a_460_290# WL18 SL3 VSS sky130_fd_pr__nfet_g5v0d10v5 ad=0.65 pd=3.3 as=0 ps=0 w=1 l=0.5
X937 BLP3 rr2t2r_0[18|3]/a_60_290# sky130_fd_pr_reram__reram_cell area_ox=0.0676
X938 BLN3 rr2t2r_0[18|3]/a_460_290# sky130_fd_pr_reram__reram_cell area_ox=0.0676
X939 rr2t2r_0[18|3]/a_60_290# WL18 SL3 VSS sky130_fd_pr__nfet_g5v0d10v5 ad=0.65 pd=3.3 as=0 ps=0 w=1 l=0.5
X940 rr2t2r_0[19|3]/a_460_290# WL19 SL3 VSS sky130_fd_pr__nfet_g5v0d10v5 ad=0.65 pd=3.3 as=0 ps=0 w=1 l=0.5
X941 BLP3 rr2t2r_0[19|3]/a_60_290# sky130_fd_pr_reram__reram_cell area_ox=0.0676
X942 BLN3 rr2t2r_0[19|3]/a_460_290# sky130_fd_pr_reram__reram_cell area_ox=0.0676
X943 rr2t2r_0[19|3]/a_60_290# WL19 SL3 VSS sky130_fd_pr__nfet_g5v0d10v5 ad=0.65 pd=3.3 as=0 ps=0 w=1 l=0.5
X944 rr2t2r_0[20|3]/a_460_290# WL20 SL3 VSS sky130_fd_pr__nfet_g5v0d10v5 ad=0.65 pd=3.3 as=0 ps=0 w=1 l=0.5
X945 BLP3 rr2t2r_0[20|3]/a_60_290# sky130_fd_pr_reram__reram_cell area_ox=0.0676
X946 BLN3 rr2t2r_0[20|3]/a_460_290# sky130_fd_pr_reram__reram_cell area_ox=0.0676
X947 rr2t2r_0[20|3]/a_60_290# WL20 SL3 VSS sky130_fd_pr__nfet_g5v0d10v5 ad=0.65 pd=3.3 as=0 ps=0 w=1 l=0.5
X948 rr2t2r_0[21|3]/a_460_290# WL21 SL3 VSS sky130_fd_pr__nfet_g5v0d10v5 ad=0.65 pd=3.3 as=0 ps=0 w=1 l=0.5
X949 BLP3 rr2t2r_0[21|3]/a_60_290# sky130_fd_pr_reram__reram_cell area_ox=0.0676
X950 BLN3 rr2t2r_0[21|3]/a_460_290# sky130_fd_pr_reram__reram_cell area_ox=0.0676
X951 rr2t2r_0[21|3]/a_60_290# WL21 SL3 VSS sky130_fd_pr__nfet_g5v0d10v5 ad=0.65 pd=3.3 as=0 ps=0 w=1 l=0.5
X952 rr2t2r_0[22|3]/a_460_290# WL22 SL3 VSS sky130_fd_pr__nfet_g5v0d10v5 ad=0.65 pd=3.3 as=0 ps=0 w=1 l=0.5
X953 BLP3 rr2t2r_0[22|3]/a_60_290# sky130_fd_pr_reram__reram_cell area_ox=0.0676
X954 BLN3 rr2t2r_0[22|3]/a_460_290# sky130_fd_pr_reram__reram_cell area_ox=0.0676
X955 rr2t2r_0[22|3]/a_60_290# WL22 SL3 VSS sky130_fd_pr__nfet_g5v0d10v5 ad=0.65 pd=3.3 as=0 ps=0 w=1 l=0.5
X956 rr2t2r_0[23|3]/a_460_290# WL23 SL3 VSS sky130_fd_pr__nfet_g5v0d10v5 ad=0.65 pd=3.3 as=0 ps=0 w=1 l=0.5
X957 BLP3 rr2t2r_0[23|3]/a_60_290# sky130_fd_pr_reram__reram_cell area_ox=0.0676
X958 BLN3 rr2t2r_0[23|3]/a_460_290# sky130_fd_pr_reram__reram_cell area_ox=0.0676
X959 rr2t2r_0[23|3]/a_60_290# WL23 SL3 VSS sky130_fd_pr__nfet_g5v0d10v5 ad=0.65 pd=3.3 as=0 ps=0 w=1 l=0.5
X960 rr2t2r_0[24|3]/a_460_290# WL24 SL3 VSS sky130_fd_pr__nfet_g5v0d10v5 ad=0.65 pd=3.3 as=0 ps=0 w=1 l=0.5
X961 BLP3 rr2t2r_0[24|3]/a_60_290# sky130_fd_pr_reram__reram_cell area_ox=0.0676
X962 BLN3 rr2t2r_0[24|3]/a_460_290# sky130_fd_pr_reram__reram_cell area_ox=0.0676
X963 rr2t2r_0[24|3]/a_60_290# WL24 SL3 VSS sky130_fd_pr__nfet_g5v0d10v5 ad=0.65 pd=3.3 as=0 ps=0 w=1 l=0.5
X964 rr2t2r_0[25|3]/a_460_290# WL25 SL3 VSS sky130_fd_pr__nfet_g5v0d10v5 ad=0.65 pd=3.3 as=0 ps=0 w=1 l=0.5
X965 BLP3 rr2t2r_0[25|3]/a_60_290# sky130_fd_pr_reram__reram_cell area_ox=0.0676
X966 BLN3 rr2t2r_0[25|3]/a_460_290# sky130_fd_pr_reram__reram_cell area_ox=0.0676
X967 rr2t2r_0[25|3]/a_60_290# WL25 SL3 VSS sky130_fd_pr__nfet_g5v0d10v5 ad=0.65 pd=3.3 as=0 ps=0 w=1 l=0.5
X968 rr2t2r_0[26|3]/a_460_290# WL26 SL3 VSS sky130_fd_pr__nfet_g5v0d10v5 ad=0.65 pd=3.3 as=0 ps=0 w=1 l=0.5
X969 BLP3 rr2t2r_0[26|3]/a_60_290# sky130_fd_pr_reram__reram_cell area_ox=0.0676
X970 BLN3 rr2t2r_0[26|3]/a_460_290# sky130_fd_pr_reram__reram_cell area_ox=0.0676
X971 rr2t2r_0[26|3]/a_60_290# WL26 SL3 VSS sky130_fd_pr__nfet_g5v0d10v5 ad=0.65 pd=3.3 as=0 ps=0 w=1 l=0.5
X972 rr2t2r_0[27|3]/a_460_290# WL27 SL3 VSS sky130_fd_pr__nfet_g5v0d10v5 ad=0.65 pd=3.3 as=0 ps=0 w=1 l=0.5
X973 BLP3 rr2t2r_0[27|3]/a_60_290# sky130_fd_pr_reram__reram_cell area_ox=0.0676
X974 BLN3 rr2t2r_0[27|3]/a_460_290# sky130_fd_pr_reram__reram_cell area_ox=0.0676
X975 rr2t2r_0[27|3]/a_60_290# WL27 SL3 VSS sky130_fd_pr__nfet_g5v0d10v5 ad=0.65 pd=3.3 as=0 ps=0 w=1 l=0.5
X976 rr2t2r_0[28|3]/a_460_290# WL28 SL3 VSS sky130_fd_pr__nfet_g5v0d10v5 ad=0.65 pd=3.3 as=0 ps=0 w=1 l=0.5
X977 BLP3 rr2t2r_0[28|3]/a_60_290# sky130_fd_pr_reram__reram_cell area_ox=0.0676
X978 BLN3 rr2t2r_0[28|3]/a_460_290# sky130_fd_pr_reram__reram_cell area_ox=0.0676
X979 rr2t2r_0[28|3]/a_60_290# WL28 SL3 VSS sky130_fd_pr__nfet_g5v0d10v5 ad=0.65 pd=3.3 as=0 ps=0 w=1 l=0.5
X980 rr2t2r_0[29|3]/a_460_290# WL29 SL3 VSS sky130_fd_pr__nfet_g5v0d10v5 ad=0.65 pd=3.3 as=0 ps=0 w=1 l=0.5
X981 BLP3 rr2t2r_0[29|3]/a_60_290# sky130_fd_pr_reram__reram_cell area_ox=0.0676
X982 BLN3 rr2t2r_0[29|3]/a_460_290# sky130_fd_pr_reram__reram_cell area_ox=0.0676
X983 rr2t2r_0[29|3]/a_60_290# WL29 SL3 VSS sky130_fd_pr__nfet_g5v0d10v5 ad=0.65 pd=3.3 as=0 ps=0 w=1 l=0.5
X984 rr2t2r_0[30|3]/a_460_290# WL30 SL3 VSS sky130_fd_pr__nfet_g5v0d10v5 ad=0.65 pd=3.3 as=0 ps=0 w=1 l=0.5
X985 BLP3 rr2t2r_0[30|3]/a_60_290# sky130_fd_pr_reram__reram_cell area_ox=0.0676
X986 BLN3 rr2t2r_0[30|3]/a_460_290# sky130_fd_pr_reram__reram_cell area_ox=0.0676
X987 rr2t2r_0[30|3]/a_60_290# WL30 SL3 VSS sky130_fd_pr__nfet_g5v0d10v5 ad=0.65 pd=3.3 as=0 ps=0 w=1 l=0.5
X988 rr2t2r_0[31|3]/a_460_290# WL31 SL3 VSS sky130_fd_pr__nfet_g5v0d10v5 ad=0.65 pd=3.3 as=0 ps=0 w=1 l=0.5
X989 BLP3 rr2t2r_0[31|3]/a_60_290# sky130_fd_pr_reram__reram_cell area_ox=0.0676
X990 BLN3 rr2t2r_0[31|3]/a_460_290# sky130_fd_pr_reram__reram_cell area_ox=0.0676
X991 rr2t2r_0[31|3]/a_60_290# WL31 SL3 VSS sky130_fd_pr__nfet_g5v0d10v5 ad=0.65 pd=3.3 as=0 ps=0 w=1 l=0.5
X992 rr2t2r_0[32|3]/a_460_290# WL32 SL3 VSS sky130_fd_pr__nfet_g5v0d10v5 ad=0.65 pd=3.3 as=0 ps=0 w=1 l=0.5
X993 BLP3 rr2t2r_0[32|3]/a_60_290# sky130_fd_pr_reram__reram_cell area_ox=0.0676
X994 BLN3 rr2t2r_0[32|3]/a_460_290# sky130_fd_pr_reram__reram_cell area_ox=0.0676
X995 rr2t2r_0[32|3]/a_60_290# WL32 SL3 VSS sky130_fd_pr__nfet_g5v0d10v5 ad=0.65 pd=3.3 as=0 ps=0 w=1 l=0.5
X996 rr2t2r_0[33|3]/a_460_290# WL33 SL3 VSS sky130_fd_pr__nfet_g5v0d10v5 ad=0.65 pd=3.3 as=0 ps=0 w=1 l=0.5
X997 BLP3 rr2t2r_0[33|3]/a_60_290# sky130_fd_pr_reram__reram_cell area_ox=0.0676
X998 BLN3 rr2t2r_0[33|3]/a_460_290# sky130_fd_pr_reram__reram_cell area_ox=0.0676
X999 rr2t2r_0[33|3]/a_60_290# WL33 SL3 VSS sky130_fd_pr__nfet_g5v0d10v5 ad=0.65 pd=3.3 as=0 ps=0 w=1 l=0.5
X1000 rr2t2r_0[34|3]/a_460_290# WL34 SL3 VSS sky130_fd_pr__nfet_g5v0d10v5 ad=0.65 pd=3.3 as=0 ps=0 w=1 l=0.5
X1001 BLP3 rr2t2r_0[34|3]/a_60_290# sky130_fd_pr_reram__reram_cell area_ox=0.0676
X1002 BLN3 rr2t2r_0[34|3]/a_460_290# sky130_fd_pr_reram__reram_cell area_ox=0.0676
X1003 rr2t2r_0[34|3]/a_60_290# WL34 SL3 VSS sky130_fd_pr__nfet_g5v0d10v5 ad=0.65 pd=3.3 as=0 ps=0 w=1 l=0.5
X1004 rr2t2r_0[35|3]/a_460_290# WL35 SL3 VSS sky130_fd_pr__nfet_g5v0d10v5 ad=0.65 pd=3.3 as=0 ps=0 w=1 l=0.5
X1005 BLP3 rr2t2r_0[35|3]/a_60_290# sky130_fd_pr_reram__reram_cell area_ox=0.0676
X1006 BLN3 rr2t2r_0[35|3]/a_460_290# sky130_fd_pr_reram__reram_cell area_ox=0.0676
X1007 rr2t2r_0[35|3]/a_60_290# WL35 SL3 VSS sky130_fd_pr__nfet_g5v0d10v5 ad=0.65 pd=3.3 as=0 ps=0 w=1 l=0.5
X1008 rr2t2r_0[36|3]/a_460_290# WL36 SL3 VSS sky130_fd_pr__nfet_g5v0d10v5 ad=0.65 pd=3.3 as=0 ps=0 w=1 l=0.5
X1009 BLP3 rr2t2r_0[36|3]/a_60_290# sky130_fd_pr_reram__reram_cell area_ox=0.0676
X1010 BLN3 rr2t2r_0[36|3]/a_460_290# sky130_fd_pr_reram__reram_cell area_ox=0.0676
X1011 rr2t2r_0[36|3]/a_60_290# WL36 SL3 VSS sky130_fd_pr__nfet_g5v0d10v5 ad=0.65 pd=3.3 as=0 ps=0 w=1 l=0.5
X1012 rr2t2r_0[37|3]/a_460_290# WL37 SL3 VSS sky130_fd_pr__nfet_g5v0d10v5 ad=0.65 pd=3.3 as=0 ps=0 w=1 l=0.5
X1013 BLP3 rr2t2r_0[37|3]/a_60_290# sky130_fd_pr_reram__reram_cell area_ox=0.0676
X1014 BLN3 rr2t2r_0[37|3]/a_460_290# sky130_fd_pr_reram__reram_cell area_ox=0.0676
X1015 rr2t2r_0[37|3]/a_60_290# WL37 SL3 VSS sky130_fd_pr__nfet_g5v0d10v5 ad=0.65 pd=3.3 as=0 ps=0 w=1 l=0.5
X1016 rr2t2r_0[38|3]/a_460_290# WL38 SL3 VSS sky130_fd_pr__nfet_g5v0d10v5 ad=0.65 pd=3.3 as=0 ps=0 w=1 l=0.5
X1017 BLP3 rr2t2r_0[38|3]/a_60_290# sky130_fd_pr_reram__reram_cell area_ox=0.0676
X1018 BLN3 rr2t2r_0[38|3]/a_460_290# sky130_fd_pr_reram__reram_cell area_ox=0.0676
X1019 rr2t2r_0[38|3]/a_60_290# WL38 SL3 VSS sky130_fd_pr__nfet_g5v0d10v5 ad=0.65 pd=3.3 as=0 ps=0 w=1 l=0.5
X1020 rr2t2r_0[39|3]/a_460_290# WL39 SL3 VSS sky130_fd_pr__nfet_g5v0d10v5 ad=0.65 pd=3.3 as=0 ps=0 w=1 l=0.5
X1021 BLP3 rr2t2r_0[39|3]/a_60_290# sky130_fd_pr_reram__reram_cell area_ox=0.0676
X1022 BLN3 rr2t2r_0[39|3]/a_460_290# sky130_fd_pr_reram__reram_cell area_ox=0.0676
X1023 rr2t2r_0[39|3]/a_60_290# WL39 SL3 VSS sky130_fd_pr__nfet_g5v0d10v5 ad=0.65 pd=3.3 as=0 ps=0 w=1 l=0.5
X1024 rr2t2r_0[40|3]/a_460_290# WL40 SL3 VSS sky130_fd_pr__nfet_g5v0d10v5 ad=0.65 pd=3.3 as=0 ps=0 w=1 l=0.5
X1025 BLP3 rr2t2r_0[40|3]/a_60_290# sky130_fd_pr_reram__reram_cell area_ox=0.0676
X1026 BLN3 rr2t2r_0[40|3]/a_460_290# sky130_fd_pr_reram__reram_cell area_ox=0.0676
X1027 rr2t2r_0[40|3]/a_60_290# WL40 SL3 VSS sky130_fd_pr__nfet_g5v0d10v5 ad=0.65 pd=3.3 as=0 ps=0 w=1 l=0.5
X1028 rr2t2r_0[41|3]/a_460_290# WL41 SL3 VSS sky130_fd_pr__nfet_g5v0d10v5 ad=0.65 pd=3.3 as=0 ps=0 w=1 l=0.5
X1029 BLP3 rr2t2r_0[41|3]/a_60_290# sky130_fd_pr_reram__reram_cell area_ox=0.0676
X1030 BLN3 rr2t2r_0[41|3]/a_460_290# sky130_fd_pr_reram__reram_cell area_ox=0.0676
X1031 rr2t2r_0[41|3]/a_60_290# WL41 SL3 VSS sky130_fd_pr__nfet_g5v0d10v5 ad=0.65 pd=3.3 as=0 ps=0 w=1 l=0.5
X1032 rr2t2r_0[42|3]/a_460_290# WL42 SL3 VSS sky130_fd_pr__nfet_g5v0d10v5 ad=0.65 pd=3.3 as=0 ps=0 w=1 l=0.5
X1033 BLP3 rr2t2r_0[42|3]/a_60_290# sky130_fd_pr_reram__reram_cell area_ox=0.0676
X1034 BLN3 rr2t2r_0[42|3]/a_460_290# sky130_fd_pr_reram__reram_cell area_ox=0.0676
X1035 rr2t2r_0[42|3]/a_60_290# WL42 SL3 VSS sky130_fd_pr__nfet_g5v0d10v5 ad=0.65 pd=3.3 as=0 ps=0 w=1 l=0.5
X1036 rr2t2r_0[43|3]/a_460_290# WL43 SL3 VSS sky130_fd_pr__nfet_g5v0d10v5 ad=0.65 pd=3.3 as=0 ps=0 w=1 l=0.5
X1037 BLP3 rr2t2r_0[43|3]/a_60_290# sky130_fd_pr_reram__reram_cell area_ox=0.0676
X1038 BLN3 rr2t2r_0[43|3]/a_460_290# sky130_fd_pr_reram__reram_cell area_ox=0.0676
X1039 rr2t2r_0[43|3]/a_60_290# WL43 SL3 VSS sky130_fd_pr__nfet_g5v0d10v5 ad=0.65 pd=3.3 as=0 ps=0 w=1 l=0.5
X1040 rr2t2r_0[44|3]/a_460_290# WL44 SL3 VSS sky130_fd_pr__nfet_g5v0d10v5 ad=0.65 pd=3.3 as=0 ps=0 w=1 l=0.5
X1041 BLP3 rr2t2r_0[44|3]/a_60_290# sky130_fd_pr_reram__reram_cell area_ox=0.0676
X1042 BLN3 rr2t2r_0[44|3]/a_460_290# sky130_fd_pr_reram__reram_cell area_ox=0.0676
X1043 rr2t2r_0[44|3]/a_60_290# WL44 SL3 VSS sky130_fd_pr__nfet_g5v0d10v5 ad=0.65 pd=3.3 as=0 ps=0 w=1 l=0.5
X1044 rr2t2r_0[45|3]/a_460_290# WL45 SL3 VSS sky130_fd_pr__nfet_g5v0d10v5 ad=0.65 pd=3.3 as=0 ps=0 w=1 l=0.5
X1045 BLP3 rr2t2r_0[45|3]/a_60_290# sky130_fd_pr_reram__reram_cell area_ox=0.0676
X1046 BLN3 rr2t2r_0[45|3]/a_460_290# sky130_fd_pr_reram__reram_cell area_ox=0.0676
X1047 rr2t2r_0[45|3]/a_60_290# WL45 SL3 VSS sky130_fd_pr__nfet_g5v0d10v5 ad=0.65 pd=3.3 as=0 ps=0 w=1 l=0.5
X1048 rr2t2r_0[46|3]/a_460_290# WL46 SL3 VSS sky130_fd_pr__nfet_g5v0d10v5 ad=0.65 pd=3.3 as=0 ps=0 w=1 l=0.5
X1049 BLP3 rr2t2r_0[46|3]/a_60_290# sky130_fd_pr_reram__reram_cell area_ox=0.0676
X1050 BLN3 rr2t2r_0[46|3]/a_460_290# sky130_fd_pr_reram__reram_cell area_ox=0.0676
X1051 rr2t2r_0[46|3]/a_60_290# WL46 SL3 VSS sky130_fd_pr__nfet_g5v0d10v5 ad=0.65 pd=3.3 as=0 ps=0 w=1 l=0.5
X1052 rr2t2r_0[47|3]/a_460_290# WL47 SL3 VSS sky130_fd_pr__nfet_g5v0d10v5 ad=0.65 pd=3.3 as=0 ps=0 w=1 l=0.5
X1053 BLP3 rr2t2r_0[47|3]/a_60_290# sky130_fd_pr_reram__reram_cell area_ox=0.0676
X1054 BLN3 rr2t2r_0[47|3]/a_460_290# sky130_fd_pr_reram__reram_cell area_ox=0.0676
X1055 rr2t2r_0[47|3]/a_60_290# WL47 SL3 VSS sky130_fd_pr__nfet_g5v0d10v5 ad=0.65 pd=3.3 as=0 ps=0 w=1 l=0.5
X1056 rr2t2r_0[48|3]/a_460_290# WL48 SL3 VSS sky130_fd_pr__nfet_g5v0d10v5 ad=0.65 pd=3.3 as=0 ps=0 w=1 l=0.5
X1057 BLP3 rr2t2r_0[48|3]/a_60_290# sky130_fd_pr_reram__reram_cell area_ox=0.0676
X1058 BLN3 rr2t2r_0[48|3]/a_460_290# sky130_fd_pr_reram__reram_cell area_ox=0.0676
X1059 rr2t2r_0[48|3]/a_60_290# WL48 SL3 VSS sky130_fd_pr__nfet_g5v0d10v5 ad=0.65 pd=3.3 as=0 ps=0 w=1 l=0.5
X1060 rr2t2r_0[49|3]/a_460_290# WL49 SL3 VSS sky130_fd_pr__nfet_g5v0d10v5 ad=0.65 pd=3.3 as=0 ps=0 w=1 l=0.5
X1061 BLP3 rr2t2r_0[49|3]/a_60_290# sky130_fd_pr_reram__reram_cell area_ox=0.0676
X1062 BLN3 rr2t2r_0[49|3]/a_460_290# sky130_fd_pr_reram__reram_cell area_ox=0.0676
X1063 rr2t2r_0[49|3]/a_60_290# WL49 SL3 VSS sky130_fd_pr__nfet_g5v0d10v5 ad=0.65 pd=3.3 as=0 ps=0 w=1 l=0.5
X1064 rr2t2r_0[50|3]/a_460_290# WL50 SL3 VSS sky130_fd_pr__nfet_g5v0d10v5 ad=0.65 pd=3.3 as=0 ps=0 w=1 l=0.5
X1065 BLP3 rr2t2r_0[50|3]/a_60_290# sky130_fd_pr_reram__reram_cell area_ox=0.0676
X1066 BLN3 rr2t2r_0[50|3]/a_460_290# sky130_fd_pr_reram__reram_cell area_ox=0.0676
X1067 rr2t2r_0[50|3]/a_60_290# WL50 SL3 VSS sky130_fd_pr__nfet_g5v0d10v5 ad=0.65 pd=3.3 as=0 ps=0 w=1 l=0.5
X1068 rr2t2r_0[51|3]/a_460_290# WL51 SL3 VSS sky130_fd_pr__nfet_g5v0d10v5 ad=0.65 pd=3.3 as=0 ps=0 w=1 l=0.5
X1069 BLP3 rr2t2r_0[51|3]/a_60_290# sky130_fd_pr_reram__reram_cell area_ox=0.0676
X1070 BLN3 rr2t2r_0[51|3]/a_460_290# sky130_fd_pr_reram__reram_cell area_ox=0.0676
X1071 rr2t2r_0[51|3]/a_60_290# WL51 SL3 VSS sky130_fd_pr__nfet_g5v0d10v5 ad=0.65 pd=3.3 as=0 ps=0 w=1 l=0.5
X1072 rr2t2r_0[52|3]/a_460_290# WL52 SL3 VSS sky130_fd_pr__nfet_g5v0d10v5 ad=0.65 pd=3.3 as=0 ps=0 w=1 l=0.5
X1073 BLP3 rr2t2r_0[52|3]/a_60_290# sky130_fd_pr_reram__reram_cell area_ox=0.0676
X1074 BLN3 rr2t2r_0[52|3]/a_460_290# sky130_fd_pr_reram__reram_cell area_ox=0.0676
X1075 rr2t2r_0[52|3]/a_60_290# WL52 SL3 VSS sky130_fd_pr__nfet_g5v0d10v5 ad=0.65 pd=3.3 as=0 ps=0 w=1 l=0.5
X1076 rr2t2r_0[53|3]/a_460_290# WL53 SL3 VSS sky130_fd_pr__nfet_g5v0d10v5 ad=0.65 pd=3.3 as=0 ps=0 w=1 l=0.5
X1077 BLP3 rr2t2r_0[53|3]/a_60_290# sky130_fd_pr_reram__reram_cell area_ox=0.0676
X1078 BLN3 rr2t2r_0[53|3]/a_460_290# sky130_fd_pr_reram__reram_cell area_ox=0.0676
X1079 rr2t2r_0[53|3]/a_60_290# WL53 SL3 VSS sky130_fd_pr__nfet_g5v0d10v5 ad=0.65 pd=3.3 as=0 ps=0 w=1 l=0.5
X1080 rr2t2r_0[54|3]/a_460_290# WL54 SL3 VSS sky130_fd_pr__nfet_g5v0d10v5 ad=0.65 pd=3.3 as=0 ps=0 w=1 l=0.5
X1081 BLP3 rr2t2r_0[54|3]/a_60_290# sky130_fd_pr_reram__reram_cell area_ox=0.0676
X1082 BLN3 rr2t2r_0[54|3]/a_460_290# sky130_fd_pr_reram__reram_cell area_ox=0.0676
X1083 rr2t2r_0[54|3]/a_60_290# WL54 SL3 VSS sky130_fd_pr__nfet_g5v0d10v5 ad=0.65 pd=3.3 as=0 ps=0 w=1 l=0.5
X1084 rr2t2r_0[55|3]/a_460_290# WL55 SL3 VSS sky130_fd_pr__nfet_g5v0d10v5 ad=0.65 pd=3.3 as=0 ps=0 w=1 l=0.5
X1085 BLP3 rr2t2r_0[55|3]/a_60_290# sky130_fd_pr_reram__reram_cell area_ox=0.0676
X1086 BLN3 rr2t2r_0[55|3]/a_460_290# sky130_fd_pr_reram__reram_cell area_ox=0.0676
X1087 rr2t2r_0[55|3]/a_60_290# WL55 SL3 VSS sky130_fd_pr__nfet_g5v0d10v5 ad=0.65 pd=3.3 as=0 ps=0 w=1 l=0.5
X1088 rr2t2r_0[56|3]/a_460_290# WL56 SL3 VSS sky130_fd_pr__nfet_g5v0d10v5 ad=0.65 pd=3.3 as=0 ps=0 w=1 l=0.5
X1089 BLP3 rr2t2r_0[56|3]/a_60_290# sky130_fd_pr_reram__reram_cell area_ox=0.0676
X1090 BLN3 rr2t2r_0[56|3]/a_460_290# sky130_fd_pr_reram__reram_cell area_ox=0.0676
X1091 rr2t2r_0[56|3]/a_60_290# WL56 SL3 VSS sky130_fd_pr__nfet_g5v0d10v5 ad=0.65 pd=3.3 as=0 ps=0 w=1 l=0.5
X1092 rr2t2r_0[57|3]/a_460_290# WL57 SL3 VSS sky130_fd_pr__nfet_g5v0d10v5 ad=0.65 pd=3.3 as=0 ps=0 w=1 l=0.5
X1093 BLP3 rr2t2r_0[57|3]/a_60_290# sky130_fd_pr_reram__reram_cell area_ox=0.0676
X1094 BLN3 rr2t2r_0[57|3]/a_460_290# sky130_fd_pr_reram__reram_cell area_ox=0.0676
X1095 rr2t2r_0[57|3]/a_60_290# WL57 SL3 VSS sky130_fd_pr__nfet_g5v0d10v5 ad=0.65 pd=3.3 as=0 ps=0 w=1 l=0.5
X1096 rr2t2r_0[58|3]/a_460_290# WL58 SL3 VSS sky130_fd_pr__nfet_g5v0d10v5 ad=0.65 pd=3.3 as=0 ps=0 w=1 l=0.5
X1097 BLP3 rr2t2r_0[58|3]/a_60_290# sky130_fd_pr_reram__reram_cell area_ox=0.0676
X1098 BLN3 rr2t2r_0[58|3]/a_460_290# sky130_fd_pr_reram__reram_cell area_ox=0.0676
X1099 rr2t2r_0[58|3]/a_60_290# WL58 SL3 VSS sky130_fd_pr__nfet_g5v0d10v5 ad=0.65 pd=3.3 as=0 ps=0 w=1 l=0.5
X1100 rr2t2r_0[59|3]/a_460_290# WL59 SL3 VSS sky130_fd_pr__nfet_g5v0d10v5 ad=0.65 pd=3.3 as=0 ps=0 w=1 l=0.5
X1101 BLP3 rr2t2r_0[59|3]/a_60_290# sky130_fd_pr_reram__reram_cell area_ox=0.0676
X1102 BLN3 rr2t2r_0[59|3]/a_460_290# sky130_fd_pr_reram__reram_cell area_ox=0.0676
X1103 rr2t2r_0[59|3]/a_60_290# WL59 SL3 VSS sky130_fd_pr__nfet_g5v0d10v5 ad=0.65 pd=3.3 as=0 ps=0 w=1 l=0.5
X1104 rr2t2r_0[60|3]/a_460_290# WL60 SL3 VSS sky130_fd_pr__nfet_g5v0d10v5 ad=0.65 pd=3.3 as=0 ps=0 w=1 l=0.5
X1105 BLP3 rr2t2r_0[60|3]/a_60_290# sky130_fd_pr_reram__reram_cell area_ox=0.0676
X1106 BLN3 rr2t2r_0[60|3]/a_460_290# sky130_fd_pr_reram__reram_cell area_ox=0.0676
X1107 rr2t2r_0[60|3]/a_60_290# WL60 SL3 VSS sky130_fd_pr__nfet_g5v0d10v5 ad=0.65 pd=3.3 as=0 ps=0 w=1 l=0.5
X1108 rr2t2r_0[61|3]/a_460_290# WL61 SL3 VSS sky130_fd_pr__nfet_g5v0d10v5 ad=0.65 pd=3.3 as=0 ps=0 w=1 l=0.5
X1109 BLP3 rr2t2r_0[61|3]/a_60_290# sky130_fd_pr_reram__reram_cell area_ox=0.0676
X1110 BLN3 rr2t2r_0[61|3]/a_460_290# sky130_fd_pr_reram__reram_cell area_ox=0.0676
X1111 rr2t2r_0[61|3]/a_60_290# WL61 SL3 VSS sky130_fd_pr__nfet_g5v0d10v5 ad=0.65 pd=3.3 as=0 ps=0 w=1 l=0.5
X1112 rr2t2r_0[62|3]/a_460_290# WL62 SL3 VSS sky130_fd_pr__nfet_g5v0d10v5 ad=0.65 pd=3.3 as=0 ps=0 w=1 l=0.5
X1113 BLP3 rr2t2r_0[62|3]/a_60_290# sky130_fd_pr_reram__reram_cell area_ox=0.0676
X1114 BLN3 rr2t2r_0[62|3]/a_460_290# sky130_fd_pr_reram__reram_cell area_ox=0.0676
X1115 rr2t2r_0[62|3]/a_60_290# WL62 SL3 VSS sky130_fd_pr__nfet_g5v0d10v5 ad=0.65 pd=3.3 as=0 ps=0 w=1 l=0.5
X1116 rr2t2r_0[63|3]/a_460_290# WL63 SL3 VSS sky130_fd_pr__nfet_g5v0d10v5 ad=0.65 pd=3.3 as=0 ps=0 w=1 l=0.5
X1117 BLP3 rr2t2r_0[63|3]/a_60_290# sky130_fd_pr_reram__reram_cell area_ox=0.0676
X1118 BLN3 rr2t2r_0[63|3]/a_460_290# sky130_fd_pr_reram__reram_cell area_ox=0.0676
X1119 rr2t2r_0[63|3]/a_60_290# WL63 SL3 VSS sky130_fd_pr__nfet_g5v0d10v5 ad=0.65 pd=3.3 as=0 ps=0 w=1 l=0.5
X1120 rr2t2r_0[64|3]/a_460_290# WL64 SL3 VSS sky130_fd_pr__nfet_g5v0d10v5 ad=0.65 pd=3.3 as=0 ps=0 w=1 l=0.5
X1121 BLP3 rr2t2r_0[64|3]/a_60_290# sky130_fd_pr_reram__reram_cell area_ox=0.0676
X1122 BLN3 rr2t2r_0[64|3]/a_460_290# sky130_fd_pr_reram__reram_cell area_ox=0.0676
X1123 rr2t2r_0[64|3]/a_60_290# WL64 SL3 VSS sky130_fd_pr__nfet_g5v0d10v5 ad=0.65 pd=3.3 as=0 ps=0 w=1 l=0.5
X1124 rr2t2r_0[65|3]/a_460_290# WL65 SL3 VSS sky130_fd_pr__nfet_g5v0d10v5 ad=0.65 pd=3.3 as=0 ps=0 w=1 l=0.5
X1125 BLP3 rr2t2r_0[65|3]/a_60_290# sky130_fd_pr_reram__reram_cell area_ox=0.0676
X1126 BLN3 rr2t2r_0[65|3]/a_460_290# sky130_fd_pr_reram__reram_cell area_ox=0.0676
X1127 rr2t2r_0[65|3]/a_60_290# WL65 SL3 VSS sky130_fd_pr__nfet_g5v0d10v5 ad=0.65 pd=3.3 as=0 ps=0 w=1 l=0.5
X1128 rr2t2r_0[66|3]/a_460_290# WL66 SL3 VSS sky130_fd_pr__nfet_g5v0d10v5 ad=0.65 pd=3.3 as=0 ps=0 w=1 l=0.5
X1129 BLP3 rr2t2r_0[66|3]/a_60_290# sky130_fd_pr_reram__reram_cell area_ox=0.0676
X1130 BLN3 rr2t2r_0[66|3]/a_460_290# sky130_fd_pr_reram__reram_cell area_ox=0.0676
X1131 rr2t2r_0[66|3]/a_60_290# WL66 SL3 VSS sky130_fd_pr__nfet_g5v0d10v5 ad=0.65 pd=3.3 as=0 ps=0 w=1 l=0.5
X1132 rr2t2r_0[67|3]/a_460_290# WL67 SL3 VSS sky130_fd_pr__nfet_g5v0d10v5 ad=0.65 pd=3.3 as=0 ps=0 w=1 l=0.5
X1133 BLP3 rr2t2r_0[67|3]/a_60_290# sky130_fd_pr_reram__reram_cell area_ox=0.0676
X1134 BLN3 rr2t2r_0[67|3]/a_460_290# sky130_fd_pr_reram__reram_cell area_ox=0.0676
X1135 rr2t2r_0[67|3]/a_60_290# WL67 SL3 VSS sky130_fd_pr__nfet_g5v0d10v5 ad=0.65 pd=3.3 as=0 ps=0 w=1 l=0.5
X1136 rr2t2r_0[68|3]/a_460_290# WL68 SL3 VSS sky130_fd_pr__nfet_g5v0d10v5 ad=0.65 pd=3.3 as=0 ps=0 w=1 l=0.5
X1137 BLP3 rr2t2r_0[68|3]/a_60_290# sky130_fd_pr_reram__reram_cell area_ox=0.0676
X1138 BLN3 rr2t2r_0[68|3]/a_460_290# sky130_fd_pr_reram__reram_cell area_ox=0.0676
X1139 rr2t2r_0[68|3]/a_60_290# WL68 SL3 VSS sky130_fd_pr__nfet_g5v0d10v5 ad=0.65 pd=3.3 as=0 ps=0 w=1 l=0.5
X1140 rr2t2r_0[69|3]/a_460_290# WL69 SL3 VSS sky130_fd_pr__nfet_g5v0d10v5 ad=0.65 pd=3.3 as=0 ps=0 w=1 l=0.5
X1141 BLP3 rr2t2r_0[69|3]/a_60_290# sky130_fd_pr_reram__reram_cell area_ox=0.0676
X1142 BLN3 rr2t2r_0[69|3]/a_460_290# sky130_fd_pr_reram__reram_cell area_ox=0.0676
X1143 rr2t2r_0[69|3]/a_60_290# WL69 SL3 VSS sky130_fd_pr__nfet_g5v0d10v5 ad=0.65 pd=3.3 as=0 ps=0 w=1 l=0.5
X1144 rr2t2r_0[70|3]/a_460_290# WL70 SL3 VSS sky130_fd_pr__nfet_g5v0d10v5 ad=0.65 pd=3.3 as=0 ps=0 w=1 l=0.5
X1145 BLP3 rr2t2r_0[70|3]/a_60_290# sky130_fd_pr_reram__reram_cell area_ox=0.0676
X1146 BLN3 rr2t2r_0[70|3]/a_460_290# sky130_fd_pr_reram__reram_cell area_ox=0.0676
X1147 rr2t2r_0[70|3]/a_60_290# WL70 SL3 VSS sky130_fd_pr__nfet_g5v0d10v5 ad=0.65 pd=3.3 as=0 ps=0 w=1 l=0.5
X1148 rr2t2r_0[71|3]/a_460_290# WL71 SL3 VSS sky130_fd_pr__nfet_g5v0d10v5 ad=0.65 pd=3.3 as=0 ps=0 w=1 l=0.5
X1149 BLP3 rr2t2r_0[71|3]/a_60_290# sky130_fd_pr_reram__reram_cell area_ox=0.0676
X1150 BLN3 rr2t2r_0[71|3]/a_460_290# sky130_fd_pr_reram__reram_cell area_ox=0.0676
X1151 rr2t2r_0[71|3]/a_60_290# WL71 SL3 VSS sky130_fd_pr__nfet_g5v0d10v5 ad=0.65 pd=3.3 as=0 ps=0 w=1 l=0.5
X1152 rr2t2r_0[0|4]/a_460_290# WL0 SL4 VSS sky130_fd_pr__nfet_g5v0d10v5 ad=0.65 pd=3.3 as=108 ps=504 w=1 l=0.5
X1153 BLP4 rr2t2r_0[0|4]/a_60_290# sky130_fd_pr_reram__reram_cell area_ox=0.0676
X1154 BLN4 rr2t2r_0[0|4]/a_460_290# sky130_fd_pr_reram__reram_cell area_ox=0.0676
X1155 rr2t2r_0[0|4]/a_60_290# WL0 SL4 VSS sky130_fd_pr__nfet_g5v0d10v5 ad=0.65 pd=3.3 as=0 ps=0 w=1 l=0.5
X1156 rr2t2r_0[1|4]/a_460_290# WL1 SL4 VSS sky130_fd_pr__nfet_g5v0d10v5 ad=0.65 pd=3.3 as=0 ps=0 w=1 l=0.5
X1157 BLP4 rr2t2r_0[1|4]/a_60_290# sky130_fd_pr_reram__reram_cell area_ox=0.0676
X1158 BLN4 rr2t2r_0[1|4]/a_460_290# sky130_fd_pr_reram__reram_cell area_ox=0.0676
X1159 rr2t2r_0[1|4]/a_60_290# WL1 SL4 VSS sky130_fd_pr__nfet_g5v0d10v5 ad=0.65 pd=3.3 as=0 ps=0 w=1 l=0.5
X1160 rr2t2r_0[2|4]/a_460_290# WL2 SL4 VSS sky130_fd_pr__nfet_g5v0d10v5 ad=0.65 pd=3.3 as=0 ps=0 w=1 l=0.5
X1161 BLP4 rr2t2r_0[2|4]/a_60_290# sky130_fd_pr_reram__reram_cell area_ox=0.0676
X1162 BLN4 rr2t2r_0[2|4]/a_460_290# sky130_fd_pr_reram__reram_cell area_ox=0.0676
X1163 rr2t2r_0[2|4]/a_60_290# WL2 SL4 VSS sky130_fd_pr__nfet_g5v0d10v5 ad=0.65 pd=3.3 as=0 ps=0 w=1 l=0.5
X1164 rr2t2r_0[3|4]/a_460_290# WL3 SL4 VSS sky130_fd_pr__nfet_g5v0d10v5 ad=0.65 pd=3.3 as=0 ps=0 w=1 l=0.5
X1165 BLP4 rr2t2r_0[3|4]/a_60_290# sky130_fd_pr_reram__reram_cell area_ox=0.0676
X1166 BLN4 rr2t2r_0[3|4]/a_460_290# sky130_fd_pr_reram__reram_cell area_ox=0.0676
X1167 rr2t2r_0[3|4]/a_60_290# WL3 SL4 VSS sky130_fd_pr__nfet_g5v0d10v5 ad=0.65 pd=3.3 as=0 ps=0 w=1 l=0.5
X1168 rr2t2r_0[4|4]/a_460_290# WL4 SL4 VSS sky130_fd_pr__nfet_g5v0d10v5 ad=0.65 pd=3.3 as=0 ps=0 w=1 l=0.5
X1169 BLP4 rr2t2r_0[4|4]/a_60_290# sky130_fd_pr_reram__reram_cell area_ox=0.0676
X1170 BLN4 rr2t2r_0[4|4]/a_460_290# sky130_fd_pr_reram__reram_cell area_ox=0.0676
X1171 rr2t2r_0[4|4]/a_60_290# WL4 SL4 VSS sky130_fd_pr__nfet_g5v0d10v5 ad=0.65 pd=3.3 as=0 ps=0 w=1 l=0.5
X1172 rr2t2r_0[5|4]/a_460_290# WL5 SL4 VSS sky130_fd_pr__nfet_g5v0d10v5 ad=0.65 pd=3.3 as=0 ps=0 w=1 l=0.5
X1173 BLP4 rr2t2r_0[5|4]/a_60_290# sky130_fd_pr_reram__reram_cell area_ox=0.0676
X1174 BLN4 rr2t2r_0[5|4]/a_460_290# sky130_fd_pr_reram__reram_cell area_ox=0.0676
X1175 rr2t2r_0[5|4]/a_60_290# WL5 SL4 VSS sky130_fd_pr__nfet_g5v0d10v5 ad=0.65 pd=3.3 as=0 ps=0 w=1 l=0.5
X1176 rr2t2r_0[6|4]/a_460_290# WL6 SL4 VSS sky130_fd_pr__nfet_g5v0d10v5 ad=0.65 pd=3.3 as=0 ps=0 w=1 l=0.5
X1177 BLP4 rr2t2r_0[6|4]/a_60_290# sky130_fd_pr_reram__reram_cell area_ox=0.0676
X1178 BLN4 rr2t2r_0[6|4]/a_460_290# sky130_fd_pr_reram__reram_cell area_ox=0.0676
X1179 rr2t2r_0[6|4]/a_60_290# WL6 SL4 VSS sky130_fd_pr__nfet_g5v0d10v5 ad=0.65 pd=3.3 as=0 ps=0 w=1 l=0.5
X1180 rr2t2r_0[7|4]/a_460_290# WL7 SL4 VSS sky130_fd_pr__nfet_g5v0d10v5 ad=0.65 pd=3.3 as=0 ps=0 w=1 l=0.5
X1181 BLP4 rr2t2r_0[7|4]/a_60_290# sky130_fd_pr_reram__reram_cell area_ox=0.0676
X1182 BLN4 rr2t2r_0[7|4]/a_460_290# sky130_fd_pr_reram__reram_cell area_ox=0.0676
X1183 rr2t2r_0[7|4]/a_60_290# WL7 SL4 VSS sky130_fd_pr__nfet_g5v0d10v5 ad=0.65 pd=3.3 as=0 ps=0 w=1 l=0.5
X1184 rr2t2r_0[8|4]/a_460_290# WL8 SL4 VSS sky130_fd_pr__nfet_g5v0d10v5 ad=0.65 pd=3.3 as=0 ps=0 w=1 l=0.5
X1185 BLP4 rr2t2r_0[8|4]/a_60_290# sky130_fd_pr_reram__reram_cell area_ox=0.0676
X1186 BLN4 rr2t2r_0[8|4]/a_460_290# sky130_fd_pr_reram__reram_cell area_ox=0.0676
X1187 rr2t2r_0[8|4]/a_60_290# WL8 SL4 VSS sky130_fd_pr__nfet_g5v0d10v5 ad=0.65 pd=3.3 as=0 ps=0 w=1 l=0.5
X1188 rr2t2r_0[9|4]/a_460_290# WL9 SL4 VSS sky130_fd_pr__nfet_g5v0d10v5 ad=0.65 pd=3.3 as=0 ps=0 w=1 l=0.5
X1189 BLP4 rr2t2r_0[9|4]/a_60_290# sky130_fd_pr_reram__reram_cell area_ox=0.0676
X1190 BLN4 rr2t2r_0[9|4]/a_460_290# sky130_fd_pr_reram__reram_cell area_ox=0.0676
X1191 rr2t2r_0[9|4]/a_60_290# WL9 SL4 VSS sky130_fd_pr__nfet_g5v0d10v5 ad=0.65 pd=3.3 as=0 ps=0 w=1 l=0.5
X1192 rr2t2r_0[10|4]/a_460_290# WL10 SL4 VSS sky130_fd_pr__nfet_g5v0d10v5 ad=0.65 pd=3.3 as=0 ps=0 w=1 l=0.5
X1193 BLP4 rr2t2r_0[10|4]/a_60_290# sky130_fd_pr_reram__reram_cell area_ox=0.0676
X1194 BLN4 rr2t2r_0[10|4]/a_460_290# sky130_fd_pr_reram__reram_cell area_ox=0.0676
X1195 rr2t2r_0[10|4]/a_60_290# WL10 SL4 VSS sky130_fd_pr__nfet_g5v0d10v5 ad=0.65 pd=3.3 as=0 ps=0 w=1 l=0.5
X1196 rr2t2r_0[11|4]/a_460_290# WL11 SL4 VSS sky130_fd_pr__nfet_g5v0d10v5 ad=0.65 pd=3.3 as=0 ps=0 w=1 l=0.5
X1197 BLP4 rr2t2r_0[11|4]/a_60_290# sky130_fd_pr_reram__reram_cell area_ox=0.0676
X1198 BLN4 rr2t2r_0[11|4]/a_460_290# sky130_fd_pr_reram__reram_cell area_ox=0.0676
X1199 rr2t2r_0[11|4]/a_60_290# WL11 SL4 VSS sky130_fd_pr__nfet_g5v0d10v5 ad=0.65 pd=3.3 as=0 ps=0 w=1 l=0.5
X1200 rr2t2r_0[12|4]/a_460_290# WL12 SL4 VSS sky130_fd_pr__nfet_g5v0d10v5 ad=0.65 pd=3.3 as=0 ps=0 w=1 l=0.5
X1201 BLP4 rr2t2r_0[12|4]/a_60_290# sky130_fd_pr_reram__reram_cell area_ox=0.0676
X1202 BLN4 rr2t2r_0[12|4]/a_460_290# sky130_fd_pr_reram__reram_cell area_ox=0.0676
X1203 rr2t2r_0[12|4]/a_60_290# WL12 SL4 VSS sky130_fd_pr__nfet_g5v0d10v5 ad=0.65 pd=3.3 as=0 ps=0 w=1 l=0.5
X1204 rr2t2r_0[13|4]/a_460_290# WL13 SL4 VSS sky130_fd_pr__nfet_g5v0d10v5 ad=0.65 pd=3.3 as=0 ps=0 w=1 l=0.5
X1205 BLP4 rr2t2r_0[13|4]/a_60_290# sky130_fd_pr_reram__reram_cell area_ox=0.0676
X1206 BLN4 rr2t2r_0[13|4]/a_460_290# sky130_fd_pr_reram__reram_cell area_ox=0.0676
X1207 rr2t2r_0[13|4]/a_60_290# WL13 SL4 VSS sky130_fd_pr__nfet_g5v0d10v5 ad=0.65 pd=3.3 as=0 ps=0 w=1 l=0.5
X1208 rr2t2r_0[14|4]/a_460_290# WL14 SL4 VSS sky130_fd_pr__nfet_g5v0d10v5 ad=0.65 pd=3.3 as=0 ps=0 w=1 l=0.5
X1209 BLP4 rr2t2r_0[14|4]/a_60_290# sky130_fd_pr_reram__reram_cell area_ox=0.0676
X1210 BLN4 rr2t2r_0[14|4]/a_460_290# sky130_fd_pr_reram__reram_cell area_ox=0.0676
X1211 rr2t2r_0[14|4]/a_60_290# WL14 SL4 VSS sky130_fd_pr__nfet_g5v0d10v5 ad=0.65 pd=3.3 as=0 ps=0 w=1 l=0.5
X1212 rr2t2r_0[15|4]/a_460_290# WL15 SL4 VSS sky130_fd_pr__nfet_g5v0d10v5 ad=0.65 pd=3.3 as=0 ps=0 w=1 l=0.5
X1213 BLP4 rr2t2r_0[15|4]/a_60_290# sky130_fd_pr_reram__reram_cell area_ox=0.0676
X1214 BLN4 rr2t2r_0[15|4]/a_460_290# sky130_fd_pr_reram__reram_cell area_ox=0.0676
X1215 rr2t2r_0[15|4]/a_60_290# WL15 SL4 VSS sky130_fd_pr__nfet_g5v0d10v5 ad=0.65 pd=3.3 as=0 ps=0 w=1 l=0.5
X1216 rr2t2r_0[16|4]/a_460_290# WL16 SL4 VSS sky130_fd_pr__nfet_g5v0d10v5 ad=0.65 pd=3.3 as=0 ps=0 w=1 l=0.5
X1217 BLP4 rr2t2r_0[16|4]/a_60_290# sky130_fd_pr_reram__reram_cell area_ox=0.0676
X1218 BLN4 rr2t2r_0[16|4]/a_460_290# sky130_fd_pr_reram__reram_cell area_ox=0.0676
X1219 rr2t2r_0[16|4]/a_60_290# WL16 SL4 VSS sky130_fd_pr__nfet_g5v0d10v5 ad=0.65 pd=3.3 as=0 ps=0 w=1 l=0.5
X1220 rr2t2r_0[17|4]/a_460_290# WL17 SL4 VSS sky130_fd_pr__nfet_g5v0d10v5 ad=0.65 pd=3.3 as=0 ps=0 w=1 l=0.5
X1221 BLP4 rr2t2r_0[17|4]/a_60_290# sky130_fd_pr_reram__reram_cell area_ox=0.0676
X1222 BLN4 rr2t2r_0[17|4]/a_460_290# sky130_fd_pr_reram__reram_cell area_ox=0.0676
X1223 rr2t2r_0[17|4]/a_60_290# WL17 SL4 VSS sky130_fd_pr__nfet_g5v0d10v5 ad=0.65 pd=3.3 as=0 ps=0 w=1 l=0.5
X1224 rr2t2r_0[18|4]/a_460_290# WL18 SL4 VSS sky130_fd_pr__nfet_g5v0d10v5 ad=0.65 pd=3.3 as=0 ps=0 w=1 l=0.5
X1225 BLP4 rr2t2r_0[18|4]/a_60_290# sky130_fd_pr_reram__reram_cell area_ox=0.0676
X1226 BLN4 rr2t2r_0[18|4]/a_460_290# sky130_fd_pr_reram__reram_cell area_ox=0.0676
X1227 rr2t2r_0[18|4]/a_60_290# WL18 SL4 VSS sky130_fd_pr__nfet_g5v0d10v5 ad=0.65 pd=3.3 as=0 ps=0 w=1 l=0.5
X1228 rr2t2r_0[19|4]/a_460_290# WL19 SL4 VSS sky130_fd_pr__nfet_g5v0d10v5 ad=0.65 pd=3.3 as=0 ps=0 w=1 l=0.5
X1229 BLP4 rr2t2r_0[19|4]/a_60_290# sky130_fd_pr_reram__reram_cell area_ox=0.0676
X1230 BLN4 rr2t2r_0[19|4]/a_460_290# sky130_fd_pr_reram__reram_cell area_ox=0.0676
X1231 rr2t2r_0[19|4]/a_60_290# WL19 SL4 VSS sky130_fd_pr__nfet_g5v0d10v5 ad=0.65 pd=3.3 as=0 ps=0 w=1 l=0.5
X1232 rr2t2r_0[20|4]/a_460_290# WL20 SL4 VSS sky130_fd_pr__nfet_g5v0d10v5 ad=0.65 pd=3.3 as=0 ps=0 w=1 l=0.5
X1233 BLP4 rr2t2r_0[20|4]/a_60_290# sky130_fd_pr_reram__reram_cell area_ox=0.0676
X1234 BLN4 rr2t2r_0[20|4]/a_460_290# sky130_fd_pr_reram__reram_cell area_ox=0.0676
X1235 rr2t2r_0[20|4]/a_60_290# WL20 SL4 VSS sky130_fd_pr__nfet_g5v0d10v5 ad=0.65 pd=3.3 as=0 ps=0 w=1 l=0.5
X1236 rr2t2r_0[21|4]/a_460_290# WL21 SL4 VSS sky130_fd_pr__nfet_g5v0d10v5 ad=0.65 pd=3.3 as=0 ps=0 w=1 l=0.5
X1237 BLP4 rr2t2r_0[21|4]/a_60_290# sky130_fd_pr_reram__reram_cell area_ox=0.0676
X1238 BLN4 rr2t2r_0[21|4]/a_460_290# sky130_fd_pr_reram__reram_cell area_ox=0.0676
X1239 rr2t2r_0[21|4]/a_60_290# WL21 SL4 VSS sky130_fd_pr__nfet_g5v0d10v5 ad=0.65 pd=3.3 as=0 ps=0 w=1 l=0.5
X1240 rr2t2r_0[22|4]/a_460_290# WL22 SL4 VSS sky130_fd_pr__nfet_g5v0d10v5 ad=0.65 pd=3.3 as=0 ps=0 w=1 l=0.5
X1241 BLP4 rr2t2r_0[22|4]/a_60_290# sky130_fd_pr_reram__reram_cell area_ox=0.0676
X1242 BLN4 rr2t2r_0[22|4]/a_460_290# sky130_fd_pr_reram__reram_cell area_ox=0.0676
X1243 rr2t2r_0[22|4]/a_60_290# WL22 SL4 VSS sky130_fd_pr__nfet_g5v0d10v5 ad=0.65 pd=3.3 as=0 ps=0 w=1 l=0.5
X1244 rr2t2r_0[23|4]/a_460_290# WL23 SL4 VSS sky130_fd_pr__nfet_g5v0d10v5 ad=0.65 pd=3.3 as=0 ps=0 w=1 l=0.5
X1245 BLP4 rr2t2r_0[23|4]/a_60_290# sky130_fd_pr_reram__reram_cell area_ox=0.0676
X1246 BLN4 rr2t2r_0[23|4]/a_460_290# sky130_fd_pr_reram__reram_cell area_ox=0.0676
X1247 rr2t2r_0[23|4]/a_60_290# WL23 SL4 VSS sky130_fd_pr__nfet_g5v0d10v5 ad=0.65 pd=3.3 as=0 ps=0 w=1 l=0.5
X1248 rr2t2r_0[24|4]/a_460_290# WL24 SL4 VSS sky130_fd_pr__nfet_g5v0d10v5 ad=0.65 pd=3.3 as=0 ps=0 w=1 l=0.5
X1249 BLP4 rr2t2r_0[24|4]/a_60_290# sky130_fd_pr_reram__reram_cell area_ox=0.0676
X1250 BLN4 rr2t2r_0[24|4]/a_460_290# sky130_fd_pr_reram__reram_cell area_ox=0.0676
X1251 rr2t2r_0[24|4]/a_60_290# WL24 SL4 VSS sky130_fd_pr__nfet_g5v0d10v5 ad=0.65 pd=3.3 as=0 ps=0 w=1 l=0.5
X1252 rr2t2r_0[25|4]/a_460_290# WL25 SL4 VSS sky130_fd_pr__nfet_g5v0d10v5 ad=0.65 pd=3.3 as=0 ps=0 w=1 l=0.5
X1253 BLP4 rr2t2r_0[25|4]/a_60_290# sky130_fd_pr_reram__reram_cell area_ox=0.0676
X1254 BLN4 rr2t2r_0[25|4]/a_460_290# sky130_fd_pr_reram__reram_cell area_ox=0.0676
X1255 rr2t2r_0[25|4]/a_60_290# WL25 SL4 VSS sky130_fd_pr__nfet_g5v0d10v5 ad=0.65 pd=3.3 as=0 ps=0 w=1 l=0.5
X1256 rr2t2r_0[26|4]/a_460_290# WL26 SL4 VSS sky130_fd_pr__nfet_g5v0d10v5 ad=0.65 pd=3.3 as=0 ps=0 w=1 l=0.5
X1257 BLP4 rr2t2r_0[26|4]/a_60_290# sky130_fd_pr_reram__reram_cell area_ox=0.0676
X1258 BLN4 rr2t2r_0[26|4]/a_460_290# sky130_fd_pr_reram__reram_cell area_ox=0.0676
X1259 rr2t2r_0[26|4]/a_60_290# WL26 SL4 VSS sky130_fd_pr__nfet_g5v0d10v5 ad=0.65 pd=3.3 as=0 ps=0 w=1 l=0.5
X1260 rr2t2r_0[27|4]/a_460_290# WL27 SL4 VSS sky130_fd_pr__nfet_g5v0d10v5 ad=0.65 pd=3.3 as=0 ps=0 w=1 l=0.5
X1261 BLP4 rr2t2r_0[27|4]/a_60_290# sky130_fd_pr_reram__reram_cell area_ox=0.0676
X1262 BLN4 rr2t2r_0[27|4]/a_460_290# sky130_fd_pr_reram__reram_cell area_ox=0.0676
X1263 rr2t2r_0[27|4]/a_60_290# WL27 SL4 VSS sky130_fd_pr__nfet_g5v0d10v5 ad=0.65 pd=3.3 as=0 ps=0 w=1 l=0.5
X1264 rr2t2r_0[28|4]/a_460_290# WL28 SL4 VSS sky130_fd_pr__nfet_g5v0d10v5 ad=0.65 pd=3.3 as=0 ps=0 w=1 l=0.5
X1265 BLP4 rr2t2r_0[28|4]/a_60_290# sky130_fd_pr_reram__reram_cell area_ox=0.0676
X1266 BLN4 rr2t2r_0[28|4]/a_460_290# sky130_fd_pr_reram__reram_cell area_ox=0.0676
X1267 rr2t2r_0[28|4]/a_60_290# WL28 SL4 VSS sky130_fd_pr__nfet_g5v0d10v5 ad=0.65 pd=3.3 as=0 ps=0 w=1 l=0.5
X1268 rr2t2r_0[29|4]/a_460_290# WL29 SL4 VSS sky130_fd_pr__nfet_g5v0d10v5 ad=0.65 pd=3.3 as=0 ps=0 w=1 l=0.5
X1269 BLP4 rr2t2r_0[29|4]/a_60_290# sky130_fd_pr_reram__reram_cell area_ox=0.0676
X1270 BLN4 rr2t2r_0[29|4]/a_460_290# sky130_fd_pr_reram__reram_cell area_ox=0.0676
X1271 rr2t2r_0[29|4]/a_60_290# WL29 SL4 VSS sky130_fd_pr__nfet_g5v0d10v5 ad=0.65 pd=3.3 as=0 ps=0 w=1 l=0.5
X1272 rr2t2r_0[30|4]/a_460_290# WL30 SL4 VSS sky130_fd_pr__nfet_g5v0d10v5 ad=0.65 pd=3.3 as=0 ps=0 w=1 l=0.5
X1273 BLP4 rr2t2r_0[30|4]/a_60_290# sky130_fd_pr_reram__reram_cell area_ox=0.0676
X1274 BLN4 rr2t2r_0[30|4]/a_460_290# sky130_fd_pr_reram__reram_cell area_ox=0.0676
X1275 rr2t2r_0[30|4]/a_60_290# WL30 SL4 VSS sky130_fd_pr__nfet_g5v0d10v5 ad=0.65 pd=3.3 as=0 ps=0 w=1 l=0.5
X1276 rr2t2r_0[31|4]/a_460_290# WL31 SL4 VSS sky130_fd_pr__nfet_g5v0d10v5 ad=0.65 pd=3.3 as=0 ps=0 w=1 l=0.5
X1277 BLP4 rr2t2r_0[31|4]/a_60_290# sky130_fd_pr_reram__reram_cell area_ox=0.0676
X1278 BLN4 rr2t2r_0[31|4]/a_460_290# sky130_fd_pr_reram__reram_cell area_ox=0.0676
X1279 rr2t2r_0[31|4]/a_60_290# WL31 SL4 VSS sky130_fd_pr__nfet_g5v0d10v5 ad=0.65 pd=3.3 as=0 ps=0 w=1 l=0.5
X1280 rr2t2r_0[32|4]/a_460_290# WL32 SL4 VSS sky130_fd_pr__nfet_g5v0d10v5 ad=0.65 pd=3.3 as=0 ps=0 w=1 l=0.5
X1281 BLP4 rr2t2r_0[32|4]/a_60_290# sky130_fd_pr_reram__reram_cell area_ox=0.0676
X1282 BLN4 rr2t2r_0[32|4]/a_460_290# sky130_fd_pr_reram__reram_cell area_ox=0.0676
X1283 rr2t2r_0[32|4]/a_60_290# WL32 SL4 VSS sky130_fd_pr__nfet_g5v0d10v5 ad=0.65 pd=3.3 as=0 ps=0 w=1 l=0.5
X1284 rr2t2r_0[33|4]/a_460_290# WL33 SL4 VSS sky130_fd_pr__nfet_g5v0d10v5 ad=0.65 pd=3.3 as=0 ps=0 w=1 l=0.5
X1285 BLP4 rr2t2r_0[33|4]/a_60_290# sky130_fd_pr_reram__reram_cell area_ox=0.0676
X1286 BLN4 rr2t2r_0[33|4]/a_460_290# sky130_fd_pr_reram__reram_cell area_ox=0.0676
X1287 rr2t2r_0[33|4]/a_60_290# WL33 SL4 VSS sky130_fd_pr__nfet_g5v0d10v5 ad=0.65 pd=3.3 as=0 ps=0 w=1 l=0.5
X1288 rr2t2r_0[34|4]/a_460_290# WL34 SL4 VSS sky130_fd_pr__nfet_g5v0d10v5 ad=0.65 pd=3.3 as=0 ps=0 w=1 l=0.5
X1289 BLP4 rr2t2r_0[34|4]/a_60_290# sky130_fd_pr_reram__reram_cell area_ox=0.0676
X1290 BLN4 rr2t2r_0[34|4]/a_460_290# sky130_fd_pr_reram__reram_cell area_ox=0.0676
X1291 rr2t2r_0[34|4]/a_60_290# WL34 SL4 VSS sky130_fd_pr__nfet_g5v0d10v5 ad=0.65 pd=3.3 as=0 ps=0 w=1 l=0.5
X1292 rr2t2r_0[35|4]/a_460_290# WL35 SL4 VSS sky130_fd_pr__nfet_g5v0d10v5 ad=0.65 pd=3.3 as=0 ps=0 w=1 l=0.5
X1293 BLP4 rr2t2r_0[35|4]/a_60_290# sky130_fd_pr_reram__reram_cell area_ox=0.0676
X1294 BLN4 rr2t2r_0[35|4]/a_460_290# sky130_fd_pr_reram__reram_cell area_ox=0.0676
X1295 rr2t2r_0[35|4]/a_60_290# WL35 SL4 VSS sky130_fd_pr__nfet_g5v0d10v5 ad=0.65 pd=3.3 as=0 ps=0 w=1 l=0.5
X1296 rr2t2r_0[36|4]/a_460_290# WL36 SL4 VSS sky130_fd_pr__nfet_g5v0d10v5 ad=0.65 pd=3.3 as=0 ps=0 w=1 l=0.5
X1297 BLP4 rr2t2r_0[36|4]/a_60_290# sky130_fd_pr_reram__reram_cell area_ox=0.0676
X1298 BLN4 rr2t2r_0[36|4]/a_460_290# sky130_fd_pr_reram__reram_cell area_ox=0.0676
X1299 rr2t2r_0[36|4]/a_60_290# WL36 SL4 VSS sky130_fd_pr__nfet_g5v0d10v5 ad=0.65 pd=3.3 as=0 ps=0 w=1 l=0.5
X1300 rr2t2r_0[37|4]/a_460_290# WL37 SL4 VSS sky130_fd_pr__nfet_g5v0d10v5 ad=0.65 pd=3.3 as=0 ps=0 w=1 l=0.5
X1301 BLP4 rr2t2r_0[37|4]/a_60_290# sky130_fd_pr_reram__reram_cell area_ox=0.0676
X1302 BLN4 rr2t2r_0[37|4]/a_460_290# sky130_fd_pr_reram__reram_cell area_ox=0.0676
X1303 rr2t2r_0[37|4]/a_60_290# WL37 SL4 VSS sky130_fd_pr__nfet_g5v0d10v5 ad=0.65 pd=3.3 as=0 ps=0 w=1 l=0.5
X1304 rr2t2r_0[38|4]/a_460_290# WL38 SL4 VSS sky130_fd_pr__nfet_g5v0d10v5 ad=0.65 pd=3.3 as=0 ps=0 w=1 l=0.5
X1305 BLP4 rr2t2r_0[38|4]/a_60_290# sky130_fd_pr_reram__reram_cell area_ox=0.0676
X1306 BLN4 rr2t2r_0[38|4]/a_460_290# sky130_fd_pr_reram__reram_cell area_ox=0.0676
X1307 rr2t2r_0[38|4]/a_60_290# WL38 SL4 VSS sky130_fd_pr__nfet_g5v0d10v5 ad=0.65 pd=3.3 as=0 ps=0 w=1 l=0.5
X1308 rr2t2r_0[39|4]/a_460_290# WL39 SL4 VSS sky130_fd_pr__nfet_g5v0d10v5 ad=0.65 pd=3.3 as=0 ps=0 w=1 l=0.5
X1309 BLP4 rr2t2r_0[39|4]/a_60_290# sky130_fd_pr_reram__reram_cell area_ox=0.0676
X1310 BLN4 rr2t2r_0[39|4]/a_460_290# sky130_fd_pr_reram__reram_cell area_ox=0.0676
X1311 rr2t2r_0[39|4]/a_60_290# WL39 SL4 VSS sky130_fd_pr__nfet_g5v0d10v5 ad=0.65 pd=3.3 as=0 ps=0 w=1 l=0.5
X1312 rr2t2r_0[40|4]/a_460_290# WL40 SL4 VSS sky130_fd_pr__nfet_g5v0d10v5 ad=0.65 pd=3.3 as=0 ps=0 w=1 l=0.5
X1313 BLP4 rr2t2r_0[40|4]/a_60_290# sky130_fd_pr_reram__reram_cell area_ox=0.0676
X1314 BLN4 rr2t2r_0[40|4]/a_460_290# sky130_fd_pr_reram__reram_cell area_ox=0.0676
X1315 rr2t2r_0[40|4]/a_60_290# WL40 SL4 VSS sky130_fd_pr__nfet_g5v0d10v5 ad=0.65 pd=3.3 as=0 ps=0 w=1 l=0.5
X1316 rr2t2r_0[41|4]/a_460_290# WL41 SL4 VSS sky130_fd_pr__nfet_g5v0d10v5 ad=0.65 pd=3.3 as=0 ps=0 w=1 l=0.5
X1317 BLP4 rr2t2r_0[41|4]/a_60_290# sky130_fd_pr_reram__reram_cell area_ox=0.0676
X1318 BLN4 rr2t2r_0[41|4]/a_460_290# sky130_fd_pr_reram__reram_cell area_ox=0.0676
X1319 rr2t2r_0[41|4]/a_60_290# WL41 SL4 VSS sky130_fd_pr__nfet_g5v0d10v5 ad=0.65 pd=3.3 as=0 ps=0 w=1 l=0.5
X1320 rr2t2r_0[42|4]/a_460_290# WL42 SL4 VSS sky130_fd_pr__nfet_g5v0d10v5 ad=0.65 pd=3.3 as=0 ps=0 w=1 l=0.5
X1321 BLP4 rr2t2r_0[42|4]/a_60_290# sky130_fd_pr_reram__reram_cell area_ox=0.0676
X1322 BLN4 rr2t2r_0[42|4]/a_460_290# sky130_fd_pr_reram__reram_cell area_ox=0.0676
X1323 rr2t2r_0[42|4]/a_60_290# WL42 SL4 VSS sky130_fd_pr__nfet_g5v0d10v5 ad=0.65 pd=3.3 as=0 ps=0 w=1 l=0.5
X1324 rr2t2r_0[43|4]/a_460_290# WL43 SL4 VSS sky130_fd_pr__nfet_g5v0d10v5 ad=0.65 pd=3.3 as=0 ps=0 w=1 l=0.5
X1325 BLP4 rr2t2r_0[43|4]/a_60_290# sky130_fd_pr_reram__reram_cell area_ox=0.0676
X1326 BLN4 rr2t2r_0[43|4]/a_460_290# sky130_fd_pr_reram__reram_cell area_ox=0.0676
X1327 rr2t2r_0[43|4]/a_60_290# WL43 SL4 VSS sky130_fd_pr__nfet_g5v0d10v5 ad=0.65 pd=3.3 as=0 ps=0 w=1 l=0.5
X1328 rr2t2r_0[44|4]/a_460_290# WL44 SL4 VSS sky130_fd_pr__nfet_g5v0d10v5 ad=0.65 pd=3.3 as=0 ps=0 w=1 l=0.5
X1329 BLP4 rr2t2r_0[44|4]/a_60_290# sky130_fd_pr_reram__reram_cell area_ox=0.0676
X1330 BLN4 rr2t2r_0[44|4]/a_460_290# sky130_fd_pr_reram__reram_cell area_ox=0.0676
X1331 rr2t2r_0[44|4]/a_60_290# WL44 SL4 VSS sky130_fd_pr__nfet_g5v0d10v5 ad=0.65 pd=3.3 as=0 ps=0 w=1 l=0.5
X1332 rr2t2r_0[45|4]/a_460_290# WL45 SL4 VSS sky130_fd_pr__nfet_g5v0d10v5 ad=0.65 pd=3.3 as=0 ps=0 w=1 l=0.5
X1333 BLP4 rr2t2r_0[45|4]/a_60_290# sky130_fd_pr_reram__reram_cell area_ox=0.0676
X1334 BLN4 rr2t2r_0[45|4]/a_460_290# sky130_fd_pr_reram__reram_cell area_ox=0.0676
X1335 rr2t2r_0[45|4]/a_60_290# WL45 SL4 VSS sky130_fd_pr__nfet_g5v0d10v5 ad=0.65 pd=3.3 as=0 ps=0 w=1 l=0.5
X1336 rr2t2r_0[46|4]/a_460_290# WL46 SL4 VSS sky130_fd_pr__nfet_g5v0d10v5 ad=0.65 pd=3.3 as=0 ps=0 w=1 l=0.5
X1337 BLP4 rr2t2r_0[46|4]/a_60_290# sky130_fd_pr_reram__reram_cell area_ox=0.0676
X1338 BLN4 rr2t2r_0[46|4]/a_460_290# sky130_fd_pr_reram__reram_cell area_ox=0.0676
X1339 rr2t2r_0[46|4]/a_60_290# WL46 SL4 VSS sky130_fd_pr__nfet_g5v0d10v5 ad=0.65 pd=3.3 as=0 ps=0 w=1 l=0.5
X1340 rr2t2r_0[47|4]/a_460_290# WL47 SL4 VSS sky130_fd_pr__nfet_g5v0d10v5 ad=0.65 pd=3.3 as=0 ps=0 w=1 l=0.5
X1341 BLP4 rr2t2r_0[47|4]/a_60_290# sky130_fd_pr_reram__reram_cell area_ox=0.0676
X1342 BLN4 rr2t2r_0[47|4]/a_460_290# sky130_fd_pr_reram__reram_cell area_ox=0.0676
X1343 rr2t2r_0[47|4]/a_60_290# WL47 SL4 VSS sky130_fd_pr__nfet_g5v0d10v5 ad=0.65 pd=3.3 as=0 ps=0 w=1 l=0.5
X1344 rr2t2r_0[48|4]/a_460_290# WL48 SL4 VSS sky130_fd_pr__nfet_g5v0d10v5 ad=0.65 pd=3.3 as=0 ps=0 w=1 l=0.5
X1345 BLP4 rr2t2r_0[48|4]/a_60_290# sky130_fd_pr_reram__reram_cell area_ox=0.0676
X1346 BLN4 rr2t2r_0[48|4]/a_460_290# sky130_fd_pr_reram__reram_cell area_ox=0.0676
X1347 rr2t2r_0[48|4]/a_60_290# WL48 SL4 VSS sky130_fd_pr__nfet_g5v0d10v5 ad=0.65 pd=3.3 as=0 ps=0 w=1 l=0.5
X1348 rr2t2r_0[49|4]/a_460_290# WL49 SL4 VSS sky130_fd_pr__nfet_g5v0d10v5 ad=0.65 pd=3.3 as=0 ps=0 w=1 l=0.5
X1349 BLP4 rr2t2r_0[49|4]/a_60_290# sky130_fd_pr_reram__reram_cell area_ox=0.0676
X1350 BLN4 rr2t2r_0[49|4]/a_460_290# sky130_fd_pr_reram__reram_cell area_ox=0.0676
X1351 rr2t2r_0[49|4]/a_60_290# WL49 SL4 VSS sky130_fd_pr__nfet_g5v0d10v5 ad=0.65 pd=3.3 as=0 ps=0 w=1 l=0.5
X1352 rr2t2r_0[50|4]/a_460_290# WL50 SL4 VSS sky130_fd_pr__nfet_g5v0d10v5 ad=0.65 pd=3.3 as=0 ps=0 w=1 l=0.5
X1353 BLP4 rr2t2r_0[50|4]/a_60_290# sky130_fd_pr_reram__reram_cell area_ox=0.0676
X1354 BLN4 rr2t2r_0[50|4]/a_460_290# sky130_fd_pr_reram__reram_cell area_ox=0.0676
X1355 rr2t2r_0[50|4]/a_60_290# WL50 SL4 VSS sky130_fd_pr__nfet_g5v0d10v5 ad=0.65 pd=3.3 as=0 ps=0 w=1 l=0.5
X1356 rr2t2r_0[51|4]/a_460_290# WL51 SL4 VSS sky130_fd_pr__nfet_g5v0d10v5 ad=0.65 pd=3.3 as=0 ps=0 w=1 l=0.5
X1357 BLP4 rr2t2r_0[51|4]/a_60_290# sky130_fd_pr_reram__reram_cell area_ox=0.0676
X1358 BLN4 rr2t2r_0[51|4]/a_460_290# sky130_fd_pr_reram__reram_cell area_ox=0.0676
X1359 rr2t2r_0[51|4]/a_60_290# WL51 SL4 VSS sky130_fd_pr__nfet_g5v0d10v5 ad=0.65 pd=3.3 as=0 ps=0 w=1 l=0.5
X1360 rr2t2r_0[52|4]/a_460_290# WL52 SL4 VSS sky130_fd_pr__nfet_g5v0d10v5 ad=0.65 pd=3.3 as=0 ps=0 w=1 l=0.5
X1361 BLP4 rr2t2r_0[52|4]/a_60_290# sky130_fd_pr_reram__reram_cell area_ox=0.0676
X1362 BLN4 rr2t2r_0[52|4]/a_460_290# sky130_fd_pr_reram__reram_cell area_ox=0.0676
X1363 rr2t2r_0[52|4]/a_60_290# WL52 SL4 VSS sky130_fd_pr__nfet_g5v0d10v5 ad=0.65 pd=3.3 as=0 ps=0 w=1 l=0.5
X1364 rr2t2r_0[53|4]/a_460_290# WL53 SL4 VSS sky130_fd_pr__nfet_g5v0d10v5 ad=0.65 pd=3.3 as=0 ps=0 w=1 l=0.5
X1365 BLP4 rr2t2r_0[53|4]/a_60_290# sky130_fd_pr_reram__reram_cell area_ox=0.0676
X1366 BLN4 rr2t2r_0[53|4]/a_460_290# sky130_fd_pr_reram__reram_cell area_ox=0.0676
X1367 rr2t2r_0[53|4]/a_60_290# WL53 SL4 VSS sky130_fd_pr__nfet_g5v0d10v5 ad=0.65 pd=3.3 as=0 ps=0 w=1 l=0.5
X1368 rr2t2r_0[54|4]/a_460_290# WL54 SL4 VSS sky130_fd_pr__nfet_g5v0d10v5 ad=0.65 pd=3.3 as=0 ps=0 w=1 l=0.5
X1369 BLP4 rr2t2r_0[54|4]/a_60_290# sky130_fd_pr_reram__reram_cell area_ox=0.0676
X1370 BLN4 rr2t2r_0[54|4]/a_460_290# sky130_fd_pr_reram__reram_cell area_ox=0.0676
X1371 rr2t2r_0[54|4]/a_60_290# WL54 SL4 VSS sky130_fd_pr__nfet_g5v0d10v5 ad=0.65 pd=3.3 as=0 ps=0 w=1 l=0.5
X1372 rr2t2r_0[55|4]/a_460_290# WL55 SL4 VSS sky130_fd_pr__nfet_g5v0d10v5 ad=0.65 pd=3.3 as=0 ps=0 w=1 l=0.5
X1373 BLP4 rr2t2r_0[55|4]/a_60_290# sky130_fd_pr_reram__reram_cell area_ox=0.0676
X1374 BLN4 rr2t2r_0[55|4]/a_460_290# sky130_fd_pr_reram__reram_cell area_ox=0.0676
X1375 rr2t2r_0[55|4]/a_60_290# WL55 SL4 VSS sky130_fd_pr__nfet_g5v0d10v5 ad=0.65 pd=3.3 as=0 ps=0 w=1 l=0.5
X1376 rr2t2r_0[56|4]/a_460_290# WL56 SL4 VSS sky130_fd_pr__nfet_g5v0d10v5 ad=0.65 pd=3.3 as=0 ps=0 w=1 l=0.5
X1377 BLP4 rr2t2r_0[56|4]/a_60_290# sky130_fd_pr_reram__reram_cell area_ox=0.0676
X1378 BLN4 rr2t2r_0[56|4]/a_460_290# sky130_fd_pr_reram__reram_cell area_ox=0.0676
X1379 rr2t2r_0[56|4]/a_60_290# WL56 SL4 VSS sky130_fd_pr__nfet_g5v0d10v5 ad=0.65 pd=3.3 as=0 ps=0 w=1 l=0.5
X1380 rr2t2r_0[57|4]/a_460_290# WL57 SL4 VSS sky130_fd_pr__nfet_g5v0d10v5 ad=0.65 pd=3.3 as=0 ps=0 w=1 l=0.5
X1381 BLP4 rr2t2r_0[57|4]/a_60_290# sky130_fd_pr_reram__reram_cell area_ox=0.0676
X1382 BLN4 rr2t2r_0[57|4]/a_460_290# sky130_fd_pr_reram__reram_cell area_ox=0.0676
X1383 rr2t2r_0[57|4]/a_60_290# WL57 SL4 VSS sky130_fd_pr__nfet_g5v0d10v5 ad=0.65 pd=3.3 as=0 ps=0 w=1 l=0.5
X1384 rr2t2r_0[58|4]/a_460_290# WL58 SL4 VSS sky130_fd_pr__nfet_g5v0d10v5 ad=0.65 pd=3.3 as=0 ps=0 w=1 l=0.5
X1385 BLP4 rr2t2r_0[58|4]/a_60_290# sky130_fd_pr_reram__reram_cell area_ox=0.0676
X1386 BLN4 rr2t2r_0[58|4]/a_460_290# sky130_fd_pr_reram__reram_cell area_ox=0.0676
X1387 rr2t2r_0[58|4]/a_60_290# WL58 SL4 VSS sky130_fd_pr__nfet_g5v0d10v5 ad=0.65 pd=3.3 as=0 ps=0 w=1 l=0.5
X1388 rr2t2r_0[59|4]/a_460_290# WL59 SL4 VSS sky130_fd_pr__nfet_g5v0d10v5 ad=0.65 pd=3.3 as=0 ps=0 w=1 l=0.5
X1389 BLP4 rr2t2r_0[59|4]/a_60_290# sky130_fd_pr_reram__reram_cell area_ox=0.0676
X1390 BLN4 rr2t2r_0[59|4]/a_460_290# sky130_fd_pr_reram__reram_cell area_ox=0.0676
X1391 rr2t2r_0[59|4]/a_60_290# WL59 SL4 VSS sky130_fd_pr__nfet_g5v0d10v5 ad=0.65 pd=3.3 as=0 ps=0 w=1 l=0.5
X1392 rr2t2r_0[60|4]/a_460_290# WL60 SL4 VSS sky130_fd_pr__nfet_g5v0d10v5 ad=0.65 pd=3.3 as=0 ps=0 w=1 l=0.5
X1393 BLP4 rr2t2r_0[60|4]/a_60_290# sky130_fd_pr_reram__reram_cell area_ox=0.0676
X1394 BLN4 rr2t2r_0[60|4]/a_460_290# sky130_fd_pr_reram__reram_cell area_ox=0.0676
X1395 rr2t2r_0[60|4]/a_60_290# WL60 SL4 VSS sky130_fd_pr__nfet_g5v0d10v5 ad=0.65 pd=3.3 as=0 ps=0 w=1 l=0.5
X1396 rr2t2r_0[61|4]/a_460_290# WL61 SL4 VSS sky130_fd_pr__nfet_g5v0d10v5 ad=0.65 pd=3.3 as=0 ps=0 w=1 l=0.5
X1397 BLP4 rr2t2r_0[61|4]/a_60_290# sky130_fd_pr_reram__reram_cell area_ox=0.0676
X1398 BLN4 rr2t2r_0[61|4]/a_460_290# sky130_fd_pr_reram__reram_cell area_ox=0.0676
X1399 rr2t2r_0[61|4]/a_60_290# WL61 SL4 VSS sky130_fd_pr__nfet_g5v0d10v5 ad=0.65 pd=3.3 as=0 ps=0 w=1 l=0.5
X1400 rr2t2r_0[62|4]/a_460_290# WL62 SL4 VSS sky130_fd_pr__nfet_g5v0d10v5 ad=0.65 pd=3.3 as=0 ps=0 w=1 l=0.5
X1401 BLP4 rr2t2r_0[62|4]/a_60_290# sky130_fd_pr_reram__reram_cell area_ox=0.0676
X1402 BLN4 rr2t2r_0[62|4]/a_460_290# sky130_fd_pr_reram__reram_cell area_ox=0.0676
X1403 rr2t2r_0[62|4]/a_60_290# WL62 SL4 VSS sky130_fd_pr__nfet_g5v0d10v5 ad=0.65 pd=3.3 as=0 ps=0 w=1 l=0.5
X1404 rr2t2r_0[63|4]/a_460_290# WL63 SL4 VSS sky130_fd_pr__nfet_g5v0d10v5 ad=0.65 pd=3.3 as=0 ps=0 w=1 l=0.5
X1405 BLP4 rr2t2r_0[63|4]/a_60_290# sky130_fd_pr_reram__reram_cell area_ox=0.0676
X1406 BLN4 rr2t2r_0[63|4]/a_460_290# sky130_fd_pr_reram__reram_cell area_ox=0.0676
X1407 rr2t2r_0[63|4]/a_60_290# WL63 SL4 VSS sky130_fd_pr__nfet_g5v0d10v5 ad=0.65 pd=3.3 as=0 ps=0 w=1 l=0.5
X1408 rr2t2r_0[64|4]/a_460_290# WL64 SL4 VSS sky130_fd_pr__nfet_g5v0d10v5 ad=0.65 pd=3.3 as=0 ps=0 w=1 l=0.5
X1409 BLP4 rr2t2r_0[64|4]/a_60_290# sky130_fd_pr_reram__reram_cell area_ox=0.0676
X1410 BLN4 rr2t2r_0[64|4]/a_460_290# sky130_fd_pr_reram__reram_cell area_ox=0.0676
X1411 rr2t2r_0[64|4]/a_60_290# WL64 SL4 VSS sky130_fd_pr__nfet_g5v0d10v5 ad=0.65 pd=3.3 as=0 ps=0 w=1 l=0.5
X1412 rr2t2r_0[65|4]/a_460_290# WL65 SL4 VSS sky130_fd_pr__nfet_g5v0d10v5 ad=0.65 pd=3.3 as=0 ps=0 w=1 l=0.5
X1413 BLP4 rr2t2r_0[65|4]/a_60_290# sky130_fd_pr_reram__reram_cell area_ox=0.0676
X1414 BLN4 rr2t2r_0[65|4]/a_460_290# sky130_fd_pr_reram__reram_cell area_ox=0.0676
X1415 rr2t2r_0[65|4]/a_60_290# WL65 SL4 VSS sky130_fd_pr__nfet_g5v0d10v5 ad=0.65 pd=3.3 as=0 ps=0 w=1 l=0.5
X1416 rr2t2r_0[66|4]/a_460_290# WL66 SL4 VSS sky130_fd_pr__nfet_g5v0d10v5 ad=0.65 pd=3.3 as=0 ps=0 w=1 l=0.5
X1417 BLP4 rr2t2r_0[66|4]/a_60_290# sky130_fd_pr_reram__reram_cell area_ox=0.0676
X1418 BLN4 rr2t2r_0[66|4]/a_460_290# sky130_fd_pr_reram__reram_cell area_ox=0.0676
X1419 rr2t2r_0[66|4]/a_60_290# WL66 SL4 VSS sky130_fd_pr__nfet_g5v0d10v5 ad=0.65 pd=3.3 as=0 ps=0 w=1 l=0.5
X1420 rr2t2r_0[67|4]/a_460_290# WL67 SL4 VSS sky130_fd_pr__nfet_g5v0d10v5 ad=0.65 pd=3.3 as=0 ps=0 w=1 l=0.5
X1421 BLP4 rr2t2r_0[67|4]/a_60_290# sky130_fd_pr_reram__reram_cell area_ox=0.0676
X1422 BLN4 rr2t2r_0[67|4]/a_460_290# sky130_fd_pr_reram__reram_cell area_ox=0.0676
X1423 rr2t2r_0[67|4]/a_60_290# WL67 SL4 VSS sky130_fd_pr__nfet_g5v0d10v5 ad=0.65 pd=3.3 as=0 ps=0 w=1 l=0.5
X1424 rr2t2r_0[68|4]/a_460_290# WL68 SL4 VSS sky130_fd_pr__nfet_g5v0d10v5 ad=0.65 pd=3.3 as=0 ps=0 w=1 l=0.5
X1425 BLP4 rr2t2r_0[68|4]/a_60_290# sky130_fd_pr_reram__reram_cell area_ox=0.0676
X1426 BLN4 rr2t2r_0[68|4]/a_460_290# sky130_fd_pr_reram__reram_cell area_ox=0.0676
X1427 rr2t2r_0[68|4]/a_60_290# WL68 SL4 VSS sky130_fd_pr__nfet_g5v0d10v5 ad=0.65 pd=3.3 as=0 ps=0 w=1 l=0.5
X1428 rr2t2r_0[69|4]/a_460_290# WL69 SL4 VSS sky130_fd_pr__nfet_g5v0d10v5 ad=0.65 pd=3.3 as=0 ps=0 w=1 l=0.5
X1429 BLP4 rr2t2r_0[69|4]/a_60_290# sky130_fd_pr_reram__reram_cell area_ox=0.0676
X1430 BLN4 rr2t2r_0[69|4]/a_460_290# sky130_fd_pr_reram__reram_cell area_ox=0.0676
X1431 rr2t2r_0[69|4]/a_60_290# WL69 SL4 VSS sky130_fd_pr__nfet_g5v0d10v5 ad=0.65 pd=3.3 as=0 ps=0 w=1 l=0.5
X1432 rr2t2r_0[70|4]/a_460_290# WL70 SL4 VSS sky130_fd_pr__nfet_g5v0d10v5 ad=0.65 pd=3.3 as=0 ps=0 w=1 l=0.5
X1433 BLP4 rr2t2r_0[70|4]/a_60_290# sky130_fd_pr_reram__reram_cell area_ox=0.0676
X1434 BLN4 rr2t2r_0[70|4]/a_460_290# sky130_fd_pr_reram__reram_cell area_ox=0.0676
X1435 rr2t2r_0[70|4]/a_60_290# WL70 SL4 VSS sky130_fd_pr__nfet_g5v0d10v5 ad=0.65 pd=3.3 as=0 ps=0 w=1 l=0.5
X1436 rr2t2r_0[71|4]/a_460_290# WL71 SL4 VSS sky130_fd_pr__nfet_g5v0d10v5 ad=0.65 pd=3.3 as=0 ps=0 w=1 l=0.5
X1437 BLP4 rr2t2r_0[71|4]/a_60_290# sky130_fd_pr_reram__reram_cell area_ox=0.0676
X1438 BLN4 rr2t2r_0[71|4]/a_460_290# sky130_fd_pr_reram__reram_cell area_ox=0.0676
X1439 rr2t2r_0[71|4]/a_60_290# WL71 SL4 VSS sky130_fd_pr__nfet_g5v0d10v5 ad=0.65 pd=3.3 as=0 ps=0 w=1 l=0.5
X1440 rr2t2r_0[0|5]/a_460_290# WL0 SL5 VSS sky130_fd_pr__nfet_g5v0d10v5 ad=0.65 pd=3.3 as=108 ps=504 w=1 l=0.5
X1441 BLP5 rr2t2r_0[0|5]/a_60_290# sky130_fd_pr_reram__reram_cell area_ox=0.0676
X1442 BLN5 rr2t2r_0[0|5]/a_460_290# sky130_fd_pr_reram__reram_cell area_ox=0.0676
X1443 rr2t2r_0[0|5]/a_60_290# WL0 SL5 VSS sky130_fd_pr__nfet_g5v0d10v5 ad=0.65 pd=3.3 as=0 ps=0 w=1 l=0.5
X1444 rr2t2r_0[1|5]/a_460_290# WL1 SL5 VSS sky130_fd_pr__nfet_g5v0d10v5 ad=0.65 pd=3.3 as=0 ps=0 w=1 l=0.5
X1445 BLP5 rr2t2r_0[1|5]/a_60_290# sky130_fd_pr_reram__reram_cell area_ox=0.0676
X1446 BLN5 rr2t2r_0[1|5]/a_460_290# sky130_fd_pr_reram__reram_cell area_ox=0.0676
X1447 rr2t2r_0[1|5]/a_60_290# WL1 SL5 VSS sky130_fd_pr__nfet_g5v0d10v5 ad=0.65 pd=3.3 as=0 ps=0 w=1 l=0.5
X1448 rr2t2r_0[2|5]/a_460_290# WL2 SL5 VSS sky130_fd_pr__nfet_g5v0d10v5 ad=0.65 pd=3.3 as=0 ps=0 w=1 l=0.5
X1449 BLP5 rr2t2r_0[2|5]/a_60_290# sky130_fd_pr_reram__reram_cell area_ox=0.0676
X1450 BLN5 rr2t2r_0[2|5]/a_460_290# sky130_fd_pr_reram__reram_cell area_ox=0.0676
X1451 rr2t2r_0[2|5]/a_60_290# WL2 SL5 VSS sky130_fd_pr__nfet_g5v0d10v5 ad=0.65 pd=3.3 as=0 ps=0 w=1 l=0.5
X1452 rr2t2r_0[3|5]/a_460_290# WL3 SL5 VSS sky130_fd_pr__nfet_g5v0d10v5 ad=0.65 pd=3.3 as=0 ps=0 w=1 l=0.5
X1453 BLP5 rr2t2r_0[3|5]/a_60_290# sky130_fd_pr_reram__reram_cell area_ox=0.0676
X1454 BLN5 rr2t2r_0[3|5]/a_460_290# sky130_fd_pr_reram__reram_cell area_ox=0.0676
X1455 rr2t2r_0[3|5]/a_60_290# WL3 SL5 VSS sky130_fd_pr__nfet_g5v0d10v5 ad=0.65 pd=3.3 as=0 ps=0 w=1 l=0.5
X1456 rr2t2r_0[4|5]/a_460_290# WL4 SL5 VSS sky130_fd_pr__nfet_g5v0d10v5 ad=0.65 pd=3.3 as=0 ps=0 w=1 l=0.5
X1457 BLP5 rr2t2r_0[4|5]/a_60_290# sky130_fd_pr_reram__reram_cell area_ox=0.0676
X1458 BLN5 rr2t2r_0[4|5]/a_460_290# sky130_fd_pr_reram__reram_cell area_ox=0.0676
X1459 rr2t2r_0[4|5]/a_60_290# WL4 SL5 VSS sky130_fd_pr__nfet_g5v0d10v5 ad=0.65 pd=3.3 as=0 ps=0 w=1 l=0.5
X1460 rr2t2r_0[5|5]/a_460_290# WL5 SL5 VSS sky130_fd_pr__nfet_g5v0d10v5 ad=0.65 pd=3.3 as=0 ps=0 w=1 l=0.5
X1461 BLP5 rr2t2r_0[5|5]/a_60_290# sky130_fd_pr_reram__reram_cell area_ox=0.0676
X1462 BLN5 rr2t2r_0[5|5]/a_460_290# sky130_fd_pr_reram__reram_cell area_ox=0.0676
X1463 rr2t2r_0[5|5]/a_60_290# WL5 SL5 VSS sky130_fd_pr__nfet_g5v0d10v5 ad=0.65 pd=3.3 as=0 ps=0 w=1 l=0.5
X1464 rr2t2r_0[6|5]/a_460_290# WL6 SL5 VSS sky130_fd_pr__nfet_g5v0d10v5 ad=0.65 pd=3.3 as=0 ps=0 w=1 l=0.5
X1465 BLP5 rr2t2r_0[6|5]/a_60_290# sky130_fd_pr_reram__reram_cell area_ox=0.0676
X1466 BLN5 rr2t2r_0[6|5]/a_460_290# sky130_fd_pr_reram__reram_cell area_ox=0.0676
X1467 rr2t2r_0[6|5]/a_60_290# WL6 SL5 VSS sky130_fd_pr__nfet_g5v0d10v5 ad=0.65 pd=3.3 as=0 ps=0 w=1 l=0.5
X1468 rr2t2r_0[7|5]/a_460_290# WL7 SL5 VSS sky130_fd_pr__nfet_g5v0d10v5 ad=0.65 pd=3.3 as=0 ps=0 w=1 l=0.5
X1469 BLP5 rr2t2r_0[7|5]/a_60_290# sky130_fd_pr_reram__reram_cell area_ox=0.0676
X1470 BLN5 rr2t2r_0[7|5]/a_460_290# sky130_fd_pr_reram__reram_cell area_ox=0.0676
X1471 rr2t2r_0[7|5]/a_60_290# WL7 SL5 VSS sky130_fd_pr__nfet_g5v0d10v5 ad=0.65 pd=3.3 as=0 ps=0 w=1 l=0.5
X1472 rr2t2r_0[8|5]/a_460_290# WL8 SL5 VSS sky130_fd_pr__nfet_g5v0d10v5 ad=0.65 pd=3.3 as=0 ps=0 w=1 l=0.5
X1473 BLP5 rr2t2r_0[8|5]/a_60_290# sky130_fd_pr_reram__reram_cell area_ox=0.0676
X1474 BLN5 rr2t2r_0[8|5]/a_460_290# sky130_fd_pr_reram__reram_cell area_ox=0.0676
X1475 rr2t2r_0[8|5]/a_60_290# WL8 SL5 VSS sky130_fd_pr__nfet_g5v0d10v5 ad=0.65 pd=3.3 as=0 ps=0 w=1 l=0.5
X1476 rr2t2r_0[9|5]/a_460_290# WL9 SL5 VSS sky130_fd_pr__nfet_g5v0d10v5 ad=0.65 pd=3.3 as=0 ps=0 w=1 l=0.5
X1477 BLP5 rr2t2r_0[9|5]/a_60_290# sky130_fd_pr_reram__reram_cell area_ox=0.0676
X1478 BLN5 rr2t2r_0[9|5]/a_460_290# sky130_fd_pr_reram__reram_cell area_ox=0.0676
X1479 rr2t2r_0[9|5]/a_60_290# WL9 SL5 VSS sky130_fd_pr__nfet_g5v0d10v5 ad=0.65 pd=3.3 as=0 ps=0 w=1 l=0.5
X1480 rr2t2r_0[10|5]/a_460_290# WL10 SL5 VSS sky130_fd_pr__nfet_g5v0d10v5 ad=0.65 pd=3.3 as=0 ps=0 w=1 l=0.5
X1481 BLP5 rr2t2r_0[10|5]/a_60_290# sky130_fd_pr_reram__reram_cell area_ox=0.0676
X1482 BLN5 rr2t2r_0[10|5]/a_460_290# sky130_fd_pr_reram__reram_cell area_ox=0.0676
X1483 rr2t2r_0[10|5]/a_60_290# WL10 SL5 VSS sky130_fd_pr__nfet_g5v0d10v5 ad=0.65 pd=3.3 as=0 ps=0 w=1 l=0.5
X1484 rr2t2r_0[11|5]/a_460_290# WL11 SL5 VSS sky130_fd_pr__nfet_g5v0d10v5 ad=0.65 pd=3.3 as=0 ps=0 w=1 l=0.5
X1485 BLP5 rr2t2r_0[11|5]/a_60_290# sky130_fd_pr_reram__reram_cell area_ox=0.0676
X1486 BLN5 rr2t2r_0[11|5]/a_460_290# sky130_fd_pr_reram__reram_cell area_ox=0.0676
X1487 rr2t2r_0[11|5]/a_60_290# WL11 SL5 VSS sky130_fd_pr__nfet_g5v0d10v5 ad=0.65 pd=3.3 as=0 ps=0 w=1 l=0.5
X1488 rr2t2r_0[12|5]/a_460_290# WL12 SL5 VSS sky130_fd_pr__nfet_g5v0d10v5 ad=0.65 pd=3.3 as=0 ps=0 w=1 l=0.5
X1489 BLP5 rr2t2r_0[12|5]/a_60_290# sky130_fd_pr_reram__reram_cell area_ox=0.0676
X1490 BLN5 rr2t2r_0[12|5]/a_460_290# sky130_fd_pr_reram__reram_cell area_ox=0.0676
X1491 rr2t2r_0[12|5]/a_60_290# WL12 SL5 VSS sky130_fd_pr__nfet_g5v0d10v5 ad=0.65 pd=3.3 as=0 ps=0 w=1 l=0.5
X1492 rr2t2r_0[13|5]/a_460_290# WL13 SL5 VSS sky130_fd_pr__nfet_g5v0d10v5 ad=0.65 pd=3.3 as=0 ps=0 w=1 l=0.5
X1493 BLP5 rr2t2r_0[13|5]/a_60_290# sky130_fd_pr_reram__reram_cell area_ox=0.0676
X1494 BLN5 rr2t2r_0[13|5]/a_460_290# sky130_fd_pr_reram__reram_cell area_ox=0.0676
X1495 rr2t2r_0[13|5]/a_60_290# WL13 SL5 VSS sky130_fd_pr__nfet_g5v0d10v5 ad=0.65 pd=3.3 as=0 ps=0 w=1 l=0.5
X1496 rr2t2r_0[14|5]/a_460_290# WL14 SL5 VSS sky130_fd_pr__nfet_g5v0d10v5 ad=0.65 pd=3.3 as=0 ps=0 w=1 l=0.5
X1497 BLP5 rr2t2r_0[14|5]/a_60_290# sky130_fd_pr_reram__reram_cell area_ox=0.0676
X1498 BLN5 rr2t2r_0[14|5]/a_460_290# sky130_fd_pr_reram__reram_cell area_ox=0.0676
X1499 rr2t2r_0[14|5]/a_60_290# WL14 SL5 VSS sky130_fd_pr__nfet_g5v0d10v5 ad=0.65 pd=3.3 as=0 ps=0 w=1 l=0.5
X1500 rr2t2r_0[15|5]/a_460_290# WL15 SL5 VSS sky130_fd_pr__nfet_g5v0d10v5 ad=0.65 pd=3.3 as=0 ps=0 w=1 l=0.5
X1501 BLP5 rr2t2r_0[15|5]/a_60_290# sky130_fd_pr_reram__reram_cell area_ox=0.0676
X1502 BLN5 rr2t2r_0[15|5]/a_460_290# sky130_fd_pr_reram__reram_cell area_ox=0.0676
X1503 rr2t2r_0[15|5]/a_60_290# WL15 SL5 VSS sky130_fd_pr__nfet_g5v0d10v5 ad=0.65 pd=3.3 as=0 ps=0 w=1 l=0.5
X1504 rr2t2r_0[16|5]/a_460_290# WL16 SL5 VSS sky130_fd_pr__nfet_g5v0d10v5 ad=0.65 pd=3.3 as=0 ps=0 w=1 l=0.5
X1505 BLP5 rr2t2r_0[16|5]/a_60_290# sky130_fd_pr_reram__reram_cell area_ox=0.0676
X1506 BLN5 rr2t2r_0[16|5]/a_460_290# sky130_fd_pr_reram__reram_cell area_ox=0.0676
X1507 rr2t2r_0[16|5]/a_60_290# WL16 SL5 VSS sky130_fd_pr__nfet_g5v0d10v5 ad=0.65 pd=3.3 as=0 ps=0 w=1 l=0.5
X1508 rr2t2r_0[17|5]/a_460_290# WL17 SL5 VSS sky130_fd_pr__nfet_g5v0d10v5 ad=0.65 pd=3.3 as=0 ps=0 w=1 l=0.5
X1509 BLP5 rr2t2r_0[17|5]/a_60_290# sky130_fd_pr_reram__reram_cell area_ox=0.0676
X1510 BLN5 rr2t2r_0[17|5]/a_460_290# sky130_fd_pr_reram__reram_cell area_ox=0.0676
X1511 rr2t2r_0[17|5]/a_60_290# WL17 SL5 VSS sky130_fd_pr__nfet_g5v0d10v5 ad=0.65 pd=3.3 as=0 ps=0 w=1 l=0.5
X1512 rr2t2r_0[18|5]/a_460_290# WL18 SL5 VSS sky130_fd_pr__nfet_g5v0d10v5 ad=0.65 pd=3.3 as=0 ps=0 w=1 l=0.5
X1513 BLP5 rr2t2r_0[18|5]/a_60_290# sky130_fd_pr_reram__reram_cell area_ox=0.0676
X1514 BLN5 rr2t2r_0[18|5]/a_460_290# sky130_fd_pr_reram__reram_cell area_ox=0.0676
X1515 rr2t2r_0[18|5]/a_60_290# WL18 SL5 VSS sky130_fd_pr__nfet_g5v0d10v5 ad=0.65 pd=3.3 as=0 ps=0 w=1 l=0.5
X1516 rr2t2r_0[19|5]/a_460_290# WL19 SL5 VSS sky130_fd_pr__nfet_g5v0d10v5 ad=0.65 pd=3.3 as=0 ps=0 w=1 l=0.5
X1517 BLP5 rr2t2r_0[19|5]/a_60_290# sky130_fd_pr_reram__reram_cell area_ox=0.0676
X1518 BLN5 rr2t2r_0[19|5]/a_460_290# sky130_fd_pr_reram__reram_cell area_ox=0.0676
X1519 rr2t2r_0[19|5]/a_60_290# WL19 SL5 VSS sky130_fd_pr__nfet_g5v0d10v5 ad=0.65 pd=3.3 as=0 ps=0 w=1 l=0.5
X1520 rr2t2r_0[20|5]/a_460_290# WL20 SL5 VSS sky130_fd_pr__nfet_g5v0d10v5 ad=0.65 pd=3.3 as=0 ps=0 w=1 l=0.5
X1521 BLP5 rr2t2r_0[20|5]/a_60_290# sky130_fd_pr_reram__reram_cell area_ox=0.0676
X1522 BLN5 rr2t2r_0[20|5]/a_460_290# sky130_fd_pr_reram__reram_cell area_ox=0.0676
X1523 rr2t2r_0[20|5]/a_60_290# WL20 SL5 VSS sky130_fd_pr__nfet_g5v0d10v5 ad=0.65 pd=3.3 as=0 ps=0 w=1 l=0.5
X1524 rr2t2r_0[21|5]/a_460_290# WL21 SL5 VSS sky130_fd_pr__nfet_g5v0d10v5 ad=0.65 pd=3.3 as=0 ps=0 w=1 l=0.5
X1525 BLP5 rr2t2r_0[21|5]/a_60_290# sky130_fd_pr_reram__reram_cell area_ox=0.0676
X1526 BLN5 rr2t2r_0[21|5]/a_460_290# sky130_fd_pr_reram__reram_cell area_ox=0.0676
X1527 rr2t2r_0[21|5]/a_60_290# WL21 SL5 VSS sky130_fd_pr__nfet_g5v0d10v5 ad=0.65 pd=3.3 as=0 ps=0 w=1 l=0.5
X1528 rr2t2r_0[22|5]/a_460_290# WL22 SL5 VSS sky130_fd_pr__nfet_g5v0d10v5 ad=0.65 pd=3.3 as=0 ps=0 w=1 l=0.5
X1529 BLP5 rr2t2r_0[22|5]/a_60_290# sky130_fd_pr_reram__reram_cell area_ox=0.0676
X1530 BLN5 rr2t2r_0[22|5]/a_460_290# sky130_fd_pr_reram__reram_cell area_ox=0.0676
X1531 rr2t2r_0[22|5]/a_60_290# WL22 SL5 VSS sky130_fd_pr__nfet_g5v0d10v5 ad=0.65 pd=3.3 as=0 ps=0 w=1 l=0.5
X1532 rr2t2r_0[23|5]/a_460_290# WL23 SL5 VSS sky130_fd_pr__nfet_g5v0d10v5 ad=0.65 pd=3.3 as=0 ps=0 w=1 l=0.5
X1533 BLP5 rr2t2r_0[23|5]/a_60_290# sky130_fd_pr_reram__reram_cell area_ox=0.0676
X1534 BLN5 rr2t2r_0[23|5]/a_460_290# sky130_fd_pr_reram__reram_cell area_ox=0.0676
X1535 rr2t2r_0[23|5]/a_60_290# WL23 SL5 VSS sky130_fd_pr__nfet_g5v0d10v5 ad=0.65 pd=3.3 as=0 ps=0 w=1 l=0.5
X1536 rr2t2r_0[24|5]/a_460_290# WL24 SL5 VSS sky130_fd_pr__nfet_g5v0d10v5 ad=0.65 pd=3.3 as=0 ps=0 w=1 l=0.5
X1537 BLP5 rr2t2r_0[24|5]/a_60_290# sky130_fd_pr_reram__reram_cell area_ox=0.0676
X1538 BLN5 rr2t2r_0[24|5]/a_460_290# sky130_fd_pr_reram__reram_cell area_ox=0.0676
X1539 rr2t2r_0[24|5]/a_60_290# WL24 SL5 VSS sky130_fd_pr__nfet_g5v0d10v5 ad=0.65 pd=3.3 as=0 ps=0 w=1 l=0.5
X1540 rr2t2r_0[25|5]/a_460_290# WL25 SL5 VSS sky130_fd_pr__nfet_g5v0d10v5 ad=0.65 pd=3.3 as=0 ps=0 w=1 l=0.5
X1541 BLP5 rr2t2r_0[25|5]/a_60_290# sky130_fd_pr_reram__reram_cell area_ox=0.0676
X1542 BLN5 rr2t2r_0[25|5]/a_460_290# sky130_fd_pr_reram__reram_cell area_ox=0.0676
X1543 rr2t2r_0[25|5]/a_60_290# WL25 SL5 VSS sky130_fd_pr__nfet_g5v0d10v5 ad=0.65 pd=3.3 as=0 ps=0 w=1 l=0.5
X1544 rr2t2r_0[26|5]/a_460_290# WL26 SL5 VSS sky130_fd_pr__nfet_g5v0d10v5 ad=0.65 pd=3.3 as=0 ps=0 w=1 l=0.5
X1545 BLP5 rr2t2r_0[26|5]/a_60_290# sky130_fd_pr_reram__reram_cell area_ox=0.0676
X1546 BLN5 rr2t2r_0[26|5]/a_460_290# sky130_fd_pr_reram__reram_cell area_ox=0.0676
X1547 rr2t2r_0[26|5]/a_60_290# WL26 SL5 VSS sky130_fd_pr__nfet_g5v0d10v5 ad=0.65 pd=3.3 as=0 ps=0 w=1 l=0.5
X1548 rr2t2r_0[27|5]/a_460_290# WL27 SL5 VSS sky130_fd_pr__nfet_g5v0d10v5 ad=0.65 pd=3.3 as=0 ps=0 w=1 l=0.5
X1549 BLP5 rr2t2r_0[27|5]/a_60_290# sky130_fd_pr_reram__reram_cell area_ox=0.0676
X1550 BLN5 rr2t2r_0[27|5]/a_460_290# sky130_fd_pr_reram__reram_cell area_ox=0.0676
X1551 rr2t2r_0[27|5]/a_60_290# WL27 SL5 VSS sky130_fd_pr__nfet_g5v0d10v5 ad=0.65 pd=3.3 as=0 ps=0 w=1 l=0.5
X1552 rr2t2r_0[28|5]/a_460_290# WL28 SL5 VSS sky130_fd_pr__nfet_g5v0d10v5 ad=0.65 pd=3.3 as=0 ps=0 w=1 l=0.5
X1553 BLP5 rr2t2r_0[28|5]/a_60_290# sky130_fd_pr_reram__reram_cell area_ox=0.0676
X1554 BLN5 rr2t2r_0[28|5]/a_460_290# sky130_fd_pr_reram__reram_cell area_ox=0.0676
X1555 rr2t2r_0[28|5]/a_60_290# WL28 SL5 VSS sky130_fd_pr__nfet_g5v0d10v5 ad=0.65 pd=3.3 as=0 ps=0 w=1 l=0.5
X1556 rr2t2r_0[29|5]/a_460_290# WL29 SL5 VSS sky130_fd_pr__nfet_g5v0d10v5 ad=0.65 pd=3.3 as=0 ps=0 w=1 l=0.5
X1557 BLP5 rr2t2r_0[29|5]/a_60_290# sky130_fd_pr_reram__reram_cell area_ox=0.0676
X1558 BLN5 rr2t2r_0[29|5]/a_460_290# sky130_fd_pr_reram__reram_cell area_ox=0.0676
X1559 rr2t2r_0[29|5]/a_60_290# WL29 SL5 VSS sky130_fd_pr__nfet_g5v0d10v5 ad=0.65 pd=3.3 as=0 ps=0 w=1 l=0.5
X1560 rr2t2r_0[30|5]/a_460_290# WL30 SL5 VSS sky130_fd_pr__nfet_g5v0d10v5 ad=0.65 pd=3.3 as=0 ps=0 w=1 l=0.5
X1561 BLP5 rr2t2r_0[30|5]/a_60_290# sky130_fd_pr_reram__reram_cell area_ox=0.0676
X1562 BLN5 rr2t2r_0[30|5]/a_460_290# sky130_fd_pr_reram__reram_cell area_ox=0.0676
X1563 rr2t2r_0[30|5]/a_60_290# WL30 SL5 VSS sky130_fd_pr__nfet_g5v0d10v5 ad=0.65 pd=3.3 as=0 ps=0 w=1 l=0.5
X1564 rr2t2r_0[31|5]/a_460_290# WL31 SL5 VSS sky130_fd_pr__nfet_g5v0d10v5 ad=0.65 pd=3.3 as=0 ps=0 w=1 l=0.5
X1565 BLP5 rr2t2r_0[31|5]/a_60_290# sky130_fd_pr_reram__reram_cell area_ox=0.0676
X1566 BLN5 rr2t2r_0[31|5]/a_460_290# sky130_fd_pr_reram__reram_cell area_ox=0.0676
X1567 rr2t2r_0[31|5]/a_60_290# WL31 SL5 VSS sky130_fd_pr__nfet_g5v0d10v5 ad=0.65 pd=3.3 as=0 ps=0 w=1 l=0.5
X1568 rr2t2r_0[32|5]/a_460_290# WL32 SL5 VSS sky130_fd_pr__nfet_g5v0d10v5 ad=0.65 pd=3.3 as=0 ps=0 w=1 l=0.5
X1569 BLP5 rr2t2r_0[32|5]/a_60_290# sky130_fd_pr_reram__reram_cell area_ox=0.0676
X1570 BLN5 rr2t2r_0[32|5]/a_460_290# sky130_fd_pr_reram__reram_cell area_ox=0.0676
X1571 rr2t2r_0[32|5]/a_60_290# WL32 SL5 VSS sky130_fd_pr__nfet_g5v0d10v5 ad=0.65 pd=3.3 as=0 ps=0 w=1 l=0.5
X1572 rr2t2r_0[33|5]/a_460_290# WL33 SL5 VSS sky130_fd_pr__nfet_g5v0d10v5 ad=0.65 pd=3.3 as=0 ps=0 w=1 l=0.5
X1573 BLP5 rr2t2r_0[33|5]/a_60_290# sky130_fd_pr_reram__reram_cell area_ox=0.0676
X1574 BLN5 rr2t2r_0[33|5]/a_460_290# sky130_fd_pr_reram__reram_cell area_ox=0.0676
X1575 rr2t2r_0[33|5]/a_60_290# WL33 SL5 VSS sky130_fd_pr__nfet_g5v0d10v5 ad=0.65 pd=3.3 as=0 ps=0 w=1 l=0.5
X1576 rr2t2r_0[34|5]/a_460_290# WL34 SL5 VSS sky130_fd_pr__nfet_g5v0d10v5 ad=0.65 pd=3.3 as=0 ps=0 w=1 l=0.5
X1577 BLP5 rr2t2r_0[34|5]/a_60_290# sky130_fd_pr_reram__reram_cell area_ox=0.0676
X1578 BLN5 rr2t2r_0[34|5]/a_460_290# sky130_fd_pr_reram__reram_cell area_ox=0.0676
X1579 rr2t2r_0[34|5]/a_60_290# WL34 SL5 VSS sky130_fd_pr__nfet_g5v0d10v5 ad=0.65 pd=3.3 as=0 ps=0 w=1 l=0.5
X1580 rr2t2r_0[35|5]/a_460_290# WL35 SL5 VSS sky130_fd_pr__nfet_g5v0d10v5 ad=0.65 pd=3.3 as=0 ps=0 w=1 l=0.5
X1581 BLP5 rr2t2r_0[35|5]/a_60_290# sky130_fd_pr_reram__reram_cell area_ox=0.0676
X1582 BLN5 rr2t2r_0[35|5]/a_460_290# sky130_fd_pr_reram__reram_cell area_ox=0.0676
X1583 rr2t2r_0[35|5]/a_60_290# WL35 SL5 VSS sky130_fd_pr__nfet_g5v0d10v5 ad=0.65 pd=3.3 as=0 ps=0 w=1 l=0.5
X1584 rr2t2r_0[36|5]/a_460_290# WL36 SL5 VSS sky130_fd_pr__nfet_g5v0d10v5 ad=0.65 pd=3.3 as=0 ps=0 w=1 l=0.5
X1585 BLP5 rr2t2r_0[36|5]/a_60_290# sky130_fd_pr_reram__reram_cell area_ox=0.0676
X1586 BLN5 rr2t2r_0[36|5]/a_460_290# sky130_fd_pr_reram__reram_cell area_ox=0.0676
X1587 rr2t2r_0[36|5]/a_60_290# WL36 SL5 VSS sky130_fd_pr__nfet_g5v0d10v5 ad=0.65 pd=3.3 as=0 ps=0 w=1 l=0.5
X1588 rr2t2r_0[37|5]/a_460_290# WL37 SL5 VSS sky130_fd_pr__nfet_g5v0d10v5 ad=0.65 pd=3.3 as=0 ps=0 w=1 l=0.5
X1589 BLP5 rr2t2r_0[37|5]/a_60_290# sky130_fd_pr_reram__reram_cell area_ox=0.0676
X1590 BLN5 rr2t2r_0[37|5]/a_460_290# sky130_fd_pr_reram__reram_cell area_ox=0.0676
X1591 rr2t2r_0[37|5]/a_60_290# WL37 SL5 VSS sky130_fd_pr__nfet_g5v0d10v5 ad=0.65 pd=3.3 as=0 ps=0 w=1 l=0.5
X1592 rr2t2r_0[38|5]/a_460_290# WL38 SL5 VSS sky130_fd_pr__nfet_g5v0d10v5 ad=0.65 pd=3.3 as=0 ps=0 w=1 l=0.5
X1593 BLP5 rr2t2r_0[38|5]/a_60_290# sky130_fd_pr_reram__reram_cell area_ox=0.0676
X1594 BLN5 rr2t2r_0[38|5]/a_460_290# sky130_fd_pr_reram__reram_cell area_ox=0.0676
X1595 rr2t2r_0[38|5]/a_60_290# WL38 SL5 VSS sky130_fd_pr__nfet_g5v0d10v5 ad=0.65 pd=3.3 as=0 ps=0 w=1 l=0.5
X1596 rr2t2r_0[39|5]/a_460_290# WL39 SL5 VSS sky130_fd_pr__nfet_g5v0d10v5 ad=0.65 pd=3.3 as=0 ps=0 w=1 l=0.5
X1597 BLP5 rr2t2r_0[39|5]/a_60_290# sky130_fd_pr_reram__reram_cell area_ox=0.0676
X1598 BLN5 rr2t2r_0[39|5]/a_460_290# sky130_fd_pr_reram__reram_cell area_ox=0.0676
X1599 rr2t2r_0[39|5]/a_60_290# WL39 SL5 VSS sky130_fd_pr__nfet_g5v0d10v5 ad=0.65 pd=3.3 as=0 ps=0 w=1 l=0.5
X1600 rr2t2r_0[40|5]/a_460_290# WL40 SL5 VSS sky130_fd_pr__nfet_g5v0d10v5 ad=0.65 pd=3.3 as=0 ps=0 w=1 l=0.5
X1601 BLP5 rr2t2r_0[40|5]/a_60_290# sky130_fd_pr_reram__reram_cell area_ox=0.0676
X1602 BLN5 rr2t2r_0[40|5]/a_460_290# sky130_fd_pr_reram__reram_cell area_ox=0.0676
X1603 rr2t2r_0[40|5]/a_60_290# WL40 SL5 VSS sky130_fd_pr__nfet_g5v0d10v5 ad=0.65 pd=3.3 as=0 ps=0 w=1 l=0.5
X1604 rr2t2r_0[41|5]/a_460_290# WL41 SL5 VSS sky130_fd_pr__nfet_g5v0d10v5 ad=0.65 pd=3.3 as=0 ps=0 w=1 l=0.5
X1605 BLP5 rr2t2r_0[41|5]/a_60_290# sky130_fd_pr_reram__reram_cell area_ox=0.0676
X1606 BLN5 rr2t2r_0[41|5]/a_460_290# sky130_fd_pr_reram__reram_cell area_ox=0.0676
X1607 rr2t2r_0[41|5]/a_60_290# WL41 SL5 VSS sky130_fd_pr__nfet_g5v0d10v5 ad=0.65 pd=3.3 as=0 ps=0 w=1 l=0.5
X1608 rr2t2r_0[42|5]/a_460_290# WL42 SL5 VSS sky130_fd_pr__nfet_g5v0d10v5 ad=0.65 pd=3.3 as=0 ps=0 w=1 l=0.5
X1609 BLP5 rr2t2r_0[42|5]/a_60_290# sky130_fd_pr_reram__reram_cell area_ox=0.0676
X1610 BLN5 rr2t2r_0[42|5]/a_460_290# sky130_fd_pr_reram__reram_cell area_ox=0.0676
X1611 rr2t2r_0[42|5]/a_60_290# WL42 SL5 VSS sky130_fd_pr__nfet_g5v0d10v5 ad=0.65 pd=3.3 as=0 ps=0 w=1 l=0.5
X1612 rr2t2r_0[43|5]/a_460_290# WL43 SL5 VSS sky130_fd_pr__nfet_g5v0d10v5 ad=0.65 pd=3.3 as=0 ps=0 w=1 l=0.5
X1613 BLP5 rr2t2r_0[43|5]/a_60_290# sky130_fd_pr_reram__reram_cell area_ox=0.0676
X1614 BLN5 rr2t2r_0[43|5]/a_460_290# sky130_fd_pr_reram__reram_cell area_ox=0.0676
X1615 rr2t2r_0[43|5]/a_60_290# WL43 SL5 VSS sky130_fd_pr__nfet_g5v0d10v5 ad=0.65 pd=3.3 as=0 ps=0 w=1 l=0.5
X1616 rr2t2r_0[44|5]/a_460_290# WL44 SL5 VSS sky130_fd_pr__nfet_g5v0d10v5 ad=0.65 pd=3.3 as=0 ps=0 w=1 l=0.5
X1617 BLP5 rr2t2r_0[44|5]/a_60_290# sky130_fd_pr_reram__reram_cell area_ox=0.0676
X1618 BLN5 rr2t2r_0[44|5]/a_460_290# sky130_fd_pr_reram__reram_cell area_ox=0.0676
X1619 rr2t2r_0[44|5]/a_60_290# WL44 SL5 VSS sky130_fd_pr__nfet_g5v0d10v5 ad=0.65 pd=3.3 as=0 ps=0 w=1 l=0.5
X1620 rr2t2r_0[45|5]/a_460_290# WL45 SL5 VSS sky130_fd_pr__nfet_g5v0d10v5 ad=0.65 pd=3.3 as=0 ps=0 w=1 l=0.5
X1621 BLP5 rr2t2r_0[45|5]/a_60_290# sky130_fd_pr_reram__reram_cell area_ox=0.0676
X1622 BLN5 rr2t2r_0[45|5]/a_460_290# sky130_fd_pr_reram__reram_cell area_ox=0.0676
X1623 rr2t2r_0[45|5]/a_60_290# WL45 SL5 VSS sky130_fd_pr__nfet_g5v0d10v5 ad=0.65 pd=3.3 as=0 ps=0 w=1 l=0.5
X1624 rr2t2r_0[46|5]/a_460_290# WL46 SL5 VSS sky130_fd_pr__nfet_g5v0d10v5 ad=0.65 pd=3.3 as=0 ps=0 w=1 l=0.5
X1625 BLP5 rr2t2r_0[46|5]/a_60_290# sky130_fd_pr_reram__reram_cell area_ox=0.0676
X1626 BLN5 rr2t2r_0[46|5]/a_460_290# sky130_fd_pr_reram__reram_cell area_ox=0.0676
X1627 rr2t2r_0[46|5]/a_60_290# WL46 SL5 VSS sky130_fd_pr__nfet_g5v0d10v5 ad=0.65 pd=3.3 as=0 ps=0 w=1 l=0.5
X1628 rr2t2r_0[47|5]/a_460_290# WL47 SL5 VSS sky130_fd_pr__nfet_g5v0d10v5 ad=0.65 pd=3.3 as=0 ps=0 w=1 l=0.5
X1629 BLP5 rr2t2r_0[47|5]/a_60_290# sky130_fd_pr_reram__reram_cell area_ox=0.0676
X1630 BLN5 rr2t2r_0[47|5]/a_460_290# sky130_fd_pr_reram__reram_cell area_ox=0.0676
X1631 rr2t2r_0[47|5]/a_60_290# WL47 SL5 VSS sky130_fd_pr__nfet_g5v0d10v5 ad=0.65 pd=3.3 as=0 ps=0 w=1 l=0.5
X1632 rr2t2r_0[48|5]/a_460_290# WL48 SL5 VSS sky130_fd_pr__nfet_g5v0d10v5 ad=0.65 pd=3.3 as=0 ps=0 w=1 l=0.5
X1633 BLP5 rr2t2r_0[48|5]/a_60_290# sky130_fd_pr_reram__reram_cell area_ox=0.0676
X1634 BLN5 rr2t2r_0[48|5]/a_460_290# sky130_fd_pr_reram__reram_cell area_ox=0.0676
X1635 rr2t2r_0[48|5]/a_60_290# WL48 SL5 VSS sky130_fd_pr__nfet_g5v0d10v5 ad=0.65 pd=3.3 as=0 ps=0 w=1 l=0.5
X1636 rr2t2r_0[49|5]/a_460_290# WL49 SL5 VSS sky130_fd_pr__nfet_g5v0d10v5 ad=0.65 pd=3.3 as=0 ps=0 w=1 l=0.5
X1637 BLP5 rr2t2r_0[49|5]/a_60_290# sky130_fd_pr_reram__reram_cell area_ox=0.0676
X1638 BLN5 rr2t2r_0[49|5]/a_460_290# sky130_fd_pr_reram__reram_cell area_ox=0.0676
X1639 rr2t2r_0[49|5]/a_60_290# WL49 SL5 VSS sky130_fd_pr__nfet_g5v0d10v5 ad=0.65 pd=3.3 as=0 ps=0 w=1 l=0.5
X1640 rr2t2r_0[50|5]/a_460_290# WL50 SL5 VSS sky130_fd_pr__nfet_g5v0d10v5 ad=0.65 pd=3.3 as=0 ps=0 w=1 l=0.5
X1641 BLP5 rr2t2r_0[50|5]/a_60_290# sky130_fd_pr_reram__reram_cell area_ox=0.0676
X1642 BLN5 rr2t2r_0[50|5]/a_460_290# sky130_fd_pr_reram__reram_cell area_ox=0.0676
X1643 rr2t2r_0[50|5]/a_60_290# WL50 SL5 VSS sky130_fd_pr__nfet_g5v0d10v5 ad=0.65 pd=3.3 as=0 ps=0 w=1 l=0.5
X1644 rr2t2r_0[51|5]/a_460_290# WL51 SL5 VSS sky130_fd_pr__nfet_g5v0d10v5 ad=0.65 pd=3.3 as=0 ps=0 w=1 l=0.5
X1645 BLP5 rr2t2r_0[51|5]/a_60_290# sky130_fd_pr_reram__reram_cell area_ox=0.0676
X1646 BLN5 rr2t2r_0[51|5]/a_460_290# sky130_fd_pr_reram__reram_cell area_ox=0.0676
X1647 rr2t2r_0[51|5]/a_60_290# WL51 SL5 VSS sky130_fd_pr__nfet_g5v0d10v5 ad=0.65 pd=3.3 as=0 ps=0 w=1 l=0.5
X1648 rr2t2r_0[52|5]/a_460_290# WL52 SL5 VSS sky130_fd_pr__nfet_g5v0d10v5 ad=0.65 pd=3.3 as=0 ps=0 w=1 l=0.5
X1649 BLP5 rr2t2r_0[52|5]/a_60_290# sky130_fd_pr_reram__reram_cell area_ox=0.0676
X1650 BLN5 rr2t2r_0[52|5]/a_460_290# sky130_fd_pr_reram__reram_cell area_ox=0.0676
X1651 rr2t2r_0[52|5]/a_60_290# WL52 SL5 VSS sky130_fd_pr__nfet_g5v0d10v5 ad=0.65 pd=3.3 as=0 ps=0 w=1 l=0.5
X1652 rr2t2r_0[53|5]/a_460_290# WL53 SL5 VSS sky130_fd_pr__nfet_g5v0d10v5 ad=0.65 pd=3.3 as=0 ps=0 w=1 l=0.5
X1653 BLP5 rr2t2r_0[53|5]/a_60_290# sky130_fd_pr_reram__reram_cell area_ox=0.0676
X1654 BLN5 rr2t2r_0[53|5]/a_460_290# sky130_fd_pr_reram__reram_cell area_ox=0.0676
X1655 rr2t2r_0[53|5]/a_60_290# WL53 SL5 VSS sky130_fd_pr__nfet_g5v0d10v5 ad=0.65 pd=3.3 as=0 ps=0 w=1 l=0.5
X1656 rr2t2r_0[54|5]/a_460_290# WL54 SL5 VSS sky130_fd_pr__nfet_g5v0d10v5 ad=0.65 pd=3.3 as=0 ps=0 w=1 l=0.5
X1657 BLP5 rr2t2r_0[54|5]/a_60_290# sky130_fd_pr_reram__reram_cell area_ox=0.0676
X1658 BLN5 rr2t2r_0[54|5]/a_460_290# sky130_fd_pr_reram__reram_cell area_ox=0.0676
X1659 rr2t2r_0[54|5]/a_60_290# WL54 SL5 VSS sky130_fd_pr__nfet_g5v0d10v5 ad=0.65 pd=3.3 as=0 ps=0 w=1 l=0.5
X1660 rr2t2r_0[55|5]/a_460_290# WL55 SL5 VSS sky130_fd_pr__nfet_g5v0d10v5 ad=0.65 pd=3.3 as=0 ps=0 w=1 l=0.5
X1661 BLP5 rr2t2r_0[55|5]/a_60_290# sky130_fd_pr_reram__reram_cell area_ox=0.0676
X1662 BLN5 rr2t2r_0[55|5]/a_460_290# sky130_fd_pr_reram__reram_cell area_ox=0.0676
X1663 rr2t2r_0[55|5]/a_60_290# WL55 SL5 VSS sky130_fd_pr__nfet_g5v0d10v5 ad=0.65 pd=3.3 as=0 ps=0 w=1 l=0.5
X1664 rr2t2r_0[56|5]/a_460_290# WL56 SL5 VSS sky130_fd_pr__nfet_g5v0d10v5 ad=0.65 pd=3.3 as=0 ps=0 w=1 l=0.5
X1665 BLP5 rr2t2r_0[56|5]/a_60_290# sky130_fd_pr_reram__reram_cell area_ox=0.0676
X1666 BLN5 rr2t2r_0[56|5]/a_460_290# sky130_fd_pr_reram__reram_cell area_ox=0.0676
X1667 rr2t2r_0[56|5]/a_60_290# WL56 SL5 VSS sky130_fd_pr__nfet_g5v0d10v5 ad=0.65 pd=3.3 as=0 ps=0 w=1 l=0.5
X1668 rr2t2r_0[57|5]/a_460_290# WL57 SL5 VSS sky130_fd_pr__nfet_g5v0d10v5 ad=0.65 pd=3.3 as=0 ps=0 w=1 l=0.5
X1669 BLP5 rr2t2r_0[57|5]/a_60_290# sky130_fd_pr_reram__reram_cell area_ox=0.0676
X1670 BLN5 rr2t2r_0[57|5]/a_460_290# sky130_fd_pr_reram__reram_cell area_ox=0.0676
X1671 rr2t2r_0[57|5]/a_60_290# WL57 SL5 VSS sky130_fd_pr__nfet_g5v0d10v5 ad=0.65 pd=3.3 as=0 ps=0 w=1 l=0.5
X1672 rr2t2r_0[58|5]/a_460_290# WL58 SL5 VSS sky130_fd_pr__nfet_g5v0d10v5 ad=0.65 pd=3.3 as=0 ps=0 w=1 l=0.5
X1673 BLP5 rr2t2r_0[58|5]/a_60_290# sky130_fd_pr_reram__reram_cell area_ox=0.0676
X1674 BLN5 rr2t2r_0[58|5]/a_460_290# sky130_fd_pr_reram__reram_cell area_ox=0.0676
X1675 rr2t2r_0[58|5]/a_60_290# WL58 SL5 VSS sky130_fd_pr__nfet_g5v0d10v5 ad=0.65 pd=3.3 as=0 ps=0 w=1 l=0.5
X1676 rr2t2r_0[59|5]/a_460_290# WL59 SL5 VSS sky130_fd_pr__nfet_g5v0d10v5 ad=0.65 pd=3.3 as=0 ps=0 w=1 l=0.5
X1677 BLP5 rr2t2r_0[59|5]/a_60_290# sky130_fd_pr_reram__reram_cell area_ox=0.0676
X1678 BLN5 rr2t2r_0[59|5]/a_460_290# sky130_fd_pr_reram__reram_cell area_ox=0.0676
X1679 rr2t2r_0[59|5]/a_60_290# WL59 SL5 VSS sky130_fd_pr__nfet_g5v0d10v5 ad=0.65 pd=3.3 as=0 ps=0 w=1 l=0.5
X1680 rr2t2r_0[60|5]/a_460_290# WL60 SL5 VSS sky130_fd_pr__nfet_g5v0d10v5 ad=0.65 pd=3.3 as=0 ps=0 w=1 l=0.5
X1681 BLP5 rr2t2r_0[60|5]/a_60_290# sky130_fd_pr_reram__reram_cell area_ox=0.0676
X1682 BLN5 rr2t2r_0[60|5]/a_460_290# sky130_fd_pr_reram__reram_cell area_ox=0.0676
X1683 rr2t2r_0[60|5]/a_60_290# WL60 SL5 VSS sky130_fd_pr__nfet_g5v0d10v5 ad=0.65 pd=3.3 as=0 ps=0 w=1 l=0.5
X1684 rr2t2r_0[61|5]/a_460_290# WL61 SL5 VSS sky130_fd_pr__nfet_g5v0d10v5 ad=0.65 pd=3.3 as=0 ps=0 w=1 l=0.5
X1685 BLP5 rr2t2r_0[61|5]/a_60_290# sky130_fd_pr_reram__reram_cell area_ox=0.0676
X1686 BLN5 rr2t2r_0[61|5]/a_460_290# sky130_fd_pr_reram__reram_cell area_ox=0.0676
X1687 rr2t2r_0[61|5]/a_60_290# WL61 SL5 VSS sky130_fd_pr__nfet_g5v0d10v5 ad=0.65 pd=3.3 as=0 ps=0 w=1 l=0.5
X1688 rr2t2r_0[62|5]/a_460_290# WL62 SL5 VSS sky130_fd_pr__nfet_g5v0d10v5 ad=0.65 pd=3.3 as=0 ps=0 w=1 l=0.5
X1689 BLP5 rr2t2r_0[62|5]/a_60_290# sky130_fd_pr_reram__reram_cell area_ox=0.0676
X1690 BLN5 rr2t2r_0[62|5]/a_460_290# sky130_fd_pr_reram__reram_cell area_ox=0.0676
X1691 rr2t2r_0[62|5]/a_60_290# WL62 SL5 VSS sky130_fd_pr__nfet_g5v0d10v5 ad=0.65 pd=3.3 as=0 ps=0 w=1 l=0.5
X1692 rr2t2r_0[63|5]/a_460_290# WL63 SL5 VSS sky130_fd_pr__nfet_g5v0d10v5 ad=0.65 pd=3.3 as=0 ps=0 w=1 l=0.5
X1693 BLP5 rr2t2r_0[63|5]/a_60_290# sky130_fd_pr_reram__reram_cell area_ox=0.0676
X1694 BLN5 rr2t2r_0[63|5]/a_460_290# sky130_fd_pr_reram__reram_cell area_ox=0.0676
X1695 rr2t2r_0[63|5]/a_60_290# WL63 SL5 VSS sky130_fd_pr__nfet_g5v0d10v5 ad=0.65 pd=3.3 as=0 ps=0 w=1 l=0.5
X1696 rr2t2r_0[64|5]/a_460_290# WL64 SL5 VSS sky130_fd_pr__nfet_g5v0d10v5 ad=0.65 pd=3.3 as=0 ps=0 w=1 l=0.5
X1697 BLP5 rr2t2r_0[64|5]/a_60_290# sky130_fd_pr_reram__reram_cell area_ox=0.0676
X1698 BLN5 rr2t2r_0[64|5]/a_460_290# sky130_fd_pr_reram__reram_cell area_ox=0.0676
X1699 rr2t2r_0[64|5]/a_60_290# WL64 SL5 VSS sky130_fd_pr__nfet_g5v0d10v5 ad=0.65 pd=3.3 as=0 ps=0 w=1 l=0.5
X1700 rr2t2r_0[65|5]/a_460_290# WL65 SL5 VSS sky130_fd_pr__nfet_g5v0d10v5 ad=0.65 pd=3.3 as=0 ps=0 w=1 l=0.5
X1701 BLP5 rr2t2r_0[65|5]/a_60_290# sky130_fd_pr_reram__reram_cell area_ox=0.0676
X1702 BLN5 rr2t2r_0[65|5]/a_460_290# sky130_fd_pr_reram__reram_cell area_ox=0.0676
X1703 rr2t2r_0[65|5]/a_60_290# WL65 SL5 VSS sky130_fd_pr__nfet_g5v0d10v5 ad=0.65 pd=3.3 as=0 ps=0 w=1 l=0.5
X1704 rr2t2r_0[66|5]/a_460_290# WL66 SL5 VSS sky130_fd_pr__nfet_g5v0d10v5 ad=0.65 pd=3.3 as=0 ps=0 w=1 l=0.5
X1705 BLP5 rr2t2r_0[66|5]/a_60_290# sky130_fd_pr_reram__reram_cell area_ox=0.0676
X1706 BLN5 rr2t2r_0[66|5]/a_460_290# sky130_fd_pr_reram__reram_cell area_ox=0.0676
X1707 rr2t2r_0[66|5]/a_60_290# WL66 SL5 VSS sky130_fd_pr__nfet_g5v0d10v5 ad=0.65 pd=3.3 as=0 ps=0 w=1 l=0.5
X1708 rr2t2r_0[67|5]/a_460_290# WL67 SL5 VSS sky130_fd_pr__nfet_g5v0d10v5 ad=0.65 pd=3.3 as=0 ps=0 w=1 l=0.5
X1709 BLP5 rr2t2r_0[67|5]/a_60_290# sky130_fd_pr_reram__reram_cell area_ox=0.0676
X1710 BLN5 rr2t2r_0[67|5]/a_460_290# sky130_fd_pr_reram__reram_cell area_ox=0.0676
X1711 rr2t2r_0[67|5]/a_60_290# WL67 SL5 VSS sky130_fd_pr__nfet_g5v0d10v5 ad=0.65 pd=3.3 as=0 ps=0 w=1 l=0.5
X1712 rr2t2r_0[68|5]/a_460_290# WL68 SL5 VSS sky130_fd_pr__nfet_g5v0d10v5 ad=0.65 pd=3.3 as=0 ps=0 w=1 l=0.5
X1713 BLP5 rr2t2r_0[68|5]/a_60_290# sky130_fd_pr_reram__reram_cell area_ox=0.0676
X1714 BLN5 rr2t2r_0[68|5]/a_460_290# sky130_fd_pr_reram__reram_cell area_ox=0.0676
X1715 rr2t2r_0[68|5]/a_60_290# WL68 SL5 VSS sky130_fd_pr__nfet_g5v0d10v5 ad=0.65 pd=3.3 as=0 ps=0 w=1 l=0.5
X1716 rr2t2r_0[69|5]/a_460_290# WL69 SL5 VSS sky130_fd_pr__nfet_g5v0d10v5 ad=0.65 pd=3.3 as=0 ps=0 w=1 l=0.5
X1717 BLP5 rr2t2r_0[69|5]/a_60_290# sky130_fd_pr_reram__reram_cell area_ox=0.0676
X1718 BLN5 rr2t2r_0[69|5]/a_460_290# sky130_fd_pr_reram__reram_cell area_ox=0.0676
X1719 rr2t2r_0[69|5]/a_60_290# WL69 SL5 VSS sky130_fd_pr__nfet_g5v0d10v5 ad=0.65 pd=3.3 as=0 ps=0 w=1 l=0.5
X1720 rr2t2r_0[70|5]/a_460_290# WL70 SL5 VSS sky130_fd_pr__nfet_g5v0d10v5 ad=0.65 pd=3.3 as=0 ps=0 w=1 l=0.5
X1721 BLP5 rr2t2r_0[70|5]/a_60_290# sky130_fd_pr_reram__reram_cell area_ox=0.0676
X1722 BLN5 rr2t2r_0[70|5]/a_460_290# sky130_fd_pr_reram__reram_cell area_ox=0.0676
X1723 rr2t2r_0[70|5]/a_60_290# WL70 SL5 VSS sky130_fd_pr__nfet_g5v0d10v5 ad=0.65 pd=3.3 as=0 ps=0 w=1 l=0.5
X1724 rr2t2r_0[71|5]/a_460_290# WL71 SL5 VSS sky130_fd_pr__nfet_g5v0d10v5 ad=0.65 pd=3.3 as=0 ps=0 w=1 l=0.5
X1725 BLP5 rr2t2r_0[71|5]/a_60_290# sky130_fd_pr_reram__reram_cell area_ox=0.0676
X1726 BLN5 rr2t2r_0[71|5]/a_460_290# sky130_fd_pr_reram__reram_cell area_ox=0.0676
X1727 rr2t2r_0[71|5]/a_60_290# WL71 SL5 VSS sky130_fd_pr__nfet_g5v0d10v5 ad=0.65 pd=3.3 as=0 ps=0 w=1 l=0.5
X1728 rr2t2r_0[0|6]/a_460_290# WL0 SL6 VSS sky130_fd_pr__nfet_g5v0d10v5 ad=0.65 pd=3.3 as=108 ps=504 w=1 l=0.5
X1729 BLP6 rr2t2r_0[0|6]/a_60_290# sky130_fd_pr_reram__reram_cell area_ox=0.0676
X1730 BLN6 rr2t2r_0[0|6]/a_460_290# sky130_fd_pr_reram__reram_cell area_ox=0.0676
X1731 rr2t2r_0[0|6]/a_60_290# WL0 SL6 VSS sky130_fd_pr__nfet_g5v0d10v5 ad=0.65 pd=3.3 as=0 ps=0 w=1 l=0.5
X1732 rr2t2r_0[1|6]/a_460_290# WL1 SL6 VSS sky130_fd_pr__nfet_g5v0d10v5 ad=0.65 pd=3.3 as=0 ps=0 w=1 l=0.5
X1733 BLP6 rr2t2r_0[1|6]/a_60_290# sky130_fd_pr_reram__reram_cell area_ox=0.0676
X1734 BLN6 rr2t2r_0[1|6]/a_460_290# sky130_fd_pr_reram__reram_cell area_ox=0.0676
X1735 rr2t2r_0[1|6]/a_60_290# WL1 SL6 VSS sky130_fd_pr__nfet_g5v0d10v5 ad=0.65 pd=3.3 as=0 ps=0 w=1 l=0.5
X1736 rr2t2r_0[2|6]/a_460_290# WL2 SL6 VSS sky130_fd_pr__nfet_g5v0d10v5 ad=0.65 pd=3.3 as=0 ps=0 w=1 l=0.5
X1737 BLP6 rr2t2r_0[2|6]/a_60_290# sky130_fd_pr_reram__reram_cell area_ox=0.0676
X1738 BLN6 rr2t2r_0[2|6]/a_460_290# sky130_fd_pr_reram__reram_cell area_ox=0.0676
X1739 rr2t2r_0[2|6]/a_60_290# WL2 SL6 VSS sky130_fd_pr__nfet_g5v0d10v5 ad=0.65 pd=3.3 as=0 ps=0 w=1 l=0.5
X1740 rr2t2r_0[3|6]/a_460_290# WL3 SL6 VSS sky130_fd_pr__nfet_g5v0d10v5 ad=0.65 pd=3.3 as=0 ps=0 w=1 l=0.5
X1741 BLP6 rr2t2r_0[3|6]/a_60_290# sky130_fd_pr_reram__reram_cell area_ox=0.0676
X1742 BLN6 rr2t2r_0[3|6]/a_460_290# sky130_fd_pr_reram__reram_cell area_ox=0.0676
X1743 rr2t2r_0[3|6]/a_60_290# WL3 SL6 VSS sky130_fd_pr__nfet_g5v0d10v5 ad=0.65 pd=3.3 as=0 ps=0 w=1 l=0.5
X1744 rr2t2r_0[4|6]/a_460_290# WL4 SL6 VSS sky130_fd_pr__nfet_g5v0d10v5 ad=0.65 pd=3.3 as=0 ps=0 w=1 l=0.5
X1745 BLP6 rr2t2r_0[4|6]/a_60_290# sky130_fd_pr_reram__reram_cell area_ox=0.0676
X1746 BLN6 rr2t2r_0[4|6]/a_460_290# sky130_fd_pr_reram__reram_cell area_ox=0.0676
X1747 rr2t2r_0[4|6]/a_60_290# WL4 SL6 VSS sky130_fd_pr__nfet_g5v0d10v5 ad=0.65 pd=3.3 as=0 ps=0 w=1 l=0.5
X1748 rr2t2r_0[5|6]/a_460_290# WL5 SL6 VSS sky130_fd_pr__nfet_g5v0d10v5 ad=0.65 pd=3.3 as=0 ps=0 w=1 l=0.5
X1749 BLP6 rr2t2r_0[5|6]/a_60_290# sky130_fd_pr_reram__reram_cell area_ox=0.0676
X1750 BLN6 rr2t2r_0[5|6]/a_460_290# sky130_fd_pr_reram__reram_cell area_ox=0.0676
X1751 rr2t2r_0[5|6]/a_60_290# WL5 SL6 VSS sky130_fd_pr__nfet_g5v0d10v5 ad=0.65 pd=3.3 as=0 ps=0 w=1 l=0.5
X1752 rr2t2r_0[6|6]/a_460_290# WL6 SL6 VSS sky130_fd_pr__nfet_g5v0d10v5 ad=0.65 pd=3.3 as=0 ps=0 w=1 l=0.5
X1753 BLP6 rr2t2r_0[6|6]/a_60_290# sky130_fd_pr_reram__reram_cell area_ox=0.0676
X1754 BLN6 rr2t2r_0[6|6]/a_460_290# sky130_fd_pr_reram__reram_cell area_ox=0.0676
X1755 rr2t2r_0[6|6]/a_60_290# WL6 SL6 VSS sky130_fd_pr__nfet_g5v0d10v5 ad=0.65 pd=3.3 as=0 ps=0 w=1 l=0.5
X1756 rr2t2r_0[7|6]/a_460_290# WL7 SL6 VSS sky130_fd_pr__nfet_g5v0d10v5 ad=0.65 pd=3.3 as=0 ps=0 w=1 l=0.5
X1757 BLP6 rr2t2r_0[7|6]/a_60_290# sky130_fd_pr_reram__reram_cell area_ox=0.0676
X1758 BLN6 rr2t2r_0[7|6]/a_460_290# sky130_fd_pr_reram__reram_cell area_ox=0.0676
X1759 rr2t2r_0[7|6]/a_60_290# WL7 SL6 VSS sky130_fd_pr__nfet_g5v0d10v5 ad=0.65 pd=3.3 as=0 ps=0 w=1 l=0.5
X1760 rr2t2r_0[8|6]/a_460_290# WL8 SL6 VSS sky130_fd_pr__nfet_g5v0d10v5 ad=0.65 pd=3.3 as=0 ps=0 w=1 l=0.5
X1761 BLP6 rr2t2r_0[8|6]/a_60_290# sky130_fd_pr_reram__reram_cell area_ox=0.0676
X1762 BLN6 rr2t2r_0[8|6]/a_460_290# sky130_fd_pr_reram__reram_cell area_ox=0.0676
X1763 rr2t2r_0[8|6]/a_60_290# WL8 SL6 VSS sky130_fd_pr__nfet_g5v0d10v5 ad=0.65 pd=3.3 as=0 ps=0 w=1 l=0.5
X1764 rr2t2r_0[9|6]/a_460_290# WL9 SL6 VSS sky130_fd_pr__nfet_g5v0d10v5 ad=0.65 pd=3.3 as=0 ps=0 w=1 l=0.5
X1765 BLP6 rr2t2r_0[9|6]/a_60_290# sky130_fd_pr_reram__reram_cell area_ox=0.0676
X1766 BLN6 rr2t2r_0[9|6]/a_460_290# sky130_fd_pr_reram__reram_cell area_ox=0.0676
X1767 rr2t2r_0[9|6]/a_60_290# WL9 SL6 VSS sky130_fd_pr__nfet_g5v0d10v5 ad=0.65 pd=3.3 as=0 ps=0 w=1 l=0.5
X1768 rr2t2r_0[10|6]/a_460_290# WL10 SL6 VSS sky130_fd_pr__nfet_g5v0d10v5 ad=0.65 pd=3.3 as=0 ps=0 w=1 l=0.5
X1769 BLP6 rr2t2r_0[10|6]/a_60_290# sky130_fd_pr_reram__reram_cell area_ox=0.0676
X1770 BLN6 rr2t2r_0[10|6]/a_460_290# sky130_fd_pr_reram__reram_cell area_ox=0.0676
X1771 rr2t2r_0[10|6]/a_60_290# WL10 SL6 VSS sky130_fd_pr__nfet_g5v0d10v5 ad=0.65 pd=3.3 as=0 ps=0 w=1 l=0.5
X1772 rr2t2r_0[11|6]/a_460_290# WL11 SL6 VSS sky130_fd_pr__nfet_g5v0d10v5 ad=0.65 pd=3.3 as=0 ps=0 w=1 l=0.5
X1773 BLP6 rr2t2r_0[11|6]/a_60_290# sky130_fd_pr_reram__reram_cell area_ox=0.0676
X1774 BLN6 rr2t2r_0[11|6]/a_460_290# sky130_fd_pr_reram__reram_cell area_ox=0.0676
X1775 rr2t2r_0[11|6]/a_60_290# WL11 SL6 VSS sky130_fd_pr__nfet_g5v0d10v5 ad=0.65 pd=3.3 as=0 ps=0 w=1 l=0.5
X1776 rr2t2r_0[12|6]/a_460_290# WL12 SL6 VSS sky130_fd_pr__nfet_g5v0d10v5 ad=0.65 pd=3.3 as=0 ps=0 w=1 l=0.5
X1777 BLP6 rr2t2r_0[12|6]/a_60_290# sky130_fd_pr_reram__reram_cell area_ox=0.0676
X1778 BLN6 rr2t2r_0[12|6]/a_460_290# sky130_fd_pr_reram__reram_cell area_ox=0.0676
X1779 rr2t2r_0[12|6]/a_60_290# WL12 SL6 VSS sky130_fd_pr__nfet_g5v0d10v5 ad=0.65 pd=3.3 as=0 ps=0 w=1 l=0.5
X1780 rr2t2r_0[13|6]/a_460_290# WL13 SL6 VSS sky130_fd_pr__nfet_g5v0d10v5 ad=0.65 pd=3.3 as=0 ps=0 w=1 l=0.5
X1781 BLP6 rr2t2r_0[13|6]/a_60_290# sky130_fd_pr_reram__reram_cell area_ox=0.0676
X1782 BLN6 rr2t2r_0[13|6]/a_460_290# sky130_fd_pr_reram__reram_cell area_ox=0.0676
X1783 rr2t2r_0[13|6]/a_60_290# WL13 SL6 VSS sky130_fd_pr__nfet_g5v0d10v5 ad=0.65 pd=3.3 as=0 ps=0 w=1 l=0.5
X1784 rr2t2r_0[14|6]/a_460_290# WL14 SL6 VSS sky130_fd_pr__nfet_g5v0d10v5 ad=0.65 pd=3.3 as=0 ps=0 w=1 l=0.5
X1785 BLP6 rr2t2r_0[14|6]/a_60_290# sky130_fd_pr_reram__reram_cell area_ox=0.0676
X1786 BLN6 rr2t2r_0[14|6]/a_460_290# sky130_fd_pr_reram__reram_cell area_ox=0.0676
X1787 rr2t2r_0[14|6]/a_60_290# WL14 SL6 VSS sky130_fd_pr__nfet_g5v0d10v5 ad=0.65 pd=3.3 as=0 ps=0 w=1 l=0.5
X1788 rr2t2r_0[15|6]/a_460_290# WL15 SL6 VSS sky130_fd_pr__nfet_g5v0d10v5 ad=0.65 pd=3.3 as=0 ps=0 w=1 l=0.5
X1789 BLP6 rr2t2r_0[15|6]/a_60_290# sky130_fd_pr_reram__reram_cell area_ox=0.0676
X1790 BLN6 rr2t2r_0[15|6]/a_460_290# sky130_fd_pr_reram__reram_cell area_ox=0.0676
X1791 rr2t2r_0[15|6]/a_60_290# WL15 SL6 VSS sky130_fd_pr__nfet_g5v0d10v5 ad=0.65 pd=3.3 as=0 ps=0 w=1 l=0.5
X1792 rr2t2r_0[16|6]/a_460_290# WL16 SL6 VSS sky130_fd_pr__nfet_g5v0d10v5 ad=0.65 pd=3.3 as=0 ps=0 w=1 l=0.5
X1793 BLP6 rr2t2r_0[16|6]/a_60_290# sky130_fd_pr_reram__reram_cell area_ox=0.0676
X1794 BLN6 rr2t2r_0[16|6]/a_460_290# sky130_fd_pr_reram__reram_cell area_ox=0.0676
X1795 rr2t2r_0[16|6]/a_60_290# WL16 SL6 VSS sky130_fd_pr__nfet_g5v0d10v5 ad=0.65 pd=3.3 as=0 ps=0 w=1 l=0.5
X1796 rr2t2r_0[17|6]/a_460_290# WL17 SL6 VSS sky130_fd_pr__nfet_g5v0d10v5 ad=0.65 pd=3.3 as=0 ps=0 w=1 l=0.5
X1797 BLP6 rr2t2r_0[17|6]/a_60_290# sky130_fd_pr_reram__reram_cell area_ox=0.0676
X1798 BLN6 rr2t2r_0[17|6]/a_460_290# sky130_fd_pr_reram__reram_cell area_ox=0.0676
X1799 rr2t2r_0[17|6]/a_60_290# WL17 SL6 VSS sky130_fd_pr__nfet_g5v0d10v5 ad=0.65 pd=3.3 as=0 ps=0 w=1 l=0.5
X1800 rr2t2r_0[18|6]/a_460_290# WL18 SL6 VSS sky130_fd_pr__nfet_g5v0d10v5 ad=0.65 pd=3.3 as=0 ps=0 w=1 l=0.5
X1801 BLP6 rr2t2r_0[18|6]/a_60_290# sky130_fd_pr_reram__reram_cell area_ox=0.0676
X1802 BLN6 rr2t2r_0[18|6]/a_460_290# sky130_fd_pr_reram__reram_cell area_ox=0.0676
X1803 rr2t2r_0[18|6]/a_60_290# WL18 SL6 VSS sky130_fd_pr__nfet_g5v0d10v5 ad=0.65 pd=3.3 as=0 ps=0 w=1 l=0.5
X1804 rr2t2r_0[19|6]/a_460_290# WL19 SL6 VSS sky130_fd_pr__nfet_g5v0d10v5 ad=0.65 pd=3.3 as=0 ps=0 w=1 l=0.5
X1805 BLP6 rr2t2r_0[19|6]/a_60_290# sky130_fd_pr_reram__reram_cell area_ox=0.0676
X1806 BLN6 rr2t2r_0[19|6]/a_460_290# sky130_fd_pr_reram__reram_cell area_ox=0.0676
X1807 rr2t2r_0[19|6]/a_60_290# WL19 SL6 VSS sky130_fd_pr__nfet_g5v0d10v5 ad=0.65 pd=3.3 as=0 ps=0 w=1 l=0.5
X1808 rr2t2r_0[20|6]/a_460_290# WL20 SL6 VSS sky130_fd_pr__nfet_g5v0d10v5 ad=0.65 pd=3.3 as=0 ps=0 w=1 l=0.5
X1809 BLP6 rr2t2r_0[20|6]/a_60_290# sky130_fd_pr_reram__reram_cell area_ox=0.0676
X1810 BLN6 rr2t2r_0[20|6]/a_460_290# sky130_fd_pr_reram__reram_cell area_ox=0.0676
X1811 rr2t2r_0[20|6]/a_60_290# WL20 SL6 VSS sky130_fd_pr__nfet_g5v0d10v5 ad=0.65 pd=3.3 as=0 ps=0 w=1 l=0.5
X1812 rr2t2r_0[21|6]/a_460_290# WL21 SL6 VSS sky130_fd_pr__nfet_g5v0d10v5 ad=0.65 pd=3.3 as=0 ps=0 w=1 l=0.5
X1813 BLP6 rr2t2r_0[21|6]/a_60_290# sky130_fd_pr_reram__reram_cell area_ox=0.0676
X1814 BLN6 rr2t2r_0[21|6]/a_460_290# sky130_fd_pr_reram__reram_cell area_ox=0.0676
X1815 rr2t2r_0[21|6]/a_60_290# WL21 SL6 VSS sky130_fd_pr__nfet_g5v0d10v5 ad=0.65 pd=3.3 as=0 ps=0 w=1 l=0.5
X1816 rr2t2r_0[22|6]/a_460_290# WL22 SL6 VSS sky130_fd_pr__nfet_g5v0d10v5 ad=0.65 pd=3.3 as=0 ps=0 w=1 l=0.5
X1817 BLP6 rr2t2r_0[22|6]/a_60_290# sky130_fd_pr_reram__reram_cell area_ox=0.0676
X1818 BLN6 rr2t2r_0[22|6]/a_460_290# sky130_fd_pr_reram__reram_cell area_ox=0.0676
X1819 rr2t2r_0[22|6]/a_60_290# WL22 SL6 VSS sky130_fd_pr__nfet_g5v0d10v5 ad=0.65 pd=3.3 as=0 ps=0 w=1 l=0.5
X1820 rr2t2r_0[23|6]/a_460_290# WL23 SL6 VSS sky130_fd_pr__nfet_g5v0d10v5 ad=0.65 pd=3.3 as=0 ps=0 w=1 l=0.5
X1821 BLP6 rr2t2r_0[23|6]/a_60_290# sky130_fd_pr_reram__reram_cell area_ox=0.0676
X1822 BLN6 rr2t2r_0[23|6]/a_460_290# sky130_fd_pr_reram__reram_cell area_ox=0.0676
X1823 rr2t2r_0[23|6]/a_60_290# WL23 SL6 VSS sky130_fd_pr__nfet_g5v0d10v5 ad=0.65 pd=3.3 as=0 ps=0 w=1 l=0.5
X1824 rr2t2r_0[24|6]/a_460_290# WL24 SL6 VSS sky130_fd_pr__nfet_g5v0d10v5 ad=0.65 pd=3.3 as=0 ps=0 w=1 l=0.5
X1825 BLP6 rr2t2r_0[24|6]/a_60_290# sky130_fd_pr_reram__reram_cell area_ox=0.0676
X1826 BLN6 rr2t2r_0[24|6]/a_460_290# sky130_fd_pr_reram__reram_cell area_ox=0.0676
X1827 rr2t2r_0[24|6]/a_60_290# WL24 SL6 VSS sky130_fd_pr__nfet_g5v0d10v5 ad=0.65 pd=3.3 as=0 ps=0 w=1 l=0.5
X1828 rr2t2r_0[25|6]/a_460_290# WL25 SL6 VSS sky130_fd_pr__nfet_g5v0d10v5 ad=0.65 pd=3.3 as=0 ps=0 w=1 l=0.5
X1829 BLP6 rr2t2r_0[25|6]/a_60_290# sky130_fd_pr_reram__reram_cell area_ox=0.0676
X1830 BLN6 rr2t2r_0[25|6]/a_460_290# sky130_fd_pr_reram__reram_cell area_ox=0.0676
X1831 rr2t2r_0[25|6]/a_60_290# WL25 SL6 VSS sky130_fd_pr__nfet_g5v0d10v5 ad=0.65 pd=3.3 as=0 ps=0 w=1 l=0.5
X1832 rr2t2r_0[26|6]/a_460_290# WL26 SL6 VSS sky130_fd_pr__nfet_g5v0d10v5 ad=0.65 pd=3.3 as=0 ps=0 w=1 l=0.5
X1833 BLP6 rr2t2r_0[26|6]/a_60_290# sky130_fd_pr_reram__reram_cell area_ox=0.0676
X1834 BLN6 rr2t2r_0[26|6]/a_460_290# sky130_fd_pr_reram__reram_cell area_ox=0.0676
X1835 rr2t2r_0[26|6]/a_60_290# WL26 SL6 VSS sky130_fd_pr__nfet_g5v0d10v5 ad=0.65 pd=3.3 as=0 ps=0 w=1 l=0.5
X1836 rr2t2r_0[27|6]/a_460_290# WL27 SL6 VSS sky130_fd_pr__nfet_g5v0d10v5 ad=0.65 pd=3.3 as=0 ps=0 w=1 l=0.5
X1837 BLP6 rr2t2r_0[27|6]/a_60_290# sky130_fd_pr_reram__reram_cell area_ox=0.0676
X1838 BLN6 rr2t2r_0[27|6]/a_460_290# sky130_fd_pr_reram__reram_cell area_ox=0.0676
X1839 rr2t2r_0[27|6]/a_60_290# WL27 SL6 VSS sky130_fd_pr__nfet_g5v0d10v5 ad=0.65 pd=3.3 as=0 ps=0 w=1 l=0.5
X1840 rr2t2r_0[28|6]/a_460_290# WL28 SL6 VSS sky130_fd_pr__nfet_g5v0d10v5 ad=0.65 pd=3.3 as=0 ps=0 w=1 l=0.5
X1841 BLP6 rr2t2r_0[28|6]/a_60_290# sky130_fd_pr_reram__reram_cell area_ox=0.0676
X1842 BLN6 rr2t2r_0[28|6]/a_460_290# sky130_fd_pr_reram__reram_cell area_ox=0.0676
X1843 rr2t2r_0[28|6]/a_60_290# WL28 SL6 VSS sky130_fd_pr__nfet_g5v0d10v5 ad=0.65 pd=3.3 as=0 ps=0 w=1 l=0.5
X1844 rr2t2r_0[29|6]/a_460_290# WL29 SL6 VSS sky130_fd_pr__nfet_g5v0d10v5 ad=0.65 pd=3.3 as=0 ps=0 w=1 l=0.5
X1845 BLP6 rr2t2r_0[29|6]/a_60_290# sky130_fd_pr_reram__reram_cell area_ox=0.0676
X1846 BLN6 rr2t2r_0[29|6]/a_460_290# sky130_fd_pr_reram__reram_cell area_ox=0.0676
X1847 rr2t2r_0[29|6]/a_60_290# WL29 SL6 VSS sky130_fd_pr__nfet_g5v0d10v5 ad=0.65 pd=3.3 as=0 ps=0 w=1 l=0.5
X1848 rr2t2r_0[30|6]/a_460_290# WL30 SL6 VSS sky130_fd_pr__nfet_g5v0d10v5 ad=0.65 pd=3.3 as=0 ps=0 w=1 l=0.5
X1849 BLP6 rr2t2r_0[30|6]/a_60_290# sky130_fd_pr_reram__reram_cell area_ox=0.0676
X1850 BLN6 rr2t2r_0[30|6]/a_460_290# sky130_fd_pr_reram__reram_cell area_ox=0.0676
X1851 rr2t2r_0[30|6]/a_60_290# WL30 SL6 VSS sky130_fd_pr__nfet_g5v0d10v5 ad=0.65 pd=3.3 as=0 ps=0 w=1 l=0.5
X1852 rr2t2r_0[31|6]/a_460_290# WL31 SL6 VSS sky130_fd_pr__nfet_g5v0d10v5 ad=0.65 pd=3.3 as=0 ps=0 w=1 l=0.5
X1853 BLP6 rr2t2r_0[31|6]/a_60_290# sky130_fd_pr_reram__reram_cell area_ox=0.0676
X1854 BLN6 rr2t2r_0[31|6]/a_460_290# sky130_fd_pr_reram__reram_cell area_ox=0.0676
X1855 rr2t2r_0[31|6]/a_60_290# WL31 SL6 VSS sky130_fd_pr__nfet_g5v0d10v5 ad=0.65 pd=3.3 as=0 ps=0 w=1 l=0.5
X1856 rr2t2r_0[32|6]/a_460_290# WL32 SL6 VSS sky130_fd_pr__nfet_g5v0d10v5 ad=0.65 pd=3.3 as=0 ps=0 w=1 l=0.5
X1857 BLP6 rr2t2r_0[32|6]/a_60_290# sky130_fd_pr_reram__reram_cell area_ox=0.0676
X1858 BLN6 rr2t2r_0[32|6]/a_460_290# sky130_fd_pr_reram__reram_cell area_ox=0.0676
X1859 rr2t2r_0[32|6]/a_60_290# WL32 SL6 VSS sky130_fd_pr__nfet_g5v0d10v5 ad=0.65 pd=3.3 as=0 ps=0 w=1 l=0.5
X1860 rr2t2r_0[33|6]/a_460_290# WL33 SL6 VSS sky130_fd_pr__nfet_g5v0d10v5 ad=0.65 pd=3.3 as=0 ps=0 w=1 l=0.5
X1861 BLP6 rr2t2r_0[33|6]/a_60_290# sky130_fd_pr_reram__reram_cell area_ox=0.0676
X1862 BLN6 rr2t2r_0[33|6]/a_460_290# sky130_fd_pr_reram__reram_cell area_ox=0.0676
X1863 rr2t2r_0[33|6]/a_60_290# WL33 SL6 VSS sky130_fd_pr__nfet_g5v0d10v5 ad=0.65 pd=3.3 as=0 ps=0 w=1 l=0.5
X1864 rr2t2r_0[34|6]/a_460_290# WL34 SL6 VSS sky130_fd_pr__nfet_g5v0d10v5 ad=0.65 pd=3.3 as=0 ps=0 w=1 l=0.5
X1865 BLP6 rr2t2r_0[34|6]/a_60_290# sky130_fd_pr_reram__reram_cell area_ox=0.0676
X1866 BLN6 rr2t2r_0[34|6]/a_460_290# sky130_fd_pr_reram__reram_cell area_ox=0.0676
X1867 rr2t2r_0[34|6]/a_60_290# WL34 SL6 VSS sky130_fd_pr__nfet_g5v0d10v5 ad=0.65 pd=3.3 as=0 ps=0 w=1 l=0.5
X1868 rr2t2r_0[35|6]/a_460_290# WL35 SL6 VSS sky130_fd_pr__nfet_g5v0d10v5 ad=0.65 pd=3.3 as=0 ps=0 w=1 l=0.5
X1869 BLP6 rr2t2r_0[35|6]/a_60_290# sky130_fd_pr_reram__reram_cell area_ox=0.0676
X1870 BLN6 rr2t2r_0[35|6]/a_460_290# sky130_fd_pr_reram__reram_cell area_ox=0.0676
X1871 rr2t2r_0[35|6]/a_60_290# WL35 SL6 VSS sky130_fd_pr__nfet_g5v0d10v5 ad=0.65 pd=3.3 as=0 ps=0 w=1 l=0.5
X1872 rr2t2r_0[36|6]/a_460_290# WL36 SL6 VSS sky130_fd_pr__nfet_g5v0d10v5 ad=0.65 pd=3.3 as=0 ps=0 w=1 l=0.5
X1873 BLP6 rr2t2r_0[36|6]/a_60_290# sky130_fd_pr_reram__reram_cell area_ox=0.0676
X1874 BLN6 rr2t2r_0[36|6]/a_460_290# sky130_fd_pr_reram__reram_cell area_ox=0.0676
X1875 rr2t2r_0[36|6]/a_60_290# WL36 SL6 VSS sky130_fd_pr__nfet_g5v0d10v5 ad=0.65 pd=3.3 as=0 ps=0 w=1 l=0.5
X1876 rr2t2r_0[37|6]/a_460_290# WL37 SL6 VSS sky130_fd_pr__nfet_g5v0d10v5 ad=0.65 pd=3.3 as=0 ps=0 w=1 l=0.5
X1877 BLP6 rr2t2r_0[37|6]/a_60_290# sky130_fd_pr_reram__reram_cell area_ox=0.0676
X1878 BLN6 rr2t2r_0[37|6]/a_460_290# sky130_fd_pr_reram__reram_cell area_ox=0.0676
X1879 rr2t2r_0[37|6]/a_60_290# WL37 SL6 VSS sky130_fd_pr__nfet_g5v0d10v5 ad=0.65 pd=3.3 as=0 ps=0 w=1 l=0.5
X1880 rr2t2r_0[38|6]/a_460_290# WL38 SL6 VSS sky130_fd_pr__nfet_g5v0d10v5 ad=0.65 pd=3.3 as=0 ps=0 w=1 l=0.5
X1881 BLP6 rr2t2r_0[38|6]/a_60_290# sky130_fd_pr_reram__reram_cell area_ox=0.0676
X1882 BLN6 rr2t2r_0[38|6]/a_460_290# sky130_fd_pr_reram__reram_cell area_ox=0.0676
X1883 rr2t2r_0[38|6]/a_60_290# WL38 SL6 VSS sky130_fd_pr__nfet_g5v0d10v5 ad=0.65 pd=3.3 as=0 ps=0 w=1 l=0.5
X1884 rr2t2r_0[39|6]/a_460_290# WL39 SL6 VSS sky130_fd_pr__nfet_g5v0d10v5 ad=0.65 pd=3.3 as=0 ps=0 w=1 l=0.5
X1885 BLP6 rr2t2r_0[39|6]/a_60_290# sky130_fd_pr_reram__reram_cell area_ox=0.0676
X1886 BLN6 rr2t2r_0[39|6]/a_460_290# sky130_fd_pr_reram__reram_cell area_ox=0.0676
X1887 rr2t2r_0[39|6]/a_60_290# WL39 SL6 VSS sky130_fd_pr__nfet_g5v0d10v5 ad=0.65 pd=3.3 as=0 ps=0 w=1 l=0.5
X1888 rr2t2r_0[40|6]/a_460_290# WL40 SL6 VSS sky130_fd_pr__nfet_g5v0d10v5 ad=0.65 pd=3.3 as=0 ps=0 w=1 l=0.5
X1889 BLP6 rr2t2r_0[40|6]/a_60_290# sky130_fd_pr_reram__reram_cell area_ox=0.0676
X1890 BLN6 rr2t2r_0[40|6]/a_460_290# sky130_fd_pr_reram__reram_cell area_ox=0.0676
X1891 rr2t2r_0[40|6]/a_60_290# WL40 SL6 VSS sky130_fd_pr__nfet_g5v0d10v5 ad=0.65 pd=3.3 as=0 ps=0 w=1 l=0.5
X1892 rr2t2r_0[41|6]/a_460_290# WL41 SL6 VSS sky130_fd_pr__nfet_g5v0d10v5 ad=0.65 pd=3.3 as=0 ps=0 w=1 l=0.5
X1893 BLP6 rr2t2r_0[41|6]/a_60_290# sky130_fd_pr_reram__reram_cell area_ox=0.0676
X1894 BLN6 rr2t2r_0[41|6]/a_460_290# sky130_fd_pr_reram__reram_cell area_ox=0.0676
X1895 rr2t2r_0[41|6]/a_60_290# WL41 SL6 VSS sky130_fd_pr__nfet_g5v0d10v5 ad=0.65 pd=3.3 as=0 ps=0 w=1 l=0.5
X1896 rr2t2r_0[42|6]/a_460_290# WL42 SL6 VSS sky130_fd_pr__nfet_g5v0d10v5 ad=0.65 pd=3.3 as=0 ps=0 w=1 l=0.5
X1897 BLP6 rr2t2r_0[42|6]/a_60_290# sky130_fd_pr_reram__reram_cell area_ox=0.0676
X1898 BLN6 rr2t2r_0[42|6]/a_460_290# sky130_fd_pr_reram__reram_cell area_ox=0.0676
X1899 rr2t2r_0[42|6]/a_60_290# WL42 SL6 VSS sky130_fd_pr__nfet_g5v0d10v5 ad=0.65 pd=3.3 as=0 ps=0 w=1 l=0.5
X1900 rr2t2r_0[43|6]/a_460_290# WL43 SL6 VSS sky130_fd_pr__nfet_g5v0d10v5 ad=0.65 pd=3.3 as=0 ps=0 w=1 l=0.5
X1901 BLP6 rr2t2r_0[43|6]/a_60_290# sky130_fd_pr_reram__reram_cell area_ox=0.0676
X1902 BLN6 rr2t2r_0[43|6]/a_460_290# sky130_fd_pr_reram__reram_cell area_ox=0.0676
X1903 rr2t2r_0[43|6]/a_60_290# WL43 SL6 VSS sky130_fd_pr__nfet_g5v0d10v5 ad=0.65 pd=3.3 as=0 ps=0 w=1 l=0.5
X1904 rr2t2r_0[44|6]/a_460_290# WL44 SL6 VSS sky130_fd_pr__nfet_g5v0d10v5 ad=0.65 pd=3.3 as=0 ps=0 w=1 l=0.5
X1905 BLP6 rr2t2r_0[44|6]/a_60_290# sky130_fd_pr_reram__reram_cell area_ox=0.0676
X1906 BLN6 rr2t2r_0[44|6]/a_460_290# sky130_fd_pr_reram__reram_cell area_ox=0.0676
X1907 rr2t2r_0[44|6]/a_60_290# WL44 SL6 VSS sky130_fd_pr__nfet_g5v0d10v5 ad=0.65 pd=3.3 as=0 ps=0 w=1 l=0.5
X1908 rr2t2r_0[45|6]/a_460_290# WL45 SL6 VSS sky130_fd_pr__nfet_g5v0d10v5 ad=0.65 pd=3.3 as=0 ps=0 w=1 l=0.5
X1909 BLP6 rr2t2r_0[45|6]/a_60_290# sky130_fd_pr_reram__reram_cell area_ox=0.0676
X1910 BLN6 rr2t2r_0[45|6]/a_460_290# sky130_fd_pr_reram__reram_cell area_ox=0.0676
X1911 rr2t2r_0[45|6]/a_60_290# WL45 SL6 VSS sky130_fd_pr__nfet_g5v0d10v5 ad=0.65 pd=3.3 as=0 ps=0 w=1 l=0.5
X1912 rr2t2r_0[46|6]/a_460_290# WL46 SL6 VSS sky130_fd_pr__nfet_g5v0d10v5 ad=0.65 pd=3.3 as=0 ps=0 w=1 l=0.5
X1913 BLP6 rr2t2r_0[46|6]/a_60_290# sky130_fd_pr_reram__reram_cell area_ox=0.0676
X1914 BLN6 rr2t2r_0[46|6]/a_460_290# sky130_fd_pr_reram__reram_cell area_ox=0.0676
X1915 rr2t2r_0[46|6]/a_60_290# WL46 SL6 VSS sky130_fd_pr__nfet_g5v0d10v5 ad=0.65 pd=3.3 as=0 ps=0 w=1 l=0.5
X1916 rr2t2r_0[47|6]/a_460_290# WL47 SL6 VSS sky130_fd_pr__nfet_g5v0d10v5 ad=0.65 pd=3.3 as=0 ps=0 w=1 l=0.5
X1917 BLP6 rr2t2r_0[47|6]/a_60_290# sky130_fd_pr_reram__reram_cell area_ox=0.0676
X1918 BLN6 rr2t2r_0[47|6]/a_460_290# sky130_fd_pr_reram__reram_cell area_ox=0.0676
X1919 rr2t2r_0[47|6]/a_60_290# WL47 SL6 VSS sky130_fd_pr__nfet_g5v0d10v5 ad=0.65 pd=3.3 as=0 ps=0 w=1 l=0.5
X1920 rr2t2r_0[48|6]/a_460_290# WL48 SL6 VSS sky130_fd_pr__nfet_g5v0d10v5 ad=0.65 pd=3.3 as=0 ps=0 w=1 l=0.5
X1921 BLP6 rr2t2r_0[48|6]/a_60_290# sky130_fd_pr_reram__reram_cell area_ox=0.0676
X1922 BLN6 rr2t2r_0[48|6]/a_460_290# sky130_fd_pr_reram__reram_cell area_ox=0.0676
X1923 rr2t2r_0[48|6]/a_60_290# WL48 SL6 VSS sky130_fd_pr__nfet_g5v0d10v5 ad=0.65 pd=3.3 as=0 ps=0 w=1 l=0.5
X1924 rr2t2r_0[49|6]/a_460_290# WL49 SL6 VSS sky130_fd_pr__nfet_g5v0d10v5 ad=0.65 pd=3.3 as=0 ps=0 w=1 l=0.5
X1925 BLP6 rr2t2r_0[49|6]/a_60_290# sky130_fd_pr_reram__reram_cell area_ox=0.0676
X1926 BLN6 rr2t2r_0[49|6]/a_460_290# sky130_fd_pr_reram__reram_cell area_ox=0.0676
X1927 rr2t2r_0[49|6]/a_60_290# WL49 SL6 VSS sky130_fd_pr__nfet_g5v0d10v5 ad=0.65 pd=3.3 as=0 ps=0 w=1 l=0.5
X1928 rr2t2r_0[50|6]/a_460_290# WL50 SL6 VSS sky130_fd_pr__nfet_g5v0d10v5 ad=0.65 pd=3.3 as=0 ps=0 w=1 l=0.5
X1929 BLP6 rr2t2r_0[50|6]/a_60_290# sky130_fd_pr_reram__reram_cell area_ox=0.0676
X1930 BLN6 rr2t2r_0[50|6]/a_460_290# sky130_fd_pr_reram__reram_cell area_ox=0.0676
X1931 rr2t2r_0[50|6]/a_60_290# WL50 SL6 VSS sky130_fd_pr__nfet_g5v0d10v5 ad=0.65 pd=3.3 as=0 ps=0 w=1 l=0.5
X1932 rr2t2r_0[51|6]/a_460_290# WL51 SL6 VSS sky130_fd_pr__nfet_g5v0d10v5 ad=0.65 pd=3.3 as=0 ps=0 w=1 l=0.5
X1933 BLP6 rr2t2r_0[51|6]/a_60_290# sky130_fd_pr_reram__reram_cell area_ox=0.0676
X1934 BLN6 rr2t2r_0[51|6]/a_460_290# sky130_fd_pr_reram__reram_cell area_ox=0.0676
X1935 rr2t2r_0[51|6]/a_60_290# WL51 SL6 VSS sky130_fd_pr__nfet_g5v0d10v5 ad=0.65 pd=3.3 as=0 ps=0 w=1 l=0.5
X1936 rr2t2r_0[52|6]/a_460_290# WL52 SL6 VSS sky130_fd_pr__nfet_g5v0d10v5 ad=0.65 pd=3.3 as=0 ps=0 w=1 l=0.5
X1937 BLP6 rr2t2r_0[52|6]/a_60_290# sky130_fd_pr_reram__reram_cell area_ox=0.0676
X1938 BLN6 rr2t2r_0[52|6]/a_460_290# sky130_fd_pr_reram__reram_cell area_ox=0.0676
X1939 rr2t2r_0[52|6]/a_60_290# WL52 SL6 VSS sky130_fd_pr__nfet_g5v0d10v5 ad=0.65 pd=3.3 as=0 ps=0 w=1 l=0.5
X1940 rr2t2r_0[53|6]/a_460_290# WL53 SL6 VSS sky130_fd_pr__nfet_g5v0d10v5 ad=0.65 pd=3.3 as=0 ps=0 w=1 l=0.5
X1941 BLP6 rr2t2r_0[53|6]/a_60_290# sky130_fd_pr_reram__reram_cell area_ox=0.0676
X1942 BLN6 rr2t2r_0[53|6]/a_460_290# sky130_fd_pr_reram__reram_cell area_ox=0.0676
X1943 rr2t2r_0[53|6]/a_60_290# WL53 SL6 VSS sky130_fd_pr__nfet_g5v0d10v5 ad=0.65 pd=3.3 as=0 ps=0 w=1 l=0.5
X1944 rr2t2r_0[54|6]/a_460_290# WL54 SL6 VSS sky130_fd_pr__nfet_g5v0d10v5 ad=0.65 pd=3.3 as=0 ps=0 w=1 l=0.5
X1945 BLP6 rr2t2r_0[54|6]/a_60_290# sky130_fd_pr_reram__reram_cell area_ox=0.0676
X1946 BLN6 rr2t2r_0[54|6]/a_460_290# sky130_fd_pr_reram__reram_cell area_ox=0.0676
X1947 rr2t2r_0[54|6]/a_60_290# WL54 SL6 VSS sky130_fd_pr__nfet_g5v0d10v5 ad=0.65 pd=3.3 as=0 ps=0 w=1 l=0.5
X1948 rr2t2r_0[55|6]/a_460_290# WL55 SL6 VSS sky130_fd_pr__nfet_g5v0d10v5 ad=0.65 pd=3.3 as=0 ps=0 w=1 l=0.5
X1949 BLP6 rr2t2r_0[55|6]/a_60_290# sky130_fd_pr_reram__reram_cell area_ox=0.0676
X1950 BLN6 rr2t2r_0[55|6]/a_460_290# sky130_fd_pr_reram__reram_cell area_ox=0.0676
X1951 rr2t2r_0[55|6]/a_60_290# WL55 SL6 VSS sky130_fd_pr__nfet_g5v0d10v5 ad=0.65 pd=3.3 as=0 ps=0 w=1 l=0.5
X1952 rr2t2r_0[56|6]/a_460_290# WL56 SL6 VSS sky130_fd_pr__nfet_g5v0d10v5 ad=0.65 pd=3.3 as=0 ps=0 w=1 l=0.5
X1953 BLP6 rr2t2r_0[56|6]/a_60_290# sky130_fd_pr_reram__reram_cell area_ox=0.0676
X1954 BLN6 rr2t2r_0[56|6]/a_460_290# sky130_fd_pr_reram__reram_cell area_ox=0.0676
X1955 rr2t2r_0[56|6]/a_60_290# WL56 SL6 VSS sky130_fd_pr__nfet_g5v0d10v5 ad=0.65 pd=3.3 as=0 ps=0 w=1 l=0.5
X1956 rr2t2r_0[57|6]/a_460_290# WL57 SL6 VSS sky130_fd_pr__nfet_g5v0d10v5 ad=0.65 pd=3.3 as=0 ps=0 w=1 l=0.5
X1957 BLP6 rr2t2r_0[57|6]/a_60_290# sky130_fd_pr_reram__reram_cell area_ox=0.0676
X1958 BLN6 rr2t2r_0[57|6]/a_460_290# sky130_fd_pr_reram__reram_cell area_ox=0.0676
X1959 rr2t2r_0[57|6]/a_60_290# WL57 SL6 VSS sky130_fd_pr__nfet_g5v0d10v5 ad=0.65 pd=3.3 as=0 ps=0 w=1 l=0.5
X1960 rr2t2r_0[58|6]/a_460_290# WL58 SL6 VSS sky130_fd_pr__nfet_g5v0d10v5 ad=0.65 pd=3.3 as=0 ps=0 w=1 l=0.5
X1961 BLP6 rr2t2r_0[58|6]/a_60_290# sky130_fd_pr_reram__reram_cell area_ox=0.0676
X1962 BLN6 rr2t2r_0[58|6]/a_460_290# sky130_fd_pr_reram__reram_cell area_ox=0.0676
X1963 rr2t2r_0[58|6]/a_60_290# WL58 SL6 VSS sky130_fd_pr__nfet_g5v0d10v5 ad=0.65 pd=3.3 as=0 ps=0 w=1 l=0.5
X1964 rr2t2r_0[59|6]/a_460_290# WL59 SL6 VSS sky130_fd_pr__nfet_g5v0d10v5 ad=0.65 pd=3.3 as=0 ps=0 w=1 l=0.5
X1965 BLP6 rr2t2r_0[59|6]/a_60_290# sky130_fd_pr_reram__reram_cell area_ox=0.0676
X1966 BLN6 rr2t2r_0[59|6]/a_460_290# sky130_fd_pr_reram__reram_cell area_ox=0.0676
X1967 rr2t2r_0[59|6]/a_60_290# WL59 SL6 VSS sky130_fd_pr__nfet_g5v0d10v5 ad=0.65 pd=3.3 as=0 ps=0 w=1 l=0.5
X1968 rr2t2r_0[60|6]/a_460_290# WL60 SL6 VSS sky130_fd_pr__nfet_g5v0d10v5 ad=0.65 pd=3.3 as=0 ps=0 w=1 l=0.5
X1969 BLP6 rr2t2r_0[60|6]/a_60_290# sky130_fd_pr_reram__reram_cell area_ox=0.0676
X1970 BLN6 rr2t2r_0[60|6]/a_460_290# sky130_fd_pr_reram__reram_cell area_ox=0.0676
X1971 rr2t2r_0[60|6]/a_60_290# WL60 SL6 VSS sky130_fd_pr__nfet_g5v0d10v5 ad=0.65 pd=3.3 as=0 ps=0 w=1 l=0.5
X1972 rr2t2r_0[61|6]/a_460_290# WL61 SL6 VSS sky130_fd_pr__nfet_g5v0d10v5 ad=0.65 pd=3.3 as=0 ps=0 w=1 l=0.5
X1973 BLP6 rr2t2r_0[61|6]/a_60_290# sky130_fd_pr_reram__reram_cell area_ox=0.0676
X1974 BLN6 rr2t2r_0[61|6]/a_460_290# sky130_fd_pr_reram__reram_cell area_ox=0.0676
X1975 rr2t2r_0[61|6]/a_60_290# WL61 SL6 VSS sky130_fd_pr__nfet_g5v0d10v5 ad=0.65 pd=3.3 as=0 ps=0 w=1 l=0.5
X1976 rr2t2r_0[62|6]/a_460_290# WL62 SL6 VSS sky130_fd_pr__nfet_g5v0d10v5 ad=0.65 pd=3.3 as=0 ps=0 w=1 l=0.5
X1977 BLP6 rr2t2r_0[62|6]/a_60_290# sky130_fd_pr_reram__reram_cell area_ox=0.0676
X1978 BLN6 rr2t2r_0[62|6]/a_460_290# sky130_fd_pr_reram__reram_cell area_ox=0.0676
X1979 rr2t2r_0[62|6]/a_60_290# WL62 SL6 VSS sky130_fd_pr__nfet_g5v0d10v5 ad=0.65 pd=3.3 as=0 ps=0 w=1 l=0.5
X1980 rr2t2r_0[63|6]/a_460_290# WL63 SL6 VSS sky130_fd_pr__nfet_g5v0d10v5 ad=0.65 pd=3.3 as=0 ps=0 w=1 l=0.5
X1981 BLP6 rr2t2r_0[63|6]/a_60_290# sky130_fd_pr_reram__reram_cell area_ox=0.0676
X1982 BLN6 rr2t2r_0[63|6]/a_460_290# sky130_fd_pr_reram__reram_cell area_ox=0.0676
X1983 rr2t2r_0[63|6]/a_60_290# WL63 SL6 VSS sky130_fd_pr__nfet_g5v0d10v5 ad=0.65 pd=3.3 as=0 ps=0 w=1 l=0.5
X1984 rr2t2r_0[64|6]/a_460_290# WL64 SL6 VSS sky130_fd_pr__nfet_g5v0d10v5 ad=0.65 pd=3.3 as=0 ps=0 w=1 l=0.5
X1985 BLP6 rr2t2r_0[64|6]/a_60_290# sky130_fd_pr_reram__reram_cell area_ox=0.0676
X1986 BLN6 rr2t2r_0[64|6]/a_460_290# sky130_fd_pr_reram__reram_cell area_ox=0.0676
X1987 rr2t2r_0[64|6]/a_60_290# WL64 SL6 VSS sky130_fd_pr__nfet_g5v0d10v5 ad=0.65 pd=3.3 as=0 ps=0 w=1 l=0.5
X1988 rr2t2r_0[65|6]/a_460_290# WL65 SL6 VSS sky130_fd_pr__nfet_g5v0d10v5 ad=0.65 pd=3.3 as=0 ps=0 w=1 l=0.5
X1989 BLP6 rr2t2r_0[65|6]/a_60_290# sky130_fd_pr_reram__reram_cell area_ox=0.0676
X1990 BLN6 rr2t2r_0[65|6]/a_460_290# sky130_fd_pr_reram__reram_cell area_ox=0.0676
X1991 rr2t2r_0[65|6]/a_60_290# WL65 SL6 VSS sky130_fd_pr__nfet_g5v0d10v5 ad=0.65 pd=3.3 as=0 ps=0 w=1 l=0.5
X1992 rr2t2r_0[66|6]/a_460_290# WL66 SL6 VSS sky130_fd_pr__nfet_g5v0d10v5 ad=0.65 pd=3.3 as=0 ps=0 w=1 l=0.5
X1993 BLP6 rr2t2r_0[66|6]/a_60_290# sky130_fd_pr_reram__reram_cell area_ox=0.0676
X1994 BLN6 rr2t2r_0[66|6]/a_460_290# sky130_fd_pr_reram__reram_cell area_ox=0.0676
X1995 rr2t2r_0[66|6]/a_60_290# WL66 SL6 VSS sky130_fd_pr__nfet_g5v0d10v5 ad=0.65 pd=3.3 as=0 ps=0 w=1 l=0.5
X1996 rr2t2r_0[67|6]/a_460_290# WL67 SL6 VSS sky130_fd_pr__nfet_g5v0d10v5 ad=0.65 pd=3.3 as=0 ps=0 w=1 l=0.5
X1997 BLP6 rr2t2r_0[67|6]/a_60_290# sky130_fd_pr_reram__reram_cell area_ox=0.0676
X1998 BLN6 rr2t2r_0[67|6]/a_460_290# sky130_fd_pr_reram__reram_cell area_ox=0.0676
X1999 rr2t2r_0[67|6]/a_60_290# WL67 SL6 VSS sky130_fd_pr__nfet_g5v0d10v5 ad=0.65 pd=3.3 as=0 ps=0 w=1 l=0.5
X2000 rr2t2r_0[68|6]/a_460_290# WL68 SL6 VSS sky130_fd_pr__nfet_g5v0d10v5 ad=0.65 pd=3.3 as=0 ps=0 w=1 l=0.5
X2001 BLP6 rr2t2r_0[68|6]/a_60_290# sky130_fd_pr_reram__reram_cell area_ox=0.0676
X2002 BLN6 rr2t2r_0[68|6]/a_460_290# sky130_fd_pr_reram__reram_cell area_ox=0.0676
X2003 rr2t2r_0[68|6]/a_60_290# WL68 SL6 VSS sky130_fd_pr__nfet_g5v0d10v5 ad=0.65 pd=3.3 as=0 ps=0 w=1 l=0.5
X2004 rr2t2r_0[69|6]/a_460_290# WL69 SL6 VSS sky130_fd_pr__nfet_g5v0d10v5 ad=0.65 pd=3.3 as=0 ps=0 w=1 l=0.5
X2005 BLP6 rr2t2r_0[69|6]/a_60_290# sky130_fd_pr_reram__reram_cell area_ox=0.0676
X2006 BLN6 rr2t2r_0[69|6]/a_460_290# sky130_fd_pr_reram__reram_cell area_ox=0.0676
X2007 rr2t2r_0[69|6]/a_60_290# WL69 SL6 VSS sky130_fd_pr__nfet_g5v0d10v5 ad=0.65 pd=3.3 as=0 ps=0 w=1 l=0.5
X2008 rr2t2r_0[70|6]/a_460_290# WL70 SL6 VSS sky130_fd_pr__nfet_g5v0d10v5 ad=0.65 pd=3.3 as=0 ps=0 w=1 l=0.5
X2009 BLP6 rr2t2r_0[70|6]/a_60_290# sky130_fd_pr_reram__reram_cell area_ox=0.0676
X2010 BLN6 rr2t2r_0[70|6]/a_460_290# sky130_fd_pr_reram__reram_cell area_ox=0.0676
X2011 rr2t2r_0[70|6]/a_60_290# WL70 SL6 VSS sky130_fd_pr__nfet_g5v0d10v5 ad=0.65 pd=3.3 as=0 ps=0 w=1 l=0.5
X2012 rr2t2r_0[71|6]/a_460_290# WL71 SL6 VSS sky130_fd_pr__nfet_g5v0d10v5 ad=0.65 pd=3.3 as=0 ps=0 w=1 l=0.5
X2013 BLP6 rr2t2r_0[71|6]/a_60_290# sky130_fd_pr_reram__reram_cell area_ox=0.0676
X2014 BLN6 rr2t2r_0[71|6]/a_460_290# sky130_fd_pr_reram__reram_cell area_ox=0.0676
X2015 rr2t2r_0[71|6]/a_60_290# WL71 SL6 VSS sky130_fd_pr__nfet_g5v0d10v5 ad=0.65 pd=3.3 as=0 ps=0 w=1 l=0.5
X2016 rr2t2r_0[0|7]/a_460_290# WL0 SL7 VSS sky130_fd_pr__nfet_g5v0d10v5 ad=0.65 pd=3.3 as=108 ps=504 w=1 l=0.5
X2017 BLP7 rr2t2r_0[0|7]/a_60_290# sky130_fd_pr_reram__reram_cell area_ox=0.0676
X2018 BLN7 rr2t2r_0[0|7]/a_460_290# sky130_fd_pr_reram__reram_cell area_ox=0.0676
X2019 rr2t2r_0[0|7]/a_60_290# WL0 SL7 VSS sky130_fd_pr__nfet_g5v0d10v5 ad=0.65 pd=3.3 as=0 ps=0 w=1 l=0.5
X2020 rr2t2r_0[1|7]/a_460_290# WL1 SL7 VSS sky130_fd_pr__nfet_g5v0d10v5 ad=0.65 pd=3.3 as=0 ps=0 w=1 l=0.5
X2021 BLP7 rr2t2r_0[1|7]/a_60_290# sky130_fd_pr_reram__reram_cell area_ox=0.0676
X2022 BLN7 rr2t2r_0[1|7]/a_460_290# sky130_fd_pr_reram__reram_cell area_ox=0.0676
X2023 rr2t2r_0[1|7]/a_60_290# WL1 SL7 VSS sky130_fd_pr__nfet_g5v0d10v5 ad=0.65 pd=3.3 as=0 ps=0 w=1 l=0.5
X2024 rr2t2r_0[2|7]/a_460_290# WL2 SL7 VSS sky130_fd_pr__nfet_g5v0d10v5 ad=0.65 pd=3.3 as=0 ps=0 w=1 l=0.5
X2025 BLP7 rr2t2r_0[2|7]/a_60_290# sky130_fd_pr_reram__reram_cell area_ox=0.0676
X2026 BLN7 rr2t2r_0[2|7]/a_460_290# sky130_fd_pr_reram__reram_cell area_ox=0.0676
X2027 rr2t2r_0[2|7]/a_60_290# WL2 SL7 VSS sky130_fd_pr__nfet_g5v0d10v5 ad=0.65 pd=3.3 as=0 ps=0 w=1 l=0.5
X2028 rr2t2r_0[3|7]/a_460_290# WL3 SL7 VSS sky130_fd_pr__nfet_g5v0d10v5 ad=0.65 pd=3.3 as=0 ps=0 w=1 l=0.5
X2029 BLP7 rr2t2r_0[3|7]/a_60_290# sky130_fd_pr_reram__reram_cell area_ox=0.0676
X2030 BLN7 rr2t2r_0[3|7]/a_460_290# sky130_fd_pr_reram__reram_cell area_ox=0.0676
X2031 rr2t2r_0[3|7]/a_60_290# WL3 SL7 VSS sky130_fd_pr__nfet_g5v0d10v5 ad=0.65 pd=3.3 as=0 ps=0 w=1 l=0.5
X2032 rr2t2r_0[4|7]/a_460_290# WL4 SL7 VSS sky130_fd_pr__nfet_g5v0d10v5 ad=0.65 pd=3.3 as=0 ps=0 w=1 l=0.5
X2033 BLP7 rr2t2r_0[4|7]/a_60_290# sky130_fd_pr_reram__reram_cell area_ox=0.0676
X2034 BLN7 rr2t2r_0[4|7]/a_460_290# sky130_fd_pr_reram__reram_cell area_ox=0.0676
X2035 rr2t2r_0[4|7]/a_60_290# WL4 SL7 VSS sky130_fd_pr__nfet_g5v0d10v5 ad=0.65 pd=3.3 as=0 ps=0 w=1 l=0.5
X2036 rr2t2r_0[5|7]/a_460_290# WL5 SL7 VSS sky130_fd_pr__nfet_g5v0d10v5 ad=0.65 pd=3.3 as=0 ps=0 w=1 l=0.5
X2037 BLP7 rr2t2r_0[5|7]/a_60_290# sky130_fd_pr_reram__reram_cell area_ox=0.0676
X2038 BLN7 rr2t2r_0[5|7]/a_460_290# sky130_fd_pr_reram__reram_cell area_ox=0.0676
X2039 rr2t2r_0[5|7]/a_60_290# WL5 SL7 VSS sky130_fd_pr__nfet_g5v0d10v5 ad=0.65 pd=3.3 as=0 ps=0 w=1 l=0.5
X2040 rr2t2r_0[6|7]/a_460_290# WL6 SL7 VSS sky130_fd_pr__nfet_g5v0d10v5 ad=0.65 pd=3.3 as=0 ps=0 w=1 l=0.5
X2041 BLP7 rr2t2r_0[6|7]/a_60_290# sky130_fd_pr_reram__reram_cell area_ox=0.0676
X2042 BLN7 rr2t2r_0[6|7]/a_460_290# sky130_fd_pr_reram__reram_cell area_ox=0.0676
X2043 rr2t2r_0[6|7]/a_60_290# WL6 SL7 VSS sky130_fd_pr__nfet_g5v0d10v5 ad=0.65 pd=3.3 as=0 ps=0 w=1 l=0.5
X2044 rr2t2r_0[7|7]/a_460_290# WL7 SL7 VSS sky130_fd_pr__nfet_g5v0d10v5 ad=0.65 pd=3.3 as=0 ps=0 w=1 l=0.5
X2045 BLP7 rr2t2r_0[7|7]/a_60_290# sky130_fd_pr_reram__reram_cell area_ox=0.0676
X2046 BLN7 rr2t2r_0[7|7]/a_460_290# sky130_fd_pr_reram__reram_cell area_ox=0.0676
X2047 rr2t2r_0[7|7]/a_60_290# WL7 SL7 VSS sky130_fd_pr__nfet_g5v0d10v5 ad=0.65 pd=3.3 as=0 ps=0 w=1 l=0.5
X2048 rr2t2r_0[8|7]/a_460_290# WL8 SL7 VSS sky130_fd_pr__nfet_g5v0d10v5 ad=0.65 pd=3.3 as=0 ps=0 w=1 l=0.5
X2049 BLP7 rr2t2r_0[8|7]/a_60_290# sky130_fd_pr_reram__reram_cell area_ox=0.0676
X2050 BLN7 rr2t2r_0[8|7]/a_460_290# sky130_fd_pr_reram__reram_cell area_ox=0.0676
X2051 rr2t2r_0[8|7]/a_60_290# WL8 SL7 VSS sky130_fd_pr__nfet_g5v0d10v5 ad=0.65 pd=3.3 as=0 ps=0 w=1 l=0.5
X2052 rr2t2r_0[9|7]/a_460_290# WL9 SL7 VSS sky130_fd_pr__nfet_g5v0d10v5 ad=0.65 pd=3.3 as=0 ps=0 w=1 l=0.5
X2053 BLP7 rr2t2r_0[9|7]/a_60_290# sky130_fd_pr_reram__reram_cell area_ox=0.0676
X2054 BLN7 rr2t2r_0[9|7]/a_460_290# sky130_fd_pr_reram__reram_cell area_ox=0.0676
X2055 rr2t2r_0[9|7]/a_60_290# WL9 SL7 VSS sky130_fd_pr__nfet_g5v0d10v5 ad=0.65 pd=3.3 as=0 ps=0 w=1 l=0.5
X2056 rr2t2r_0[10|7]/a_460_290# WL10 SL7 VSS sky130_fd_pr__nfet_g5v0d10v5 ad=0.65 pd=3.3 as=0 ps=0 w=1 l=0.5
X2057 BLP7 rr2t2r_0[10|7]/a_60_290# sky130_fd_pr_reram__reram_cell area_ox=0.0676
X2058 BLN7 rr2t2r_0[10|7]/a_460_290# sky130_fd_pr_reram__reram_cell area_ox=0.0676
X2059 rr2t2r_0[10|7]/a_60_290# WL10 SL7 VSS sky130_fd_pr__nfet_g5v0d10v5 ad=0.65 pd=3.3 as=0 ps=0 w=1 l=0.5
X2060 rr2t2r_0[11|7]/a_460_290# WL11 SL7 VSS sky130_fd_pr__nfet_g5v0d10v5 ad=0.65 pd=3.3 as=0 ps=0 w=1 l=0.5
X2061 BLP7 rr2t2r_0[11|7]/a_60_290# sky130_fd_pr_reram__reram_cell area_ox=0.0676
X2062 BLN7 rr2t2r_0[11|7]/a_460_290# sky130_fd_pr_reram__reram_cell area_ox=0.0676
X2063 rr2t2r_0[11|7]/a_60_290# WL11 SL7 VSS sky130_fd_pr__nfet_g5v0d10v5 ad=0.65 pd=3.3 as=0 ps=0 w=1 l=0.5
X2064 rr2t2r_0[12|7]/a_460_290# WL12 SL7 VSS sky130_fd_pr__nfet_g5v0d10v5 ad=0.65 pd=3.3 as=0 ps=0 w=1 l=0.5
X2065 BLP7 rr2t2r_0[12|7]/a_60_290# sky130_fd_pr_reram__reram_cell area_ox=0.0676
X2066 BLN7 rr2t2r_0[12|7]/a_460_290# sky130_fd_pr_reram__reram_cell area_ox=0.0676
X2067 rr2t2r_0[12|7]/a_60_290# WL12 SL7 VSS sky130_fd_pr__nfet_g5v0d10v5 ad=0.65 pd=3.3 as=0 ps=0 w=1 l=0.5
X2068 rr2t2r_0[13|7]/a_460_290# WL13 SL7 VSS sky130_fd_pr__nfet_g5v0d10v5 ad=0.65 pd=3.3 as=0 ps=0 w=1 l=0.5
X2069 BLP7 rr2t2r_0[13|7]/a_60_290# sky130_fd_pr_reram__reram_cell area_ox=0.0676
X2070 BLN7 rr2t2r_0[13|7]/a_460_290# sky130_fd_pr_reram__reram_cell area_ox=0.0676
X2071 rr2t2r_0[13|7]/a_60_290# WL13 SL7 VSS sky130_fd_pr__nfet_g5v0d10v5 ad=0.65 pd=3.3 as=0 ps=0 w=1 l=0.5
X2072 rr2t2r_0[14|7]/a_460_290# WL14 SL7 VSS sky130_fd_pr__nfet_g5v0d10v5 ad=0.65 pd=3.3 as=0 ps=0 w=1 l=0.5
X2073 BLP7 rr2t2r_0[14|7]/a_60_290# sky130_fd_pr_reram__reram_cell area_ox=0.0676
X2074 BLN7 rr2t2r_0[14|7]/a_460_290# sky130_fd_pr_reram__reram_cell area_ox=0.0676
X2075 rr2t2r_0[14|7]/a_60_290# WL14 SL7 VSS sky130_fd_pr__nfet_g5v0d10v5 ad=0.65 pd=3.3 as=0 ps=0 w=1 l=0.5
X2076 rr2t2r_0[15|7]/a_460_290# WL15 SL7 VSS sky130_fd_pr__nfet_g5v0d10v5 ad=0.65 pd=3.3 as=0 ps=0 w=1 l=0.5
X2077 BLP7 rr2t2r_0[15|7]/a_60_290# sky130_fd_pr_reram__reram_cell area_ox=0.0676
X2078 BLN7 rr2t2r_0[15|7]/a_460_290# sky130_fd_pr_reram__reram_cell area_ox=0.0676
X2079 rr2t2r_0[15|7]/a_60_290# WL15 SL7 VSS sky130_fd_pr__nfet_g5v0d10v5 ad=0.65 pd=3.3 as=0 ps=0 w=1 l=0.5
X2080 rr2t2r_0[16|7]/a_460_290# WL16 SL7 VSS sky130_fd_pr__nfet_g5v0d10v5 ad=0.65 pd=3.3 as=0 ps=0 w=1 l=0.5
X2081 BLP7 rr2t2r_0[16|7]/a_60_290# sky130_fd_pr_reram__reram_cell area_ox=0.0676
X2082 BLN7 rr2t2r_0[16|7]/a_460_290# sky130_fd_pr_reram__reram_cell area_ox=0.0676
X2083 rr2t2r_0[16|7]/a_60_290# WL16 SL7 VSS sky130_fd_pr__nfet_g5v0d10v5 ad=0.65 pd=3.3 as=0 ps=0 w=1 l=0.5
X2084 rr2t2r_0[17|7]/a_460_290# WL17 SL7 VSS sky130_fd_pr__nfet_g5v0d10v5 ad=0.65 pd=3.3 as=0 ps=0 w=1 l=0.5
X2085 BLP7 rr2t2r_0[17|7]/a_60_290# sky130_fd_pr_reram__reram_cell area_ox=0.0676
X2086 BLN7 rr2t2r_0[17|7]/a_460_290# sky130_fd_pr_reram__reram_cell area_ox=0.0676
X2087 rr2t2r_0[17|7]/a_60_290# WL17 SL7 VSS sky130_fd_pr__nfet_g5v0d10v5 ad=0.65 pd=3.3 as=0 ps=0 w=1 l=0.5
X2088 rr2t2r_0[18|7]/a_460_290# WL18 SL7 VSS sky130_fd_pr__nfet_g5v0d10v5 ad=0.65 pd=3.3 as=0 ps=0 w=1 l=0.5
X2089 BLP7 rr2t2r_0[18|7]/a_60_290# sky130_fd_pr_reram__reram_cell area_ox=0.0676
X2090 BLN7 rr2t2r_0[18|7]/a_460_290# sky130_fd_pr_reram__reram_cell area_ox=0.0676
X2091 rr2t2r_0[18|7]/a_60_290# WL18 SL7 VSS sky130_fd_pr__nfet_g5v0d10v5 ad=0.65 pd=3.3 as=0 ps=0 w=1 l=0.5
X2092 rr2t2r_0[19|7]/a_460_290# WL19 SL7 VSS sky130_fd_pr__nfet_g5v0d10v5 ad=0.65 pd=3.3 as=0 ps=0 w=1 l=0.5
X2093 BLP7 rr2t2r_0[19|7]/a_60_290# sky130_fd_pr_reram__reram_cell area_ox=0.0676
X2094 BLN7 rr2t2r_0[19|7]/a_460_290# sky130_fd_pr_reram__reram_cell area_ox=0.0676
X2095 rr2t2r_0[19|7]/a_60_290# WL19 SL7 VSS sky130_fd_pr__nfet_g5v0d10v5 ad=0.65 pd=3.3 as=0 ps=0 w=1 l=0.5
X2096 rr2t2r_0[20|7]/a_460_290# WL20 SL7 VSS sky130_fd_pr__nfet_g5v0d10v5 ad=0.65 pd=3.3 as=0 ps=0 w=1 l=0.5
X2097 BLP7 rr2t2r_0[20|7]/a_60_290# sky130_fd_pr_reram__reram_cell area_ox=0.0676
X2098 BLN7 rr2t2r_0[20|7]/a_460_290# sky130_fd_pr_reram__reram_cell area_ox=0.0676
X2099 rr2t2r_0[20|7]/a_60_290# WL20 SL7 VSS sky130_fd_pr__nfet_g5v0d10v5 ad=0.65 pd=3.3 as=0 ps=0 w=1 l=0.5
X2100 rr2t2r_0[21|7]/a_460_290# WL21 SL7 VSS sky130_fd_pr__nfet_g5v0d10v5 ad=0.65 pd=3.3 as=0 ps=0 w=1 l=0.5
X2101 BLP7 rr2t2r_0[21|7]/a_60_290# sky130_fd_pr_reram__reram_cell area_ox=0.0676
X2102 BLN7 rr2t2r_0[21|7]/a_460_290# sky130_fd_pr_reram__reram_cell area_ox=0.0676
X2103 rr2t2r_0[21|7]/a_60_290# WL21 SL7 VSS sky130_fd_pr__nfet_g5v0d10v5 ad=0.65 pd=3.3 as=0 ps=0 w=1 l=0.5
X2104 rr2t2r_0[22|7]/a_460_290# WL22 SL7 VSS sky130_fd_pr__nfet_g5v0d10v5 ad=0.65 pd=3.3 as=0 ps=0 w=1 l=0.5
X2105 BLP7 rr2t2r_0[22|7]/a_60_290# sky130_fd_pr_reram__reram_cell area_ox=0.0676
X2106 BLN7 rr2t2r_0[22|7]/a_460_290# sky130_fd_pr_reram__reram_cell area_ox=0.0676
X2107 rr2t2r_0[22|7]/a_60_290# WL22 SL7 VSS sky130_fd_pr__nfet_g5v0d10v5 ad=0.65 pd=3.3 as=0 ps=0 w=1 l=0.5
X2108 rr2t2r_0[23|7]/a_460_290# WL23 SL7 VSS sky130_fd_pr__nfet_g5v0d10v5 ad=0.65 pd=3.3 as=0 ps=0 w=1 l=0.5
X2109 BLP7 rr2t2r_0[23|7]/a_60_290# sky130_fd_pr_reram__reram_cell area_ox=0.0676
X2110 BLN7 rr2t2r_0[23|7]/a_460_290# sky130_fd_pr_reram__reram_cell area_ox=0.0676
X2111 rr2t2r_0[23|7]/a_60_290# WL23 SL7 VSS sky130_fd_pr__nfet_g5v0d10v5 ad=0.65 pd=3.3 as=0 ps=0 w=1 l=0.5
X2112 rr2t2r_0[24|7]/a_460_290# WL24 SL7 VSS sky130_fd_pr__nfet_g5v0d10v5 ad=0.65 pd=3.3 as=0 ps=0 w=1 l=0.5
X2113 BLP7 rr2t2r_0[24|7]/a_60_290# sky130_fd_pr_reram__reram_cell area_ox=0.0676
X2114 BLN7 rr2t2r_0[24|7]/a_460_290# sky130_fd_pr_reram__reram_cell area_ox=0.0676
X2115 rr2t2r_0[24|7]/a_60_290# WL24 SL7 VSS sky130_fd_pr__nfet_g5v0d10v5 ad=0.65 pd=3.3 as=0 ps=0 w=1 l=0.5
X2116 rr2t2r_0[25|7]/a_460_290# WL25 SL7 VSS sky130_fd_pr__nfet_g5v0d10v5 ad=0.65 pd=3.3 as=0 ps=0 w=1 l=0.5
X2117 BLP7 rr2t2r_0[25|7]/a_60_290# sky130_fd_pr_reram__reram_cell area_ox=0.0676
X2118 BLN7 rr2t2r_0[25|7]/a_460_290# sky130_fd_pr_reram__reram_cell area_ox=0.0676
X2119 rr2t2r_0[25|7]/a_60_290# WL25 SL7 VSS sky130_fd_pr__nfet_g5v0d10v5 ad=0.65 pd=3.3 as=0 ps=0 w=1 l=0.5
X2120 rr2t2r_0[26|7]/a_460_290# WL26 SL7 VSS sky130_fd_pr__nfet_g5v0d10v5 ad=0.65 pd=3.3 as=0 ps=0 w=1 l=0.5
X2121 BLP7 rr2t2r_0[26|7]/a_60_290# sky130_fd_pr_reram__reram_cell area_ox=0.0676
X2122 BLN7 rr2t2r_0[26|7]/a_460_290# sky130_fd_pr_reram__reram_cell area_ox=0.0676
X2123 rr2t2r_0[26|7]/a_60_290# WL26 SL7 VSS sky130_fd_pr__nfet_g5v0d10v5 ad=0.65 pd=3.3 as=0 ps=0 w=1 l=0.5
X2124 rr2t2r_0[27|7]/a_460_290# WL27 SL7 VSS sky130_fd_pr__nfet_g5v0d10v5 ad=0.65 pd=3.3 as=0 ps=0 w=1 l=0.5
X2125 BLP7 rr2t2r_0[27|7]/a_60_290# sky130_fd_pr_reram__reram_cell area_ox=0.0676
X2126 BLN7 rr2t2r_0[27|7]/a_460_290# sky130_fd_pr_reram__reram_cell area_ox=0.0676
X2127 rr2t2r_0[27|7]/a_60_290# WL27 SL7 VSS sky130_fd_pr__nfet_g5v0d10v5 ad=0.65 pd=3.3 as=0 ps=0 w=1 l=0.5
X2128 rr2t2r_0[28|7]/a_460_290# WL28 SL7 VSS sky130_fd_pr__nfet_g5v0d10v5 ad=0.65 pd=3.3 as=0 ps=0 w=1 l=0.5
X2129 BLP7 rr2t2r_0[28|7]/a_60_290# sky130_fd_pr_reram__reram_cell area_ox=0.0676
X2130 BLN7 rr2t2r_0[28|7]/a_460_290# sky130_fd_pr_reram__reram_cell area_ox=0.0676
X2131 rr2t2r_0[28|7]/a_60_290# WL28 SL7 VSS sky130_fd_pr__nfet_g5v0d10v5 ad=0.65 pd=3.3 as=0 ps=0 w=1 l=0.5
X2132 rr2t2r_0[29|7]/a_460_290# WL29 SL7 VSS sky130_fd_pr__nfet_g5v0d10v5 ad=0.65 pd=3.3 as=0 ps=0 w=1 l=0.5
X2133 BLP7 rr2t2r_0[29|7]/a_60_290# sky130_fd_pr_reram__reram_cell area_ox=0.0676
X2134 BLN7 rr2t2r_0[29|7]/a_460_290# sky130_fd_pr_reram__reram_cell area_ox=0.0676
X2135 rr2t2r_0[29|7]/a_60_290# WL29 SL7 VSS sky130_fd_pr__nfet_g5v0d10v5 ad=0.65 pd=3.3 as=0 ps=0 w=1 l=0.5
X2136 rr2t2r_0[30|7]/a_460_290# WL30 SL7 VSS sky130_fd_pr__nfet_g5v0d10v5 ad=0.65 pd=3.3 as=0 ps=0 w=1 l=0.5
X2137 BLP7 rr2t2r_0[30|7]/a_60_290# sky130_fd_pr_reram__reram_cell area_ox=0.0676
X2138 BLN7 rr2t2r_0[30|7]/a_460_290# sky130_fd_pr_reram__reram_cell area_ox=0.0676
X2139 rr2t2r_0[30|7]/a_60_290# WL30 SL7 VSS sky130_fd_pr__nfet_g5v0d10v5 ad=0.65 pd=3.3 as=0 ps=0 w=1 l=0.5
X2140 rr2t2r_0[31|7]/a_460_290# WL31 SL7 VSS sky130_fd_pr__nfet_g5v0d10v5 ad=0.65 pd=3.3 as=0 ps=0 w=1 l=0.5
X2141 BLP7 rr2t2r_0[31|7]/a_60_290# sky130_fd_pr_reram__reram_cell area_ox=0.0676
X2142 BLN7 rr2t2r_0[31|7]/a_460_290# sky130_fd_pr_reram__reram_cell area_ox=0.0676
X2143 rr2t2r_0[31|7]/a_60_290# WL31 SL7 VSS sky130_fd_pr__nfet_g5v0d10v5 ad=0.65 pd=3.3 as=0 ps=0 w=1 l=0.5
X2144 rr2t2r_0[32|7]/a_460_290# WL32 SL7 VSS sky130_fd_pr__nfet_g5v0d10v5 ad=0.65 pd=3.3 as=0 ps=0 w=1 l=0.5
X2145 BLP7 rr2t2r_0[32|7]/a_60_290# sky130_fd_pr_reram__reram_cell area_ox=0.0676
X2146 BLN7 rr2t2r_0[32|7]/a_460_290# sky130_fd_pr_reram__reram_cell area_ox=0.0676
X2147 rr2t2r_0[32|7]/a_60_290# WL32 SL7 VSS sky130_fd_pr__nfet_g5v0d10v5 ad=0.65 pd=3.3 as=0 ps=0 w=1 l=0.5
X2148 rr2t2r_0[33|7]/a_460_290# WL33 SL7 VSS sky130_fd_pr__nfet_g5v0d10v5 ad=0.65 pd=3.3 as=0 ps=0 w=1 l=0.5
X2149 BLP7 rr2t2r_0[33|7]/a_60_290# sky130_fd_pr_reram__reram_cell area_ox=0.0676
X2150 BLN7 rr2t2r_0[33|7]/a_460_290# sky130_fd_pr_reram__reram_cell area_ox=0.0676
X2151 rr2t2r_0[33|7]/a_60_290# WL33 SL7 VSS sky130_fd_pr__nfet_g5v0d10v5 ad=0.65 pd=3.3 as=0 ps=0 w=1 l=0.5
X2152 rr2t2r_0[34|7]/a_460_290# WL34 SL7 VSS sky130_fd_pr__nfet_g5v0d10v5 ad=0.65 pd=3.3 as=0 ps=0 w=1 l=0.5
X2153 BLP7 rr2t2r_0[34|7]/a_60_290# sky130_fd_pr_reram__reram_cell area_ox=0.0676
X2154 BLN7 rr2t2r_0[34|7]/a_460_290# sky130_fd_pr_reram__reram_cell area_ox=0.0676
X2155 rr2t2r_0[34|7]/a_60_290# WL34 SL7 VSS sky130_fd_pr__nfet_g5v0d10v5 ad=0.65 pd=3.3 as=0 ps=0 w=1 l=0.5
X2156 rr2t2r_0[35|7]/a_460_290# WL35 SL7 VSS sky130_fd_pr__nfet_g5v0d10v5 ad=0.65 pd=3.3 as=0 ps=0 w=1 l=0.5
X2157 BLP7 rr2t2r_0[35|7]/a_60_290# sky130_fd_pr_reram__reram_cell area_ox=0.0676
X2158 BLN7 rr2t2r_0[35|7]/a_460_290# sky130_fd_pr_reram__reram_cell area_ox=0.0676
X2159 rr2t2r_0[35|7]/a_60_290# WL35 SL7 VSS sky130_fd_pr__nfet_g5v0d10v5 ad=0.65 pd=3.3 as=0 ps=0 w=1 l=0.5
X2160 rr2t2r_0[36|7]/a_460_290# WL36 SL7 VSS sky130_fd_pr__nfet_g5v0d10v5 ad=0.65 pd=3.3 as=0 ps=0 w=1 l=0.5
X2161 BLP7 rr2t2r_0[36|7]/a_60_290# sky130_fd_pr_reram__reram_cell area_ox=0.0676
X2162 BLN7 rr2t2r_0[36|7]/a_460_290# sky130_fd_pr_reram__reram_cell area_ox=0.0676
X2163 rr2t2r_0[36|7]/a_60_290# WL36 SL7 VSS sky130_fd_pr__nfet_g5v0d10v5 ad=0.65 pd=3.3 as=0 ps=0 w=1 l=0.5
X2164 rr2t2r_0[37|7]/a_460_290# WL37 SL7 VSS sky130_fd_pr__nfet_g5v0d10v5 ad=0.65 pd=3.3 as=0 ps=0 w=1 l=0.5
X2165 BLP7 rr2t2r_0[37|7]/a_60_290# sky130_fd_pr_reram__reram_cell area_ox=0.0676
X2166 BLN7 rr2t2r_0[37|7]/a_460_290# sky130_fd_pr_reram__reram_cell area_ox=0.0676
X2167 rr2t2r_0[37|7]/a_60_290# WL37 SL7 VSS sky130_fd_pr__nfet_g5v0d10v5 ad=0.65 pd=3.3 as=0 ps=0 w=1 l=0.5
X2168 rr2t2r_0[38|7]/a_460_290# WL38 SL7 VSS sky130_fd_pr__nfet_g5v0d10v5 ad=0.65 pd=3.3 as=0 ps=0 w=1 l=0.5
X2169 BLP7 rr2t2r_0[38|7]/a_60_290# sky130_fd_pr_reram__reram_cell area_ox=0.0676
X2170 BLN7 rr2t2r_0[38|7]/a_460_290# sky130_fd_pr_reram__reram_cell area_ox=0.0676
X2171 rr2t2r_0[38|7]/a_60_290# WL38 SL7 VSS sky130_fd_pr__nfet_g5v0d10v5 ad=0.65 pd=3.3 as=0 ps=0 w=1 l=0.5
X2172 rr2t2r_0[39|7]/a_460_290# WL39 SL7 VSS sky130_fd_pr__nfet_g5v0d10v5 ad=0.65 pd=3.3 as=0 ps=0 w=1 l=0.5
X2173 BLP7 rr2t2r_0[39|7]/a_60_290# sky130_fd_pr_reram__reram_cell area_ox=0.0676
X2174 BLN7 rr2t2r_0[39|7]/a_460_290# sky130_fd_pr_reram__reram_cell area_ox=0.0676
X2175 rr2t2r_0[39|7]/a_60_290# WL39 SL7 VSS sky130_fd_pr__nfet_g5v0d10v5 ad=0.65 pd=3.3 as=0 ps=0 w=1 l=0.5
X2176 rr2t2r_0[40|7]/a_460_290# WL40 SL7 VSS sky130_fd_pr__nfet_g5v0d10v5 ad=0.65 pd=3.3 as=0 ps=0 w=1 l=0.5
X2177 BLP7 rr2t2r_0[40|7]/a_60_290# sky130_fd_pr_reram__reram_cell area_ox=0.0676
X2178 BLN7 rr2t2r_0[40|7]/a_460_290# sky130_fd_pr_reram__reram_cell area_ox=0.0676
X2179 rr2t2r_0[40|7]/a_60_290# WL40 SL7 VSS sky130_fd_pr__nfet_g5v0d10v5 ad=0.65 pd=3.3 as=0 ps=0 w=1 l=0.5
X2180 rr2t2r_0[41|7]/a_460_290# WL41 SL7 VSS sky130_fd_pr__nfet_g5v0d10v5 ad=0.65 pd=3.3 as=0 ps=0 w=1 l=0.5
X2181 BLP7 rr2t2r_0[41|7]/a_60_290# sky130_fd_pr_reram__reram_cell area_ox=0.0676
X2182 BLN7 rr2t2r_0[41|7]/a_460_290# sky130_fd_pr_reram__reram_cell area_ox=0.0676
X2183 rr2t2r_0[41|7]/a_60_290# WL41 SL7 VSS sky130_fd_pr__nfet_g5v0d10v5 ad=0.65 pd=3.3 as=0 ps=0 w=1 l=0.5
X2184 rr2t2r_0[42|7]/a_460_290# WL42 SL7 VSS sky130_fd_pr__nfet_g5v0d10v5 ad=0.65 pd=3.3 as=0 ps=0 w=1 l=0.5
X2185 BLP7 rr2t2r_0[42|7]/a_60_290# sky130_fd_pr_reram__reram_cell area_ox=0.0676
X2186 BLN7 rr2t2r_0[42|7]/a_460_290# sky130_fd_pr_reram__reram_cell area_ox=0.0676
X2187 rr2t2r_0[42|7]/a_60_290# WL42 SL7 VSS sky130_fd_pr__nfet_g5v0d10v5 ad=0.65 pd=3.3 as=0 ps=0 w=1 l=0.5
X2188 rr2t2r_0[43|7]/a_460_290# WL43 SL7 VSS sky130_fd_pr__nfet_g5v0d10v5 ad=0.65 pd=3.3 as=0 ps=0 w=1 l=0.5
X2189 BLP7 rr2t2r_0[43|7]/a_60_290# sky130_fd_pr_reram__reram_cell area_ox=0.0676
X2190 BLN7 rr2t2r_0[43|7]/a_460_290# sky130_fd_pr_reram__reram_cell area_ox=0.0676
X2191 rr2t2r_0[43|7]/a_60_290# WL43 SL7 VSS sky130_fd_pr__nfet_g5v0d10v5 ad=0.65 pd=3.3 as=0 ps=0 w=1 l=0.5
X2192 rr2t2r_0[44|7]/a_460_290# WL44 SL7 VSS sky130_fd_pr__nfet_g5v0d10v5 ad=0.65 pd=3.3 as=0 ps=0 w=1 l=0.5
X2193 BLP7 rr2t2r_0[44|7]/a_60_290# sky130_fd_pr_reram__reram_cell area_ox=0.0676
X2194 BLN7 rr2t2r_0[44|7]/a_460_290# sky130_fd_pr_reram__reram_cell area_ox=0.0676
X2195 rr2t2r_0[44|7]/a_60_290# WL44 SL7 VSS sky130_fd_pr__nfet_g5v0d10v5 ad=0.65 pd=3.3 as=0 ps=0 w=1 l=0.5
X2196 rr2t2r_0[45|7]/a_460_290# WL45 SL7 VSS sky130_fd_pr__nfet_g5v0d10v5 ad=0.65 pd=3.3 as=0 ps=0 w=1 l=0.5
X2197 BLP7 rr2t2r_0[45|7]/a_60_290# sky130_fd_pr_reram__reram_cell area_ox=0.0676
X2198 BLN7 rr2t2r_0[45|7]/a_460_290# sky130_fd_pr_reram__reram_cell area_ox=0.0676
X2199 rr2t2r_0[45|7]/a_60_290# WL45 SL7 VSS sky130_fd_pr__nfet_g5v0d10v5 ad=0.65 pd=3.3 as=0 ps=0 w=1 l=0.5
X2200 rr2t2r_0[46|7]/a_460_290# WL46 SL7 VSS sky130_fd_pr__nfet_g5v0d10v5 ad=0.65 pd=3.3 as=0 ps=0 w=1 l=0.5
X2201 BLP7 rr2t2r_0[46|7]/a_60_290# sky130_fd_pr_reram__reram_cell area_ox=0.0676
X2202 BLN7 rr2t2r_0[46|7]/a_460_290# sky130_fd_pr_reram__reram_cell area_ox=0.0676
X2203 rr2t2r_0[46|7]/a_60_290# WL46 SL7 VSS sky130_fd_pr__nfet_g5v0d10v5 ad=0.65 pd=3.3 as=0 ps=0 w=1 l=0.5
X2204 rr2t2r_0[47|7]/a_460_290# WL47 SL7 VSS sky130_fd_pr__nfet_g5v0d10v5 ad=0.65 pd=3.3 as=0 ps=0 w=1 l=0.5
X2205 BLP7 rr2t2r_0[47|7]/a_60_290# sky130_fd_pr_reram__reram_cell area_ox=0.0676
X2206 BLN7 rr2t2r_0[47|7]/a_460_290# sky130_fd_pr_reram__reram_cell area_ox=0.0676
X2207 rr2t2r_0[47|7]/a_60_290# WL47 SL7 VSS sky130_fd_pr__nfet_g5v0d10v5 ad=0.65 pd=3.3 as=0 ps=0 w=1 l=0.5
X2208 rr2t2r_0[48|7]/a_460_290# WL48 SL7 VSS sky130_fd_pr__nfet_g5v0d10v5 ad=0.65 pd=3.3 as=0 ps=0 w=1 l=0.5
X2209 BLP7 rr2t2r_0[48|7]/a_60_290# sky130_fd_pr_reram__reram_cell area_ox=0.0676
X2210 BLN7 rr2t2r_0[48|7]/a_460_290# sky130_fd_pr_reram__reram_cell area_ox=0.0676
X2211 rr2t2r_0[48|7]/a_60_290# WL48 SL7 VSS sky130_fd_pr__nfet_g5v0d10v5 ad=0.65 pd=3.3 as=0 ps=0 w=1 l=0.5
X2212 rr2t2r_0[49|7]/a_460_290# WL49 SL7 VSS sky130_fd_pr__nfet_g5v0d10v5 ad=0.65 pd=3.3 as=0 ps=0 w=1 l=0.5
X2213 BLP7 rr2t2r_0[49|7]/a_60_290# sky130_fd_pr_reram__reram_cell area_ox=0.0676
X2214 BLN7 rr2t2r_0[49|7]/a_460_290# sky130_fd_pr_reram__reram_cell area_ox=0.0676
X2215 rr2t2r_0[49|7]/a_60_290# WL49 SL7 VSS sky130_fd_pr__nfet_g5v0d10v5 ad=0.65 pd=3.3 as=0 ps=0 w=1 l=0.5
X2216 rr2t2r_0[50|7]/a_460_290# WL50 SL7 VSS sky130_fd_pr__nfet_g5v0d10v5 ad=0.65 pd=3.3 as=0 ps=0 w=1 l=0.5
X2217 BLP7 rr2t2r_0[50|7]/a_60_290# sky130_fd_pr_reram__reram_cell area_ox=0.0676
X2218 BLN7 rr2t2r_0[50|7]/a_460_290# sky130_fd_pr_reram__reram_cell area_ox=0.0676
X2219 rr2t2r_0[50|7]/a_60_290# WL50 SL7 VSS sky130_fd_pr__nfet_g5v0d10v5 ad=0.65 pd=3.3 as=0 ps=0 w=1 l=0.5
X2220 rr2t2r_0[51|7]/a_460_290# WL51 SL7 VSS sky130_fd_pr__nfet_g5v0d10v5 ad=0.65 pd=3.3 as=0 ps=0 w=1 l=0.5
X2221 BLP7 rr2t2r_0[51|7]/a_60_290# sky130_fd_pr_reram__reram_cell area_ox=0.0676
X2222 BLN7 rr2t2r_0[51|7]/a_460_290# sky130_fd_pr_reram__reram_cell area_ox=0.0676
X2223 rr2t2r_0[51|7]/a_60_290# WL51 SL7 VSS sky130_fd_pr__nfet_g5v0d10v5 ad=0.65 pd=3.3 as=0 ps=0 w=1 l=0.5
X2224 rr2t2r_0[52|7]/a_460_290# WL52 SL7 VSS sky130_fd_pr__nfet_g5v0d10v5 ad=0.65 pd=3.3 as=0 ps=0 w=1 l=0.5
X2225 BLP7 rr2t2r_0[52|7]/a_60_290# sky130_fd_pr_reram__reram_cell area_ox=0.0676
X2226 BLN7 rr2t2r_0[52|7]/a_460_290# sky130_fd_pr_reram__reram_cell area_ox=0.0676
X2227 rr2t2r_0[52|7]/a_60_290# WL52 SL7 VSS sky130_fd_pr__nfet_g5v0d10v5 ad=0.65 pd=3.3 as=0 ps=0 w=1 l=0.5
X2228 rr2t2r_0[53|7]/a_460_290# WL53 SL7 VSS sky130_fd_pr__nfet_g5v0d10v5 ad=0.65 pd=3.3 as=0 ps=0 w=1 l=0.5
X2229 BLP7 rr2t2r_0[53|7]/a_60_290# sky130_fd_pr_reram__reram_cell area_ox=0.0676
X2230 BLN7 rr2t2r_0[53|7]/a_460_290# sky130_fd_pr_reram__reram_cell area_ox=0.0676
X2231 rr2t2r_0[53|7]/a_60_290# WL53 SL7 VSS sky130_fd_pr__nfet_g5v0d10v5 ad=0.65 pd=3.3 as=0 ps=0 w=1 l=0.5
X2232 rr2t2r_0[54|7]/a_460_290# WL54 SL7 VSS sky130_fd_pr__nfet_g5v0d10v5 ad=0.65 pd=3.3 as=0 ps=0 w=1 l=0.5
X2233 BLP7 rr2t2r_0[54|7]/a_60_290# sky130_fd_pr_reram__reram_cell area_ox=0.0676
X2234 BLN7 rr2t2r_0[54|7]/a_460_290# sky130_fd_pr_reram__reram_cell area_ox=0.0676
X2235 rr2t2r_0[54|7]/a_60_290# WL54 SL7 VSS sky130_fd_pr__nfet_g5v0d10v5 ad=0.65 pd=3.3 as=0 ps=0 w=1 l=0.5
X2236 rr2t2r_0[55|7]/a_460_290# WL55 SL7 VSS sky130_fd_pr__nfet_g5v0d10v5 ad=0.65 pd=3.3 as=0 ps=0 w=1 l=0.5
X2237 BLP7 rr2t2r_0[55|7]/a_60_290# sky130_fd_pr_reram__reram_cell area_ox=0.0676
X2238 BLN7 rr2t2r_0[55|7]/a_460_290# sky130_fd_pr_reram__reram_cell area_ox=0.0676
X2239 rr2t2r_0[55|7]/a_60_290# WL55 SL7 VSS sky130_fd_pr__nfet_g5v0d10v5 ad=0.65 pd=3.3 as=0 ps=0 w=1 l=0.5
X2240 rr2t2r_0[56|7]/a_460_290# WL56 SL7 VSS sky130_fd_pr__nfet_g5v0d10v5 ad=0.65 pd=3.3 as=0 ps=0 w=1 l=0.5
X2241 BLP7 rr2t2r_0[56|7]/a_60_290# sky130_fd_pr_reram__reram_cell area_ox=0.0676
X2242 BLN7 rr2t2r_0[56|7]/a_460_290# sky130_fd_pr_reram__reram_cell area_ox=0.0676
X2243 rr2t2r_0[56|7]/a_60_290# WL56 SL7 VSS sky130_fd_pr__nfet_g5v0d10v5 ad=0.65 pd=3.3 as=0 ps=0 w=1 l=0.5
X2244 rr2t2r_0[57|7]/a_460_290# WL57 SL7 VSS sky130_fd_pr__nfet_g5v0d10v5 ad=0.65 pd=3.3 as=0 ps=0 w=1 l=0.5
X2245 BLP7 rr2t2r_0[57|7]/a_60_290# sky130_fd_pr_reram__reram_cell area_ox=0.0676
X2246 BLN7 rr2t2r_0[57|7]/a_460_290# sky130_fd_pr_reram__reram_cell area_ox=0.0676
X2247 rr2t2r_0[57|7]/a_60_290# WL57 SL7 VSS sky130_fd_pr__nfet_g5v0d10v5 ad=0.65 pd=3.3 as=0 ps=0 w=1 l=0.5
X2248 rr2t2r_0[58|7]/a_460_290# WL58 SL7 VSS sky130_fd_pr__nfet_g5v0d10v5 ad=0.65 pd=3.3 as=0 ps=0 w=1 l=0.5
X2249 BLP7 rr2t2r_0[58|7]/a_60_290# sky130_fd_pr_reram__reram_cell area_ox=0.0676
X2250 BLN7 rr2t2r_0[58|7]/a_460_290# sky130_fd_pr_reram__reram_cell area_ox=0.0676
X2251 rr2t2r_0[58|7]/a_60_290# WL58 SL7 VSS sky130_fd_pr__nfet_g5v0d10v5 ad=0.65 pd=3.3 as=0 ps=0 w=1 l=0.5
X2252 rr2t2r_0[59|7]/a_460_290# WL59 SL7 VSS sky130_fd_pr__nfet_g5v0d10v5 ad=0.65 pd=3.3 as=0 ps=0 w=1 l=0.5
X2253 BLP7 rr2t2r_0[59|7]/a_60_290# sky130_fd_pr_reram__reram_cell area_ox=0.0676
X2254 BLN7 rr2t2r_0[59|7]/a_460_290# sky130_fd_pr_reram__reram_cell area_ox=0.0676
X2255 rr2t2r_0[59|7]/a_60_290# WL59 SL7 VSS sky130_fd_pr__nfet_g5v0d10v5 ad=0.65 pd=3.3 as=0 ps=0 w=1 l=0.5
X2256 rr2t2r_0[60|7]/a_460_290# WL60 SL7 VSS sky130_fd_pr__nfet_g5v0d10v5 ad=0.65 pd=3.3 as=0 ps=0 w=1 l=0.5
X2257 BLP7 rr2t2r_0[60|7]/a_60_290# sky130_fd_pr_reram__reram_cell area_ox=0.0676
X2258 BLN7 rr2t2r_0[60|7]/a_460_290# sky130_fd_pr_reram__reram_cell area_ox=0.0676
X2259 rr2t2r_0[60|7]/a_60_290# WL60 SL7 VSS sky130_fd_pr__nfet_g5v0d10v5 ad=0.65 pd=3.3 as=0 ps=0 w=1 l=0.5
X2260 rr2t2r_0[61|7]/a_460_290# WL61 SL7 VSS sky130_fd_pr__nfet_g5v0d10v5 ad=0.65 pd=3.3 as=0 ps=0 w=1 l=0.5
X2261 BLP7 rr2t2r_0[61|7]/a_60_290# sky130_fd_pr_reram__reram_cell area_ox=0.0676
X2262 BLN7 rr2t2r_0[61|7]/a_460_290# sky130_fd_pr_reram__reram_cell area_ox=0.0676
X2263 rr2t2r_0[61|7]/a_60_290# WL61 SL7 VSS sky130_fd_pr__nfet_g5v0d10v5 ad=0.65 pd=3.3 as=0 ps=0 w=1 l=0.5
X2264 rr2t2r_0[62|7]/a_460_290# WL62 SL7 VSS sky130_fd_pr__nfet_g5v0d10v5 ad=0.65 pd=3.3 as=0 ps=0 w=1 l=0.5
X2265 BLP7 rr2t2r_0[62|7]/a_60_290# sky130_fd_pr_reram__reram_cell area_ox=0.0676
X2266 BLN7 rr2t2r_0[62|7]/a_460_290# sky130_fd_pr_reram__reram_cell area_ox=0.0676
X2267 rr2t2r_0[62|7]/a_60_290# WL62 SL7 VSS sky130_fd_pr__nfet_g5v0d10v5 ad=0.65 pd=3.3 as=0 ps=0 w=1 l=0.5
X2268 rr2t2r_0[63|7]/a_460_290# WL63 SL7 VSS sky130_fd_pr__nfet_g5v0d10v5 ad=0.65 pd=3.3 as=0 ps=0 w=1 l=0.5
X2269 BLP7 rr2t2r_0[63|7]/a_60_290# sky130_fd_pr_reram__reram_cell area_ox=0.0676
X2270 BLN7 rr2t2r_0[63|7]/a_460_290# sky130_fd_pr_reram__reram_cell area_ox=0.0676
X2271 rr2t2r_0[63|7]/a_60_290# WL63 SL7 VSS sky130_fd_pr__nfet_g5v0d10v5 ad=0.65 pd=3.3 as=0 ps=0 w=1 l=0.5
X2272 rr2t2r_0[64|7]/a_460_290# WL64 SL7 VSS sky130_fd_pr__nfet_g5v0d10v5 ad=0.65 pd=3.3 as=0 ps=0 w=1 l=0.5
X2273 BLP7 rr2t2r_0[64|7]/a_60_290# sky130_fd_pr_reram__reram_cell area_ox=0.0676
X2274 BLN7 rr2t2r_0[64|7]/a_460_290# sky130_fd_pr_reram__reram_cell area_ox=0.0676
X2275 rr2t2r_0[64|7]/a_60_290# WL64 SL7 VSS sky130_fd_pr__nfet_g5v0d10v5 ad=0.65 pd=3.3 as=0 ps=0 w=1 l=0.5
X2276 rr2t2r_0[65|7]/a_460_290# WL65 SL7 VSS sky130_fd_pr__nfet_g5v0d10v5 ad=0.65 pd=3.3 as=0 ps=0 w=1 l=0.5
X2277 BLP7 rr2t2r_0[65|7]/a_60_290# sky130_fd_pr_reram__reram_cell area_ox=0.0676
X2278 BLN7 rr2t2r_0[65|7]/a_460_290# sky130_fd_pr_reram__reram_cell area_ox=0.0676
X2279 rr2t2r_0[65|7]/a_60_290# WL65 SL7 VSS sky130_fd_pr__nfet_g5v0d10v5 ad=0.65 pd=3.3 as=0 ps=0 w=1 l=0.5
X2280 rr2t2r_0[66|7]/a_460_290# WL66 SL7 VSS sky130_fd_pr__nfet_g5v0d10v5 ad=0.65 pd=3.3 as=0 ps=0 w=1 l=0.5
X2281 BLP7 rr2t2r_0[66|7]/a_60_290# sky130_fd_pr_reram__reram_cell area_ox=0.0676
X2282 BLN7 rr2t2r_0[66|7]/a_460_290# sky130_fd_pr_reram__reram_cell area_ox=0.0676
X2283 rr2t2r_0[66|7]/a_60_290# WL66 SL7 VSS sky130_fd_pr__nfet_g5v0d10v5 ad=0.65 pd=3.3 as=0 ps=0 w=1 l=0.5
X2284 rr2t2r_0[67|7]/a_460_290# WL67 SL7 VSS sky130_fd_pr__nfet_g5v0d10v5 ad=0.65 pd=3.3 as=0 ps=0 w=1 l=0.5
X2285 BLP7 rr2t2r_0[67|7]/a_60_290# sky130_fd_pr_reram__reram_cell area_ox=0.0676
X2286 BLN7 rr2t2r_0[67|7]/a_460_290# sky130_fd_pr_reram__reram_cell area_ox=0.0676
X2287 rr2t2r_0[67|7]/a_60_290# WL67 SL7 VSS sky130_fd_pr__nfet_g5v0d10v5 ad=0.65 pd=3.3 as=0 ps=0 w=1 l=0.5
X2288 rr2t2r_0[68|7]/a_460_290# WL68 SL7 VSS sky130_fd_pr__nfet_g5v0d10v5 ad=0.65 pd=3.3 as=0 ps=0 w=1 l=0.5
X2289 BLP7 rr2t2r_0[68|7]/a_60_290# sky130_fd_pr_reram__reram_cell area_ox=0.0676
X2290 BLN7 rr2t2r_0[68|7]/a_460_290# sky130_fd_pr_reram__reram_cell area_ox=0.0676
X2291 rr2t2r_0[68|7]/a_60_290# WL68 SL7 VSS sky130_fd_pr__nfet_g5v0d10v5 ad=0.65 pd=3.3 as=0 ps=0 w=1 l=0.5
X2292 rr2t2r_0[69|7]/a_460_290# WL69 SL7 VSS sky130_fd_pr__nfet_g5v0d10v5 ad=0.65 pd=3.3 as=0 ps=0 w=1 l=0.5
X2293 BLP7 rr2t2r_0[69|7]/a_60_290# sky130_fd_pr_reram__reram_cell area_ox=0.0676
X2294 BLN7 rr2t2r_0[69|7]/a_460_290# sky130_fd_pr_reram__reram_cell area_ox=0.0676
X2295 rr2t2r_0[69|7]/a_60_290# WL69 SL7 VSS sky130_fd_pr__nfet_g5v0d10v5 ad=0.65 pd=3.3 as=0 ps=0 w=1 l=0.5
X2296 rr2t2r_0[70|7]/a_460_290# WL70 SL7 VSS sky130_fd_pr__nfet_g5v0d10v5 ad=0.65 pd=3.3 as=0 ps=0 w=1 l=0.5
X2297 BLP7 rr2t2r_0[70|7]/a_60_290# sky130_fd_pr_reram__reram_cell area_ox=0.0676
X2298 BLN7 rr2t2r_0[70|7]/a_460_290# sky130_fd_pr_reram__reram_cell area_ox=0.0676
X2299 rr2t2r_0[70|7]/a_60_290# WL70 SL7 VSS sky130_fd_pr__nfet_g5v0d10v5 ad=0.65 pd=3.3 as=0 ps=0 w=1 l=0.5
X2300 rr2t2r_0[71|7]/a_460_290# WL71 SL7 VSS sky130_fd_pr__nfet_g5v0d10v5 ad=0.65 pd=3.3 as=0 ps=0 w=1 l=0.5
X2301 BLP7 rr2t2r_0[71|7]/a_60_290# sky130_fd_pr_reram__reram_cell area_ox=0.0676
X2302 BLN7 rr2t2r_0[71|7]/a_460_290# sky130_fd_pr_reram__reram_cell area_ox=0.0676
X2303 rr2t2r_0[71|7]/a_60_290# WL71 SL7 VSS sky130_fd_pr__nfet_g5v0d10v5 ad=0.65 pd=3.3 as=0 ps=0 w=1 l=0.5
X2304 rr2t2r_0[0|8]/a_460_290# WL0 SL8 VSS sky130_fd_pr__nfet_g5v0d10v5 ad=0.65 pd=3.3 as=108 ps=504 w=1 l=0.5
X2305 BLP8 rr2t2r_0[0|8]/a_60_290# sky130_fd_pr_reram__reram_cell area_ox=0.0676
X2306 BLN8 rr2t2r_0[0|8]/a_460_290# sky130_fd_pr_reram__reram_cell area_ox=0.0676
X2307 rr2t2r_0[0|8]/a_60_290# WL0 SL8 VSS sky130_fd_pr__nfet_g5v0d10v5 ad=0.65 pd=3.3 as=0 ps=0 w=1 l=0.5
X2308 rr2t2r_0[1|8]/a_460_290# WL1 SL8 VSS sky130_fd_pr__nfet_g5v0d10v5 ad=0.65 pd=3.3 as=0 ps=0 w=1 l=0.5
X2309 BLP8 rr2t2r_0[1|8]/a_60_290# sky130_fd_pr_reram__reram_cell area_ox=0.0676
X2310 BLN8 rr2t2r_0[1|8]/a_460_290# sky130_fd_pr_reram__reram_cell area_ox=0.0676
X2311 rr2t2r_0[1|8]/a_60_290# WL1 SL8 VSS sky130_fd_pr__nfet_g5v0d10v5 ad=0.65 pd=3.3 as=0 ps=0 w=1 l=0.5
X2312 rr2t2r_0[2|8]/a_460_290# WL2 SL8 VSS sky130_fd_pr__nfet_g5v0d10v5 ad=0.65 pd=3.3 as=0 ps=0 w=1 l=0.5
X2313 BLP8 rr2t2r_0[2|8]/a_60_290# sky130_fd_pr_reram__reram_cell area_ox=0.0676
X2314 BLN8 rr2t2r_0[2|8]/a_460_290# sky130_fd_pr_reram__reram_cell area_ox=0.0676
X2315 rr2t2r_0[2|8]/a_60_290# WL2 SL8 VSS sky130_fd_pr__nfet_g5v0d10v5 ad=0.65 pd=3.3 as=0 ps=0 w=1 l=0.5
X2316 rr2t2r_0[3|8]/a_460_290# WL3 SL8 VSS sky130_fd_pr__nfet_g5v0d10v5 ad=0.65 pd=3.3 as=0 ps=0 w=1 l=0.5
X2317 BLP8 rr2t2r_0[3|8]/a_60_290# sky130_fd_pr_reram__reram_cell area_ox=0.0676
X2318 BLN8 rr2t2r_0[3|8]/a_460_290# sky130_fd_pr_reram__reram_cell area_ox=0.0676
X2319 rr2t2r_0[3|8]/a_60_290# WL3 SL8 VSS sky130_fd_pr__nfet_g5v0d10v5 ad=0.65 pd=3.3 as=0 ps=0 w=1 l=0.5
X2320 rr2t2r_0[4|8]/a_460_290# WL4 SL8 VSS sky130_fd_pr__nfet_g5v0d10v5 ad=0.65 pd=3.3 as=0 ps=0 w=1 l=0.5
X2321 BLP8 rr2t2r_0[4|8]/a_60_290# sky130_fd_pr_reram__reram_cell area_ox=0.0676
X2322 BLN8 rr2t2r_0[4|8]/a_460_290# sky130_fd_pr_reram__reram_cell area_ox=0.0676
X2323 rr2t2r_0[4|8]/a_60_290# WL4 SL8 VSS sky130_fd_pr__nfet_g5v0d10v5 ad=0.65 pd=3.3 as=0 ps=0 w=1 l=0.5
X2324 rr2t2r_0[5|8]/a_460_290# WL5 SL8 VSS sky130_fd_pr__nfet_g5v0d10v5 ad=0.65 pd=3.3 as=0 ps=0 w=1 l=0.5
X2325 BLP8 rr2t2r_0[5|8]/a_60_290# sky130_fd_pr_reram__reram_cell area_ox=0.0676
X2326 BLN8 rr2t2r_0[5|8]/a_460_290# sky130_fd_pr_reram__reram_cell area_ox=0.0676
X2327 rr2t2r_0[5|8]/a_60_290# WL5 SL8 VSS sky130_fd_pr__nfet_g5v0d10v5 ad=0.65 pd=3.3 as=0 ps=0 w=1 l=0.5
X2328 rr2t2r_0[6|8]/a_460_290# WL6 SL8 VSS sky130_fd_pr__nfet_g5v0d10v5 ad=0.65 pd=3.3 as=0 ps=0 w=1 l=0.5
X2329 BLP8 rr2t2r_0[6|8]/a_60_290# sky130_fd_pr_reram__reram_cell area_ox=0.0676
X2330 BLN8 rr2t2r_0[6|8]/a_460_290# sky130_fd_pr_reram__reram_cell area_ox=0.0676
X2331 rr2t2r_0[6|8]/a_60_290# WL6 SL8 VSS sky130_fd_pr__nfet_g5v0d10v5 ad=0.65 pd=3.3 as=0 ps=0 w=1 l=0.5
X2332 rr2t2r_0[7|8]/a_460_290# WL7 SL8 VSS sky130_fd_pr__nfet_g5v0d10v5 ad=0.65 pd=3.3 as=0 ps=0 w=1 l=0.5
X2333 BLP8 rr2t2r_0[7|8]/a_60_290# sky130_fd_pr_reram__reram_cell area_ox=0.0676
X2334 BLN8 rr2t2r_0[7|8]/a_460_290# sky130_fd_pr_reram__reram_cell area_ox=0.0676
X2335 rr2t2r_0[7|8]/a_60_290# WL7 SL8 VSS sky130_fd_pr__nfet_g5v0d10v5 ad=0.65 pd=3.3 as=0 ps=0 w=1 l=0.5
X2336 rr2t2r_0[8|8]/a_460_290# WL8 SL8 VSS sky130_fd_pr__nfet_g5v0d10v5 ad=0.65 pd=3.3 as=0 ps=0 w=1 l=0.5
X2337 BLP8 rr2t2r_0[8|8]/a_60_290# sky130_fd_pr_reram__reram_cell area_ox=0.0676
X2338 BLN8 rr2t2r_0[8|8]/a_460_290# sky130_fd_pr_reram__reram_cell area_ox=0.0676
X2339 rr2t2r_0[8|8]/a_60_290# WL8 SL8 VSS sky130_fd_pr__nfet_g5v0d10v5 ad=0.65 pd=3.3 as=0 ps=0 w=1 l=0.5
X2340 rr2t2r_0[9|8]/a_460_290# WL9 SL8 VSS sky130_fd_pr__nfet_g5v0d10v5 ad=0.65 pd=3.3 as=0 ps=0 w=1 l=0.5
X2341 BLP8 rr2t2r_0[9|8]/a_60_290# sky130_fd_pr_reram__reram_cell area_ox=0.0676
X2342 BLN8 rr2t2r_0[9|8]/a_460_290# sky130_fd_pr_reram__reram_cell area_ox=0.0676
X2343 rr2t2r_0[9|8]/a_60_290# WL9 SL8 VSS sky130_fd_pr__nfet_g5v0d10v5 ad=0.65 pd=3.3 as=0 ps=0 w=1 l=0.5
X2344 rr2t2r_0[10|8]/a_460_290# WL10 SL8 VSS sky130_fd_pr__nfet_g5v0d10v5 ad=0.65 pd=3.3 as=0 ps=0 w=1 l=0.5
X2345 BLP8 rr2t2r_0[10|8]/a_60_290# sky130_fd_pr_reram__reram_cell area_ox=0.0676
X2346 BLN8 rr2t2r_0[10|8]/a_460_290# sky130_fd_pr_reram__reram_cell area_ox=0.0676
X2347 rr2t2r_0[10|8]/a_60_290# WL10 SL8 VSS sky130_fd_pr__nfet_g5v0d10v5 ad=0.65 pd=3.3 as=0 ps=0 w=1 l=0.5
X2348 rr2t2r_0[11|8]/a_460_290# WL11 SL8 VSS sky130_fd_pr__nfet_g5v0d10v5 ad=0.65 pd=3.3 as=0 ps=0 w=1 l=0.5
X2349 BLP8 rr2t2r_0[11|8]/a_60_290# sky130_fd_pr_reram__reram_cell area_ox=0.0676
X2350 BLN8 rr2t2r_0[11|8]/a_460_290# sky130_fd_pr_reram__reram_cell area_ox=0.0676
X2351 rr2t2r_0[11|8]/a_60_290# WL11 SL8 VSS sky130_fd_pr__nfet_g5v0d10v5 ad=0.65 pd=3.3 as=0 ps=0 w=1 l=0.5
X2352 rr2t2r_0[12|8]/a_460_290# WL12 SL8 VSS sky130_fd_pr__nfet_g5v0d10v5 ad=0.65 pd=3.3 as=0 ps=0 w=1 l=0.5
X2353 BLP8 rr2t2r_0[12|8]/a_60_290# sky130_fd_pr_reram__reram_cell area_ox=0.0676
X2354 BLN8 rr2t2r_0[12|8]/a_460_290# sky130_fd_pr_reram__reram_cell area_ox=0.0676
X2355 rr2t2r_0[12|8]/a_60_290# WL12 SL8 VSS sky130_fd_pr__nfet_g5v0d10v5 ad=0.65 pd=3.3 as=0 ps=0 w=1 l=0.5
X2356 rr2t2r_0[13|8]/a_460_290# WL13 SL8 VSS sky130_fd_pr__nfet_g5v0d10v5 ad=0.65 pd=3.3 as=0 ps=0 w=1 l=0.5
X2357 BLP8 rr2t2r_0[13|8]/a_60_290# sky130_fd_pr_reram__reram_cell area_ox=0.0676
X2358 BLN8 rr2t2r_0[13|8]/a_460_290# sky130_fd_pr_reram__reram_cell area_ox=0.0676
X2359 rr2t2r_0[13|8]/a_60_290# WL13 SL8 VSS sky130_fd_pr__nfet_g5v0d10v5 ad=0.65 pd=3.3 as=0 ps=0 w=1 l=0.5
X2360 rr2t2r_0[14|8]/a_460_290# WL14 SL8 VSS sky130_fd_pr__nfet_g5v0d10v5 ad=0.65 pd=3.3 as=0 ps=0 w=1 l=0.5
X2361 BLP8 rr2t2r_0[14|8]/a_60_290# sky130_fd_pr_reram__reram_cell area_ox=0.0676
X2362 BLN8 rr2t2r_0[14|8]/a_460_290# sky130_fd_pr_reram__reram_cell area_ox=0.0676
X2363 rr2t2r_0[14|8]/a_60_290# WL14 SL8 VSS sky130_fd_pr__nfet_g5v0d10v5 ad=0.65 pd=3.3 as=0 ps=0 w=1 l=0.5
X2364 rr2t2r_0[15|8]/a_460_290# WL15 SL8 VSS sky130_fd_pr__nfet_g5v0d10v5 ad=0.65 pd=3.3 as=0 ps=0 w=1 l=0.5
X2365 BLP8 rr2t2r_0[15|8]/a_60_290# sky130_fd_pr_reram__reram_cell area_ox=0.0676
X2366 BLN8 rr2t2r_0[15|8]/a_460_290# sky130_fd_pr_reram__reram_cell area_ox=0.0676
X2367 rr2t2r_0[15|8]/a_60_290# WL15 SL8 VSS sky130_fd_pr__nfet_g5v0d10v5 ad=0.65 pd=3.3 as=0 ps=0 w=1 l=0.5
X2368 rr2t2r_0[16|8]/a_460_290# WL16 SL8 VSS sky130_fd_pr__nfet_g5v0d10v5 ad=0.65 pd=3.3 as=0 ps=0 w=1 l=0.5
X2369 BLP8 rr2t2r_0[16|8]/a_60_290# sky130_fd_pr_reram__reram_cell area_ox=0.0676
X2370 BLN8 rr2t2r_0[16|8]/a_460_290# sky130_fd_pr_reram__reram_cell area_ox=0.0676
X2371 rr2t2r_0[16|8]/a_60_290# WL16 SL8 VSS sky130_fd_pr__nfet_g5v0d10v5 ad=0.65 pd=3.3 as=0 ps=0 w=1 l=0.5
X2372 rr2t2r_0[17|8]/a_460_290# WL17 SL8 VSS sky130_fd_pr__nfet_g5v0d10v5 ad=0.65 pd=3.3 as=0 ps=0 w=1 l=0.5
X2373 BLP8 rr2t2r_0[17|8]/a_60_290# sky130_fd_pr_reram__reram_cell area_ox=0.0676
X2374 BLN8 rr2t2r_0[17|8]/a_460_290# sky130_fd_pr_reram__reram_cell area_ox=0.0676
X2375 rr2t2r_0[17|8]/a_60_290# WL17 SL8 VSS sky130_fd_pr__nfet_g5v0d10v5 ad=0.65 pd=3.3 as=0 ps=0 w=1 l=0.5
X2376 rr2t2r_0[18|8]/a_460_290# WL18 SL8 VSS sky130_fd_pr__nfet_g5v0d10v5 ad=0.65 pd=3.3 as=0 ps=0 w=1 l=0.5
X2377 BLP8 rr2t2r_0[18|8]/a_60_290# sky130_fd_pr_reram__reram_cell area_ox=0.0676
X2378 BLN8 rr2t2r_0[18|8]/a_460_290# sky130_fd_pr_reram__reram_cell area_ox=0.0676
X2379 rr2t2r_0[18|8]/a_60_290# WL18 SL8 VSS sky130_fd_pr__nfet_g5v0d10v5 ad=0.65 pd=3.3 as=0 ps=0 w=1 l=0.5
X2380 rr2t2r_0[19|8]/a_460_290# WL19 SL8 VSS sky130_fd_pr__nfet_g5v0d10v5 ad=0.65 pd=3.3 as=0 ps=0 w=1 l=0.5
X2381 BLP8 rr2t2r_0[19|8]/a_60_290# sky130_fd_pr_reram__reram_cell area_ox=0.0676
X2382 BLN8 rr2t2r_0[19|8]/a_460_290# sky130_fd_pr_reram__reram_cell area_ox=0.0676
X2383 rr2t2r_0[19|8]/a_60_290# WL19 SL8 VSS sky130_fd_pr__nfet_g5v0d10v5 ad=0.65 pd=3.3 as=0 ps=0 w=1 l=0.5
X2384 rr2t2r_0[20|8]/a_460_290# WL20 SL8 VSS sky130_fd_pr__nfet_g5v0d10v5 ad=0.65 pd=3.3 as=0 ps=0 w=1 l=0.5
X2385 BLP8 rr2t2r_0[20|8]/a_60_290# sky130_fd_pr_reram__reram_cell area_ox=0.0676
X2386 BLN8 rr2t2r_0[20|8]/a_460_290# sky130_fd_pr_reram__reram_cell area_ox=0.0676
X2387 rr2t2r_0[20|8]/a_60_290# WL20 SL8 VSS sky130_fd_pr__nfet_g5v0d10v5 ad=0.65 pd=3.3 as=0 ps=0 w=1 l=0.5
X2388 rr2t2r_0[21|8]/a_460_290# WL21 SL8 VSS sky130_fd_pr__nfet_g5v0d10v5 ad=0.65 pd=3.3 as=0 ps=0 w=1 l=0.5
X2389 BLP8 rr2t2r_0[21|8]/a_60_290# sky130_fd_pr_reram__reram_cell area_ox=0.0676
X2390 BLN8 rr2t2r_0[21|8]/a_460_290# sky130_fd_pr_reram__reram_cell area_ox=0.0676
X2391 rr2t2r_0[21|8]/a_60_290# WL21 SL8 VSS sky130_fd_pr__nfet_g5v0d10v5 ad=0.65 pd=3.3 as=0 ps=0 w=1 l=0.5
X2392 rr2t2r_0[22|8]/a_460_290# WL22 SL8 VSS sky130_fd_pr__nfet_g5v0d10v5 ad=0.65 pd=3.3 as=0 ps=0 w=1 l=0.5
X2393 BLP8 rr2t2r_0[22|8]/a_60_290# sky130_fd_pr_reram__reram_cell area_ox=0.0676
X2394 BLN8 rr2t2r_0[22|8]/a_460_290# sky130_fd_pr_reram__reram_cell area_ox=0.0676
X2395 rr2t2r_0[22|8]/a_60_290# WL22 SL8 VSS sky130_fd_pr__nfet_g5v0d10v5 ad=0.65 pd=3.3 as=0 ps=0 w=1 l=0.5
X2396 rr2t2r_0[23|8]/a_460_290# WL23 SL8 VSS sky130_fd_pr__nfet_g5v0d10v5 ad=0.65 pd=3.3 as=0 ps=0 w=1 l=0.5
X2397 BLP8 rr2t2r_0[23|8]/a_60_290# sky130_fd_pr_reram__reram_cell area_ox=0.0676
X2398 BLN8 rr2t2r_0[23|8]/a_460_290# sky130_fd_pr_reram__reram_cell area_ox=0.0676
X2399 rr2t2r_0[23|8]/a_60_290# WL23 SL8 VSS sky130_fd_pr__nfet_g5v0d10v5 ad=0.65 pd=3.3 as=0 ps=0 w=1 l=0.5
X2400 rr2t2r_0[24|8]/a_460_290# WL24 SL8 VSS sky130_fd_pr__nfet_g5v0d10v5 ad=0.65 pd=3.3 as=0 ps=0 w=1 l=0.5
X2401 BLP8 rr2t2r_0[24|8]/a_60_290# sky130_fd_pr_reram__reram_cell area_ox=0.0676
X2402 BLN8 rr2t2r_0[24|8]/a_460_290# sky130_fd_pr_reram__reram_cell area_ox=0.0676
X2403 rr2t2r_0[24|8]/a_60_290# WL24 SL8 VSS sky130_fd_pr__nfet_g5v0d10v5 ad=0.65 pd=3.3 as=0 ps=0 w=1 l=0.5
X2404 rr2t2r_0[25|8]/a_460_290# WL25 SL8 VSS sky130_fd_pr__nfet_g5v0d10v5 ad=0.65 pd=3.3 as=0 ps=0 w=1 l=0.5
X2405 BLP8 rr2t2r_0[25|8]/a_60_290# sky130_fd_pr_reram__reram_cell area_ox=0.0676
X2406 BLN8 rr2t2r_0[25|8]/a_460_290# sky130_fd_pr_reram__reram_cell area_ox=0.0676
X2407 rr2t2r_0[25|8]/a_60_290# WL25 SL8 VSS sky130_fd_pr__nfet_g5v0d10v5 ad=0.65 pd=3.3 as=0 ps=0 w=1 l=0.5
X2408 rr2t2r_0[26|8]/a_460_290# WL26 SL8 VSS sky130_fd_pr__nfet_g5v0d10v5 ad=0.65 pd=3.3 as=0 ps=0 w=1 l=0.5
X2409 BLP8 rr2t2r_0[26|8]/a_60_290# sky130_fd_pr_reram__reram_cell area_ox=0.0676
X2410 BLN8 rr2t2r_0[26|8]/a_460_290# sky130_fd_pr_reram__reram_cell area_ox=0.0676
X2411 rr2t2r_0[26|8]/a_60_290# WL26 SL8 VSS sky130_fd_pr__nfet_g5v0d10v5 ad=0.65 pd=3.3 as=0 ps=0 w=1 l=0.5
X2412 rr2t2r_0[27|8]/a_460_290# WL27 SL8 VSS sky130_fd_pr__nfet_g5v0d10v5 ad=0.65 pd=3.3 as=0 ps=0 w=1 l=0.5
X2413 BLP8 rr2t2r_0[27|8]/a_60_290# sky130_fd_pr_reram__reram_cell area_ox=0.0676
X2414 BLN8 rr2t2r_0[27|8]/a_460_290# sky130_fd_pr_reram__reram_cell area_ox=0.0676
X2415 rr2t2r_0[27|8]/a_60_290# WL27 SL8 VSS sky130_fd_pr__nfet_g5v0d10v5 ad=0.65 pd=3.3 as=0 ps=0 w=1 l=0.5
X2416 rr2t2r_0[28|8]/a_460_290# WL28 SL8 VSS sky130_fd_pr__nfet_g5v0d10v5 ad=0.65 pd=3.3 as=0 ps=0 w=1 l=0.5
X2417 BLP8 rr2t2r_0[28|8]/a_60_290# sky130_fd_pr_reram__reram_cell area_ox=0.0676
X2418 BLN8 rr2t2r_0[28|8]/a_460_290# sky130_fd_pr_reram__reram_cell area_ox=0.0676
X2419 rr2t2r_0[28|8]/a_60_290# WL28 SL8 VSS sky130_fd_pr__nfet_g5v0d10v5 ad=0.65 pd=3.3 as=0 ps=0 w=1 l=0.5
X2420 rr2t2r_0[29|8]/a_460_290# WL29 SL8 VSS sky130_fd_pr__nfet_g5v0d10v5 ad=0.65 pd=3.3 as=0 ps=0 w=1 l=0.5
X2421 BLP8 rr2t2r_0[29|8]/a_60_290# sky130_fd_pr_reram__reram_cell area_ox=0.0676
X2422 BLN8 rr2t2r_0[29|8]/a_460_290# sky130_fd_pr_reram__reram_cell area_ox=0.0676
X2423 rr2t2r_0[29|8]/a_60_290# WL29 SL8 VSS sky130_fd_pr__nfet_g5v0d10v5 ad=0.65 pd=3.3 as=0 ps=0 w=1 l=0.5
X2424 rr2t2r_0[30|8]/a_460_290# WL30 SL8 VSS sky130_fd_pr__nfet_g5v0d10v5 ad=0.65 pd=3.3 as=0 ps=0 w=1 l=0.5
X2425 BLP8 rr2t2r_0[30|8]/a_60_290# sky130_fd_pr_reram__reram_cell area_ox=0.0676
X2426 BLN8 rr2t2r_0[30|8]/a_460_290# sky130_fd_pr_reram__reram_cell area_ox=0.0676
X2427 rr2t2r_0[30|8]/a_60_290# WL30 SL8 VSS sky130_fd_pr__nfet_g5v0d10v5 ad=0.65 pd=3.3 as=0 ps=0 w=1 l=0.5
X2428 rr2t2r_0[31|8]/a_460_290# WL31 SL8 VSS sky130_fd_pr__nfet_g5v0d10v5 ad=0.65 pd=3.3 as=0 ps=0 w=1 l=0.5
X2429 BLP8 rr2t2r_0[31|8]/a_60_290# sky130_fd_pr_reram__reram_cell area_ox=0.0676
X2430 BLN8 rr2t2r_0[31|8]/a_460_290# sky130_fd_pr_reram__reram_cell area_ox=0.0676
X2431 rr2t2r_0[31|8]/a_60_290# WL31 SL8 VSS sky130_fd_pr__nfet_g5v0d10v5 ad=0.65 pd=3.3 as=0 ps=0 w=1 l=0.5
X2432 rr2t2r_0[32|8]/a_460_290# WL32 SL8 VSS sky130_fd_pr__nfet_g5v0d10v5 ad=0.65 pd=3.3 as=0 ps=0 w=1 l=0.5
X2433 BLP8 rr2t2r_0[32|8]/a_60_290# sky130_fd_pr_reram__reram_cell area_ox=0.0676
X2434 BLN8 rr2t2r_0[32|8]/a_460_290# sky130_fd_pr_reram__reram_cell area_ox=0.0676
X2435 rr2t2r_0[32|8]/a_60_290# WL32 SL8 VSS sky130_fd_pr__nfet_g5v0d10v5 ad=0.65 pd=3.3 as=0 ps=0 w=1 l=0.5
X2436 rr2t2r_0[33|8]/a_460_290# WL33 SL8 VSS sky130_fd_pr__nfet_g5v0d10v5 ad=0.65 pd=3.3 as=0 ps=0 w=1 l=0.5
X2437 BLP8 rr2t2r_0[33|8]/a_60_290# sky130_fd_pr_reram__reram_cell area_ox=0.0676
X2438 BLN8 rr2t2r_0[33|8]/a_460_290# sky130_fd_pr_reram__reram_cell area_ox=0.0676
X2439 rr2t2r_0[33|8]/a_60_290# WL33 SL8 VSS sky130_fd_pr__nfet_g5v0d10v5 ad=0.65 pd=3.3 as=0 ps=0 w=1 l=0.5
X2440 rr2t2r_0[34|8]/a_460_290# WL34 SL8 VSS sky130_fd_pr__nfet_g5v0d10v5 ad=0.65 pd=3.3 as=0 ps=0 w=1 l=0.5
X2441 BLP8 rr2t2r_0[34|8]/a_60_290# sky130_fd_pr_reram__reram_cell area_ox=0.0676
X2442 BLN8 rr2t2r_0[34|8]/a_460_290# sky130_fd_pr_reram__reram_cell area_ox=0.0676
X2443 rr2t2r_0[34|8]/a_60_290# WL34 SL8 VSS sky130_fd_pr__nfet_g5v0d10v5 ad=0.65 pd=3.3 as=0 ps=0 w=1 l=0.5
X2444 rr2t2r_0[35|8]/a_460_290# WL35 SL8 VSS sky130_fd_pr__nfet_g5v0d10v5 ad=0.65 pd=3.3 as=0 ps=0 w=1 l=0.5
X2445 BLP8 rr2t2r_0[35|8]/a_60_290# sky130_fd_pr_reram__reram_cell area_ox=0.0676
X2446 BLN8 rr2t2r_0[35|8]/a_460_290# sky130_fd_pr_reram__reram_cell area_ox=0.0676
X2447 rr2t2r_0[35|8]/a_60_290# WL35 SL8 VSS sky130_fd_pr__nfet_g5v0d10v5 ad=0.65 pd=3.3 as=0 ps=0 w=1 l=0.5
X2448 rr2t2r_0[36|8]/a_460_290# WL36 SL8 VSS sky130_fd_pr__nfet_g5v0d10v5 ad=0.65 pd=3.3 as=0 ps=0 w=1 l=0.5
X2449 BLP8 rr2t2r_0[36|8]/a_60_290# sky130_fd_pr_reram__reram_cell area_ox=0.0676
X2450 BLN8 rr2t2r_0[36|8]/a_460_290# sky130_fd_pr_reram__reram_cell area_ox=0.0676
X2451 rr2t2r_0[36|8]/a_60_290# WL36 SL8 VSS sky130_fd_pr__nfet_g5v0d10v5 ad=0.65 pd=3.3 as=0 ps=0 w=1 l=0.5
X2452 rr2t2r_0[37|8]/a_460_290# WL37 SL8 VSS sky130_fd_pr__nfet_g5v0d10v5 ad=0.65 pd=3.3 as=0 ps=0 w=1 l=0.5
X2453 BLP8 rr2t2r_0[37|8]/a_60_290# sky130_fd_pr_reram__reram_cell area_ox=0.0676
X2454 BLN8 rr2t2r_0[37|8]/a_460_290# sky130_fd_pr_reram__reram_cell area_ox=0.0676
X2455 rr2t2r_0[37|8]/a_60_290# WL37 SL8 VSS sky130_fd_pr__nfet_g5v0d10v5 ad=0.65 pd=3.3 as=0 ps=0 w=1 l=0.5
X2456 rr2t2r_0[38|8]/a_460_290# WL38 SL8 VSS sky130_fd_pr__nfet_g5v0d10v5 ad=0.65 pd=3.3 as=0 ps=0 w=1 l=0.5
X2457 BLP8 rr2t2r_0[38|8]/a_60_290# sky130_fd_pr_reram__reram_cell area_ox=0.0676
X2458 BLN8 rr2t2r_0[38|8]/a_460_290# sky130_fd_pr_reram__reram_cell area_ox=0.0676
X2459 rr2t2r_0[38|8]/a_60_290# WL38 SL8 VSS sky130_fd_pr__nfet_g5v0d10v5 ad=0.65 pd=3.3 as=0 ps=0 w=1 l=0.5
X2460 rr2t2r_0[39|8]/a_460_290# WL39 SL8 VSS sky130_fd_pr__nfet_g5v0d10v5 ad=0.65 pd=3.3 as=0 ps=0 w=1 l=0.5
X2461 BLP8 rr2t2r_0[39|8]/a_60_290# sky130_fd_pr_reram__reram_cell area_ox=0.0676
X2462 BLN8 rr2t2r_0[39|8]/a_460_290# sky130_fd_pr_reram__reram_cell area_ox=0.0676
X2463 rr2t2r_0[39|8]/a_60_290# WL39 SL8 VSS sky130_fd_pr__nfet_g5v0d10v5 ad=0.65 pd=3.3 as=0 ps=0 w=1 l=0.5
X2464 rr2t2r_0[40|8]/a_460_290# WL40 SL8 VSS sky130_fd_pr__nfet_g5v0d10v5 ad=0.65 pd=3.3 as=0 ps=0 w=1 l=0.5
X2465 BLP8 rr2t2r_0[40|8]/a_60_290# sky130_fd_pr_reram__reram_cell area_ox=0.0676
X2466 BLN8 rr2t2r_0[40|8]/a_460_290# sky130_fd_pr_reram__reram_cell area_ox=0.0676
X2467 rr2t2r_0[40|8]/a_60_290# WL40 SL8 VSS sky130_fd_pr__nfet_g5v0d10v5 ad=0.65 pd=3.3 as=0 ps=0 w=1 l=0.5
X2468 rr2t2r_0[41|8]/a_460_290# WL41 SL8 VSS sky130_fd_pr__nfet_g5v0d10v5 ad=0.65 pd=3.3 as=0 ps=0 w=1 l=0.5
X2469 BLP8 rr2t2r_0[41|8]/a_60_290# sky130_fd_pr_reram__reram_cell area_ox=0.0676
X2470 BLN8 rr2t2r_0[41|8]/a_460_290# sky130_fd_pr_reram__reram_cell area_ox=0.0676
X2471 rr2t2r_0[41|8]/a_60_290# WL41 SL8 VSS sky130_fd_pr__nfet_g5v0d10v5 ad=0.65 pd=3.3 as=0 ps=0 w=1 l=0.5
X2472 rr2t2r_0[42|8]/a_460_290# WL42 SL8 VSS sky130_fd_pr__nfet_g5v0d10v5 ad=0.65 pd=3.3 as=0 ps=0 w=1 l=0.5
X2473 BLP8 rr2t2r_0[42|8]/a_60_290# sky130_fd_pr_reram__reram_cell area_ox=0.0676
X2474 BLN8 rr2t2r_0[42|8]/a_460_290# sky130_fd_pr_reram__reram_cell area_ox=0.0676
X2475 rr2t2r_0[42|8]/a_60_290# WL42 SL8 VSS sky130_fd_pr__nfet_g5v0d10v5 ad=0.65 pd=3.3 as=0 ps=0 w=1 l=0.5
X2476 rr2t2r_0[43|8]/a_460_290# WL43 SL8 VSS sky130_fd_pr__nfet_g5v0d10v5 ad=0.65 pd=3.3 as=0 ps=0 w=1 l=0.5
X2477 BLP8 rr2t2r_0[43|8]/a_60_290# sky130_fd_pr_reram__reram_cell area_ox=0.0676
X2478 BLN8 rr2t2r_0[43|8]/a_460_290# sky130_fd_pr_reram__reram_cell area_ox=0.0676
X2479 rr2t2r_0[43|8]/a_60_290# WL43 SL8 VSS sky130_fd_pr__nfet_g5v0d10v5 ad=0.65 pd=3.3 as=0 ps=0 w=1 l=0.5
X2480 rr2t2r_0[44|8]/a_460_290# WL44 SL8 VSS sky130_fd_pr__nfet_g5v0d10v5 ad=0.65 pd=3.3 as=0 ps=0 w=1 l=0.5
X2481 BLP8 rr2t2r_0[44|8]/a_60_290# sky130_fd_pr_reram__reram_cell area_ox=0.0676
X2482 BLN8 rr2t2r_0[44|8]/a_460_290# sky130_fd_pr_reram__reram_cell area_ox=0.0676
X2483 rr2t2r_0[44|8]/a_60_290# WL44 SL8 VSS sky130_fd_pr__nfet_g5v0d10v5 ad=0.65 pd=3.3 as=0 ps=0 w=1 l=0.5
X2484 rr2t2r_0[45|8]/a_460_290# WL45 SL8 VSS sky130_fd_pr__nfet_g5v0d10v5 ad=0.65 pd=3.3 as=0 ps=0 w=1 l=0.5
X2485 BLP8 rr2t2r_0[45|8]/a_60_290# sky130_fd_pr_reram__reram_cell area_ox=0.0676
X2486 BLN8 rr2t2r_0[45|8]/a_460_290# sky130_fd_pr_reram__reram_cell area_ox=0.0676
X2487 rr2t2r_0[45|8]/a_60_290# WL45 SL8 VSS sky130_fd_pr__nfet_g5v0d10v5 ad=0.65 pd=3.3 as=0 ps=0 w=1 l=0.5
X2488 rr2t2r_0[46|8]/a_460_290# WL46 SL8 VSS sky130_fd_pr__nfet_g5v0d10v5 ad=0.65 pd=3.3 as=0 ps=0 w=1 l=0.5
X2489 BLP8 rr2t2r_0[46|8]/a_60_290# sky130_fd_pr_reram__reram_cell area_ox=0.0676
X2490 BLN8 rr2t2r_0[46|8]/a_460_290# sky130_fd_pr_reram__reram_cell area_ox=0.0676
X2491 rr2t2r_0[46|8]/a_60_290# WL46 SL8 VSS sky130_fd_pr__nfet_g5v0d10v5 ad=0.65 pd=3.3 as=0 ps=0 w=1 l=0.5
X2492 rr2t2r_0[47|8]/a_460_290# WL47 SL8 VSS sky130_fd_pr__nfet_g5v0d10v5 ad=0.65 pd=3.3 as=0 ps=0 w=1 l=0.5
X2493 BLP8 rr2t2r_0[47|8]/a_60_290# sky130_fd_pr_reram__reram_cell area_ox=0.0676
X2494 BLN8 rr2t2r_0[47|8]/a_460_290# sky130_fd_pr_reram__reram_cell area_ox=0.0676
X2495 rr2t2r_0[47|8]/a_60_290# WL47 SL8 VSS sky130_fd_pr__nfet_g5v0d10v5 ad=0.65 pd=3.3 as=0 ps=0 w=1 l=0.5
X2496 rr2t2r_0[48|8]/a_460_290# WL48 SL8 VSS sky130_fd_pr__nfet_g5v0d10v5 ad=0.65 pd=3.3 as=0 ps=0 w=1 l=0.5
X2497 BLP8 rr2t2r_0[48|8]/a_60_290# sky130_fd_pr_reram__reram_cell area_ox=0.0676
X2498 BLN8 rr2t2r_0[48|8]/a_460_290# sky130_fd_pr_reram__reram_cell area_ox=0.0676
X2499 rr2t2r_0[48|8]/a_60_290# WL48 SL8 VSS sky130_fd_pr__nfet_g5v0d10v5 ad=0.65 pd=3.3 as=0 ps=0 w=1 l=0.5
X2500 rr2t2r_0[49|8]/a_460_290# WL49 SL8 VSS sky130_fd_pr__nfet_g5v0d10v5 ad=0.65 pd=3.3 as=0 ps=0 w=1 l=0.5
X2501 BLP8 rr2t2r_0[49|8]/a_60_290# sky130_fd_pr_reram__reram_cell area_ox=0.0676
X2502 BLN8 rr2t2r_0[49|8]/a_460_290# sky130_fd_pr_reram__reram_cell area_ox=0.0676
X2503 rr2t2r_0[49|8]/a_60_290# WL49 SL8 VSS sky130_fd_pr__nfet_g5v0d10v5 ad=0.65 pd=3.3 as=0 ps=0 w=1 l=0.5
X2504 rr2t2r_0[50|8]/a_460_290# WL50 SL8 VSS sky130_fd_pr__nfet_g5v0d10v5 ad=0.65 pd=3.3 as=0 ps=0 w=1 l=0.5
X2505 BLP8 rr2t2r_0[50|8]/a_60_290# sky130_fd_pr_reram__reram_cell area_ox=0.0676
X2506 BLN8 rr2t2r_0[50|8]/a_460_290# sky130_fd_pr_reram__reram_cell area_ox=0.0676
X2507 rr2t2r_0[50|8]/a_60_290# WL50 SL8 VSS sky130_fd_pr__nfet_g5v0d10v5 ad=0.65 pd=3.3 as=0 ps=0 w=1 l=0.5
X2508 rr2t2r_0[51|8]/a_460_290# WL51 SL8 VSS sky130_fd_pr__nfet_g5v0d10v5 ad=0.65 pd=3.3 as=0 ps=0 w=1 l=0.5
X2509 BLP8 rr2t2r_0[51|8]/a_60_290# sky130_fd_pr_reram__reram_cell area_ox=0.0676
X2510 BLN8 rr2t2r_0[51|8]/a_460_290# sky130_fd_pr_reram__reram_cell area_ox=0.0676
X2511 rr2t2r_0[51|8]/a_60_290# WL51 SL8 VSS sky130_fd_pr__nfet_g5v0d10v5 ad=0.65 pd=3.3 as=0 ps=0 w=1 l=0.5
X2512 rr2t2r_0[52|8]/a_460_290# WL52 SL8 VSS sky130_fd_pr__nfet_g5v0d10v5 ad=0.65 pd=3.3 as=0 ps=0 w=1 l=0.5
X2513 BLP8 rr2t2r_0[52|8]/a_60_290# sky130_fd_pr_reram__reram_cell area_ox=0.0676
X2514 BLN8 rr2t2r_0[52|8]/a_460_290# sky130_fd_pr_reram__reram_cell area_ox=0.0676
X2515 rr2t2r_0[52|8]/a_60_290# WL52 SL8 VSS sky130_fd_pr__nfet_g5v0d10v5 ad=0.65 pd=3.3 as=0 ps=0 w=1 l=0.5
X2516 rr2t2r_0[53|8]/a_460_290# WL53 SL8 VSS sky130_fd_pr__nfet_g5v0d10v5 ad=0.65 pd=3.3 as=0 ps=0 w=1 l=0.5
X2517 BLP8 rr2t2r_0[53|8]/a_60_290# sky130_fd_pr_reram__reram_cell area_ox=0.0676
X2518 BLN8 rr2t2r_0[53|8]/a_460_290# sky130_fd_pr_reram__reram_cell area_ox=0.0676
X2519 rr2t2r_0[53|8]/a_60_290# WL53 SL8 VSS sky130_fd_pr__nfet_g5v0d10v5 ad=0.65 pd=3.3 as=0 ps=0 w=1 l=0.5
X2520 rr2t2r_0[54|8]/a_460_290# WL54 SL8 VSS sky130_fd_pr__nfet_g5v0d10v5 ad=0.65 pd=3.3 as=0 ps=0 w=1 l=0.5
X2521 BLP8 rr2t2r_0[54|8]/a_60_290# sky130_fd_pr_reram__reram_cell area_ox=0.0676
X2522 BLN8 rr2t2r_0[54|8]/a_460_290# sky130_fd_pr_reram__reram_cell area_ox=0.0676
X2523 rr2t2r_0[54|8]/a_60_290# WL54 SL8 VSS sky130_fd_pr__nfet_g5v0d10v5 ad=0.65 pd=3.3 as=0 ps=0 w=1 l=0.5
X2524 rr2t2r_0[55|8]/a_460_290# WL55 SL8 VSS sky130_fd_pr__nfet_g5v0d10v5 ad=0.65 pd=3.3 as=0 ps=0 w=1 l=0.5
X2525 BLP8 rr2t2r_0[55|8]/a_60_290# sky130_fd_pr_reram__reram_cell area_ox=0.0676
X2526 BLN8 rr2t2r_0[55|8]/a_460_290# sky130_fd_pr_reram__reram_cell area_ox=0.0676
X2527 rr2t2r_0[55|8]/a_60_290# WL55 SL8 VSS sky130_fd_pr__nfet_g5v0d10v5 ad=0.65 pd=3.3 as=0 ps=0 w=1 l=0.5
X2528 rr2t2r_0[56|8]/a_460_290# WL56 SL8 VSS sky130_fd_pr__nfet_g5v0d10v5 ad=0.65 pd=3.3 as=0 ps=0 w=1 l=0.5
X2529 BLP8 rr2t2r_0[56|8]/a_60_290# sky130_fd_pr_reram__reram_cell area_ox=0.0676
X2530 BLN8 rr2t2r_0[56|8]/a_460_290# sky130_fd_pr_reram__reram_cell area_ox=0.0676
X2531 rr2t2r_0[56|8]/a_60_290# WL56 SL8 VSS sky130_fd_pr__nfet_g5v0d10v5 ad=0.65 pd=3.3 as=0 ps=0 w=1 l=0.5
X2532 rr2t2r_0[57|8]/a_460_290# WL57 SL8 VSS sky130_fd_pr__nfet_g5v0d10v5 ad=0.65 pd=3.3 as=0 ps=0 w=1 l=0.5
X2533 BLP8 rr2t2r_0[57|8]/a_60_290# sky130_fd_pr_reram__reram_cell area_ox=0.0676
X2534 BLN8 rr2t2r_0[57|8]/a_460_290# sky130_fd_pr_reram__reram_cell area_ox=0.0676
X2535 rr2t2r_0[57|8]/a_60_290# WL57 SL8 VSS sky130_fd_pr__nfet_g5v0d10v5 ad=0.65 pd=3.3 as=0 ps=0 w=1 l=0.5
X2536 rr2t2r_0[58|8]/a_460_290# WL58 SL8 VSS sky130_fd_pr__nfet_g5v0d10v5 ad=0.65 pd=3.3 as=0 ps=0 w=1 l=0.5
X2537 BLP8 rr2t2r_0[58|8]/a_60_290# sky130_fd_pr_reram__reram_cell area_ox=0.0676
X2538 BLN8 rr2t2r_0[58|8]/a_460_290# sky130_fd_pr_reram__reram_cell area_ox=0.0676
X2539 rr2t2r_0[58|8]/a_60_290# WL58 SL8 VSS sky130_fd_pr__nfet_g5v0d10v5 ad=0.65 pd=3.3 as=0 ps=0 w=1 l=0.5
X2540 rr2t2r_0[59|8]/a_460_290# WL59 SL8 VSS sky130_fd_pr__nfet_g5v0d10v5 ad=0.65 pd=3.3 as=0 ps=0 w=1 l=0.5
X2541 BLP8 rr2t2r_0[59|8]/a_60_290# sky130_fd_pr_reram__reram_cell area_ox=0.0676
X2542 BLN8 rr2t2r_0[59|8]/a_460_290# sky130_fd_pr_reram__reram_cell area_ox=0.0676
X2543 rr2t2r_0[59|8]/a_60_290# WL59 SL8 VSS sky130_fd_pr__nfet_g5v0d10v5 ad=0.65 pd=3.3 as=0 ps=0 w=1 l=0.5
X2544 rr2t2r_0[60|8]/a_460_290# WL60 SL8 VSS sky130_fd_pr__nfet_g5v0d10v5 ad=0.65 pd=3.3 as=0 ps=0 w=1 l=0.5
X2545 BLP8 rr2t2r_0[60|8]/a_60_290# sky130_fd_pr_reram__reram_cell area_ox=0.0676
X2546 BLN8 rr2t2r_0[60|8]/a_460_290# sky130_fd_pr_reram__reram_cell area_ox=0.0676
X2547 rr2t2r_0[60|8]/a_60_290# WL60 SL8 VSS sky130_fd_pr__nfet_g5v0d10v5 ad=0.65 pd=3.3 as=0 ps=0 w=1 l=0.5
X2548 rr2t2r_0[61|8]/a_460_290# WL61 SL8 VSS sky130_fd_pr__nfet_g5v0d10v5 ad=0.65 pd=3.3 as=0 ps=0 w=1 l=0.5
X2549 BLP8 rr2t2r_0[61|8]/a_60_290# sky130_fd_pr_reram__reram_cell area_ox=0.0676
X2550 BLN8 rr2t2r_0[61|8]/a_460_290# sky130_fd_pr_reram__reram_cell area_ox=0.0676
X2551 rr2t2r_0[61|8]/a_60_290# WL61 SL8 VSS sky130_fd_pr__nfet_g5v0d10v5 ad=0.65 pd=3.3 as=0 ps=0 w=1 l=0.5
X2552 rr2t2r_0[62|8]/a_460_290# WL62 SL8 VSS sky130_fd_pr__nfet_g5v0d10v5 ad=0.65 pd=3.3 as=0 ps=0 w=1 l=0.5
X2553 BLP8 rr2t2r_0[62|8]/a_60_290# sky130_fd_pr_reram__reram_cell area_ox=0.0676
X2554 BLN8 rr2t2r_0[62|8]/a_460_290# sky130_fd_pr_reram__reram_cell area_ox=0.0676
X2555 rr2t2r_0[62|8]/a_60_290# WL62 SL8 VSS sky130_fd_pr__nfet_g5v0d10v5 ad=0.65 pd=3.3 as=0 ps=0 w=1 l=0.5
X2556 rr2t2r_0[63|8]/a_460_290# WL63 SL8 VSS sky130_fd_pr__nfet_g5v0d10v5 ad=0.65 pd=3.3 as=0 ps=0 w=1 l=0.5
X2557 BLP8 rr2t2r_0[63|8]/a_60_290# sky130_fd_pr_reram__reram_cell area_ox=0.0676
X2558 BLN8 rr2t2r_0[63|8]/a_460_290# sky130_fd_pr_reram__reram_cell area_ox=0.0676
X2559 rr2t2r_0[63|8]/a_60_290# WL63 SL8 VSS sky130_fd_pr__nfet_g5v0d10v5 ad=0.65 pd=3.3 as=0 ps=0 w=1 l=0.5
X2560 rr2t2r_0[64|8]/a_460_290# WL64 SL8 VSS sky130_fd_pr__nfet_g5v0d10v5 ad=0.65 pd=3.3 as=0 ps=0 w=1 l=0.5
X2561 BLP8 rr2t2r_0[64|8]/a_60_290# sky130_fd_pr_reram__reram_cell area_ox=0.0676
X2562 BLN8 rr2t2r_0[64|8]/a_460_290# sky130_fd_pr_reram__reram_cell area_ox=0.0676
X2563 rr2t2r_0[64|8]/a_60_290# WL64 SL8 VSS sky130_fd_pr__nfet_g5v0d10v5 ad=0.65 pd=3.3 as=0 ps=0 w=1 l=0.5
X2564 rr2t2r_0[65|8]/a_460_290# WL65 SL8 VSS sky130_fd_pr__nfet_g5v0d10v5 ad=0.65 pd=3.3 as=0 ps=0 w=1 l=0.5
X2565 BLP8 rr2t2r_0[65|8]/a_60_290# sky130_fd_pr_reram__reram_cell area_ox=0.0676
X2566 BLN8 rr2t2r_0[65|8]/a_460_290# sky130_fd_pr_reram__reram_cell area_ox=0.0676
X2567 rr2t2r_0[65|8]/a_60_290# WL65 SL8 VSS sky130_fd_pr__nfet_g5v0d10v5 ad=0.65 pd=3.3 as=0 ps=0 w=1 l=0.5
X2568 rr2t2r_0[66|8]/a_460_290# WL66 SL8 VSS sky130_fd_pr__nfet_g5v0d10v5 ad=0.65 pd=3.3 as=0 ps=0 w=1 l=0.5
X2569 BLP8 rr2t2r_0[66|8]/a_60_290# sky130_fd_pr_reram__reram_cell area_ox=0.0676
X2570 BLN8 rr2t2r_0[66|8]/a_460_290# sky130_fd_pr_reram__reram_cell area_ox=0.0676
X2571 rr2t2r_0[66|8]/a_60_290# WL66 SL8 VSS sky130_fd_pr__nfet_g5v0d10v5 ad=0.65 pd=3.3 as=0 ps=0 w=1 l=0.5
X2572 rr2t2r_0[67|8]/a_460_290# WL67 SL8 VSS sky130_fd_pr__nfet_g5v0d10v5 ad=0.65 pd=3.3 as=0 ps=0 w=1 l=0.5
X2573 BLP8 rr2t2r_0[67|8]/a_60_290# sky130_fd_pr_reram__reram_cell area_ox=0.0676
X2574 BLN8 rr2t2r_0[67|8]/a_460_290# sky130_fd_pr_reram__reram_cell area_ox=0.0676
X2575 rr2t2r_0[67|8]/a_60_290# WL67 SL8 VSS sky130_fd_pr__nfet_g5v0d10v5 ad=0.65 pd=3.3 as=0 ps=0 w=1 l=0.5
X2576 rr2t2r_0[68|8]/a_460_290# WL68 SL8 VSS sky130_fd_pr__nfet_g5v0d10v5 ad=0.65 pd=3.3 as=0 ps=0 w=1 l=0.5
X2577 BLP8 rr2t2r_0[68|8]/a_60_290# sky130_fd_pr_reram__reram_cell area_ox=0.0676
X2578 BLN8 rr2t2r_0[68|8]/a_460_290# sky130_fd_pr_reram__reram_cell area_ox=0.0676
X2579 rr2t2r_0[68|8]/a_60_290# WL68 SL8 VSS sky130_fd_pr__nfet_g5v0d10v5 ad=0.65 pd=3.3 as=0 ps=0 w=1 l=0.5
X2580 rr2t2r_0[69|8]/a_460_290# WL69 SL8 VSS sky130_fd_pr__nfet_g5v0d10v5 ad=0.65 pd=3.3 as=0 ps=0 w=1 l=0.5
X2581 BLP8 rr2t2r_0[69|8]/a_60_290# sky130_fd_pr_reram__reram_cell area_ox=0.0676
X2582 BLN8 rr2t2r_0[69|8]/a_460_290# sky130_fd_pr_reram__reram_cell area_ox=0.0676
X2583 rr2t2r_0[69|8]/a_60_290# WL69 SL8 VSS sky130_fd_pr__nfet_g5v0d10v5 ad=0.65 pd=3.3 as=0 ps=0 w=1 l=0.5
X2584 rr2t2r_0[70|8]/a_460_290# WL70 SL8 VSS sky130_fd_pr__nfet_g5v0d10v5 ad=0.65 pd=3.3 as=0 ps=0 w=1 l=0.5
X2585 BLP8 rr2t2r_0[70|8]/a_60_290# sky130_fd_pr_reram__reram_cell area_ox=0.0676
X2586 BLN8 rr2t2r_0[70|8]/a_460_290# sky130_fd_pr_reram__reram_cell area_ox=0.0676
X2587 rr2t2r_0[70|8]/a_60_290# WL70 SL8 VSS sky130_fd_pr__nfet_g5v0d10v5 ad=0.65 pd=3.3 as=0 ps=0 w=1 l=0.5
X2588 rr2t2r_0[71|8]/a_460_290# WL71 SL8 VSS sky130_fd_pr__nfet_g5v0d10v5 ad=0.65 pd=3.3 as=0 ps=0 w=1 l=0.5
X2589 BLP8 rr2t2r_0[71|8]/a_60_290# sky130_fd_pr_reram__reram_cell area_ox=0.0676
X2590 BLN8 rr2t2r_0[71|8]/a_460_290# sky130_fd_pr_reram__reram_cell area_ox=0.0676
X2591 rr2t2r_0[71|8]/a_60_290# WL71 SL8 VSS sky130_fd_pr__nfet_g5v0d10v5 ad=0.65 pd=3.3 as=0 ps=0 w=1 l=0.5
X2592 rr2t2r_0[0|9]/a_460_290# WL0 SL9 VSS sky130_fd_pr__nfet_g5v0d10v5 ad=0.65 pd=3.3 as=108 ps=504 w=1 l=0.5
X2593 BLP9 rr2t2r_0[0|9]/a_60_290# sky130_fd_pr_reram__reram_cell area_ox=0.0676
X2594 BLN9 rr2t2r_0[0|9]/a_460_290# sky130_fd_pr_reram__reram_cell area_ox=0.0676
X2595 rr2t2r_0[0|9]/a_60_290# WL0 SL9 VSS sky130_fd_pr__nfet_g5v0d10v5 ad=0.65 pd=3.3 as=0 ps=0 w=1 l=0.5
X2596 rr2t2r_0[1|9]/a_460_290# WL1 SL9 VSS sky130_fd_pr__nfet_g5v0d10v5 ad=0.65 pd=3.3 as=0 ps=0 w=1 l=0.5
X2597 BLP9 rr2t2r_0[1|9]/a_60_290# sky130_fd_pr_reram__reram_cell area_ox=0.0676
X2598 BLN9 rr2t2r_0[1|9]/a_460_290# sky130_fd_pr_reram__reram_cell area_ox=0.0676
X2599 rr2t2r_0[1|9]/a_60_290# WL1 SL9 VSS sky130_fd_pr__nfet_g5v0d10v5 ad=0.65 pd=3.3 as=0 ps=0 w=1 l=0.5
X2600 rr2t2r_0[2|9]/a_460_290# WL2 SL9 VSS sky130_fd_pr__nfet_g5v0d10v5 ad=0.65 pd=3.3 as=0 ps=0 w=1 l=0.5
X2601 BLP9 rr2t2r_0[2|9]/a_60_290# sky130_fd_pr_reram__reram_cell area_ox=0.0676
X2602 BLN9 rr2t2r_0[2|9]/a_460_290# sky130_fd_pr_reram__reram_cell area_ox=0.0676
X2603 rr2t2r_0[2|9]/a_60_290# WL2 SL9 VSS sky130_fd_pr__nfet_g5v0d10v5 ad=0.65 pd=3.3 as=0 ps=0 w=1 l=0.5
X2604 rr2t2r_0[3|9]/a_460_290# WL3 SL9 VSS sky130_fd_pr__nfet_g5v0d10v5 ad=0.65 pd=3.3 as=0 ps=0 w=1 l=0.5
X2605 BLP9 rr2t2r_0[3|9]/a_60_290# sky130_fd_pr_reram__reram_cell area_ox=0.0676
X2606 BLN9 rr2t2r_0[3|9]/a_460_290# sky130_fd_pr_reram__reram_cell area_ox=0.0676
X2607 rr2t2r_0[3|9]/a_60_290# WL3 SL9 VSS sky130_fd_pr__nfet_g5v0d10v5 ad=0.65 pd=3.3 as=0 ps=0 w=1 l=0.5
X2608 rr2t2r_0[4|9]/a_460_290# WL4 SL9 VSS sky130_fd_pr__nfet_g5v0d10v5 ad=0.65 pd=3.3 as=0 ps=0 w=1 l=0.5
X2609 BLP9 rr2t2r_0[4|9]/a_60_290# sky130_fd_pr_reram__reram_cell area_ox=0.0676
X2610 BLN9 rr2t2r_0[4|9]/a_460_290# sky130_fd_pr_reram__reram_cell area_ox=0.0676
X2611 rr2t2r_0[4|9]/a_60_290# WL4 SL9 VSS sky130_fd_pr__nfet_g5v0d10v5 ad=0.65 pd=3.3 as=0 ps=0 w=1 l=0.5
X2612 rr2t2r_0[5|9]/a_460_290# WL5 SL9 VSS sky130_fd_pr__nfet_g5v0d10v5 ad=0.65 pd=3.3 as=0 ps=0 w=1 l=0.5
X2613 BLP9 rr2t2r_0[5|9]/a_60_290# sky130_fd_pr_reram__reram_cell area_ox=0.0676
X2614 BLN9 rr2t2r_0[5|9]/a_460_290# sky130_fd_pr_reram__reram_cell area_ox=0.0676
X2615 rr2t2r_0[5|9]/a_60_290# WL5 SL9 VSS sky130_fd_pr__nfet_g5v0d10v5 ad=0.65 pd=3.3 as=0 ps=0 w=1 l=0.5
X2616 rr2t2r_0[6|9]/a_460_290# WL6 SL9 VSS sky130_fd_pr__nfet_g5v0d10v5 ad=0.65 pd=3.3 as=0 ps=0 w=1 l=0.5
X2617 BLP9 rr2t2r_0[6|9]/a_60_290# sky130_fd_pr_reram__reram_cell area_ox=0.0676
X2618 BLN9 rr2t2r_0[6|9]/a_460_290# sky130_fd_pr_reram__reram_cell area_ox=0.0676
X2619 rr2t2r_0[6|9]/a_60_290# WL6 SL9 VSS sky130_fd_pr__nfet_g5v0d10v5 ad=0.65 pd=3.3 as=0 ps=0 w=1 l=0.5
X2620 rr2t2r_0[7|9]/a_460_290# WL7 SL9 VSS sky130_fd_pr__nfet_g5v0d10v5 ad=0.65 pd=3.3 as=0 ps=0 w=1 l=0.5
X2621 BLP9 rr2t2r_0[7|9]/a_60_290# sky130_fd_pr_reram__reram_cell area_ox=0.0676
X2622 BLN9 rr2t2r_0[7|9]/a_460_290# sky130_fd_pr_reram__reram_cell area_ox=0.0676
X2623 rr2t2r_0[7|9]/a_60_290# WL7 SL9 VSS sky130_fd_pr__nfet_g5v0d10v5 ad=0.65 pd=3.3 as=0 ps=0 w=1 l=0.5
X2624 rr2t2r_0[8|9]/a_460_290# WL8 SL9 VSS sky130_fd_pr__nfet_g5v0d10v5 ad=0.65 pd=3.3 as=0 ps=0 w=1 l=0.5
X2625 BLP9 rr2t2r_0[8|9]/a_60_290# sky130_fd_pr_reram__reram_cell area_ox=0.0676
X2626 BLN9 rr2t2r_0[8|9]/a_460_290# sky130_fd_pr_reram__reram_cell area_ox=0.0676
X2627 rr2t2r_0[8|9]/a_60_290# WL8 SL9 VSS sky130_fd_pr__nfet_g5v0d10v5 ad=0.65 pd=3.3 as=0 ps=0 w=1 l=0.5
X2628 rr2t2r_0[9|9]/a_460_290# WL9 SL9 VSS sky130_fd_pr__nfet_g5v0d10v5 ad=0.65 pd=3.3 as=0 ps=0 w=1 l=0.5
X2629 BLP9 rr2t2r_0[9|9]/a_60_290# sky130_fd_pr_reram__reram_cell area_ox=0.0676
X2630 BLN9 rr2t2r_0[9|9]/a_460_290# sky130_fd_pr_reram__reram_cell area_ox=0.0676
X2631 rr2t2r_0[9|9]/a_60_290# WL9 SL9 VSS sky130_fd_pr__nfet_g5v0d10v5 ad=0.65 pd=3.3 as=0 ps=0 w=1 l=0.5
X2632 rr2t2r_0[10|9]/a_460_290# WL10 SL9 VSS sky130_fd_pr__nfet_g5v0d10v5 ad=0.65 pd=3.3 as=0 ps=0 w=1 l=0.5
X2633 BLP9 rr2t2r_0[10|9]/a_60_290# sky130_fd_pr_reram__reram_cell area_ox=0.0676
X2634 BLN9 rr2t2r_0[10|9]/a_460_290# sky130_fd_pr_reram__reram_cell area_ox=0.0676
X2635 rr2t2r_0[10|9]/a_60_290# WL10 SL9 VSS sky130_fd_pr__nfet_g5v0d10v5 ad=0.65 pd=3.3 as=0 ps=0 w=1 l=0.5
X2636 rr2t2r_0[11|9]/a_460_290# WL11 SL9 VSS sky130_fd_pr__nfet_g5v0d10v5 ad=0.65 pd=3.3 as=0 ps=0 w=1 l=0.5
X2637 BLP9 rr2t2r_0[11|9]/a_60_290# sky130_fd_pr_reram__reram_cell area_ox=0.0676
X2638 BLN9 rr2t2r_0[11|9]/a_460_290# sky130_fd_pr_reram__reram_cell area_ox=0.0676
X2639 rr2t2r_0[11|9]/a_60_290# WL11 SL9 VSS sky130_fd_pr__nfet_g5v0d10v5 ad=0.65 pd=3.3 as=0 ps=0 w=1 l=0.5
X2640 rr2t2r_0[12|9]/a_460_290# WL12 SL9 VSS sky130_fd_pr__nfet_g5v0d10v5 ad=0.65 pd=3.3 as=0 ps=0 w=1 l=0.5
X2641 BLP9 rr2t2r_0[12|9]/a_60_290# sky130_fd_pr_reram__reram_cell area_ox=0.0676
X2642 BLN9 rr2t2r_0[12|9]/a_460_290# sky130_fd_pr_reram__reram_cell area_ox=0.0676
X2643 rr2t2r_0[12|9]/a_60_290# WL12 SL9 VSS sky130_fd_pr__nfet_g5v0d10v5 ad=0.65 pd=3.3 as=0 ps=0 w=1 l=0.5
X2644 rr2t2r_0[13|9]/a_460_290# WL13 SL9 VSS sky130_fd_pr__nfet_g5v0d10v5 ad=0.65 pd=3.3 as=0 ps=0 w=1 l=0.5
X2645 BLP9 rr2t2r_0[13|9]/a_60_290# sky130_fd_pr_reram__reram_cell area_ox=0.0676
X2646 BLN9 rr2t2r_0[13|9]/a_460_290# sky130_fd_pr_reram__reram_cell area_ox=0.0676
X2647 rr2t2r_0[13|9]/a_60_290# WL13 SL9 VSS sky130_fd_pr__nfet_g5v0d10v5 ad=0.65 pd=3.3 as=0 ps=0 w=1 l=0.5
X2648 rr2t2r_0[14|9]/a_460_290# WL14 SL9 VSS sky130_fd_pr__nfet_g5v0d10v5 ad=0.65 pd=3.3 as=0 ps=0 w=1 l=0.5
X2649 BLP9 rr2t2r_0[14|9]/a_60_290# sky130_fd_pr_reram__reram_cell area_ox=0.0676
X2650 BLN9 rr2t2r_0[14|9]/a_460_290# sky130_fd_pr_reram__reram_cell area_ox=0.0676
X2651 rr2t2r_0[14|9]/a_60_290# WL14 SL9 VSS sky130_fd_pr__nfet_g5v0d10v5 ad=0.65 pd=3.3 as=0 ps=0 w=1 l=0.5
X2652 rr2t2r_0[15|9]/a_460_290# WL15 SL9 VSS sky130_fd_pr__nfet_g5v0d10v5 ad=0.65 pd=3.3 as=0 ps=0 w=1 l=0.5
X2653 BLP9 rr2t2r_0[15|9]/a_60_290# sky130_fd_pr_reram__reram_cell area_ox=0.0676
X2654 BLN9 rr2t2r_0[15|9]/a_460_290# sky130_fd_pr_reram__reram_cell area_ox=0.0676
X2655 rr2t2r_0[15|9]/a_60_290# WL15 SL9 VSS sky130_fd_pr__nfet_g5v0d10v5 ad=0.65 pd=3.3 as=0 ps=0 w=1 l=0.5
X2656 rr2t2r_0[16|9]/a_460_290# WL16 SL9 VSS sky130_fd_pr__nfet_g5v0d10v5 ad=0.65 pd=3.3 as=0 ps=0 w=1 l=0.5
X2657 BLP9 rr2t2r_0[16|9]/a_60_290# sky130_fd_pr_reram__reram_cell area_ox=0.0676
X2658 BLN9 rr2t2r_0[16|9]/a_460_290# sky130_fd_pr_reram__reram_cell area_ox=0.0676
X2659 rr2t2r_0[16|9]/a_60_290# WL16 SL9 VSS sky130_fd_pr__nfet_g5v0d10v5 ad=0.65 pd=3.3 as=0 ps=0 w=1 l=0.5
X2660 rr2t2r_0[17|9]/a_460_290# WL17 SL9 VSS sky130_fd_pr__nfet_g5v0d10v5 ad=0.65 pd=3.3 as=0 ps=0 w=1 l=0.5
X2661 BLP9 rr2t2r_0[17|9]/a_60_290# sky130_fd_pr_reram__reram_cell area_ox=0.0676
X2662 BLN9 rr2t2r_0[17|9]/a_460_290# sky130_fd_pr_reram__reram_cell area_ox=0.0676
X2663 rr2t2r_0[17|9]/a_60_290# WL17 SL9 VSS sky130_fd_pr__nfet_g5v0d10v5 ad=0.65 pd=3.3 as=0 ps=0 w=1 l=0.5
X2664 rr2t2r_0[18|9]/a_460_290# WL18 SL9 VSS sky130_fd_pr__nfet_g5v0d10v5 ad=0.65 pd=3.3 as=0 ps=0 w=1 l=0.5
X2665 BLP9 rr2t2r_0[18|9]/a_60_290# sky130_fd_pr_reram__reram_cell area_ox=0.0676
X2666 BLN9 rr2t2r_0[18|9]/a_460_290# sky130_fd_pr_reram__reram_cell area_ox=0.0676
X2667 rr2t2r_0[18|9]/a_60_290# WL18 SL9 VSS sky130_fd_pr__nfet_g5v0d10v5 ad=0.65 pd=3.3 as=0 ps=0 w=1 l=0.5
X2668 rr2t2r_0[19|9]/a_460_290# WL19 SL9 VSS sky130_fd_pr__nfet_g5v0d10v5 ad=0.65 pd=3.3 as=0 ps=0 w=1 l=0.5
X2669 BLP9 rr2t2r_0[19|9]/a_60_290# sky130_fd_pr_reram__reram_cell area_ox=0.0676
X2670 BLN9 rr2t2r_0[19|9]/a_460_290# sky130_fd_pr_reram__reram_cell area_ox=0.0676
X2671 rr2t2r_0[19|9]/a_60_290# WL19 SL9 VSS sky130_fd_pr__nfet_g5v0d10v5 ad=0.65 pd=3.3 as=0 ps=0 w=1 l=0.5
X2672 rr2t2r_0[20|9]/a_460_290# WL20 SL9 VSS sky130_fd_pr__nfet_g5v0d10v5 ad=0.65 pd=3.3 as=0 ps=0 w=1 l=0.5
X2673 BLP9 rr2t2r_0[20|9]/a_60_290# sky130_fd_pr_reram__reram_cell area_ox=0.0676
X2674 BLN9 rr2t2r_0[20|9]/a_460_290# sky130_fd_pr_reram__reram_cell area_ox=0.0676
X2675 rr2t2r_0[20|9]/a_60_290# WL20 SL9 VSS sky130_fd_pr__nfet_g5v0d10v5 ad=0.65 pd=3.3 as=0 ps=0 w=1 l=0.5
X2676 rr2t2r_0[21|9]/a_460_290# WL21 SL9 VSS sky130_fd_pr__nfet_g5v0d10v5 ad=0.65 pd=3.3 as=0 ps=0 w=1 l=0.5
X2677 BLP9 rr2t2r_0[21|9]/a_60_290# sky130_fd_pr_reram__reram_cell area_ox=0.0676
X2678 BLN9 rr2t2r_0[21|9]/a_460_290# sky130_fd_pr_reram__reram_cell area_ox=0.0676
X2679 rr2t2r_0[21|9]/a_60_290# WL21 SL9 VSS sky130_fd_pr__nfet_g5v0d10v5 ad=0.65 pd=3.3 as=0 ps=0 w=1 l=0.5
X2680 rr2t2r_0[22|9]/a_460_290# WL22 SL9 VSS sky130_fd_pr__nfet_g5v0d10v5 ad=0.65 pd=3.3 as=0 ps=0 w=1 l=0.5
X2681 BLP9 rr2t2r_0[22|9]/a_60_290# sky130_fd_pr_reram__reram_cell area_ox=0.0676
X2682 BLN9 rr2t2r_0[22|9]/a_460_290# sky130_fd_pr_reram__reram_cell area_ox=0.0676
X2683 rr2t2r_0[22|9]/a_60_290# WL22 SL9 VSS sky130_fd_pr__nfet_g5v0d10v5 ad=0.65 pd=3.3 as=0 ps=0 w=1 l=0.5
X2684 rr2t2r_0[23|9]/a_460_290# WL23 SL9 VSS sky130_fd_pr__nfet_g5v0d10v5 ad=0.65 pd=3.3 as=0 ps=0 w=1 l=0.5
X2685 BLP9 rr2t2r_0[23|9]/a_60_290# sky130_fd_pr_reram__reram_cell area_ox=0.0676
X2686 BLN9 rr2t2r_0[23|9]/a_460_290# sky130_fd_pr_reram__reram_cell area_ox=0.0676
X2687 rr2t2r_0[23|9]/a_60_290# WL23 SL9 VSS sky130_fd_pr__nfet_g5v0d10v5 ad=0.65 pd=3.3 as=0 ps=0 w=1 l=0.5
X2688 rr2t2r_0[24|9]/a_460_290# WL24 SL9 VSS sky130_fd_pr__nfet_g5v0d10v5 ad=0.65 pd=3.3 as=0 ps=0 w=1 l=0.5
X2689 BLP9 rr2t2r_0[24|9]/a_60_290# sky130_fd_pr_reram__reram_cell area_ox=0.0676
X2690 BLN9 rr2t2r_0[24|9]/a_460_290# sky130_fd_pr_reram__reram_cell area_ox=0.0676
X2691 rr2t2r_0[24|9]/a_60_290# WL24 SL9 VSS sky130_fd_pr__nfet_g5v0d10v5 ad=0.65 pd=3.3 as=0 ps=0 w=1 l=0.5
X2692 rr2t2r_0[25|9]/a_460_290# WL25 SL9 VSS sky130_fd_pr__nfet_g5v0d10v5 ad=0.65 pd=3.3 as=0 ps=0 w=1 l=0.5
X2693 BLP9 rr2t2r_0[25|9]/a_60_290# sky130_fd_pr_reram__reram_cell area_ox=0.0676
X2694 BLN9 rr2t2r_0[25|9]/a_460_290# sky130_fd_pr_reram__reram_cell area_ox=0.0676
X2695 rr2t2r_0[25|9]/a_60_290# WL25 SL9 VSS sky130_fd_pr__nfet_g5v0d10v5 ad=0.65 pd=3.3 as=0 ps=0 w=1 l=0.5
X2696 rr2t2r_0[26|9]/a_460_290# WL26 SL9 VSS sky130_fd_pr__nfet_g5v0d10v5 ad=0.65 pd=3.3 as=0 ps=0 w=1 l=0.5
X2697 BLP9 rr2t2r_0[26|9]/a_60_290# sky130_fd_pr_reram__reram_cell area_ox=0.0676
X2698 BLN9 rr2t2r_0[26|9]/a_460_290# sky130_fd_pr_reram__reram_cell area_ox=0.0676
X2699 rr2t2r_0[26|9]/a_60_290# WL26 SL9 VSS sky130_fd_pr__nfet_g5v0d10v5 ad=0.65 pd=3.3 as=0 ps=0 w=1 l=0.5
X2700 rr2t2r_0[27|9]/a_460_290# WL27 SL9 VSS sky130_fd_pr__nfet_g5v0d10v5 ad=0.65 pd=3.3 as=0 ps=0 w=1 l=0.5
X2701 BLP9 rr2t2r_0[27|9]/a_60_290# sky130_fd_pr_reram__reram_cell area_ox=0.0676
X2702 BLN9 rr2t2r_0[27|9]/a_460_290# sky130_fd_pr_reram__reram_cell area_ox=0.0676
X2703 rr2t2r_0[27|9]/a_60_290# WL27 SL9 VSS sky130_fd_pr__nfet_g5v0d10v5 ad=0.65 pd=3.3 as=0 ps=0 w=1 l=0.5
X2704 rr2t2r_0[28|9]/a_460_290# WL28 SL9 VSS sky130_fd_pr__nfet_g5v0d10v5 ad=0.65 pd=3.3 as=0 ps=0 w=1 l=0.5
X2705 BLP9 rr2t2r_0[28|9]/a_60_290# sky130_fd_pr_reram__reram_cell area_ox=0.0676
X2706 BLN9 rr2t2r_0[28|9]/a_460_290# sky130_fd_pr_reram__reram_cell area_ox=0.0676
X2707 rr2t2r_0[28|9]/a_60_290# WL28 SL9 VSS sky130_fd_pr__nfet_g5v0d10v5 ad=0.65 pd=3.3 as=0 ps=0 w=1 l=0.5
X2708 rr2t2r_0[29|9]/a_460_290# WL29 SL9 VSS sky130_fd_pr__nfet_g5v0d10v5 ad=0.65 pd=3.3 as=0 ps=0 w=1 l=0.5
X2709 BLP9 rr2t2r_0[29|9]/a_60_290# sky130_fd_pr_reram__reram_cell area_ox=0.0676
X2710 BLN9 rr2t2r_0[29|9]/a_460_290# sky130_fd_pr_reram__reram_cell area_ox=0.0676
X2711 rr2t2r_0[29|9]/a_60_290# WL29 SL9 VSS sky130_fd_pr__nfet_g5v0d10v5 ad=0.65 pd=3.3 as=0 ps=0 w=1 l=0.5
X2712 rr2t2r_0[30|9]/a_460_290# WL30 SL9 VSS sky130_fd_pr__nfet_g5v0d10v5 ad=0.65 pd=3.3 as=0 ps=0 w=1 l=0.5
X2713 BLP9 rr2t2r_0[30|9]/a_60_290# sky130_fd_pr_reram__reram_cell area_ox=0.0676
X2714 BLN9 rr2t2r_0[30|9]/a_460_290# sky130_fd_pr_reram__reram_cell area_ox=0.0676
X2715 rr2t2r_0[30|9]/a_60_290# WL30 SL9 VSS sky130_fd_pr__nfet_g5v0d10v5 ad=0.65 pd=3.3 as=0 ps=0 w=1 l=0.5
X2716 rr2t2r_0[31|9]/a_460_290# WL31 SL9 VSS sky130_fd_pr__nfet_g5v0d10v5 ad=0.65 pd=3.3 as=0 ps=0 w=1 l=0.5
X2717 BLP9 rr2t2r_0[31|9]/a_60_290# sky130_fd_pr_reram__reram_cell area_ox=0.0676
X2718 BLN9 rr2t2r_0[31|9]/a_460_290# sky130_fd_pr_reram__reram_cell area_ox=0.0676
X2719 rr2t2r_0[31|9]/a_60_290# WL31 SL9 VSS sky130_fd_pr__nfet_g5v0d10v5 ad=0.65 pd=3.3 as=0 ps=0 w=1 l=0.5
X2720 rr2t2r_0[32|9]/a_460_290# WL32 SL9 VSS sky130_fd_pr__nfet_g5v0d10v5 ad=0.65 pd=3.3 as=0 ps=0 w=1 l=0.5
X2721 BLP9 rr2t2r_0[32|9]/a_60_290# sky130_fd_pr_reram__reram_cell area_ox=0.0676
X2722 BLN9 rr2t2r_0[32|9]/a_460_290# sky130_fd_pr_reram__reram_cell area_ox=0.0676
X2723 rr2t2r_0[32|9]/a_60_290# WL32 SL9 VSS sky130_fd_pr__nfet_g5v0d10v5 ad=0.65 pd=3.3 as=0 ps=0 w=1 l=0.5
X2724 rr2t2r_0[33|9]/a_460_290# WL33 SL9 VSS sky130_fd_pr__nfet_g5v0d10v5 ad=0.65 pd=3.3 as=0 ps=0 w=1 l=0.5
X2725 BLP9 rr2t2r_0[33|9]/a_60_290# sky130_fd_pr_reram__reram_cell area_ox=0.0676
X2726 BLN9 rr2t2r_0[33|9]/a_460_290# sky130_fd_pr_reram__reram_cell area_ox=0.0676
X2727 rr2t2r_0[33|9]/a_60_290# WL33 SL9 VSS sky130_fd_pr__nfet_g5v0d10v5 ad=0.65 pd=3.3 as=0 ps=0 w=1 l=0.5
X2728 rr2t2r_0[34|9]/a_460_290# WL34 SL9 VSS sky130_fd_pr__nfet_g5v0d10v5 ad=0.65 pd=3.3 as=0 ps=0 w=1 l=0.5
X2729 BLP9 rr2t2r_0[34|9]/a_60_290# sky130_fd_pr_reram__reram_cell area_ox=0.0676
X2730 BLN9 rr2t2r_0[34|9]/a_460_290# sky130_fd_pr_reram__reram_cell area_ox=0.0676
X2731 rr2t2r_0[34|9]/a_60_290# WL34 SL9 VSS sky130_fd_pr__nfet_g5v0d10v5 ad=0.65 pd=3.3 as=0 ps=0 w=1 l=0.5
X2732 rr2t2r_0[35|9]/a_460_290# WL35 SL9 VSS sky130_fd_pr__nfet_g5v0d10v5 ad=0.65 pd=3.3 as=0 ps=0 w=1 l=0.5
X2733 BLP9 rr2t2r_0[35|9]/a_60_290# sky130_fd_pr_reram__reram_cell area_ox=0.0676
X2734 BLN9 rr2t2r_0[35|9]/a_460_290# sky130_fd_pr_reram__reram_cell area_ox=0.0676
X2735 rr2t2r_0[35|9]/a_60_290# WL35 SL9 VSS sky130_fd_pr__nfet_g5v0d10v5 ad=0.65 pd=3.3 as=0 ps=0 w=1 l=0.5
X2736 rr2t2r_0[36|9]/a_460_290# WL36 SL9 VSS sky130_fd_pr__nfet_g5v0d10v5 ad=0.65 pd=3.3 as=0 ps=0 w=1 l=0.5
X2737 BLP9 rr2t2r_0[36|9]/a_60_290# sky130_fd_pr_reram__reram_cell area_ox=0.0676
X2738 BLN9 rr2t2r_0[36|9]/a_460_290# sky130_fd_pr_reram__reram_cell area_ox=0.0676
X2739 rr2t2r_0[36|9]/a_60_290# WL36 SL9 VSS sky130_fd_pr__nfet_g5v0d10v5 ad=0.65 pd=3.3 as=0 ps=0 w=1 l=0.5
X2740 rr2t2r_0[37|9]/a_460_290# WL37 SL9 VSS sky130_fd_pr__nfet_g5v0d10v5 ad=0.65 pd=3.3 as=0 ps=0 w=1 l=0.5
X2741 BLP9 rr2t2r_0[37|9]/a_60_290# sky130_fd_pr_reram__reram_cell area_ox=0.0676
X2742 BLN9 rr2t2r_0[37|9]/a_460_290# sky130_fd_pr_reram__reram_cell area_ox=0.0676
X2743 rr2t2r_0[37|9]/a_60_290# WL37 SL9 VSS sky130_fd_pr__nfet_g5v0d10v5 ad=0.65 pd=3.3 as=0 ps=0 w=1 l=0.5
X2744 rr2t2r_0[38|9]/a_460_290# WL38 SL9 VSS sky130_fd_pr__nfet_g5v0d10v5 ad=0.65 pd=3.3 as=0 ps=0 w=1 l=0.5
X2745 BLP9 rr2t2r_0[38|9]/a_60_290# sky130_fd_pr_reram__reram_cell area_ox=0.0676
X2746 BLN9 rr2t2r_0[38|9]/a_460_290# sky130_fd_pr_reram__reram_cell area_ox=0.0676
X2747 rr2t2r_0[38|9]/a_60_290# WL38 SL9 VSS sky130_fd_pr__nfet_g5v0d10v5 ad=0.65 pd=3.3 as=0 ps=0 w=1 l=0.5
X2748 rr2t2r_0[39|9]/a_460_290# WL39 SL9 VSS sky130_fd_pr__nfet_g5v0d10v5 ad=0.65 pd=3.3 as=0 ps=0 w=1 l=0.5
X2749 BLP9 rr2t2r_0[39|9]/a_60_290# sky130_fd_pr_reram__reram_cell area_ox=0.0676
X2750 BLN9 rr2t2r_0[39|9]/a_460_290# sky130_fd_pr_reram__reram_cell area_ox=0.0676
X2751 rr2t2r_0[39|9]/a_60_290# WL39 SL9 VSS sky130_fd_pr__nfet_g5v0d10v5 ad=0.65 pd=3.3 as=0 ps=0 w=1 l=0.5
X2752 rr2t2r_0[40|9]/a_460_290# WL40 SL9 VSS sky130_fd_pr__nfet_g5v0d10v5 ad=0.65 pd=3.3 as=0 ps=0 w=1 l=0.5
X2753 BLP9 rr2t2r_0[40|9]/a_60_290# sky130_fd_pr_reram__reram_cell area_ox=0.0676
X2754 BLN9 rr2t2r_0[40|9]/a_460_290# sky130_fd_pr_reram__reram_cell area_ox=0.0676
X2755 rr2t2r_0[40|9]/a_60_290# WL40 SL9 VSS sky130_fd_pr__nfet_g5v0d10v5 ad=0.65 pd=3.3 as=0 ps=0 w=1 l=0.5
X2756 rr2t2r_0[41|9]/a_460_290# WL41 SL9 VSS sky130_fd_pr__nfet_g5v0d10v5 ad=0.65 pd=3.3 as=0 ps=0 w=1 l=0.5
X2757 BLP9 rr2t2r_0[41|9]/a_60_290# sky130_fd_pr_reram__reram_cell area_ox=0.0676
X2758 BLN9 rr2t2r_0[41|9]/a_460_290# sky130_fd_pr_reram__reram_cell area_ox=0.0676
X2759 rr2t2r_0[41|9]/a_60_290# WL41 SL9 VSS sky130_fd_pr__nfet_g5v0d10v5 ad=0.65 pd=3.3 as=0 ps=0 w=1 l=0.5
X2760 rr2t2r_0[42|9]/a_460_290# WL42 SL9 VSS sky130_fd_pr__nfet_g5v0d10v5 ad=0.65 pd=3.3 as=0 ps=0 w=1 l=0.5
X2761 BLP9 rr2t2r_0[42|9]/a_60_290# sky130_fd_pr_reram__reram_cell area_ox=0.0676
X2762 BLN9 rr2t2r_0[42|9]/a_460_290# sky130_fd_pr_reram__reram_cell area_ox=0.0676
X2763 rr2t2r_0[42|9]/a_60_290# WL42 SL9 VSS sky130_fd_pr__nfet_g5v0d10v5 ad=0.65 pd=3.3 as=0 ps=0 w=1 l=0.5
X2764 rr2t2r_0[43|9]/a_460_290# WL43 SL9 VSS sky130_fd_pr__nfet_g5v0d10v5 ad=0.65 pd=3.3 as=0 ps=0 w=1 l=0.5
X2765 BLP9 rr2t2r_0[43|9]/a_60_290# sky130_fd_pr_reram__reram_cell area_ox=0.0676
X2766 BLN9 rr2t2r_0[43|9]/a_460_290# sky130_fd_pr_reram__reram_cell area_ox=0.0676
X2767 rr2t2r_0[43|9]/a_60_290# WL43 SL9 VSS sky130_fd_pr__nfet_g5v0d10v5 ad=0.65 pd=3.3 as=0 ps=0 w=1 l=0.5
X2768 rr2t2r_0[44|9]/a_460_290# WL44 SL9 VSS sky130_fd_pr__nfet_g5v0d10v5 ad=0.65 pd=3.3 as=0 ps=0 w=1 l=0.5
X2769 BLP9 rr2t2r_0[44|9]/a_60_290# sky130_fd_pr_reram__reram_cell area_ox=0.0676
X2770 BLN9 rr2t2r_0[44|9]/a_460_290# sky130_fd_pr_reram__reram_cell area_ox=0.0676
X2771 rr2t2r_0[44|9]/a_60_290# WL44 SL9 VSS sky130_fd_pr__nfet_g5v0d10v5 ad=0.65 pd=3.3 as=0 ps=0 w=1 l=0.5
X2772 rr2t2r_0[45|9]/a_460_290# WL45 SL9 VSS sky130_fd_pr__nfet_g5v0d10v5 ad=0.65 pd=3.3 as=0 ps=0 w=1 l=0.5
X2773 BLP9 rr2t2r_0[45|9]/a_60_290# sky130_fd_pr_reram__reram_cell area_ox=0.0676
X2774 BLN9 rr2t2r_0[45|9]/a_460_290# sky130_fd_pr_reram__reram_cell area_ox=0.0676
X2775 rr2t2r_0[45|9]/a_60_290# WL45 SL9 VSS sky130_fd_pr__nfet_g5v0d10v5 ad=0.65 pd=3.3 as=0 ps=0 w=1 l=0.5
X2776 rr2t2r_0[46|9]/a_460_290# WL46 SL9 VSS sky130_fd_pr__nfet_g5v0d10v5 ad=0.65 pd=3.3 as=0 ps=0 w=1 l=0.5
X2777 BLP9 rr2t2r_0[46|9]/a_60_290# sky130_fd_pr_reram__reram_cell area_ox=0.0676
X2778 BLN9 rr2t2r_0[46|9]/a_460_290# sky130_fd_pr_reram__reram_cell area_ox=0.0676
X2779 rr2t2r_0[46|9]/a_60_290# WL46 SL9 VSS sky130_fd_pr__nfet_g5v0d10v5 ad=0.65 pd=3.3 as=0 ps=0 w=1 l=0.5
X2780 rr2t2r_0[47|9]/a_460_290# WL47 SL9 VSS sky130_fd_pr__nfet_g5v0d10v5 ad=0.65 pd=3.3 as=0 ps=0 w=1 l=0.5
X2781 BLP9 rr2t2r_0[47|9]/a_60_290# sky130_fd_pr_reram__reram_cell area_ox=0.0676
X2782 BLN9 rr2t2r_0[47|9]/a_460_290# sky130_fd_pr_reram__reram_cell area_ox=0.0676
X2783 rr2t2r_0[47|9]/a_60_290# WL47 SL9 VSS sky130_fd_pr__nfet_g5v0d10v5 ad=0.65 pd=3.3 as=0 ps=0 w=1 l=0.5
X2784 rr2t2r_0[48|9]/a_460_290# WL48 SL9 VSS sky130_fd_pr__nfet_g5v0d10v5 ad=0.65 pd=3.3 as=0 ps=0 w=1 l=0.5
X2785 BLP9 rr2t2r_0[48|9]/a_60_290# sky130_fd_pr_reram__reram_cell area_ox=0.0676
X2786 BLN9 rr2t2r_0[48|9]/a_460_290# sky130_fd_pr_reram__reram_cell area_ox=0.0676
X2787 rr2t2r_0[48|9]/a_60_290# WL48 SL9 VSS sky130_fd_pr__nfet_g5v0d10v5 ad=0.65 pd=3.3 as=0 ps=0 w=1 l=0.5
X2788 rr2t2r_0[49|9]/a_460_290# WL49 SL9 VSS sky130_fd_pr__nfet_g5v0d10v5 ad=0.65 pd=3.3 as=0 ps=0 w=1 l=0.5
X2789 BLP9 rr2t2r_0[49|9]/a_60_290# sky130_fd_pr_reram__reram_cell area_ox=0.0676
X2790 BLN9 rr2t2r_0[49|9]/a_460_290# sky130_fd_pr_reram__reram_cell area_ox=0.0676
X2791 rr2t2r_0[49|9]/a_60_290# WL49 SL9 VSS sky130_fd_pr__nfet_g5v0d10v5 ad=0.65 pd=3.3 as=0 ps=0 w=1 l=0.5
X2792 rr2t2r_0[50|9]/a_460_290# WL50 SL9 VSS sky130_fd_pr__nfet_g5v0d10v5 ad=0.65 pd=3.3 as=0 ps=0 w=1 l=0.5
X2793 BLP9 rr2t2r_0[50|9]/a_60_290# sky130_fd_pr_reram__reram_cell area_ox=0.0676
X2794 BLN9 rr2t2r_0[50|9]/a_460_290# sky130_fd_pr_reram__reram_cell area_ox=0.0676
X2795 rr2t2r_0[50|9]/a_60_290# WL50 SL9 VSS sky130_fd_pr__nfet_g5v0d10v5 ad=0.65 pd=3.3 as=0 ps=0 w=1 l=0.5
X2796 rr2t2r_0[51|9]/a_460_290# WL51 SL9 VSS sky130_fd_pr__nfet_g5v0d10v5 ad=0.65 pd=3.3 as=0 ps=0 w=1 l=0.5
X2797 BLP9 rr2t2r_0[51|9]/a_60_290# sky130_fd_pr_reram__reram_cell area_ox=0.0676
X2798 BLN9 rr2t2r_0[51|9]/a_460_290# sky130_fd_pr_reram__reram_cell area_ox=0.0676
X2799 rr2t2r_0[51|9]/a_60_290# WL51 SL9 VSS sky130_fd_pr__nfet_g5v0d10v5 ad=0.65 pd=3.3 as=0 ps=0 w=1 l=0.5
X2800 rr2t2r_0[52|9]/a_460_290# WL52 SL9 VSS sky130_fd_pr__nfet_g5v0d10v5 ad=0.65 pd=3.3 as=0 ps=0 w=1 l=0.5
X2801 BLP9 rr2t2r_0[52|9]/a_60_290# sky130_fd_pr_reram__reram_cell area_ox=0.0676
X2802 BLN9 rr2t2r_0[52|9]/a_460_290# sky130_fd_pr_reram__reram_cell area_ox=0.0676
X2803 rr2t2r_0[52|9]/a_60_290# WL52 SL9 VSS sky130_fd_pr__nfet_g5v0d10v5 ad=0.65 pd=3.3 as=0 ps=0 w=1 l=0.5
X2804 rr2t2r_0[53|9]/a_460_290# WL53 SL9 VSS sky130_fd_pr__nfet_g5v0d10v5 ad=0.65 pd=3.3 as=0 ps=0 w=1 l=0.5
X2805 BLP9 rr2t2r_0[53|9]/a_60_290# sky130_fd_pr_reram__reram_cell area_ox=0.0676
X2806 BLN9 rr2t2r_0[53|9]/a_460_290# sky130_fd_pr_reram__reram_cell area_ox=0.0676
X2807 rr2t2r_0[53|9]/a_60_290# WL53 SL9 VSS sky130_fd_pr__nfet_g5v0d10v5 ad=0.65 pd=3.3 as=0 ps=0 w=1 l=0.5
X2808 rr2t2r_0[54|9]/a_460_290# WL54 SL9 VSS sky130_fd_pr__nfet_g5v0d10v5 ad=0.65 pd=3.3 as=0 ps=0 w=1 l=0.5
X2809 BLP9 rr2t2r_0[54|9]/a_60_290# sky130_fd_pr_reram__reram_cell area_ox=0.0676
X2810 BLN9 rr2t2r_0[54|9]/a_460_290# sky130_fd_pr_reram__reram_cell area_ox=0.0676
X2811 rr2t2r_0[54|9]/a_60_290# WL54 SL9 VSS sky130_fd_pr__nfet_g5v0d10v5 ad=0.65 pd=3.3 as=0 ps=0 w=1 l=0.5
X2812 rr2t2r_0[55|9]/a_460_290# WL55 SL9 VSS sky130_fd_pr__nfet_g5v0d10v5 ad=0.65 pd=3.3 as=0 ps=0 w=1 l=0.5
X2813 BLP9 rr2t2r_0[55|9]/a_60_290# sky130_fd_pr_reram__reram_cell area_ox=0.0676
X2814 BLN9 rr2t2r_0[55|9]/a_460_290# sky130_fd_pr_reram__reram_cell area_ox=0.0676
X2815 rr2t2r_0[55|9]/a_60_290# WL55 SL9 VSS sky130_fd_pr__nfet_g5v0d10v5 ad=0.65 pd=3.3 as=0 ps=0 w=1 l=0.5
X2816 rr2t2r_0[56|9]/a_460_290# WL56 SL9 VSS sky130_fd_pr__nfet_g5v0d10v5 ad=0.65 pd=3.3 as=0 ps=0 w=1 l=0.5
X2817 BLP9 rr2t2r_0[56|9]/a_60_290# sky130_fd_pr_reram__reram_cell area_ox=0.0676
X2818 BLN9 rr2t2r_0[56|9]/a_460_290# sky130_fd_pr_reram__reram_cell area_ox=0.0676
X2819 rr2t2r_0[56|9]/a_60_290# WL56 SL9 VSS sky130_fd_pr__nfet_g5v0d10v5 ad=0.65 pd=3.3 as=0 ps=0 w=1 l=0.5
X2820 rr2t2r_0[57|9]/a_460_290# WL57 SL9 VSS sky130_fd_pr__nfet_g5v0d10v5 ad=0.65 pd=3.3 as=0 ps=0 w=1 l=0.5
X2821 BLP9 rr2t2r_0[57|9]/a_60_290# sky130_fd_pr_reram__reram_cell area_ox=0.0676
X2822 BLN9 rr2t2r_0[57|9]/a_460_290# sky130_fd_pr_reram__reram_cell area_ox=0.0676
X2823 rr2t2r_0[57|9]/a_60_290# WL57 SL9 VSS sky130_fd_pr__nfet_g5v0d10v5 ad=0.65 pd=3.3 as=0 ps=0 w=1 l=0.5
X2824 rr2t2r_0[58|9]/a_460_290# WL58 SL9 VSS sky130_fd_pr__nfet_g5v0d10v5 ad=0.65 pd=3.3 as=0 ps=0 w=1 l=0.5
X2825 BLP9 rr2t2r_0[58|9]/a_60_290# sky130_fd_pr_reram__reram_cell area_ox=0.0676
X2826 BLN9 rr2t2r_0[58|9]/a_460_290# sky130_fd_pr_reram__reram_cell area_ox=0.0676
X2827 rr2t2r_0[58|9]/a_60_290# WL58 SL9 VSS sky130_fd_pr__nfet_g5v0d10v5 ad=0.65 pd=3.3 as=0 ps=0 w=1 l=0.5
X2828 rr2t2r_0[59|9]/a_460_290# WL59 SL9 VSS sky130_fd_pr__nfet_g5v0d10v5 ad=0.65 pd=3.3 as=0 ps=0 w=1 l=0.5
X2829 BLP9 rr2t2r_0[59|9]/a_60_290# sky130_fd_pr_reram__reram_cell area_ox=0.0676
X2830 BLN9 rr2t2r_0[59|9]/a_460_290# sky130_fd_pr_reram__reram_cell area_ox=0.0676
X2831 rr2t2r_0[59|9]/a_60_290# WL59 SL9 VSS sky130_fd_pr__nfet_g5v0d10v5 ad=0.65 pd=3.3 as=0 ps=0 w=1 l=0.5
X2832 rr2t2r_0[60|9]/a_460_290# WL60 SL9 VSS sky130_fd_pr__nfet_g5v0d10v5 ad=0.65 pd=3.3 as=0 ps=0 w=1 l=0.5
X2833 BLP9 rr2t2r_0[60|9]/a_60_290# sky130_fd_pr_reram__reram_cell area_ox=0.0676
X2834 BLN9 rr2t2r_0[60|9]/a_460_290# sky130_fd_pr_reram__reram_cell area_ox=0.0676
X2835 rr2t2r_0[60|9]/a_60_290# WL60 SL9 VSS sky130_fd_pr__nfet_g5v0d10v5 ad=0.65 pd=3.3 as=0 ps=0 w=1 l=0.5
X2836 rr2t2r_0[61|9]/a_460_290# WL61 SL9 VSS sky130_fd_pr__nfet_g5v0d10v5 ad=0.65 pd=3.3 as=0 ps=0 w=1 l=0.5
X2837 BLP9 rr2t2r_0[61|9]/a_60_290# sky130_fd_pr_reram__reram_cell area_ox=0.0676
X2838 BLN9 rr2t2r_0[61|9]/a_460_290# sky130_fd_pr_reram__reram_cell area_ox=0.0676
X2839 rr2t2r_0[61|9]/a_60_290# WL61 SL9 VSS sky130_fd_pr__nfet_g5v0d10v5 ad=0.65 pd=3.3 as=0 ps=0 w=1 l=0.5
X2840 rr2t2r_0[62|9]/a_460_290# WL62 SL9 VSS sky130_fd_pr__nfet_g5v0d10v5 ad=0.65 pd=3.3 as=0 ps=0 w=1 l=0.5
X2841 BLP9 rr2t2r_0[62|9]/a_60_290# sky130_fd_pr_reram__reram_cell area_ox=0.0676
X2842 BLN9 rr2t2r_0[62|9]/a_460_290# sky130_fd_pr_reram__reram_cell area_ox=0.0676
X2843 rr2t2r_0[62|9]/a_60_290# WL62 SL9 VSS sky130_fd_pr__nfet_g5v0d10v5 ad=0.65 pd=3.3 as=0 ps=0 w=1 l=0.5
X2844 rr2t2r_0[63|9]/a_460_290# WL63 SL9 VSS sky130_fd_pr__nfet_g5v0d10v5 ad=0.65 pd=3.3 as=0 ps=0 w=1 l=0.5
X2845 BLP9 rr2t2r_0[63|9]/a_60_290# sky130_fd_pr_reram__reram_cell area_ox=0.0676
X2846 BLN9 rr2t2r_0[63|9]/a_460_290# sky130_fd_pr_reram__reram_cell area_ox=0.0676
X2847 rr2t2r_0[63|9]/a_60_290# WL63 SL9 VSS sky130_fd_pr__nfet_g5v0d10v5 ad=0.65 pd=3.3 as=0 ps=0 w=1 l=0.5
X2848 rr2t2r_0[64|9]/a_460_290# WL64 SL9 VSS sky130_fd_pr__nfet_g5v0d10v5 ad=0.65 pd=3.3 as=0 ps=0 w=1 l=0.5
X2849 BLP9 rr2t2r_0[64|9]/a_60_290# sky130_fd_pr_reram__reram_cell area_ox=0.0676
X2850 BLN9 rr2t2r_0[64|9]/a_460_290# sky130_fd_pr_reram__reram_cell area_ox=0.0676
X2851 rr2t2r_0[64|9]/a_60_290# WL64 SL9 VSS sky130_fd_pr__nfet_g5v0d10v5 ad=0.65 pd=3.3 as=0 ps=0 w=1 l=0.5
X2852 rr2t2r_0[65|9]/a_460_290# WL65 SL9 VSS sky130_fd_pr__nfet_g5v0d10v5 ad=0.65 pd=3.3 as=0 ps=0 w=1 l=0.5
X2853 BLP9 rr2t2r_0[65|9]/a_60_290# sky130_fd_pr_reram__reram_cell area_ox=0.0676
X2854 BLN9 rr2t2r_0[65|9]/a_460_290# sky130_fd_pr_reram__reram_cell area_ox=0.0676
X2855 rr2t2r_0[65|9]/a_60_290# WL65 SL9 VSS sky130_fd_pr__nfet_g5v0d10v5 ad=0.65 pd=3.3 as=0 ps=0 w=1 l=0.5
X2856 rr2t2r_0[66|9]/a_460_290# WL66 SL9 VSS sky130_fd_pr__nfet_g5v0d10v5 ad=0.65 pd=3.3 as=0 ps=0 w=1 l=0.5
X2857 BLP9 rr2t2r_0[66|9]/a_60_290# sky130_fd_pr_reram__reram_cell area_ox=0.0676
X2858 BLN9 rr2t2r_0[66|9]/a_460_290# sky130_fd_pr_reram__reram_cell area_ox=0.0676
X2859 rr2t2r_0[66|9]/a_60_290# WL66 SL9 VSS sky130_fd_pr__nfet_g5v0d10v5 ad=0.65 pd=3.3 as=0 ps=0 w=1 l=0.5
X2860 rr2t2r_0[67|9]/a_460_290# WL67 SL9 VSS sky130_fd_pr__nfet_g5v0d10v5 ad=0.65 pd=3.3 as=0 ps=0 w=1 l=0.5
X2861 BLP9 rr2t2r_0[67|9]/a_60_290# sky130_fd_pr_reram__reram_cell area_ox=0.0676
X2862 BLN9 rr2t2r_0[67|9]/a_460_290# sky130_fd_pr_reram__reram_cell area_ox=0.0676
X2863 rr2t2r_0[67|9]/a_60_290# WL67 SL9 VSS sky130_fd_pr__nfet_g5v0d10v5 ad=0.65 pd=3.3 as=0 ps=0 w=1 l=0.5
X2864 rr2t2r_0[68|9]/a_460_290# WL68 SL9 VSS sky130_fd_pr__nfet_g5v0d10v5 ad=0.65 pd=3.3 as=0 ps=0 w=1 l=0.5
X2865 BLP9 rr2t2r_0[68|9]/a_60_290# sky130_fd_pr_reram__reram_cell area_ox=0.0676
X2866 BLN9 rr2t2r_0[68|9]/a_460_290# sky130_fd_pr_reram__reram_cell area_ox=0.0676
X2867 rr2t2r_0[68|9]/a_60_290# WL68 SL9 VSS sky130_fd_pr__nfet_g5v0d10v5 ad=0.65 pd=3.3 as=0 ps=0 w=1 l=0.5
X2868 rr2t2r_0[69|9]/a_460_290# WL69 SL9 VSS sky130_fd_pr__nfet_g5v0d10v5 ad=0.65 pd=3.3 as=0 ps=0 w=1 l=0.5
X2869 BLP9 rr2t2r_0[69|9]/a_60_290# sky130_fd_pr_reram__reram_cell area_ox=0.0676
X2870 BLN9 rr2t2r_0[69|9]/a_460_290# sky130_fd_pr_reram__reram_cell area_ox=0.0676
X2871 rr2t2r_0[69|9]/a_60_290# WL69 SL9 VSS sky130_fd_pr__nfet_g5v0d10v5 ad=0.65 pd=3.3 as=0 ps=0 w=1 l=0.5
X2872 rr2t2r_0[70|9]/a_460_290# WL70 SL9 VSS sky130_fd_pr__nfet_g5v0d10v5 ad=0.65 pd=3.3 as=0 ps=0 w=1 l=0.5
X2873 BLP9 rr2t2r_0[70|9]/a_60_290# sky130_fd_pr_reram__reram_cell area_ox=0.0676
X2874 BLN9 rr2t2r_0[70|9]/a_460_290# sky130_fd_pr_reram__reram_cell area_ox=0.0676
X2875 rr2t2r_0[70|9]/a_60_290# WL70 SL9 VSS sky130_fd_pr__nfet_g5v0d10v5 ad=0.65 pd=3.3 as=0 ps=0 w=1 l=0.5
X2876 rr2t2r_0[71|9]/a_460_290# WL71 SL9 VSS sky130_fd_pr__nfet_g5v0d10v5 ad=0.65 pd=3.3 as=0 ps=0 w=1 l=0.5
X2877 BLP9 rr2t2r_0[71|9]/a_60_290# sky130_fd_pr_reram__reram_cell area_ox=0.0676
X2878 BLN9 rr2t2r_0[71|9]/a_460_290# sky130_fd_pr_reram__reram_cell area_ox=0.0676
X2879 rr2t2r_0[71|9]/a_60_290# WL71 SL9 VSS sky130_fd_pr__nfet_g5v0d10v5 ad=0.65 pd=3.3 as=0 ps=0 w=1 l=0.5
X2880 rr2t2r_0[0|10]/a_460_290# WL0 SL10 VSS sky130_fd_pr__nfet_g5v0d10v5 ad=0.65 pd=3.3 as=108 ps=504 w=1 l=0.5
X2881 BLP10 rr2t2r_0[0|10]/a_60_290# sky130_fd_pr_reram__reram_cell area_ox=0.0676
X2882 BLN10 rr2t2r_0[0|10]/a_460_290# sky130_fd_pr_reram__reram_cell area_ox=0.0676
X2883 rr2t2r_0[0|10]/a_60_290# WL0 SL10 VSS sky130_fd_pr__nfet_g5v0d10v5 ad=0.65 pd=3.3 as=0 ps=0 w=1 l=0.5
X2884 rr2t2r_0[1|10]/a_460_290# WL1 SL10 VSS sky130_fd_pr__nfet_g5v0d10v5 ad=0.65 pd=3.3 as=0 ps=0 w=1 l=0.5
X2885 BLP10 rr2t2r_0[1|10]/a_60_290# sky130_fd_pr_reram__reram_cell area_ox=0.0676
X2886 BLN10 rr2t2r_0[1|10]/a_460_290# sky130_fd_pr_reram__reram_cell area_ox=0.0676
X2887 rr2t2r_0[1|10]/a_60_290# WL1 SL10 VSS sky130_fd_pr__nfet_g5v0d10v5 ad=0.65 pd=3.3 as=0 ps=0 w=1 l=0.5
X2888 rr2t2r_0[2|10]/a_460_290# WL2 SL10 VSS sky130_fd_pr__nfet_g5v0d10v5 ad=0.65 pd=3.3 as=0 ps=0 w=1 l=0.5
X2889 BLP10 rr2t2r_0[2|10]/a_60_290# sky130_fd_pr_reram__reram_cell area_ox=0.0676
X2890 BLN10 rr2t2r_0[2|10]/a_460_290# sky130_fd_pr_reram__reram_cell area_ox=0.0676
X2891 rr2t2r_0[2|10]/a_60_290# WL2 SL10 VSS sky130_fd_pr__nfet_g5v0d10v5 ad=0.65 pd=3.3 as=0 ps=0 w=1 l=0.5
X2892 rr2t2r_0[3|10]/a_460_290# WL3 SL10 VSS sky130_fd_pr__nfet_g5v0d10v5 ad=0.65 pd=3.3 as=0 ps=0 w=1 l=0.5
X2893 BLP10 rr2t2r_0[3|10]/a_60_290# sky130_fd_pr_reram__reram_cell area_ox=0.0676
X2894 BLN10 rr2t2r_0[3|10]/a_460_290# sky130_fd_pr_reram__reram_cell area_ox=0.0676
X2895 rr2t2r_0[3|10]/a_60_290# WL3 SL10 VSS sky130_fd_pr__nfet_g5v0d10v5 ad=0.65 pd=3.3 as=0 ps=0 w=1 l=0.5
X2896 rr2t2r_0[4|10]/a_460_290# WL4 SL10 VSS sky130_fd_pr__nfet_g5v0d10v5 ad=0.65 pd=3.3 as=0 ps=0 w=1 l=0.5
X2897 BLP10 rr2t2r_0[4|10]/a_60_290# sky130_fd_pr_reram__reram_cell area_ox=0.0676
X2898 BLN10 rr2t2r_0[4|10]/a_460_290# sky130_fd_pr_reram__reram_cell area_ox=0.0676
X2899 rr2t2r_0[4|10]/a_60_290# WL4 SL10 VSS sky130_fd_pr__nfet_g5v0d10v5 ad=0.65 pd=3.3 as=0 ps=0 w=1 l=0.5
X2900 rr2t2r_0[5|10]/a_460_290# WL5 SL10 VSS sky130_fd_pr__nfet_g5v0d10v5 ad=0.65 pd=3.3 as=0 ps=0 w=1 l=0.5
X2901 BLP10 rr2t2r_0[5|10]/a_60_290# sky130_fd_pr_reram__reram_cell area_ox=0.0676
X2902 BLN10 rr2t2r_0[5|10]/a_460_290# sky130_fd_pr_reram__reram_cell area_ox=0.0676
X2903 rr2t2r_0[5|10]/a_60_290# WL5 SL10 VSS sky130_fd_pr__nfet_g5v0d10v5 ad=0.65 pd=3.3 as=0 ps=0 w=1 l=0.5
X2904 rr2t2r_0[6|10]/a_460_290# WL6 SL10 VSS sky130_fd_pr__nfet_g5v0d10v5 ad=0.65 pd=3.3 as=0 ps=0 w=1 l=0.5
X2905 BLP10 rr2t2r_0[6|10]/a_60_290# sky130_fd_pr_reram__reram_cell area_ox=0.0676
X2906 BLN10 rr2t2r_0[6|10]/a_460_290# sky130_fd_pr_reram__reram_cell area_ox=0.0676
X2907 rr2t2r_0[6|10]/a_60_290# WL6 SL10 VSS sky130_fd_pr__nfet_g5v0d10v5 ad=0.65 pd=3.3 as=0 ps=0 w=1 l=0.5
X2908 rr2t2r_0[7|10]/a_460_290# WL7 SL10 VSS sky130_fd_pr__nfet_g5v0d10v5 ad=0.65 pd=3.3 as=0 ps=0 w=1 l=0.5
X2909 BLP10 rr2t2r_0[7|10]/a_60_290# sky130_fd_pr_reram__reram_cell area_ox=0.0676
X2910 BLN10 rr2t2r_0[7|10]/a_460_290# sky130_fd_pr_reram__reram_cell area_ox=0.0676
X2911 rr2t2r_0[7|10]/a_60_290# WL7 SL10 VSS sky130_fd_pr__nfet_g5v0d10v5 ad=0.65 pd=3.3 as=0 ps=0 w=1 l=0.5
X2912 rr2t2r_0[8|10]/a_460_290# WL8 SL10 VSS sky130_fd_pr__nfet_g5v0d10v5 ad=0.65 pd=3.3 as=0 ps=0 w=1 l=0.5
X2913 BLP10 rr2t2r_0[8|10]/a_60_290# sky130_fd_pr_reram__reram_cell area_ox=0.0676
X2914 BLN10 rr2t2r_0[8|10]/a_460_290# sky130_fd_pr_reram__reram_cell area_ox=0.0676
X2915 rr2t2r_0[8|10]/a_60_290# WL8 SL10 VSS sky130_fd_pr__nfet_g5v0d10v5 ad=0.65 pd=3.3 as=0 ps=0 w=1 l=0.5
X2916 rr2t2r_0[9|10]/a_460_290# WL9 SL10 VSS sky130_fd_pr__nfet_g5v0d10v5 ad=0.65 pd=3.3 as=0 ps=0 w=1 l=0.5
X2917 BLP10 rr2t2r_0[9|10]/a_60_290# sky130_fd_pr_reram__reram_cell area_ox=0.0676
X2918 BLN10 rr2t2r_0[9|10]/a_460_290# sky130_fd_pr_reram__reram_cell area_ox=0.0676
X2919 rr2t2r_0[9|10]/a_60_290# WL9 SL10 VSS sky130_fd_pr__nfet_g5v0d10v5 ad=0.65 pd=3.3 as=0 ps=0 w=1 l=0.5
X2920 rr2t2r_0[10|10]/a_460_290# WL10 SL10 VSS sky130_fd_pr__nfet_g5v0d10v5 ad=0.65 pd=3.3 as=0 ps=0 w=1 l=0.5
X2921 BLP10 rr2t2r_0[10|10]/a_60_290# sky130_fd_pr_reram__reram_cell area_ox=0.0676
X2922 BLN10 rr2t2r_0[10|10]/a_460_290# sky130_fd_pr_reram__reram_cell area_ox=0.0676
X2923 rr2t2r_0[10|10]/a_60_290# WL10 SL10 VSS sky130_fd_pr__nfet_g5v0d10v5 ad=0.65 pd=3.3 as=0 ps=0 w=1 l=0.5
X2924 rr2t2r_0[11|10]/a_460_290# WL11 SL10 VSS sky130_fd_pr__nfet_g5v0d10v5 ad=0.65 pd=3.3 as=0 ps=0 w=1 l=0.5
X2925 BLP10 rr2t2r_0[11|10]/a_60_290# sky130_fd_pr_reram__reram_cell area_ox=0.0676
X2926 BLN10 rr2t2r_0[11|10]/a_460_290# sky130_fd_pr_reram__reram_cell area_ox=0.0676
X2927 rr2t2r_0[11|10]/a_60_290# WL11 SL10 VSS sky130_fd_pr__nfet_g5v0d10v5 ad=0.65 pd=3.3 as=0 ps=0 w=1 l=0.5
X2928 rr2t2r_0[12|10]/a_460_290# WL12 SL10 VSS sky130_fd_pr__nfet_g5v0d10v5 ad=0.65 pd=3.3 as=0 ps=0 w=1 l=0.5
X2929 BLP10 rr2t2r_0[12|10]/a_60_290# sky130_fd_pr_reram__reram_cell area_ox=0.0676
X2930 BLN10 rr2t2r_0[12|10]/a_460_290# sky130_fd_pr_reram__reram_cell area_ox=0.0676
X2931 rr2t2r_0[12|10]/a_60_290# WL12 SL10 VSS sky130_fd_pr__nfet_g5v0d10v5 ad=0.65 pd=3.3 as=0 ps=0 w=1 l=0.5
X2932 rr2t2r_0[13|10]/a_460_290# WL13 SL10 VSS sky130_fd_pr__nfet_g5v0d10v5 ad=0.65 pd=3.3 as=0 ps=0 w=1 l=0.5
X2933 BLP10 rr2t2r_0[13|10]/a_60_290# sky130_fd_pr_reram__reram_cell area_ox=0.0676
X2934 BLN10 rr2t2r_0[13|10]/a_460_290# sky130_fd_pr_reram__reram_cell area_ox=0.0676
X2935 rr2t2r_0[13|10]/a_60_290# WL13 SL10 VSS sky130_fd_pr__nfet_g5v0d10v5 ad=0.65 pd=3.3 as=0 ps=0 w=1 l=0.5
X2936 rr2t2r_0[14|10]/a_460_290# WL14 SL10 VSS sky130_fd_pr__nfet_g5v0d10v5 ad=0.65 pd=3.3 as=0 ps=0 w=1 l=0.5
X2937 BLP10 rr2t2r_0[14|10]/a_60_290# sky130_fd_pr_reram__reram_cell area_ox=0.0676
X2938 BLN10 rr2t2r_0[14|10]/a_460_290# sky130_fd_pr_reram__reram_cell area_ox=0.0676
X2939 rr2t2r_0[14|10]/a_60_290# WL14 SL10 VSS sky130_fd_pr__nfet_g5v0d10v5 ad=0.65 pd=3.3 as=0 ps=0 w=1 l=0.5
X2940 rr2t2r_0[15|10]/a_460_290# WL15 SL10 VSS sky130_fd_pr__nfet_g5v0d10v5 ad=0.65 pd=3.3 as=0 ps=0 w=1 l=0.5
X2941 BLP10 rr2t2r_0[15|10]/a_60_290# sky130_fd_pr_reram__reram_cell area_ox=0.0676
X2942 BLN10 rr2t2r_0[15|10]/a_460_290# sky130_fd_pr_reram__reram_cell area_ox=0.0676
X2943 rr2t2r_0[15|10]/a_60_290# WL15 SL10 VSS sky130_fd_pr__nfet_g5v0d10v5 ad=0.65 pd=3.3 as=0 ps=0 w=1 l=0.5
X2944 rr2t2r_0[16|10]/a_460_290# WL16 SL10 VSS sky130_fd_pr__nfet_g5v0d10v5 ad=0.65 pd=3.3 as=0 ps=0 w=1 l=0.5
X2945 BLP10 rr2t2r_0[16|10]/a_60_290# sky130_fd_pr_reram__reram_cell area_ox=0.0676
X2946 BLN10 rr2t2r_0[16|10]/a_460_290# sky130_fd_pr_reram__reram_cell area_ox=0.0676
X2947 rr2t2r_0[16|10]/a_60_290# WL16 SL10 VSS sky130_fd_pr__nfet_g5v0d10v5 ad=0.65 pd=3.3 as=0 ps=0 w=1 l=0.5
X2948 rr2t2r_0[17|10]/a_460_290# WL17 SL10 VSS sky130_fd_pr__nfet_g5v0d10v5 ad=0.65 pd=3.3 as=0 ps=0 w=1 l=0.5
X2949 BLP10 rr2t2r_0[17|10]/a_60_290# sky130_fd_pr_reram__reram_cell area_ox=0.0676
X2950 BLN10 rr2t2r_0[17|10]/a_460_290# sky130_fd_pr_reram__reram_cell area_ox=0.0676
X2951 rr2t2r_0[17|10]/a_60_290# WL17 SL10 VSS sky130_fd_pr__nfet_g5v0d10v5 ad=0.65 pd=3.3 as=0 ps=0 w=1 l=0.5
X2952 rr2t2r_0[18|10]/a_460_290# WL18 SL10 VSS sky130_fd_pr__nfet_g5v0d10v5 ad=0.65 pd=3.3 as=0 ps=0 w=1 l=0.5
X2953 BLP10 rr2t2r_0[18|10]/a_60_290# sky130_fd_pr_reram__reram_cell area_ox=0.0676
X2954 BLN10 rr2t2r_0[18|10]/a_460_290# sky130_fd_pr_reram__reram_cell area_ox=0.0676
X2955 rr2t2r_0[18|10]/a_60_290# WL18 SL10 VSS sky130_fd_pr__nfet_g5v0d10v5 ad=0.65 pd=3.3 as=0 ps=0 w=1 l=0.5
X2956 rr2t2r_0[19|10]/a_460_290# WL19 SL10 VSS sky130_fd_pr__nfet_g5v0d10v5 ad=0.65 pd=3.3 as=0 ps=0 w=1 l=0.5
X2957 BLP10 rr2t2r_0[19|10]/a_60_290# sky130_fd_pr_reram__reram_cell area_ox=0.0676
X2958 BLN10 rr2t2r_0[19|10]/a_460_290# sky130_fd_pr_reram__reram_cell area_ox=0.0676
X2959 rr2t2r_0[19|10]/a_60_290# WL19 SL10 VSS sky130_fd_pr__nfet_g5v0d10v5 ad=0.65 pd=3.3 as=0 ps=0 w=1 l=0.5
X2960 rr2t2r_0[20|10]/a_460_290# WL20 SL10 VSS sky130_fd_pr__nfet_g5v0d10v5 ad=0.65 pd=3.3 as=0 ps=0 w=1 l=0.5
X2961 BLP10 rr2t2r_0[20|10]/a_60_290# sky130_fd_pr_reram__reram_cell area_ox=0.0676
X2962 BLN10 rr2t2r_0[20|10]/a_460_290# sky130_fd_pr_reram__reram_cell area_ox=0.0676
X2963 rr2t2r_0[20|10]/a_60_290# WL20 SL10 VSS sky130_fd_pr__nfet_g5v0d10v5 ad=0.65 pd=3.3 as=0 ps=0 w=1 l=0.5
X2964 rr2t2r_0[21|10]/a_460_290# WL21 SL10 VSS sky130_fd_pr__nfet_g5v0d10v5 ad=0.65 pd=3.3 as=0 ps=0 w=1 l=0.5
X2965 BLP10 rr2t2r_0[21|10]/a_60_290# sky130_fd_pr_reram__reram_cell area_ox=0.0676
X2966 BLN10 rr2t2r_0[21|10]/a_460_290# sky130_fd_pr_reram__reram_cell area_ox=0.0676
X2967 rr2t2r_0[21|10]/a_60_290# WL21 SL10 VSS sky130_fd_pr__nfet_g5v0d10v5 ad=0.65 pd=3.3 as=0 ps=0 w=1 l=0.5
X2968 rr2t2r_0[22|10]/a_460_290# WL22 SL10 VSS sky130_fd_pr__nfet_g5v0d10v5 ad=0.65 pd=3.3 as=0 ps=0 w=1 l=0.5
X2969 BLP10 rr2t2r_0[22|10]/a_60_290# sky130_fd_pr_reram__reram_cell area_ox=0.0676
X2970 BLN10 rr2t2r_0[22|10]/a_460_290# sky130_fd_pr_reram__reram_cell area_ox=0.0676
X2971 rr2t2r_0[22|10]/a_60_290# WL22 SL10 VSS sky130_fd_pr__nfet_g5v0d10v5 ad=0.65 pd=3.3 as=0 ps=0 w=1 l=0.5
X2972 rr2t2r_0[23|10]/a_460_290# WL23 SL10 VSS sky130_fd_pr__nfet_g5v0d10v5 ad=0.65 pd=3.3 as=0 ps=0 w=1 l=0.5
X2973 BLP10 rr2t2r_0[23|10]/a_60_290# sky130_fd_pr_reram__reram_cell area_ox=0.0676
X2974 BLN10 rr2t2r_0[23|10]/a_460_290# sky130_fd_pr_reram__reram_cell area_ox=0.0676
X2975 rr2t2r_0[23|10]/a_60_290# WL23 SL10 VSS sky130_fd_pr__nfet_g5v0d10v5 ad=0.65 pd=3.3 as=0 ps=0 w=1 l=0.5
X2976 rr2t2r_0[24|10]/a_460_290# WL24 SL10 VSS sky130_fd_pr__nfet_g5v0d10v5 ad=0.65 pd=3.3 as=0 ps=0 w=1 l=0.5
X2977 BLP10 rr2t2r_0[24|10]/a_60_290# sky130_fd_pr_reram__reram_cell area_ox=0.0676
X2978 BLN10 rr2t2r_0[24|10]/a_460_290# sky130_fd_pr_reram__reram_cell area_ox=0.0676
X2979 rr2t2r_0[24|10]/a_60_290# WL24 SL10 VSS sky130_fd_pr__nfet_g5v0d10v5 ad=0.65 pd=3.3 as=0 ps=0 w=1 l=0.5
X2980 rr2t2r_0[25|10]/a_460_290# WL25 SL10 VSS sky130_fd_pr__nfet_g5v0d10v5 ad=0.65 pd=3.3 as=0 ps=0 w=1 l=0.5
X2981 BLP10 rr2t2r_0[25|10]/a_60_290# sky130_fd_pr_reram__reram_cell area_ox=0.0676
X2982 BLN10 rr2t2r_0[25|10]/a_460_290# sky130_fd_pr_reram__reram_cell area_ox=0.0676
X2983 rr2t2r_0[25|10]/a_60_290# WL25 SL10 VSS sky130_fd_pr__nfet_g5v0d10v5 ad=0.65 pd=3.3 as=0 ps=0 w=1 l=0.5
X2984 rr2t2r_0[26|10]/a_460_290# WL26 SL10 VSS sky130_fd_pr__nfet_g5v0d10v5 ad=0.65 pd=3.3 as=0 ps=0 w=1 l=0.5
X2985 BLP10 rr2t2r_0[26|10]/a_60_290# sky130_fd_pr_reram__reram_cell area_ox=0.0676
X2986 BLN10 rr2t2r_0[26|10]/a_460_290# sky130_fd_pr_reram__reram_cell area_ox=0.0676
X2987 rr2t2r_0[26|10]/a_60_290# WL26 SL10 VSS sky130_fd_pr__nfet_g5v0d10v5 ad=0.65 pd=3.3 as=0 ps=0 w=1 l=0.5
X2988 rr2t2r_0[27|10]/a_460_290# WL27 SL10 VSS sky130_fd_pr__nfet_g5v0d10v5 ad=0.65 pd=3.3 as=0 ps=0 w=1 l=0.5
X2989 BLP10 rr2t2r_0[27|10]/a_60_290# sky130_fd_pr_reram__reram_cell area_ox=0.0676
X2990 BLN10 rr2t2r_0[27|10]/a_460_290# sky130_fd_pr_reram__reram_cell area_ox=0.0676
X2991 rr2t2r_0[27|10]/a_60_290# WL27 SL10 VSS sky130_fd_pr__nfet_g5v0d10v5 ad=0.65 pd=3.3 as=0 ps=0 w=1 l=0.5
X2992 rr2t2r_0[28|10]/a_460_290# WL28 SL10 VSS sky130_fd_pr__nfet_g5v0d10v5 ad=0.65 pd=3.3 as=0 ps=0 w=1 l=0.5
X2993 BLP10 rr2t2r_0[28|10]/a_60_290# sky130_fd_pr_reram__reram_cell area_ox=0.0676
X2994 BLN10 rr2t2r_0[28|10]/a_460_290# sky130_fd_pr_reram__reram_cell area_ox=0.0676
X2995 rr2t2r_0[28|10]/a_60_290# WL28 SL10 VSS sky130_fd_pr__nfet_g5v0d10v5 ad=0.65 pd=3.3 as=0 ps=0 w=1 l=0.5
X2996 rr2t2r_0[29|10]/a_460_290# WL29 SL10 VSS sky130_fd_pr__nfet_g5v0d10v5 ad=0.65 pd=3.3 as=0 ps=0 w=1 l=0.5
X2997 BLP10 rr2t2r_0[29|10]/a_60_290# sky130_fd_pr_reram__reram_cell area_ox=0.0676
X2998 BLN10 rr2t2r_0[29|10]/a_460_290# sky130_fd_pr_reram__reram_cell area_ox=0.0676
X2999 rr2t2r_0[29|10]/a_60_290# WL29 SL10 VSS sky130_fd_pr__nfet_g5v0d10v5 ad=0.65 pd=3.3 as=0 ps=0 w=1 l=0.5
X3000 rr2t2r_0[30|10]/a_460_290# WL30 SL10 VSS sky130_fd_pr__nfet_g5v0d10v5 ad=0.65 pd=3.3 as=0 ps=0 w=1 l=0.5
X3001 BLP10 rr2t2r_0[30|10]/a_60_290# sky130_fd_pr_reram__reram_cell area_ox=0.0676
X3002 BLN10 rr2t2r_0[30|10]/a_460_290# sky130_fd_pr_reram__reram_cell area_ox=0.0676
X3003 rr2t2r_0[30|10]/a_60_290# WL30 SL10 VSS sky130_fd_pr__nfet_g5v0d10v5 ad=0.65 pd=3.3 as=0 ps=0 w=1 l=0.5
X3004 rr2t2r_0[31|10]/a_460_290# WL31 SL10 VSS sky130_fd_pr__nfet_g5v0d10v5 ad=0.65 pd=3.3 as=0 ps=0 w=1 l=0.5
X3005 BLP10 rr2t2r_0[31|10]/a_60_290# sky130_fd_pr_reram__reram_cell area_ox=0.0676
X3006 BLN10 rr2t2r_0[31|10]/a_460_290# sky130_fd_pr_reram__reram_cell area_ox=0.0676
X3007 rr2t2r_0[31|10]/a_60_290# WL31 SL10 VSS sky130_fd_pr__nfet_g5v0d10v5 ad=0.65 pd=3.3 as=0 ps=0 w=1 l=0.5
X3008 rr2t2r_0[32|10]/a_460_290# WL32 SL10 VSS sky130_fd_pr__nfet_g5v0d10v5 ad=0.65 pd=3.3 as=0 ps=0 w=1 l=0.5
X3009 BLP10 rr2t2r_0[32|10]/a_60_290# sky130_fd_pr_reram__reram_cell area_ox=0.0676
X3010 BLN10 rr2t2r_0[32|10]/a_460_290# sky130_fd_pr_reram__reram_cell area_ox=0.0676
X3011 rr2t2r_0[32|10]/a_60_290# WL32 SL10 VSS sky130_fd_pr__nfet_g5v0d10v5 ad=0.65 pd=3.3 as=0 ps=0 w=1 l=0.5
X3012 rr2t2r_0[33|10]/a_460_290# WL33 SL10 VSS sky130_fd_pr__nfet_g5v0d10v5 ad=0.65 pd=3.3 as=0 ps=0 w=1 l=0.5
X3013 BLP10 rr2t2r_0[33|10]/a_60_290# sky130_fd_pr_reram__reram_cell area_ox=0.0676
X3014 BLN10 rr2t2r_0[33|10]/a_460_290# sky130_fd_pr_reram__reram_cell area_ox=0.0676
X3015 rr2t2r_0[33|10]/a_60_290# WL33 SL10 VSS sky130_fd_pr__nfet_g5v0d10v5 ad=0.65 pd=3.3 as=0 ps=0 w=1 l=0.5
X3016 rr2t2r_0[34|10]/a_460_290# WL34 SL10 VSS sky130_fd_pr__nfet_g5v0d10v5 ad=0.65 pd=3.3 as=0 ps=0 w=1 l=0.5
X3017 BLP10 rr2t2r_0[34|10]/a_60_290# sky130_fd_pr_reram__reram_cell area_ox=0.0676
X3018 BLN10 rr2t2r_0[34|10]/a_460_290# sky130_fd_pr_reram__reram_cell area_ox=0.0676
X3019 rr2t2r_0[34|10]/a_60_290# WL34 SL10 VSS sky130_fd_pr__nfet_g5v0d10v5 ad=0.65 pd=3.3 as=0 ps=0 w=1 l=0.5
X3020 rr2t2r_0[35|10]/a_460_290# WL35 SL10 VSS sky130_fd_pr__nfet_g5v0d10v5 ad=0.65 pd=3.3 as=0 ps=0 w=1 l=0.5
X3021 BLP10 rr2t2r_0[35|10]/a_60_290# sky130_fd_pr_reram__reram_cell area_ox=0.0676
X3022 BLN10 rr2t2r_0[35|10]/a_460_290# sky130_fd_pr_reram__reram_cell area_ox=0.0676
X3023 rr2t2r_0[35|10]/a_60_290# WL35 SL10 VSS sky130_fd_pr__nfet_g5v0d10v5 ad=0.65 pd=3.3 as=0 ps=0 w=1 l=0.5
X3024 rr2t2r_0[36|10]/a_460_290# WL36 SL10 VSS sky130_fd_pr__nfet_g5v0d10v5 ad=0.65 pd=3.3 as=0 ps=0 w=1 l=0.5
X3025 BLP10 rr2t2r_0[36|10]/a_60_290# sky130_fd_pr_reram__reram_cell area_ox=0.0676
X3026 BLN10 rr2t2r_0[36|10]/a_460_290# sky130_fd_pr_reram__reram_cell area_ox=0.0676
X3027 rr2t2r_0[36|10]/a_60_290# WL36 SL10 VSS sky130_fd_pr__nfet_g5v0d10v5 ad=0.65 pd=3.3 as=0 ps=0 w=1 l=0.5
X3028 rr2t2r_0[37|10]/a_460_290# WL37 SL10 VSS sky130_fd_pr__nfet_g5v0d10v5 ad=0.65 pd=3.3 as=0 ps=0 w=1 l=0.5
X3029 BLP10 rr2t2r_0[37|10]/a_60_290# sky130_fd_pr_reram__reram_cell area_ox=0.0676
X3030 BLN10 rr2t2r_0[37|10]/a_460_290# sky130_fd_pr_reram__reram_cell area_ox=0.0676
X3031 rr2t2r_0[37|10]/a_60_290# WL37 SL10 VSS sky130_fd_pr__nfet_g5v0d10v5 ad=0.65 pd=3.3 as=0 ps=0 w=1 l=0.5
X3032 rr2t2r_0[38|10]/a_460_290# WL38 SL10 VSS sky130_fd_pr__nfet_g5v0d10v5 ad=0.65 pd=3.3 as=0 ps=0 w=1 l=0.5
X3033 BLP10 rr2t2r_0[38|10]/a_60_290# sky130_fd_pr_reram__reram_cell area_ox=0.0676
X3034 BLN10 rr2t2r_0[38|10]/a_460_290# sky130_fd_pr_reram__reram_cell area_ox=0.0676
X3035 rr2t2r_0[38|10]/a_60_290# WL38 SL10 VSS sky130_fd_pr__nfet_g5v0d10v5 ad=0.65 pd=3.3 as=0 ps=0 w=1 l=0.5
X3036 rr2t2r_0[39|10]/a_460_290# WL39 SL10 VSS sky130_fd_pr__nfet_g5v0d10v5 ad=0.65 pd=3.3 as=0 ps=0 w=1 l=0.5
X3037 BLP10 rr2t2r_0[39|10]/a_60_290# sky130_fd_pr_reram__reram_cell area_ox=0.0676
X3038 BLN10 rr2t2r_0[39|10]/a_460_290# sky130_fd_pr_reram__reram_cell area_ox=0.0676
X3039 rr2t2r_0[39|10]/a_60_290# WL39 SL10 VSS sky130_fd_pr__nfet_g5v0d10v5 ad=0.65 pd=3.3 as=0 ps=0 w=1 l=0.5
X3040 rr2t2r_0[40|10]/a_460_290# WL40 SL10 VSS sky130_fd_pr__nfet_g5v0d10v5 ad=0.65 pd=3.3 as=0 ps=0 w=1 l=0.5
X3041 BLP10 rr2t2r_0[40|10]/a_60_290# sky130_fd_pr_reram__reram_cell area_ox=0.0676
X3042 BLN10 rr2t2r_0[40|10]/a_460_290# sky130_fd_pr_reram__reram_cell area_ox=0.0676
X3043 rr2t2r_0[40|10]/a_60_290# WL40 SL10 VSS sky130_fd_pr__nfet_g5v0d10v5 ad=0.65 pd=3.3 as=0 ps=0 w=1 l=0.5
X3044 rr2t2r_0[41|10]/a_460_290# WL41 SL10 VSS sky130_fd_pr__nfet_g5v0d10v5 ad=0.65 pd=3.3 as=0 ps=0 w=1 l=0.5
X3045 BLP10 rr2t2r_0[41|10]/a_60_290# sky130_fd_pr_reram__reram_cell area_ox=0.0676
X3046 BLN10 rr2t2r_0[41|10]/a_460_290# sky130_fd_pr_reram__reram_cell area_ox=0.0676
X3047 rr2t2r_0[41|10]/a_60_290# WL41 SL10 VSS sky130_fd_pr__nfet_g5v0d10v5 ad=0.65 pd=3.3 as=0 ps=0 w=1 l=0.5
X3048 rr2t2r_0[42|10]/a_460_290# WL42 SL10 VSS sky130_fd_pr__nfet_g5v0d10v5 ad=0.65 pd=3.3 as=0 ps=0 w=1 l=0.5
X3049 BLP10 rr2t2r_0[42|10]/a_60_290# sky130_fd_pr_reram__reram_cell area_ox=0.0676
X3050 BLN10 rr2t2r_0[42|10]/a_460_290# sky130_fd_pr_reram__reram_cell area_ox=0.0676
X3051 rr2t2r_0[42|10]/a_60_290# WL42 SL10 VSS sky130_fd_pr__nfet_g5v0d10v5 ad=0.65 pd=3.3 as=0 ps=0 w=1 l=0.5
X3052 rr2t2r_0[43|10]/a_460_290# WL43 SL10 VSS sky130_fd_pr__nfet_g5v0d10v5 ad=0.65 pd=3.3 as=0 ps=0 w=1 l=0.5
X3053 BLP10 rr2t2r_0[43|10]/a_60_290# sky130_fd_pr_reram__reram_cell area_ox=0.0676
X3054 BLN10 rr2t2r_0[43|10]/a_460_290# sky130_fd_pr_reram__reram_cell area_ox=0.0676
X3055 rr2t2r_0[43|10]/a_60_290# WL43 SL10 VSS sky130_fd_pr__nfet_g5v0d10v5 ad=0.65 pd=3.3 as=0 ps=0 w=1 l=0.5
X3056 rr2t2r_0[44|10]/a_460_290# WL44 SL10 VSS sky130_fd_pr__nfet_g5v0d10v5 ad=0.65 pd=3.3 as=0 ps=0 w=1 l=0.5
X3057 BLP10 rr2t2r_0[44|10]/a_60_290# sky130_fd_pr_reram__reram_cell area_ox=0.0676
X3058 BLN10 rr2t2r_0[44|10]/a_460_290# sky130_fd_pr_reram__reram_cell area_ox=0.0676
X3059 rr2t2r_0[44|10]/a_60_290# WL44 SL10 VSS sky130_fd_pr__nfet_g5v0d10v5 ad=0.65 pd=3.3 as=0 ps=0 w=1 l=0.5
X3060 rr2t2r_0[45|10]/a_460_290# WL45 SL10 VSS sky130_fd_pr__nfet_g5v0d10v5 ad=0.65 pd=3.3 as=0 ps=0 w=1 l=0.5
X3061 BLP10 rr2t2r_0[45|10]/a_60_290# sky130_fd_pr_reram__reram_cell area_ox=0.0676
X3062 BLN10 rr2t2r_0[45|10]/a_460_290# sky130_fd_pr_reram__reram_cell area_ox=0.0676
X3063 rr2t2r_0[45|10]/a_60_290# WL45 SL10 VSS sky130_fd_pr__nfet_g5v0d10v5 ad=0.65 pd=3.3 as=0 ps=0 w=1 l=0.5
X3064 rr2t2r_0[46|10]/a_460_290# WL46 SL10 VSS sky130_fd_pr__nfet_g5v0d10v5 ad=0.65 pd=3.3 as=0 ps=0 w=1 l=0.5
X3065 BLP10 rr2t2r_0[46|10]/a_60_290# sky130_fd_pr_reram__reram_cell area_ox=0.0676
X3066 BLN10 rr2t2r_0[46|10]/a_460_290# sky130_fd_pr_reram__reram_cell area_ox=0.0676
X3067 rr2t2r_0[46|10]/a_60_290# WL46 SL10 VSS sky130_fd_pr__nfet_g5v0d10v5 ad=0.65 pd=3.3 as=0 ps=0 w=1 l=0.5
X3068 rr2t2r_0[47|10]/a_460_290# WL47 SL10 VSS sky130_fd_pr__nfet_g5v0d10v5 ad=0.65 pd=3.3 as=0 ps=0 w=1 l=0.5
X3069 BLP10 rr2t2r_0[47|10]/a_60_290# sky130_fd_pr_reram__reram_cell area_ox=0.0676
X3070 BLN10 rr2t2r_0[47|10]/a_460_290# sky130_fd_pr_reram__reram_cell area_ox=0.0676
X3071 rr2t2r_0[47|10]/a_60_290# WL47 SL10 VSS sky130_fd_pr__nfet_g5v0d10v5 ad=0.65 pd=3.3 as=0 ps=0 w=1 l=0.5
X3072 rr2t2r_0[48|10]/a_460_290# WL48 SL10 VSS sky130_fd_pr__nfet_g5v0d10v5 ad=0.65 pd=3.3 as=0 ps=0 w=1 l=0.5
X3073 BLP10 rr2t2r_0[48|10]/a_60_290# sky130_fd_pr_reram__reram_cell area_ox=0.0676
X3074 BLN10 rr2t2r_0[48|10]/a_460_290# sky130_fd_pr_reram__reram_cell area_ox=0.0676
X3075 rr2t2r_0[48|10]/a_60_290# WL48 SL10 VSS sky130_fd_pr__nfet_g5v0d10v5 ad=0.65 pd=3.3 as=0 ps=0 w=1 l=0.5
X3076 rr2t2r_0[49|10]/a_460_290# WL49 SL10 VSS sky130_fd_pr__nfet_g5v0d10v5 ad=0.65 pd=3.3 as=0 ps=0 w=1 l=0.5
X3077 BLP10 rr2t2r_0[49|10]/a_60_290# sky130_fd_pr_reram__reram_cell area_ox=0.0676
X3078 BLN10 rr2t2r_0[49|10]/a_460_290# sky130_fd_pr_reram__reram_cell area_ox=0.0676
X3079 rr2t2r_0[49|10]/a_60_290# WL49 SL10 VSS sky130_fd_pr__nfet_g5v0d10v5 ad=0.65 pd=3.3 as=0 ps=0 w=1 l=0.5
X3080 rr2t2r_0[50|10]/a_460_290# WL50 SL10 VSS sky130_fd_pr__nfet_g5v0d10v5 ad=0.65 pd=3.3 as=0 ps=0 w=1 l=0.5
X3081 BLP10 rr2t2r_0[50|10]/a_60_290# sky130_fd_pr_reram__reram_cell area_ox=0.0676
X3082 BLN10 rr2t2r_0[50|10]/a_460_290# sky130_fd_pr_reram__reram_cell area_ox=0.0676
X3083 rr2t2r_0[50|10]/a_60_290# WL50 SL10 VSS sky130_fd_pr__nfet_g5v0d10v5 ad=0.65 pd=3.3 as=0 ps=0 w=1 l=0.5
X3084 rr2t2r_0[51|10]/a_460_290# WL51 SL10 VSS sky130_fd_pr__nfet_g5v0d10v5 ad=0.65 pd=3.3 as=0 ps=0 w=1 l=0.5
X3085 BLP10 rr2t2r_0[51|10]/a_60_290# sky130_fd_pr_reram__reram_cell area_ox=0.0676
X3086 BLN10 rr2t2r_0[51|10]/a_460_290# sky130_fd_pr_reram__reram_cell area_ox=0.0676
X3087 rr2t2r_0[51|10]/a_60_290# WL51 SL10 VSS sky130_fd_pr__nfet_g5v0d10v5 ad=0.65 pd=3.3 as=0 ps=0 w=1 l=0.5
X3088 rr2t2r_0[52|10]/a_460_290# WL52 SL10 VSS sky130_fd_pr__nfet_g5v0d10v5 ad=0.65 pd=3.3 as=0 ps=0 w=1 l=0.5
X3089 BLP10 rr2t2r_0[52|10]/a_60_290# sky130_fd_pr_reram__reram_cell area_ox=0.0676
X3090 BLN10 rr2t2r_0[52|10]/a_460_290# sky130_fd_pr_reram__reram_cell area_ox=0.0676
X3091 rr2t2r_0[52|10]/a_60_290# WL52 SL10 VSS sky130_fd_pr__nfet_g5v0d10v5 ad=0.65 pd=3.3 as=0 ps=0 w=1 l=0.5
X3092 rr2t2r_0[53|10]/a_460_290# WL53 SL10 VSS sky130_fd_pr__nfet_g5v0d10v5 ad=0.65 pd=3.3 as=0 ps=0 w=1 l=0.5
X3093 BLP10 rr2t2r_0[53|10]/a_60_290# sky130_fd_pr_reram__reram_cell area_ox=0.0676
X3094 BLN10 rr2t2r_0[53|10]/a_460_290# sky130_fd_pr_reram__reram_cell area_ox=0.0676
X3095 rr2t2r_0[53|10]/a_60_290# WL53 SL10 VSS sky130_fd_pr__nfet_g5v0d10v5 ad=0.65 pd=3.3 as=0 ps=0 w=1 l=0.5
X3096 rr2t2r_0[54|10]/a_460_290# WL54 SL10 VSS sky130_fd_pr__nfet_g5v0d10v5 ad=0.65 pd=3.3 as=0 ps=0 w=1 l=0.5
X3097 BLP10 rr2t2r_0[54|10]/a_60_290# sky130_fd_pr_reram__reram_cell area_ox=0.0676
X3098 BLN10 rr2t2r_0[54|10]/a_460_290# sky130_fd_pr_reram__reram_cell area_ox=0.0676
X3099 rr2t2r_0[54|10]/a_60_290# WL54 SL10 VSS sky130_fd_pr__nfet_g5v0d10v5 ad=0.65 pd=3.3 as=0 ps=0 w=1 l=0.5
X3100 rr2t2r_0[55|10]/a_460_290# WL55 SL10 VSS sky130_fd_pr__nfet_g5v0d10v5 ad=0.65 pd=3.3 as=0 ps=0 w=1 l=0.5
X3101 BLP10 rr2t2r_0[55|10]/a_60_290# sky130_fd_pr_reram__reram_cell area_ox=0.0676
X3102 BLN10 rr2t2r_0[55|10]/a_460_290# sky130_fd_pr_reram__reram_cell area_ox=0.0676
X3103 rr2t2r_0[55|10]/a_60_290# WL55 SL10 VSS sky130_fd_pr__nfet_g5v0d10v5 ad=0.65 pd=3.3 as=0 ps=0 w=1 l=0.5
X3104 rr2t2r_0[56|10]/a_460_290# WL56 SL10 VSS sky130_fd_pr__nfet_g5v0d10v5 ad=0.65 pd=3.3 as=0 ps=0 w=1 l=0.5
X3105 BLP10 rr2t2r_0[56|10]/a_60_290# sky130_fd_pr_reram__reram_cell area_ox=0.0676
X3106 BLN10 rr2t2r_0[56|10]/a_460_290# sky130_fd_pr_reram__reram_cell area_ox=0.0676
X3107 rr2t2r_0[56|10]/a_60_290# WL56 SL10 VSS sky130_fd_pr__nfet_g5v0d10v5 ad=0.65 pd=3.3 as=0 ps=0 w=1 l=0.5
X3108 rr2t2r_0[57|10]/a_460_290# WL57 SL10 VSS sky130_fd_pr__nfet_g5v0d10v5 ad=0.65 pd=3.3 as=0 ps=0 w=1 l=0.5
X3109 BLP10 rr2t2r_0[57|10]/a_60_290# sky130_fd_pr_reram__reram_cell area_ox=0.0676
X3110 BLN10 rr2t2r_0[57|10]/a_460_290# sky130_fd_pr_reram__reram_cell area_ox=0.0676
X3111 rr2t2r_0[57|10]/a_60_290# WL57 SL10 VSS sky130_fd_pr__nfet_g5v0d10v5 ad=0.65 pd=3.3 as=0 ps=0 w=1 l=0.5
X3112 rr2t2r_0[58|10]/a_460_290# WL58 SL10 VSS sky130_fd_pr__nfet_g5v0d10v5 ad=0.65 pd=3.3 as=0 ps=0 w=1 l=0.5
X3113 BLP10 rr2t2r_0[58|10]/a_60_290# sky130_fd_pr_reram__reram_cell area_ox=0.0676
X3114 BLN10 rr2t2r_0[58|10]/a_460_290# sky130_fd_pr_reram__reram_cell area_ox=0.0676
X3115 rr2t2r_0[58|10]/a_60_290# WL58 SL10 VSS sky130_fd_pr__nfet_g5v0d10v5 ad=0.65 pd=3.3 as=0 ps=0 w=1 l=0.5
X3116 rr2t2r_0[59|10]/a_460_290# WL59 SL10 VSS sky130_fd_pr__nfet_g5v0d10v5 ad=0.65 pd=3.3 as=0 ps=0 w=1 l=0.5
X3117 BLP10 rr2t2r_0[59|10]/a_60_290# sky130_fd_pr_reram__reram_cell area_ox=0.0676
X3118 BLN10 rr2t2r_0[59|10]/a_460_290# sky130_fd_pr_reram__reram_cell area_ox=0.0676
X3119 rr2t2r_0[59|10]/a_60_290# WL59 SL10 VSS sky130_fd_pr__nfet_g5v0d10v5 ad=0.65 pd=3.3 as=0 ps=0 w=1 l=0.5
X3120 rr2t2r_0[60|10]/a_460_290# WL60 SL10 VSS sky130_fd_pr__nfet_g5v0d10v5 ad=0.65 pd=3.3 as=0 ps=0 w=1 l=0.5
X3121 BLP10 rr2t2r_0[60|10]/a_60_290# sky130_fd_pr_reram__reram_cell area_ox=0.0676
X3122 BLN10 rr2t2r_0[60|10]/a_460_290# sky130_fd_pr_reram__reram_cell area_ox=0.0676
X3123 rr2t2r_0[60|10]/a_60_290# WL60 SL10 VSS sky130_fd_pr__nfet_g5v0d10v5 ad=0.65 pd=3.3 as=0 ps=0 w=1 l=0.5
X3124 rr2t2r_0[61|10]/a_460_290# WL61 SL10 VSS sky130_fd_pr__nfet_g5v0d10v5 ad=0.65 pd=3.3 as=0 ps=0 w=1 l=0.5
X3125 BLP10 rr2t2r_0[61|10]/a_60_290# sky130_fd_pr_reram__reram_cell area_ox=0.0676
X3126 BLN10 rr2t2r_0[61|10]/a_460_290# sky130_fd_pr_reram__reram_cell area_ox=0.0676
X3127 rr2t2r_0[61|10]/a_60_290# WL61 SL10 VSS sky130_fd_pr__nfet_g5v0d10v5 ad=0.65 pd=3.3 as=0 ps=0 w=1 l=0.5
X3128 rr2t2r_0[62|10]/a_460_290# WL62 SL10 VSS sky130_fd_pr__nfet_g5v0d10v5 ad=0.65 pd=3.3 as=0 ps=0 w=1 l=0.5
X3129 BLP10 rr2t2r_0[62|10]/a_60_290# sky130_fd_pr_reram__reram_cell area_ox=0.0676
X3130 BLN10 rr2t2r_0[62|10]/a_460_290# sky130_fd_pr_reram__reram_cell area_ox=0.0676
X3131 rr2t2r_0[62|10]/a_60_290# WL62 SL10 VSS sky130_fd_pr__nfet_g5v0d10v5 ad=0.65 pd=3.3 as=0 ps=0 w=1 l=0.5
X3132 rr2t2r_0[63|10]/a_460_290# WL63 SL10 VSS sky130_fd_pr__nfet_g5v0d10v5 ad=0.65 pd=3.3 as=0 ps=0 w=1 l=0.5
X3133 BLP10 rr2t2r_0[63|10]/a_60_290# sky130_fd_pr_reram__reram_cell area_ox=0.0676
X3134 BLN10 rr2t2r_0[63|10]/a_460_290# sky130_fd_pr_reram__reram_cell area_ox=0.0676
X3135 rr2t2r_0[63|10]/a_60_290# WL63 SL10 VSS sky130_fd_pr__nfet_g5v0d10v5 ad=0.65 pd=3.3 as=0 ps=0 w=1 l=0.5
X3136 rr2t2r_0[64|10]/a_460_290# WL64 SL10 VSS sky130_fd_pr__nfet_g5v0d10v5 ad=0.65 pd=3.3 as=0 ps=0 w=1 l=0.5
X3137 BLP10 rr2t2r_0[64|10]/a_60_290# sky130_fd_pr_reram__reram_cell area_ox=0.0676
X3138 BLN10 rr2t2r_0[64|10]/a_460_290# sky130_fd_pr_reram__reram_cell area_ox=0.0676
X3139 rr2t2r_0[64|10]/a_60_290# WL64 SL10 VSS sky130_fd_pr__nfet_g5v0d10v5 ad=0.65 pd=3.3 as=0 ps=0 w=1 l=0.5
X3140 rr2t2r_0[65|10]/a_460_290# WL65 SL10 VSS sky130_fd_pr__nfet_g5v0d10v5 ad=0.65 pd=3.3 as=0 ps=0 w=1 l=0.5
X3141 BLP10 rr2t2r_0[65|10]/a_60_290# sky130_fd_pr_reram__reram_cell area_ox=0.0676
X3142 BLN10 rr2t2r_0[65|10]/a_460_290# sky130_fd_pr_reram__reram_cell area_ox=0.0676
X3143 rr2t2r_0[65|10]/a_60_290# WL65 SL10 VSS sky130_fd_pr__nfet_g5v0d10v5 ad=0.65 pd=3.3 as=0 ps=0 w=1 l=0.5
X3144 rr2t2r_0[66|10]/a_460_290# WL66 SL10 VSS sky130_fd_pr__nfet_g5v0d10v5 ad=0.65 pd=3.3 as=0 ps=0 w=1 l=0.5
X3145 BLP10 rr2t2r_0[66|10]/a_60_290# sky130_fd_pr_reram__reram_cell area_ox=0.0676
X3146 BLN10 rr2t2r_0[66|10]/a_460_290# sky130_fd_pr_reram__reram_cell area_ox=0.0676
X3147 rr2t2r_0[66|10]/a_60_290# WL66 SL10 VSS sky130_fd_pr__nfet_g5v0d10v5 ad=0.65 pd=3.3 as=0 ps=0 w=1 l=0.5
X3148 rr2t2r_0[67|10]/a_460_290# WL67 SL10 VSS sky130_fd_pr__nfet_g5v0d10v5 ad=0.65 pd=3.3 as=0 ps=0 w=1 l=0.5
X3149 BLP10 rr2t2r_0[67|10]/a_60_290# sky130_fd_pr_reram__reram_cell area_ox=0.0676
X3150 BLN10 rr2t2r_0[67|10]/a_460_290# sky130_fd_pr_reram__reram_cell area_ox=0.0676
X3151 rr2t2r_0[67|10]/a_60_290# WL67 SL10 VSS sky130_fd_pr__nfet_g5v0d10v5 ad=0.65 pd=3.3 as=0 ps=0 w=1 l=0.5
X3152 rr2t2r_0[68|10]/a_460_290# WL68 SL10 VSS sky130_fd_pr__nfet_g5v0d10v5 ad=0.65 pd=3.3 as=0 ps=0 w=1 l=0.5
X3153 BLP10 rr2t2r_0[68|10]/a_60_290# sky130_fd_pr_reram__reram_cell area_ox=0.0676
X3154 BLN10 rr2t2r_0[68|10]/a_460_290# sky130_fd_pr_reram__reram_cell area_ox=0.0676
X3155 rr2t2r_0[68|10]/a_60_290# WL68 SL10 VSS sky130_fd_pr__nfet_g5v0d10v5 ad=0.65 pd=3.3 as=0 ps=0 w=1 l=0.5
X3156 rr2t2r_0[69|10]/a_460_290# WL69 SL10 VSS sky130_fd_pr__nfet_g5v0d10v5 ad=0.65 pd=3.3 as=0 ps=0 w=1 l=0.5
X3157 BLP10 rr2t2r_0[69|10]/a_60_290# sky130_fd_pr_reram__reram_cell area_ox=0.0676
X3158 BLN10 rr2t2r_0[69|10]/a_460_290# sky130_fd_pr_reram__reram_cell area_ox=0.0676
X3159 rr2t2r_0[69|10]/a_60_290# WL69 SL10 VSS sky130_fd_pr__nfet_g5v0d10v5 ad=0.65 pd=3.3 as=0 ps=0 w=1 l=0.5
X3160 rr2t2r_0[70|10]/a_460_290# WL70 SL10 VSS sky130_fd_pr__nfet_g5v0d10v5 ad=0.65 pd=3.3 as=0 ps=0 w=1 l=0.5
X3161 BLP10 rr2t2r_0[70|10]/a_60_290# sky130_fd_pr_reram__reram_cell area_ox=0.0676
X3162 BLN10 rr2t2r_0[70|10]/a_460_290# sky130_fd_pr_reram__reram_cell area_ox=0.0676
X3163 rr2t2r_0[70|10]/a_60_290# WL70 SL10 VSS sky130_fd_pr__nfet_g5v0d10v5 ad=0.65 pd=3.3 as=0 ps=0 w=1 l=0.5
X3164 rr2t2r_0[71|10]/a_460_290# WL71 SL10 VSS sky130_fd_pr__nfet_g5v0d10v5 ad=0.65 pd=3.3 as=0 ps=0 w=1 l=0.5
X3165 BLP10 rr2t2r_0[71|10]/a_60_290# sky130_fd_pr_reram__reram_cell area_ox=0.0676
X3166 BLN10 rr2t2r_0[71|10]/a_460_290# sky130_fd_pr_reram__reram_cell area_ox=0.0676
X3167 rr2t2r_0[71|10]/a_60_290# WL71 SL10 VSS sky130_fd_pr__nfet_g5v0d10v5 ad=0.65 pd=3.3 as=0 ps=0 w=1 l=0.5
X3168 rr2t2r_0[0|11]/a_460_290# WL0 SL11 VSS sky130_fd_pr__nfet_g5v0d10v5 ad=0.65 pd=3.3 as=108 ps=504 w=1 l=0.5
X3169 BLP11 rr2t2r_0[0|11]/a_60_290# sky130_fd_pr_reram__reram_cell area_ox=0.0676
X3170 BLN11 rr2t2r_0[0|11]/a_460_290# sky130_fd_pr_reram__reram_cell area_ox=0.0676
X3171 rr2t2r_0[0|11]/a_60_290# WL0 SL11 VSS sky130_fd_pr__nfet_g5v0d10v5 ad=0.65 pd=3.3 as=0 ps=0 w=1 l=0.5
X3172 rr2t2r_0[1|11]/a_460_290# WL1 SL11 VSS sky130_fd_pr__nfet_g5v0d10v5 ad=0.65 pd=3.3 as=0 ps=0 w=1 l=0.5
X3173 BLP11 rr2t2r_0[1|11]/a_60_290# sky130_fd_pr_reram__reram_cell area_ox=0.0676
X3174 BLN11 rr2t2r_0[1|11]/a_460_290# sky130_fd_pr_reram__reram_cell area_ox=0.0676
X3175 rr2t2r_0[1|11]/a_60_290# WL1 SL11 VSS sky130_fd_pr__nfet_g5v0d10v5 ad=0.65 pd=3.3 as=0 ps=0 w=1 l=0.5
X3176 rr2t2r_0[2|11]/a_460_290# WL2 SL11 VSS sky130_fd_pr__nfet_g5v0d10v5 ad=0.65 pd=3.3 as=0 ps=0 w=1 l=0.5
X3177 BLP11 rr2t2r_0[2|11]/a_60_290# sky130_fd_pr_reram__reram_cell area_ox=0.0676
X3178 BLN11 rr2t2r_0[2|11]/a_460_290# sky130_fd_pr_reram__reram_cell area_ox=0.0676
X3179 rr2t2r_0[2|11]/a_60_290# WL2 SL11 VSS sky130_fd_pr__nfet_g5v0d10v5 ad=0.65 pd=3.3 as=0 ps=0 w=1 l=0.5
X3180 rr2t2r_0[3|11]/a_460_290# WL3 SL11 VSS sky130_fd_pr__nfet_g5v0d10v5 ad=0.65 pd=3.3 as=0 ps=0 w=1 l=0.5
X3181 BLP11 rr2t2r_0[3|11]/a_60_290# sky130_fd_pr_reram__reram_cell area_ox=0.0676
X3182 BLN11 rr2t2r_0[3|11]/a_460_290# sky130_fd_pr_reram__reram_cell area_ox=0.0676
X3183 rr2t2r_0[3|11]/a_60_290# WL3 SL11 VSS sky130_fd_pr__nfet_g5v0d10v5 ad=0.65 pd=3.3 as=0 ps=0 w=1 l=0.5
X3184 rr2t2r_0[4|11]/a_460_290# WL4 SL11 VSS sky130_fd_pr__nfet_g5v0d10v5 ad=0.65 pd=3.3 as=0 ps=0 w=1 l=0.5
X3185 BLP11 rr2t2r_0[4|11]/a_60_290# sky130_fd_pr_reram__reram_cell area_ox=0.0676
X3186 BLN11 rr2t2r_0[4|11]/a_460_290# sky130_fd_pr_reram__reram_cell area_ox=0.0676
X3187 rr2t2r_0[4|11]/a_60_290# WL4 SL11 VSS sky130_fd_pr__nfet_g5v0d10v5 ad=0.65 pd=3.3 as=0 ps=0 w=1 l=0.5
X3188 rr2t2r_0[5|11]/a_460_290# WL5 SL11 VSS sky130_fd_pr__nfet_g5v0d10v5 ad=0.65 pd=3.3 as=0 ps=0 w=1 l=0.5
X3189 BLP11 rr2t2r_0[5|11]/a_60_290# sky130_fd_pr_reram__reram_cell area_ox=0.0676
X3190 BLN11 rr2t2r_0[5|11]/a_460_290# sky130_fd_pr_reram__reram_cell area_ox=0.0676
X3191 rr2t2r_0[5|11]/a_60_290# WL5 SL11 VSS sky130_fd_pr__nfet_g5v0d10v5 ad=0.65 pd=3.3 as=0 ps=0 w=1 l=0.5
X3192 rr2t2r_0[6|11]/a_460_290# WL6 SL11 VSS sky130_fd_pr__nfet_g5v0d10v5 ad=0.65 pd=3.3 as=0 ps=0 w=1 l=0.5
X3193 BLP11 rr2t2r_0[6|11]/a_60_290# sky130_fd_pr_reram__reram_cell area_ox=0.0676
X3194 BLN11 rr2t2r_0[6|11]/a_460_290# sky130_fd_pr_reram__reram_cell area_ox=0.0676
X3195 rr2t2r_0[6|11]/a_60_290# WL6 SL11 VSS sky130_fd_pr__nfet_g5v0d10v5 ad=0.65 pd=3.3 as=0 ps=0 w=1 l=0.5
X3196 rr2t2r_0[7|11]/a_460_290# WL7 SL11 VSS sky130_fd_pr__nfet_g5v0d10v5 ad=0.65 pd=3.3 as=0 ps=0 w=1 l=0.5
X3197 BLP11 rr2t2r_0[7|11]/a_60_290# sky130_fd_pr_reram__reram_cell area_ox=0.0676
X3198 BLN11 rr2t2r_0[7|11]/a_460_290# sky130_fd_pr_reram__reram_cell area_ox=0.0676
X3199 rr2t2r_0[7|11]/a_60_290# WL7 SL11 VSS sky130_fd_pr__nfet_g5v0d10v5 ad=0.65 pd=3.3 as=0 ps=0 w=1 l=0.5
X3200 rr2t2r_0[8|11]/a_460_290# WL8 SL11 VSS sky130_fd_pr__nfet_g5v0d10v5 ad=0.65 pd=3.3 as=0 ps=0 w=1 l=0.5
X3201 BLP11 rr2t2r_0[8|11]/a_60_290# sky130_fd_pr_reram__reram_cell area_ox=0.0676
X3202 BLN11 rr2t2r_0[8|11]/a_460_290# sky130_fd_pr_reram__reram_cell area_ox=0.0676
X3203 rr2t2r_0[8|11]/a_60_290# WL8 SL11 VSS sky130_fd_pr__nfet_g5v0d10v5 ad=0.65 pd=3.3 as=0 ps=0 w=1 l=0.5
X3204 rr2t2r_0[9|11]/a_460_290# WL9 SL11 VSS sky130_fd_pr__nfet_g5v0d10v5 ad=0.65 pd=3.3 as=0 ps=0 w=1 l=0.5
X3205 BLP11 rr2t2r_0[9|11]/a_60_290# sky130_fd_pr_reram__reram_cell area_ox=0.0676
X3206 BLN11 rr2t2r_0[9|11]/a_460_290# sky130_fd_pr_reram__reram_cell area_ox=0.0676
X3207 rr2t2r_0[9|11]/a_60_290# WL9 SL11 VSS sky130_fd_pr__nfet_g5v0d10v5 ad=0.65 pd=3.3 as=0 ps=0 w=1 l=0.5
X3208 rr2t2r_0[10|11]/a_460_290# WL10 SL11 VSS sky130_fd_pr__nfet_g5v0d10v5 ad=0.65 pd=3.3 as=0 ps=0 w=1 l=0.5
X3209 BLP11 rr2t2r_0[10|11]/a_60_290# sky130_fd_pr_reram__reram_cell area_ox=0.0676
X3210 BLN11 rr2t2r_0[10|11]/a_460_290# sky130_fd_pr_reram__reram_cell area_ox=0.0676
X3211 rr2t2r_0[10|11]/a_60_290# WL10 SL11 VSS sky130_fd_pr__nfet_g5v0d10v5 ad=0.65 pd=3.3 as=0 ps=0 w=1 l=0.5
X3212 rr2t2r_0[11|11]/a_460_290# WL11 SL11 VSS sky130_fd_pr__nfet_g5v0d10v5 ad=0.65 pd=3.3 as=0 ps=0 w=1 l=0.5
X3213 BLP11 rr2t2r_0[11|11]/a_60_290# sky130_fd_pr_reram__reram_cell area_ox=0.0676
X3214 BLN11 rr2t2r_0[11|11]/a_460_290# sky130_fd_pr_reram__reram_cell area_ox=0.0676
X3215 rr2t2r_0[11|11]/a_60_290# WL11 SL11 VSS sky130_fd_pr__nfet_g5v0d10v5 ad=0.65 pd=3.3 as=0 ps=0 w=1 l=0.5
X3216 rr2t2r_0[12|11]/a_460_290# WL12 SL11 VSS sky130_fd_pr__nfet_g5v0d10v5 ad=0.65 pd=3.3 as=0 ps=0 w=1 l=0.5
X3217 BLP11 rr2t2r_0[12|11]/a_60_290# sky130_fd_pr_reram__reram_cell area_ox=0.0676
X3218 BLN11 rr2t2r_0[12|11]/a_460_290# sky130_fd_pr_reram__reram_cell area_ox=0.0676
X3219 rr2t2r_0[12|11]/a_60_290# WL12 SL11 VSS sky130_fd_pr__nfet_g5v0d10v5 ad=0.65 pd=3.3 as=0 ps=0 w=1 l=0.5
X3220 rr2t2r_0[13|11]/a_460_290# WL13 SL11 VSS sky130_fd_pr__nfet_g5v0d10v5 ad=0.65 pd=3.3 as=0 ps=0 w=1 l=0.5
X3221 BLP11 rr2t2r_0[13|11]/a_60_290# sky130_fd_pr_reram__reram_cell area_ox=0.0676
X3222 BLN11 rr2t2r_0[13|11]/a_460_290# sky130_fd_pr_reram__reram_cell area_ox=0.0676
X3223 rr2t2r_0[13|11]/a_60_290# WL13 SL11 VSS sky130_fd_pr__nfet_g5v0d10v5 ad=0.65 pd=3.3 as=0 ps=0 w=1 l=0.5
X3224 rr2t2r_0[14|11]/a_460_290# WL14 SL11 VSS sky130_fd_pr__nfet_g5v0d10v5 ad=0.65 pd=3.3 as=0 ps=0 w=1 l=0.5
X3225 BLP11 rr2t2r_0[14|11]/a_60_290# sky130_fd_pr_reram__reram_cell area_ox=0.0676
X3226 BLN11 rr2t2r_0[14|11]/a_460_290# sky130_fd_pr_reram__reram_cell area_ox=0.0676
X3227 rr2t2r_0[14|11]/a_60_290# WL14 SL11 VSS sky130_fd_pr__nfet_g5v0d10v5 ad=0.65 pd=3.3 as=0 ps=0 w=1 l=0.5
X3228 rr2t2r_0[15|11]/a_460_290# WL15 SL11 VSS sky130_fd_pr__nfet_g5v0d10v5 ad=0.65 pd=3.3 as=0 ps=0 w=1 l=0.5
X3229 BLP11 rr2t2r_0[15|11]/a_60_290# sky130_fd_pr_reram__reram_cell area_ox=0.0676
X3230 BLN11 rr2t2r_0[15|11]/a_460_290# sky130_fd_pr_reram__reram_cell area_ox=0.0676
X3231 rr2t2r_0[15|11]/a_60_290# WL15 SL11 VSS sky130_fd_pr__nfet_g5v0d10v5 ad=0.65 pd=3.3 as=0 ps=0 w=1 l=0.5
X3232 rr2t2r_0[16|11]/a_460_290# WL16 SL11 VSS sky130_fd_pr__nfet_g5v0d10v5 ad=0.65 pd=3.3 as=0 ps=0 w=1 l=0.5
X3233 BLP11 rr2t2r_0[16|11]/a_60_290# sky130_fd_pr_reram__reram_cell area_ox=0.0676
X3234 BLN11 rr2t2r_0[16|11]/a_460_290# sky130_fd_pr_reram__reram_cell area_ox=0.0676
X3235 rr2t2r_0[16|11]/a_60_290# WL16 SL11 VSS sky130_fd_pr__nfet_g5v0d10v5 ad=0.65 pd=3.3 as=0 ps=0 w=1 l=0.5
X3236 rr2t2r_0[17|11]/a_460_290# WL17 SL11 VSS sky130_fd_pr__nfet_g5v0d10v5 ad=0.65 pd=3.3 as=0 ps=0 w=1 l=0.5
X3237 BLP11 rr2t2r_0[17|11]/a_60_290# sky130_fd_pr_reram__reram_cell area_ox=0.0676
X3238 BLN11 rr2t2r_0[17|11]/a_460_290# sky130_fd_pr_reram__reram_cell area_ox=0.0676
X3239 rr2t2r_0[17|11]/a_60_290# WL17 SL11 VSS sky130_fd_pr__nfet_g5v0d10v5 ad=0.65 pd=3.3 as=0 ps=0 w=1 l=0.5
X3240 rr2t2r_0[18|11]/a_460_290# WL18 SL11 VSS sky130_fd_pr__nfet_g5v0d10v5 ad=0.65 pd=3.3 as=0 ps=0 w=1 l=0.5
X3241 BLP11 rr2t2r_0[18|11]/a_60_290# sky130_fd_pr_reram__reram_cell area_ox=0.0676
X3242 BLN11 rr2t2r_0[18|11]/a_460_290# sky130_fd_pr_reram__reram_cell area_ox=0.0676
X3243 rr2t2r_0[18|11]/a_60_290# WL18 SL11 VSS sky130_fd_pr__nfet_g5v0d10v5 ad=0.65 pd=3.3 as=0 ps=0 w=1 l=0.5
X3244 rr2t2r_0[19|11]/a_460_290# WL19 SL11 VSS sky130_fd_pr__nfet_g5v0d10v5 ad=0.65 pd=3.3 as=0 ps=0 w=1 l=0.5
X3245 BLP11 rr2t2r_0[19|11]/a_60_290# sky130_fd_pr_reram__reram_cell area_ox=0.0676
X3246 BLN11 rr2t2r_0[19|11]/a_460_290# sky130_fd_pr_reram__reram_cell area_ox=0.0676
X3247 rr2t2r_0[19|11]/a_60_290# WL19 SL11 VSS sky130_fd_pr__nfet_g5v0d10v5 ad=0.65 pd=3.3 as=0 ps=0 w=1 l=0.5
X3248 rr2t2r_0[20|11]/a_460_290# WL20 SL11 VSS sky130_fd_pr__nfet_g5v0d10v5 ad=0.65 pd=3.3 as=0 ps=0 w=1 l=0.5
X3249 BLP11 rr2t2r_0[20|11]/a_60_290# sky130_fd_pr_reram__reram_cell area_ox=0.0676
X3250 BLN11 rr2t2r_0[20|11]/a_460_290# sky130_fd_pr_reram__reram_cell area_ox=0.0676
X3251 rr2t2r_0[20|11]/a_60_290# WL20 SL11 VSS sky130_fd_pr__nfet_g5v0d10v5 ad=0.65 pd=3.3 as=0 ps=0 w=1 l=0.5
X3252 rr2t2r_0[21|11]/a_460_290# WL21 SL11 VSS sky130_fd_pr__nfet_g5v0d10v5 ad=0.65 pd=3.3 as=0 ps=0 w=1 l=0.5
X3253 BLP11 rr2t2r_0[21|11]/a_60_290# sky130_fd_pr_reram__reram_cell area_ox=0.0676
X3254 BLN11 rr2t2r_0[21|11]/a_460_290# sky130_fd_pr_reram__reram_cell area_ox=0.0676
X3255 rr2t2r_0[21|11]/a_60_290# WL21 SL11 VSS sky130_fd_pr__nfet_g5v0d10v5 ad=0.65 pd=3.3 as=0 ps=0 w=1 l=0.5
X3256 rr2t2r_0[22|11]/a_460_290# WL22 SL11 VSS sky130_fd_pr__nfet_g5v0d10v5 ad=0.65 pd=3.3 as=0 ps=0 w=1 l=0.5
X3257 BLP11 rr2t2r_0[22|11]/a_60_290# sky130_fd_pr_reram__reram_cell area_ox=0.0676
X3258 BLN11 rr2t2r_0[22|11]/a_460_290# sky130_fd_pr_reram__reram_cell area_ox=0.0676
X3259 rr2t2r_0[22|11]/a_60_290# WL22 SL11 VSS sky130_fd_pr__nfet_g5v0d10v5 ad=0.65 pd=3.3 as=0 ps=0 w=1 l=0.5
X3260 rr2t2r_0[23|11]/a_460_290# WL23 SL11 VSS sky130_fd_pr__nfet_g5v0d10v5 ad=0.65 pd=3.3 as=0 ps=0 w=1 l=0.5
X3261 BLP11 rr2t2r_0[23|11]/a_60_290# sky130_fd_pr_reram__reram_cell area_ox=0.0676
X3262 BLN11 rr2t2r_0[23|11]/a_460_290# sky130_fd_pr_reram__reram_cell area_ox=0.0676
X3263 rr2t2r_0[23|11]/a_60_290# WL23 SL11 VSS sky130_fd_pr__nfet_g5v0d10v5 ad=0.65 pd=3.3 as=0 ps=0 w=1 l=0.5
X3264 rr2t2r_0[24|11]/a_460_290# WL24 SL11 VSS sky130_fd_pr__nfet_g5v0d10v5 ad=0.65 pd=3.3 as=0 ps=0 w=1 l=0.5
X3265 BLP11 rr2t2r_0[24|11]/a_60_290# sky130_fd_pr_reram__reram_cell area_ox=0.0676
X3266 BLN11 rr2t2r_0[24|11]/a_460_290# sky130_fd_pr_reram__reram_cell area_ox=0.0676
X3267 rr2t2r_0[24|11]/a_60_290# WL24 SL11 VSS sky130_fd_pr__nfet_g5v0d10v5 ad=0.65 pd=3.3 as=0 ps=0 w=1 l=0.5
X3268 rr2t2r_0[25|11]/a_460_290# WL25 SL11 VSS sky130_fd_pr__nfet_g5v0d10v5 ad=0.65 pd=3.3 as=0 ps=0 w=1 l=0.5
X3269 BLP11 rr2t2r_0[25|11]/a_60_290# sky130_fd_pr_reram__reram_cell area_ox=0.0676
X3270 BLN11 rr2t2r_0[25|11]/a_460_290# sky130_fd_pr_reram__reram_cell area_ox=0.0676
X3271 rr2t2r_0[25|11]/a_60_290# WL25 SL11 VSS sky130_fd_pr__nfet_g5v0d10v5 ad=0.65 pd=3.3 as=0 ps=0 w=1 l=0.5
X3272 rr2t2r_0[26|11]/a_460_290# WL26 SL11 VSS sky130_fd_pr__nfet_g5v0d10v5 ad=0.65 pd=3.3 as=0 ps=0 w=1 l=0.5
X3273 BLP11 rr2t2r_0[26|11]/a_60_290# sky130_fd_pr_reram__reram_cell area_ox=0.0676
X3274 BLN11 rr2t2r_0[26|11]/a_460_290# sky130_fd_pr_reram__reram_cell area_ox=0.0676
X3275 rr2t2r_0[26|11]/a_60_290# WL26 SL11 VSS sky130_fd_pr__nfet_g5v0d10v5 ad=0.65 pd=3.3 as=0 ps=0 w=1 l=0.5
X3276 rr2t2r_0[27|11]/a_460_290# WL27 SL11 VSS sky130_fd_pr__nfet_g5v0d10v5 ad=0.65 pd=3.3 as=0 ps=0 w=1 l=0.5
X3277 BLP11 rr2t2r_0[27|11]/a_60_290# sky130_fd_pr_reram__reram_cell area_ox=0.0676
X3278 BLN11 rr2t2r_0[27|11]/a_460_290# sky130_fd_pr_reram__reram_cell area_ox=0.0676
X3279 rr2t2r_0[27|11]/a_60_290# WL27 SL11 VSS sky130_fd_pr__nfet_g5v0d10v5 ad=0.65 pd=3.3 as=0 ps=0 w=1 l=0.5
X3280 rr2t2r_0[28|11]/a_460_290# WL28 SL11 VSS sky130_fd_pr__nfet_g5v0d10v5 ad=0.65 pd=3.3 as=0 ps=0 w=1 l=0.5
X3281 BLP11 rr2t2r_0[28|11]/a_60_290# sky130_fd_pr_reram__reram_cell area_ox=0.0676
X3282 BLN11 rr2t2r_0[28|11]/a_460_290# sky130_fd_pr_reram__reram_cell area_ox=0.0676
X3283 rr2t2r_0[28|11]/a_60_290# WL28 SL11 VSS sky130_fd_pr__nfet_g5v0d10v5 ad=0.65 pd=3.3 as=0 ps=0 w=1 l=0.5
X3284 rr2t2r_0[29|11]/a_460_290# WL29 SL11 VSS sky130_fd_pr__nfet_g5v0d10v5 ad=0.65 pd=3.3 as=0 ps=0 w=1 l=0.5
X3285 BLP11 rr2t2r_0[29|11]/a_60_290# sky130_fd_pr_reram__reram_cell area_ox=0.0676
X3286 BLN11 rr2t2r_0[29|11]/a_460_290# sky130_fd_pr_reram__reram_cell area_ox=0.0676
X3287 rr2t2r_0[29|11]/a_60_290# WL29 SL11 VSS sky130_fd_pr__nfet_g5v0d10v5 ad=0.65 pd=3.3 as=0 ps=0 w=1 l=0.5
X3288 rr2t2r_0[30|11]/a_460_290# WL30 SL11 VSS sky130_fd_pr__nfet_g5v0d10v5 ad=0.65 pd=3.3 as=0 ps=0 w=1 l=0.5
X3289 BLP11 rr2t2r_0[30|11]/a_60_290# sky130_fd_pr_reram__reram_cell area_ox=0.0676
X3290 BLN11 rr2t2r_0[30|11]/a_460_290# sky130_fd_pr_reram__reram_cell area_ox=0.0676
X3291 rr2t2r_0[30|11]/a_60_290# WL30 SL11 VSS sky130_fd_pr__nfet_g5v0d10v5 ad=0.65 pd=3.3 as=0 ps=0 w=1 l=0.5
X3292 rr2t2r_0[31|11]/a_460_290# WL31 SL11 VSS sky130_fd_pr__nfet_g5v0d10v5 ad=0.65 pd=3.3 as=0 ps=0 w=1 l=0.5
X3293 BLP11 rr2t2r_0[31|11]/a_60_290# sky130_fd_pr_reram__reram_cell area_ox=0.0676
X3294 BLN11 rr2t2r_0[31|11]/a_460_290# sky130_fd_pr_reram__reram_cell area_ox=0.0676
X3295 rr2t2r_0[31|11]/a_60_290# WL31 SL11 VSS sky130_fd_pr__nfet_g5v0d10v5 ad=0.65 pd=3.3 as=0 ps=0 w=1 l=0.5
X3296 rr2t2r_0[32|11]/a_460_290# WL32 SL11 VSS sky130_fd_pr__nfet_g5v0d10v5 ad=0.65 pd=3.3 as=0 ps=0 w=1 l=0.5
X3297 BLP11 rr2t2r_0[32|11]/a_60_290# sky130_fd_pr_reram__reram_cell area_ox=0.0676
X3298 BLN11 rr2t2r_0[32|11]/a_460_290# sky130_fd_pr_reram__reram_cell area_ox=0.0676
X3299 rr2t2r_0[32|11]/a_60_290# WL32 SL11 VSS sky130_fd_pr__nfet_g5v0d10v5 ad=0.65 pd=3.3 as=0 ps=0 w=1 l=0.5
X3300 rr2t2r_0[33|11]/a_460_290# WL33 SL11 VSS sky130_fd_pr__nfet_g5v0d10v5 ad=0.65 pd=3.3 as=0 ps=0 w=1 l=0.5
X3301 BLP11 rr2t2r_0[33|11]/a_60_290# sky130_fd_pr_reram__reram_cell area_ox=0.0676
X3302 BLN11 rr2t2r_0[33|11]/a_460_290# sky130_fd_pr_reram__reram_cell area_ox=0.0676
X3303 rr2t2r_0[33|11]/a_60_290# WL33 SL11 VSS sky130_fd_pr__nfet_g5v0d10v5 ad=0.65 pd=3.3 as=0 ps=0 w=1 l=0.5
X3304 rr2t2r_0[34|11]/a_460_290# WL34 SL11 VSS sky130_fd_pr__nfet_g5v0d10v5 ad=0.65 pd=3.3 as=0 ps=0 w=1 l=0.5
X3305 BLP11 rr2t2r_0[34|11]/a_60_290# sky130_fd_pr_reram__reram_cell area_ox=0.0676
X3306 BLN11 rr2t2r_0[34|11]/a_460_290# sky130_fd_pr_reram__reram_cell area_ox=0.0676
X3307 rr2t2r_0[34|11]/a_60_290# WL34 SL11 VSS sky130_fd_pr__nfet_g5v0d10v5 ad=0.65 pd=3.3 as=0 ps=0 w=1 l=0.5
X3308 rr2t2r_0[35|11]/a_460_290# WL35 SL11 VSS sky130_fd_pr__nfet_g5v0d10v5 ad=0.65 pd=3.3 as=0 ps=0 w=1 l=0.5
X3309 BLP11 rr2t2r_0[35|11]/a_60_290# sky130_fd_pr_reram__reram_cell area_ox=0.0676
X3310 BLN11 rr2t2r_0[35|11]/a_460_290# sky130_fd_pr_reram__reram_cell area_ox=0.0676
X3311 rr2t2r_0[35|11]/a_60_290# WL35 SL11 VSS sky130_fd_pr__nfet_g5v0d10v5 ad=0.65 pd=3.3 as=0 ps=0 w=1 l=0.5
X3312 rr2t2r_0[36|11]/a_460_290# WL36 SL11 VSS sky130_fd_pr__nfet_g5v0d10v5 ad=0.65 pd=3.3 as=0 ps=0 w=1 l=0.5
X3313 BLP11 rr2t2r_0[36|11]/a_60_290# sky130_fd_pr_reram__reram_cell area_ox=0.0676
X3314 BLN11 rr2t2r_0[36|11]/a_460_290# sky130_fd_pr_reram__reram_cell area_ox=0.0676
X3315 rr2t2r_0[36|11]/a_60_290# WL36 SL11 VSS sky130_fd_pr__nfet_g5v0d10v5 ad=0.65 pd=3.3 as=0 ps=0 w=1 l=0.5
X3316 rr2t2r_0[37|11]/a_460_290# WL37 SL11 VSS sky130_fd_pr__nfet_g5v0d10v5 ad=0.65 pd=3.3 as=0 ps=0 w=1 l=0.5
X3317 BLP11 rr2t2r_0[37|11]/a_60_290# sky130_fd_pr_reram__reram_cell area_ox=0.0676
X3318 BLN11 rr2t2r_0[37|11]/a_460_290# sky130_fd_pr_reram__reram_cell area_ox=0.0676
X3319 rr2t2r_0[37|11]/a_60_290# WL37 SL11 VSS sky130_fd_pr__nfet_g5v0d10v5 ad=0.65 pd=3.3 as=0 ps=0 w=1 l=0.5
X3320 rr2t2r_0[38|11]/a_460_290# WL38 SL11 VSS sky130_fd_pr__nfet_g5v0d10v5 ad=0.65 pd=3.3 as=0 ps=0 w=1 l=0.5
X3321 BLP11 rr2t2r_0[38|11]/a_60_290# sky130_fd_pr_reram__reram_cell area_ox=0.0676
X3322 BLN11 rr2t2r_0[38|11]/a_460_290# sky130_fd_pr_reram__reram_cell area_ox=0.0676
X3323 rr2t2r_0[38|11]/a_60_290# WL38 SL11 VSS sky130_fd_pr__nfet_g5v0d10v5 ad=0.65 pd=3.3 as=0 ps=0 w=1 l=0.5
X3324 rr2t2r_0[39|11]/a_460_290# WL39 SL11 VSS sky130_fd_pr__nfet_g5v0d10v5 ad=0.65 pd=3.3 as=0 ps=0 w=1 l=0.5
X3325 BLP11 rr2t2r_0[39|11]/a_60_290# sky130_fd_pr_reram__reram_cell area_ox=0.0676
X3326 BLN11 rr2t2r_0[39|11]/a_460_290# sky130_fd_pr_reram__reram_cell area_ox=0.0676
X3327 rr2t2r_0[39|11]/a_60_290# WL39 SL11 VSS sky130_fd_pr__nfet_g5v0d10v5 ad=0.65 pd=3.3 as=0 ps=0 w=1 l=0.5
X3328 rr2t2r_0[40|11]/a_460_290# WL40 SL11 VSS sky130_fd_pr__nfet_g5v0d10v5 ad=0.65 pd=3.3 as=0 ps=0 w=1 l=0.5
X3329 BLP11 rr2t2r_0[40|11]/a_60_290# sky130_fd_pr_reram__reram_cell area_ox=0.0676
X3330 BLN11 rr2t2r_0[40|11]/a_460_290# sky130_fd_pr_reram__reram_cell area_ox=0.0676
X3331 rr2t2r_0[40|11]/a_60_290# WL40 SL11 VSS sky130_fd_pr__nfet_g5v0d10v5 ad=0.65 pd=3.3 as=0 ps=0 w=1 l=0.5
X3332 rr2t2r_0[41|11]/a_460_290# WL41 SL11 VSS sky130_fd_pr__nfet_g5v0d10v5 ad=0.65 pd=3.3 as=0 ps=0 w=1 l=0.5
X3333 BLP11 rr2t2r_0[41|11]/a_60_290# sky130_fd_pr_reram__reram_cell area_ox=0.0676
X3334 BLN11 rr2t2r_0[41|11]/a_460_290# sky130_fd_pr_reram__reram_cell area_ox=0.0676
X3335 rr2t2r_0[41|11]/a_60_290# WL41 SL11 VSS sky130_fd_pr__nfet_g5v0d10v5 ad=0.65 pd=3.3 as=0 ps=0 w=1 l=0.5
X3336 rr2t2r_0[42|11]/a_460_290# WL42 SL11 VSS sky130_fd_pr__nfet_g5v0d10v5 ad=0.65 pd=3.3 as=0 ps=0 w=1 l=0.5
X3337 BLP11 rr2t2r_0[42|11]/a_60_290# sky130_fd_pr_reram__reram_cell area_ox=0.0676
X3338 BLN11 rr2t2r_0[42|11]/a_460_290# sky130_fd_pr_reram__reram_cell area_ox=0.0676
X3339 rr2t2r_0[42|11]/a_60_290# WL42 SL11 VSS sky130_fd_pr__nfet_g5v0d10v5 ad=0.65 pd=3.3 as=0 ps=0 w=1 l=0.5
X3340 rr2t2r_0[43|11]/a_460_290# WL43 SL11 VSS sky130_fd_pr__nfet_g5v0d10v5 ad=0.65 pd=3.3 as=0 ps=0 w=1 l=0.5
X3341 BLP11 rr2t2r_0[43|11]/a_60_290# sky130_fd_pr_reram__reram_cell area_ox=0.0676
X3342 BLN11 rr2t2r_0[43|11]/a_460_290# sky130_fd_pr_reram__reram_cell area_ox=0.0676
X3343 rr2t2r_0[43|11]/a_60_290# WL43 SL11 VSS sky130_fd_pr__nfet_g5v0d10v5 ad=0.65 pd=3.3 as=0 ps=0 w=1 l=0.5
X3344 rr2t2r_0[44|11]/a_460_290# WL44 SL11 VSS sky130_fd_pr__nfet_g5v0d10v5 ad=0.65 pd=3.3 as=0 ps=0 w=1 l=0.5
X3345 BLP11 rr2t2r_0[44|11]/a_60_290# sky130_fd_pr_reram__reram_cell area_ox=0.0676
X3346 BLN11 rr2t2r_0[44|11]/a_460_290# sky130_fd_pr_reram__reram_cell area_ox=0.0676
X3347 rr2t2r_0[44|11]/a_60_290# WL44 SL11 VSS sky130_fd_pr__nfet_g5v0d10v5 ad=0.65 pd=3.3 as=0 ps=0 w=1 l=0.5
X3348 rr2t2r_0[45|11]/a_460_290# WL45 SL11 VSS sky130_fd_pr__nfet_g5v0d10v5 ad=0.65 pd=3.3 as=0 ps=0 w=1 l=0.5
X3349 BLP11 rr2t2r_0[45|11]/a_60_290# sky130_fd_pr_reram__reram_cell area_ox=0.0676
X3350 BLN11 rr2t2r_0[45|11]/a_460_290# sky130_fd_pr_reram__reram_cell area_ox=0.0676
X3351 rr2t2r_0[45|11]/a_60_290# WL45 SL11 VSS sky130_fd_pr__nfet_g5v0d10v5 ad=0.65 pd=3.3 as=0 ps=0 w=1 l=0.5
X3352 rr2t2r_0[46|11]/a_460_290# WL46 SL11 VSS sky130_fd_pr__nfet_g5v0d10v5 ad=0.65 pd=3.3 as=0 ps=0 w=1 l=0.5
X3353 BLP11 rr2t2r_0[46|11]/a_60_290# sky130_fd_pr_reram__reram_cell area_ox=0.0676
X3354 BLN11 rr2t2r_0[46|11]/a_460_290# sky130_fd_pr_reram__reram_cell area_ox=0.0676
X3355 rr2t2r_0[46|11]/a_60_290# WL46 SL11 VSS sky130_fd_pr__nfet_g5v0d10v5 ad=0.65 pd=3.3 as=0 ps=0 w=1 l=0.5
X3356 rr2t2r_0[47|11]/a_460_290# WL47 SL11 VSS sky130_fd_pr__nfet_g5v0d10v5 ad=0.65 pd=3.3 as=0 ps=0 w=1 l=0.5
X3357 BLP11 rr2t2r_0[47|11]/a_60_290# sky130_fd_pr_reram__reram_cell area_ox=0.0676
X3358 BLN11 rr2t2r_0[47|11]/a_460_290# sky130_fd_pr_reram__reram_cell area_ox=0.0676
X3359 rr2t2r_0[47|11]/a_60_290# WL47 SL11 VSS sky130_fd_pr__nfet_g5v0d10v5 ad=0.65 pd=3.3 as=0 ps=0 w=1 l=0.5
X3360 rr2t2r_0[48|11]/a_460_290# WL48 SL11 VSS sky130_fd_pr__nfet_g5v0d10v5 ad=0.65 pd=3.3 as=0 ps=0 w=1 l=0.5
X3361 BLP11 rr2t2r_0[48|11]/a_60_290# sky130_fd_pr_reram__reram_cell area_ox=0.0676
X3362 BLN11 rr2t2r_0[48|11]/a_460_290# sky130_fd_pr_reram__reram_cell area_ox=0.0676
X3363 rr2t2r_0[48|11]/a_60_290# WL48 SL11 VSS sky130_fd_pr__nfet_g5v0d10v5 ad=0.65 pd=3.3 as=0 ps=0 w=1 l=0.5
X3364 rr2t2r_0[49|11]/a_460_290# WL49 SL11 VSS sky130_fd_pr__nfet_g5v0d10v5 ad=0.65 pd=3.3 as=0 ps=0 w=1 l=0.5
X3365 BLP11 rr2t2r_0[49|11]/a_60_290# sky130_fd_pr_reram__reram_cell area_ox=0.0676
X3366 BLN11 rr2t2r_0[49|11]/a_460_290# sky130_fd_pr_reram__reram_cell area_ox=0.0676
X3367 rr2t2r_0[49|11]/a_60_290# WL49 SL11 VSS sky130_fd_pr__nfet_g5v0d10v5 ad=0.65 pd=3.3 as=0 ps=0 w=1 l=0.5
X3368 rr2t2r_0[50|11]/a_460_290# WL50 SL11 VSS sky130_fd_pr__nfet_g5v0d10v5 ad=0.65 pd=3.3 as=0 ps=0 w=1 l=0.5
X3369 BLP11 rr2t2r_0[50|11]/a_60_290# sky130_fd_pr_reram__reram_cell area_ox=0.0676
X3370 BLN11 rr2t2r_0[50|11]/a_460_290# sky130_fd_pr_reram__reram_cell area_ox=0.0676
X3371 rr2t2r_0[50|11]/a_60_290# WL50 SL11 VSS sky130_fd_pr__nfet_g5v0d10v5 ad=0.65 pd=3.3 as=0 ps=0 w=1 l=0.5
X3372 rr2t2r_0[51|11]/a_460_290# WL51 SL11 VSS sky130_fd_pr__nfet_g5v0d10v5 ad=0.65 pd=3.3 as=0 ps=0 w=1 l=0.5
X3373 BLP11 rr2t2r_0[51|11]/a_60_290# sky130_fd_pr_reram__reram_cell area_ox=0.0676
X3374 BLN11 rr2t2r_0[51|11]/a_460_290# sky130_fd_pr_reram__reram_cell area_ox=0.0676
X3375 rr2t2r_0[51|11]/a_60_290# WL51 SL11 VSS sky130_fd_pr__nfet_g5v0d10v5 ad=0.65 pd=3.3 as=0 ps=0 w=1 l=0.5
X3376 rr2t2r_0[52|11]/a_460_290# WL52 SL11 VSS sky130_fd_pr__nfet_g5v0d10v5 ad=0.65 pd=3.3 as=0 ps=0 w=1 l=0.5
X3377 BLP11 rr2t2r_0[52|11]/a_60_290# sky130_fd_pr_reram__reram_cell area_ox=0.0676
X3378 BLN11 rr2t2r_0[52|11]/a_460_290# sky130_fd_pr_reram__reram_cell area_ox=0.0676
X3379 rr2t2r_0[52|11]/a_60_290# WL52 SL11 VSS sky130_fd_pr__nfet_g5v0d10v5 ad=0.65 pd=3.3 as=0 ps=0 w=1 l=0.5
X3380 rr2t2r_0[53|11]/a_460_290# WL53 SL11 VSS sky130_fd_pr__nfet_g5v0d10v5 ad=0.65 pd=3.3 as=0 ps=0 w=1 l=0.5
X3381 BLP11 rr2t2r_0[53|11]/a_60_290# sky130_fd_pr_reram__reram_cell area_ox=0.0676
X3382 BLN11 rr2t2r_0[53|11]/a_460_290# sky130_fd_pr_reram__reram_cell area_ox=0.0676
X3383 rr2t2r_0[53|11]/a_60_290# WL53 SL11 VSS sky130_fd_pr__nfet_g5v0d10v5 ad=0.65 pd=3.3 as=0 ps=0 w=1 l=0.5
X3384 rr2t2r_0[54|11]/a_460_290# WL54 SL11 VSS sky130_fd_pr__nfet_g5v0d10v5 ad=0.65 pd=3.3 as=0 ps=0 w=1 l=0.5
X3385 BLP11 rr2t2r_0[54|11]/a_60_290# sky130_fd_pr_reram__reram_cell area_ox=0.0676
X3386 BLN11 rr2t2r_0[54|11]/a_460_290# sky130_fd_pr_reram__reram_cell area_ox=0.0676
X3387 rr2t2r_0[54|11]/a_60_290# WL54 SL11 VSS sky130_fd_pr__nfet_g5v0d10v5 ad=0.65 pd=3.3 as=0 ps=0 w=1 l=0.5
X3388 rr2t2r_0[55|11]/a_460_290# WL55 SL11 VSS sky130_fd_pr__nfet_g5v0d10v5 ad=0.65 pd=3.3 as=0 ps=0 w=1 l=0.5
X3389 BLP11 rr2t2r_0[55|11]/a_60_290# sky130_fd_pr_reram__reram_cell area_ox=0.0676
X3390 BLN11 rr2t2r_0[55|11]/a_460_290# sky130_fd_pr_reram__reram_cell area_ox=0.0676
X3391 rr2t2r_0[55|11]/a_60_290# WL55 SL11 VSS sky130_fd_pr__nfet_g5v0d10v5 ad=0.65 pd=3.3 as=0 ps=0 w=1 l=0.5
X3392 rr2t2r_0[56|11]/a_460_290# WL56 SL11 VSS sky130_fd_pr__nfet_g5v0d10v5 ad=0.65 pd=3.3 as=0 ps=0 w=1 l=0.5
X3393 BLP11 rr2t2r_0[56|11]/a_60_290# sky130_fd_pr_reram__reram_cell area_ox=0.0676
X3394 BLN11 rr2t2r_0[56|11]/a_460_290# sky130_fd_pr_reram__reram_cell area_ox=0.0676
X3395 rr2t2r_0[56|11]/a_60_290# WL56 SL11 VSS sky130_fd_pr__nfet_g5v0d10v5 ad=0.65 pd=3.3 as=0 ps=0 w=1 l=0.5
X3396 rr2t2r_0[57|11]/a_460_290# WL57 SL11 VSS sky130_fd_pr__nfet_g5v0d10v5 ad=0.65 pd=3.3 as=0 ps=0 w=1 l=0.5
X3397 BLP11 rr2t2r_0[57|11]/a_60_290# sky130_fd_pr_reram__reram_cell area_ox=0.0676
X3398 BLN11 rr2t2r_0[57|11]/a_460_290# sky130_fd_pr_reram__reram_cell area_ox=0.0676
X3399 rr2t2r_0[57|11]/a_60_290# WL57 SL11 VSS sky130_fd_pr__nfet_g5v0d10v5 ad=0.65 pd=3.3 as=0 ps=0 w=1 l=0.5
X3400 rr2t2r_0[58|11]/a_460_290# WL58 SL11 VSS sky130_fd_pr__nfet_g5v0d10v5 ad=0.65 pd=3.3 as=0 ps=0 w=1 l=0.5
X3401 BLP11 rr2t2r_0[58|11]/a_60_290# sky130_fd_pr_reram__reram_cell area_ox=0.0676
X3402 BLN11 rr2t2r_0[58|11]/a_460_290# sky130_fd_pr_reram__reram_cell area_ox=0.0676
X3403 rr2t2r_0[58|11]/a_60_290# WL58 SL11 VSS sky130_fd_pr__nfet_g5v0d10v5 ad=0.65 pd=3.3 as=0 ps=0 w=1 l=0.5
X3404 rr2t2r_0[59|11]/a_460_290# WL59 SL11 VSS sky130_fd_pr__nfet_g5v0d10v5 ad=0.65 pd=3.3 as=0 ps=0 w=1 l=0.5
X3405 BLP11 rr2t2r_0[59|11]/a_60_290# sky130_fd_pr_reram__reram_cell area_ox=0.0676
X3406 BLN11 rr2t2r_0[59|11]/a_460_290# sky130_fd_pr_reram__reram_cell area_ox=0.0676
X3407 rr2t2r_0[59|11]/a_60_290# WL59 SL11 VSS sky130_fd_pr__nfet_g5v0d10v5 ad=0.65 pd=3.3 as=0 ps=0 w=1 l=0.5
X3408 rr2t2r_0[60|11]/a_460_290# WL60 SL11 VSS sky130_fd_pr__nfet_g5v0d10v5 ad=0.65 pd=3.3 as=0 ps=0 w=1 l=0.5
X3409 BLP11 rr2t2r_0[60|11]/a_60_290# sky130_fd_pr_reram__reram_cell area_ox=0.0676
X3410 BLN11 rr2t2r_0[60|11]/a_460_290# sky130_fd_pr_reram__reram_cell area_ox=0.0676
X3411 rr2t2r_0[60|11]/a_60_290# WL60 SL11 VSS sky130_fd_pr__nfet_g5v0d10v5 ad=0.65 pd=3.3 as=0 ps=0 w=1 l=0.5
X3412 rr2t2r_0[61|11]/a_460_290# WL61 SL11 VSS sky130_fd_pr__nfet_g5v0d10v5 ad=0.65 pd=3.3 as=0 ps=0 w=1 l=0.5
X3413 BLP11 rr2t2r_0[61|11]/a_60_290# sky130_fd_pr_reram__reram_cell area_ox=0.0676
X3414 BLN11 rr2t2r_0[61|11]/a_460_290# sky130_fd_pr_reram__reram_cell area_ox=0.0676
X3415 rr2t2r_0[61|11]/a_60_290# WL61 SL11 VSS sky130_fd_pr__nfet_g5v0d10v5 ad=0.65 pd=3.3 as=0 ps=0 w=1 l=0.5
X3416 rr2t2r_0[62|11]/a_460_290# WL62 SL11 VSS sky130_fd_pr__nfet_g5v0d10v5 ad=0.65 pd=3.3 as=0 ps=0 w=1 l=0.5
X3417 BLP11 rr2t2r_0[62|11]/a_60_290# sky130_fd_pr_reram__reram_cell area_ox=0.0676
X3418 BLN11 rr2t2r_0[62|11]/a_460_290# sky130_fd_pr_reram__reram_cell area_ox=0.0676
X3419 rr2t2r_0[62|11]/a_60_290# WL62 SL11 VSS sky130_fd_pr__nfet_g5v0d10v5 ad=0.65 pd=3.3 as=0 ps=0 w=1 l=0.5
X3420 rr2t2r_0[63|11]/a_460_290# WL63 SL11 VSS sky130_fd_pr__nfet_g5v0d10v5 ad=0.65 pd=3.3 as=0 ps=0 w=1 l=0.5
X3421 BLP11 rr2t2r_0[63|11]/a_60_290# sky130_fd_pr_reram__reram_cell area_ox=0.0676
X3422 BLN11 rr2t2r_0[63|11]/a_460_290# sky130_fd_pr_reram__reram_cell area_ox=0.0676
X3423 rr2t2r_0[63|11]/a_60_290# WL63 SL11 VSS sky130_fd_pr__nfet_g5v0d10v5 ad=0.65 pd=3.3 as=0 ps=0 w=1 l=0.5
X3424 rr2t2r_0[64|11]/a_460_290# WL64 SL11 VSS sky130_fd_pr__nfet_g5v0d10v5 ad=0.65 pd=3.3 as=0 ps=0 w=1 l=0.5
X3425 BLP11 rr2t2r_0[64|11]/a_60_290# sky130_fd_pr_reram__reram_cell area_ox=0.0676
X3426 BLN11 rr2t2r_0[64|11]/a_460_290# sky130_fd_pr_reram__reram_cell area_ox=0.0676
X3427 rr2t2r_0[64|11]/a_60_290# WL64 SL11 VSS sky130_fd_pr__nfet_g5v0d10v5 ad=0.65 pd=3.3 as=0 ps=0 w=1 l=0.5
X3428 rr2t2r_0[65|11]/a_460_290# WL65 SL11 VSS sky130_fd_pr__nfet_g5v0d10v5 ad=0.65 pd=3.3 as=0 ps=0 w=1 l=0.5
X3429 BLP11 rr2t2r_0[65|11]/a_60_290# sky130_fd_pr_reram__reram_cell area_ox=0.0676
X3430 BLN11 rr2t2r_0[65|11]/a_460_290# sky130_fd_pr_reram__reram_cell area_ox=0.0676
X3431 rr2t2r_0[65|11]/a_60_290# WL65 SL11 VSS sky130_fd_pr__nfet_g5v0d10v5 ad=0.65 pd=3.3 as=0 ps=0 w=1 l=0.5
X3432 rr2t2r_0[66|11]/a_460_290# WL66 SL11 VSS sky130_fd_pr__nfet_g5v0d10v5 ad=0.65 pd=3.3 as=0 ps=0 w=1 l=0.5
X3433 BLP11 rr2t2r_0[66|11]/a_60_290# sky130_fd_pr_reram__reram_cell area_ox=0.0676
X3434 BLN11 rr2t2r_0[66|11]/a_460_290# sky130_fd_pr_reram__reram_cell area_ox=0.0676
X3435 rr2t2r_0[66|11]/a_60_290# WL66 SL11 VSS sky130_fd_pr__nfet_g5v0d10v5 ad=0.65 pd=3.3 as=0 ps=0 w=1 l=0.5
X3436 rr2t2r_0[67|11]/a_460_290# WL67 SL11 VSS sky130_fd_pr__nfet_g5v0d10v5 ad=0.65 pd=3.3 as=0 ps=0 w=1 l=0.5
X3437 BLP11 rr2t2r_0[67|11]/a_60_290# sky130_fd_pr_reram__reram_cell area_ox=0.0676
X3438 BLN11 rr2t2r_0[67|11]/a_460_290# sky130_fd_pr_reram__reram_cell area_ox=0.0676
X3439 rr2t2r_0[67|11]/a_60_290# WL67 SL11 VSS sky130_fd_pr__nfet_g5v0d10v5 ad=0.65 pd=3.3 as=0 ps=0 w=1 l=0.5
X3440 rr2t2r_0[68|11]/a_460_290# WL68 SL11 VSS sky130_fd_pr__nfet_g5v0d10v5 ad=0.65 pd=3.3 as=0 ps=0 w=1 l=0.5
X3441 BLP11 rr2t2r_0[68|11]/a_60_290# sky130_fd_pr_reram__reram_cell area_ox=0.0676
X3442 BLN11 rr2t2r_0[68|11]/a_460_290# sky130_fd_pr_reram__reram_cell area_ox=0.0676
X3443 rr2t2r_0[68|11]/a_60_290# WL68 SL11 VSS sky130_fd_pr__nfet_g5v0d10v5 ad=0.65 pd=3.3 as=0 ps=0 w=1 l=0.5
X3444 rr2t2r_0[69|11]/a_460_290# WL69 SL11 VSS sky130_fd_pr__nfet_g5v0d10v5 ad=0.65 pd=3.3 as=0 ps=0 w=1 l=0.5
X3445 BLP11 rr2t2r_0[69|11]/a_60_290# sky130_fd_pr_reram__reram_cell area_ox=0.0676
X3446 BLN11 rr2t2r_0[69|11]/a_460_290# sky130_fd_pr_reram__reram_cell area_ox=0.0676
X3447 rr2t2r_0[69|11]/a_60_290# WL69 SL11 VSS sky130_fd_pr__nfet_g5v0d10v5 ad=0.65 pd=3.3 as=0 ps=0 w=1 l=0.5
X3448 rr2t2r_0[70|11]/a_460_290# WL70 SL11 VSS sky130_fd_pr__nfet_g5v0d10v5 ad=0.65 pd=3.3 as=0 ps=0 w=1 l=0.5
X3449 BLP11 rr2t2r_0[70|11]/a_60_290# sky130_fd_pr_reram__reram_cell area_ox=0.0676
X3450 BLN11 rr2t2r_0[70|11]/a_460_290# sky130_fd_pr_reram__reram_cell area_ox=0.0676
X3451 rr2t2r_0[70|11]/a_60_290# WL70 SL11 VSS sky130_fd_pr__nfet_g5v0d10v5 ad=0.65 pd=3.3 as=0 ps=0 w=1 l=0.5
X3452 rr2t2r_0[71|11]/a_460_290# WL71 SL11 VSS sky130_fd_pr__nfet_g5v0d10v5 ad=0.65 pd=3.3 as=0 ps=0 w=1 l=0.5
X3453 BLP11 rr2t2r_0[71|11]/a_60_290# sky130_fd_pr_reram__reram_cell area_ox=0.0676
X3454 BLN11 rr2t2r_0[71|11]/a_460_290# sky130_fd_pr_reram__reram_cell area_ox=0.0676
X3455 rr2t2r_0[71|11]/a_60_290# WL71 SL11 VSS sky130_fd_pr__nfet_g5v0d10v5 ad=0.65 pd=3.3 as=0 ps=0 w=1 l=0.5
X3456 rr2t2r_0[0|12]/a_460_290# WL0 SL12 VSS sky130_fd_pr__nfet_g5v0d10v5 ad=0.65 pd=3.3 as=108 ps=504 w=1 l=0.5
X3457 BLP12 rr2t2r_0[0|12]/a_60_290# sky130_fd_pr_reram__reram_cell area_ox=0.0676
X3458 BLN12 rr2t2r_0[0|12]/a_460_290# sky130_fd_pr_reram__reram_cell area_ox=0.0676
X3459 rr2t2r_0[0|12]/a_60_290# WL0 SL12 VSS sky130_fd_pr__nfet_g5v0d10v5 ad=0.65 pd=3.3 as=0 ps=0 w=1 l=0.5
X3460 rr2t2r_0[1|12]/a_460_290# WL1 SL12 VSS sky130_fd_pr__nfet_g5v0d10v5 ad=0.65 pd=3.3 as=0 ps=0 w=1 l=0.5
X3461 BLP12 rr2t2r_0[1|12]/a_60_290# sky130_fd_pr_reram__reram_cell area_ox=0.0676
X3462 BLN12 rr2t2r_0[1|12]/a_460_290# sky130_fd_pr_reram__reram_cell area_ox=0.0676
X3463 rr2t2r_0[1|12]/a_60_290# WL1 SL12 VSS sky130_fd_pr__nfet_g5v0d10v5 ad=0.65 pd=3.3 as=0 ps=0 w=1 l=0.5
X3464 rr2t2r_0[2|12]/a_460_290# WL2 SL12 VSS sky130_fd_pr__nfet_g5v0d10v5 ad=0.65 pd=3.3 as=0 ps=0 w=1 l=0.5
X3465 BLP12 rr2t2r_0[2|12]/a_60_290# sky130_fd_pr_reram__reram_cell area_ox=0.0676
X3466 BLN12 rr2t2r_0[2|12]/a_460_290# sky130_fd_pr_reram__reram_cell area_ox=0.0676
X3467 rr2t2r_0[2|12]/a_60_290# WL2 SL12 VSS sky130_fd_pr__nfet_g5v0d10v5 ad=0.65 pd=3.3 as=0 ps=0 w=1 l=0.5
X3468 rr2t2r_0[3|12]/a_460_290# WL3 SL12 VSS sky130_fd_pr__nfet_g5v0d10v5 ad=0.65 pd=3.3 as=0 ps=0 w=1 l=0.5
X3469 BLP12 rr2t2r_0[3|12]/a_60_290# sky130_fd_pr_reram__reram_cell area_ox=0.0676
X3470 BLN12 rr2t2r_0[3|12]/a_460_290# sky130_fd_pr_reram__reram_cell area_ox=0.0676
X3471 rr2t2r_0[3|12]/a_60_290# WL3 SL12 VSS sky130_fd_pr__nfet_g5v0d10v5 ad=0.65 pd=3.3 as=0 ps=0 w=1 l=0.5
X3472 rr2t2r_0[4|12]/a_460_290# WL4 SL12 VSS sky130_fd_pr__nfet_g5v0d10v5 ad=0.65 pd=3.3 as=0 ps=0 w=1 l=0.5
X3473 BLP12 rr2t2r_0[4|12]/a_60_290# sky130_fd_pr_reram__reram_cell area_ox=0.0676
X3474 BLN12 rr2t2r_0[4|12]/a_460_290# sky130_fd_pr_reram__reram_cell area_ox=0.0676
X3475 rr2t2r_0[4|12]/a_60_290# WL4 SL12 VSS sky130_fd_pr__nfet_g5v0d10v5 ad=0.65 pd=3.3 as=0 ps=0 w=1 l=0.5
X3476 rr2t2r_0[5|12]/a_460_290# WL5 SL12 VSS sky130_fd_pr__nfet_g5v0d10v5 ad=0.65 pd=3.3 as=0 ps=0 w=1 l=0.5
X3477 BLP12 rr2t2r_0[5|12]/a_60_290# sky130_fd_pr_reram__reram_cell area_ox=0.0676
X3478 BLN12 rr2t2r_0[5|12]/a_460_290# sky130_fd_pr_reram__reram_cell area_ox=0.0676
X3479 rr2t2r_0[5|12]/a_60_290# WL5 SL12 VSS sky130_fd_pr__nfet_g5v0d10v5 ad=0.65 pd=3.3 as=0 ps=0 w=1 l=0.5
X3480 rr2t2r_0[6|12]/a_460_290# WL6 SL12 VSS sky130_fd_pr__nfet_g5v0d10v5 ad=0.65 pd=3.3 as=0 ps=0 w=1 l=0.5
X3481 BLP12 rr2t2r_0[6|12]/a_60_290# sky130_fd_pr_reram__reram_cell area_ox=0.0676
X3482 BLN12 rr2t2r_0[6|12]/a_460_290# sky130_fd_pr_reram__reram_cell area_ox=0.0676
X3483 rr2t2r_0[6|12]/a_60_290# WL6 SL12 VSS sky130_fd_pr__nfet_g5v0d10v5 ad=0.65 pd=3.3 as=0 ps=0 w=1 l=0.5
X3484 rr2t2r_0[7|12]/a_460_290# WL7 SL12 VSS sky130_fd_pr__nfet_g5v0d10v5 ad=0.65 pd=3.3 as=0 ps=0 w=1 l=0.5
X3485 BLP12 rr2t2r_0[7|12]/a_60_290# sky130_fd_pr_reram__reram_cell area_ox=0.0676
X3486 BLN12 rr2t2r_0[7|12]/a_460_290# sky130_fd_pr_reram__reram_cell area_ox=0.0676
X3487 rr2t2r_0[7|12]/a_60_290# WL7 SL12 VSS sky130_fd_pr__nfet_g5v0d10v5 ad=0.65 pd=3.3 as=0 ps=0 w=1 l=0.5
X3488 rr2t2r_0[8|12]/a_460_290# WL8 SL12 VSS sky130_fd_pr__nfet_g5v0d10v5 ad=0.65 pd=3.3 as=0 ps=0 w=1 l=0.5
X3489 BLP12 rr2t2r_0[8|12]/a_60_290# sky130_fd_pr_reram__reram_cell area_ox=0.0676
X3490 BLN12 rr2t2r_0[8|12]/a_460_290# sky130_fd_pr_reram__reram_cell area_ox=0.0676
X3491 rr2t2r_0[8|12]/a_60_290# WL8 SL12 VSS sky130_fd_pr__nfet_g5v0d10v5 ad=0.65 pd=3.3 as=0 ps=0 w=1 l=0.5
X3492 rr2t2r_0[9|12]/a_460_290# WL9 SL12 VSS sky130_fd_pr__nfet_g5v0d10v5 ad=0.65 pd=3.3 as=0 ps=0 w=1 l=0.5
X3493 BLP12 rr2t2r_0[9|12]/a_60_290# sky130_fd_pr_reram__reram_cell area_ox=0.0676
X3494 BLN12 rr2t2r_0[9|12]/a_460_290# sky130_fd_pr_reram__reram_cell area_ox=0.0676
X3495 rr2t2r_0[9|12]/a_60_290# WL9 SL12 VSS sky130_fd_pr__nfet_g5v0d10v5 ad=0.65 pd=3.3 as=0 ps=0 w=1 l=0.5
X3496 rr2t2r_0[10|12]/a_460_290# WL10 SL12 VSS sky130_fd_pr__nfet_g5v0d10v5 ad=0.65 pd=3.3 as=0 ps=0 w=1 l=0.5
X3497 BLP12 rr2t2r_0[10|12]/a_60_290# sky130_fd_pr_reram__reram_cell area_ox=0.0676
X3498 BLN12 rr2t2r_0[10|12]/a_460_290# sky130_fd_pr_reram__reram_cell area_ox=0.0676
X3499 rr2t2r_0[10|12]/a_60_290# WL10 SL12 VSS sky130_fd_pr__nfet_g5v0d10v5 ad=0.65 pd=3.3 as=0 ps=0 w=1 l=0.5
X3500 rr2t2r_0[11|12]/a_460_290# WL11 SL12 VSS sky130_fd_pr__nfet_g5v0d10v5 ad=0.65 pd=3.3 as=0 ps=0 w=1 l=0.5
X3501 BLP12 rr2t2r_0[11|12]/a_60_290# sky130_fd_pr_reram__reram_cell area_ox=0.0676
X3502 BLN12 rr2t2r_0[11|12]/a_460_290# sky130_fd_pr_reram__reram_cell area_ox=0.0676
X3503 rr2t2r_0[11|12]/a_60_290# WL11 SL12 VSS sky130_fd_pr__nfet_g5v0d10v5 ad=0.65 pd=3.3 as=0 ps=0 w=1 l=0.5
X3504 rr2t2r_0[12|12]/a_460_290# WL12 SL12 VSS sky130_fd_pr__nfet_g5v0d10v5 ad=0.65 pd=3.3 as=0 ps=0 w=1 l=0.5
X3505 BLP12 rr2t2r_0[12|12]/a_60_290# sky130_fd_pr_reram__reram_cell area_ox=0.0676
X3506 BLN12 rr2t2r_0[12|12]/a_460_290# sky130_fd_pr_reram__reram_cell area_ox=0.0676
X3507 rr2t2r_0[12|12]/a_60_290# WL12 SL12 VSS sky130_fd_pr__nfet_g5v0d10v5 ad=0.65 pd=3.3 as=0 ps=0 w=1 l=0.5
X3508 rr2t2r_0[13|12]/a_460_290# WL13 SL12 VSS sky130_fd_pr__nfet_g5v0d10v5 ad=0.65 pd=3.3 as=0 ps=0 w=1 l=0.5
X3509 BLP12 rr2t2r_0[13|12]/a_60_290# sky130_fd_pr_reram__reram_cell area_ox=0.0676
X3510 BLN12 rr2t2r_0[13|12]/a_460_290# sky130_fd_pr_reram__reram_cell area_ox=0.0676
X3511 rr2t2r_0[13|12]/a_60_290# WL13 SL12 VSS sky130_fd_pr__nfet_g5v0d10v5 ad=0.65 pd=3.3 as=0 ps=0 w=1 l=0.5
X3512 rr2t2r_0[14|12]/a_460_290# WL14 SL12 VSS sky130_fd_pr__nfet_g5v0d10v5 ad=0.65 pd=3.3 as=0 ps=0 w=1 l=0.5
X3513 BLP12 rr2t2r_0[14|12]/a_60_290# sky130_fd_pr_reram__reram_cell area_ox=0.0676
X3514 BLN12 rr2t2r_0[14|12]/a_460_290# sky130_fd_pr_reram__reram_cell area_ox=0.0676
X3515 rr2t2r_0[14|12]/a_60_290# WL14 SL12 VSS sky130_fd_pr__nfet_g5v0d10v5 ad=0.65 pd=3.3 as=0 ps=0 w=1 l=0.5
X3516 rr2t2r_0[15|12]/a_460_290# WL15 SL12 VSS sky130_fd_pr__nfet_g5v0d10v5 ad=0.65 pd=3.3 as=0 ps=0 w=1 l=0.5
X3517 BLP12 rr2t2r_0[15|12]/a_60_290# sky130_fd_pr_reram__reram_cell area_ox=0.0676
X3518 BLN12 rr2t2r_0[15|12]/a_460_290# sky130_fd_pr_reram__reram_cell area_ox=0.0676
X3519 rr2t2r_0[15|12]/a_60_290# WL15 SL12 VSS sky130_fd_pr__nfet_g5v0d10v5 ad=0.65 pd=3.3 as=0 ps=0 w=1 l=0.5
X3520 rr2t2r_0[16|12]/a_460_290# WL16 SL12 VSS sky130_fd_pr__nfet_g5v0d10v5 ad=0.65 pd=3.3 as=0 ps=0 w=1 l=0.5
X3521 BLP12 rr2t2r_0[16|12]/a_60_290# sky130_fd_pr_reram__reram_cell area_ox=0.0676
X3522 BLN12 rr2t2r_0[16|12]/a_460_290# sky130_fd_pr_reram__reram_cell area_ox=0.0676
X3523 rr2t2r_0[16|12]/a_60_290# WL16 SL12 VSS sky130_fd_pr__nfet_g5v0d10v5 ad=0.65 pd=3.3 as=0 ps=0 w=1 l=0.5
X3524 rr2t2r_0[17|12]/a_460_290# WL17 SL12 VSS sky130_fd_pr__nfet_g5v0d10v5 ad=0.65 pd=3.3 as=0 ps=0 w=1 l=0.5
X3525 BLP12 rr2t2r_0[17|12]/a_60_290# sky130_fd_pr_reram__reram_cell area_ox=0.0676
X3526 BLN12 rr2t2r_0[17|12]/a_460_290# sky130_fd_pr_reram__reram_cell area_ox=0.0676
X3527 rr2t2r_0[17|12]/a_60_290# WL17 SL12 VSS sky130_fd_pr__nfet_g5v0d10v5 ad=0.65 pd=3.3 as=0 ps=0 w=1 l=0.5
X3528 rr2t2r_0[18|12]/a_460_290# WL18 SL12 VSS sky130_fd_pr__nfet_g5v0d10v5 ad=0.65 pd=3.3 as=0 ps=0 w=1 l=0.5
X3529 BLP12 rr2t2r_0[18|12]/a_60_290# sky130_fd_pr_reram__reram_cell area_ox=0.0676
X3530 BLN12 rr2t2r_0[18|12]/a_460_290# sky130_fd_pr_reram__reram_cell area_ox=0.0676
X3531 rr2t2r_0[18|12]/a_60_290# WL18 SL12 VSS sky130_fd_pr__nfet_g5v0d10v5 ad=0.65 pd=3.3 as=0 ps=0 w=1 l=0.5
X3532 rr2t2r_0[19|12]/a_460_290# WL19 SL12 VSS sky130_fd_pr__nfet_g5v0d10v5 ad=0.65 pd=3.3 as=0 ps=0 w=1 l=0.5
X3533 BLP12 rr2t2r_0[19|12]/a_60_290# sky130_fd_pr_reram__reram_cell area_ox=0.0676
X3534 BLN12 rr2t2r_0[19|12]/a_460_290# sky130_fd_pr_reram__reram_cell area_ox=0.0676
X3535 rr2t2r_0[19|12]/a_60_290# WL19 SL12 VSS sky130_fd_pr__nfet_g5v0d10v5 ad=0.65 pd=3.3 as=0 ps=0 w=1 l=0.5
X3536 rr2t2r_0[20|12]/a_460_290# WL20 SL12 VSS sky130_fd_pr__nfet_g5v0d10v5 ad=0.65 pd=3.3 as=0 ps=0 w=1 l=0.5
X3537 BLP12 rr2t2r_0[20|12]/a_60_290# sky130_fd_pr_reram__reram_cell area_ox=0.0676
X3538 BLN12 rr2t2r_0[20|12]/a_460_290# sky130_fd_pr_reram__reram_cell area_ox=0.0676
X3539 rr2t2r_0[20|12]/a_60_290# WL20 SL12 VSS sky130_fd_pr__nfet_g5v0d10v5 ad=0.65 pd=3.3 as=0 ps=0 w=1 l=0.5
X3540 rr2t2r_0[21|12]/a_460_290# WL21 SL12 VSS sky130_fd_pr__nfet_g5v0d10v5 ad=0.65 pd=3.3 as=0 ps=0 w=1 l=0.5
X3541 BLP12 rr2t2r_0[21|12]/a_60_290# sky130_fd_pr_reram__reram_cell area_ox=0.0676
X3542 BLN12 rr2t2r_0[21|12]/a_460_290# sky130_fd_pr_reram__reram_cell area_ox=0.0676
X3543 rr2t2r_0[21|12]/a_60_290# WL21 SL12 VSS sky130_fd_pr__nfet_g5v0d10v5 ad=0.65 pd=3.3 as=0 ps=0 w=1 l=0.5
X3544 rr2t2r_0[22|12]/a_460_290# WL22 SL12 VSS sky130_fd_pr__nfet_g5v0d10v5 ad=0.65 pd=3.3 as=0 ps=0 w=1 l=0.5
X3545 BLP12 rr2t2r_0[22|12]/a_60_290# sky130_fd_pr_reram__reram_cell area_ox=0.0676
X3546 BLN12 rr2t2r_0[22|12]/a_460_290# sky130_fd_pr_reram__reram_cell area_ox=0.0676
X3547 rr2t2r_0[22|12]/a_60_290# WL22 SL12 VSS sky130_fd_pr__nfet_g5v0d10v5 ad=0.65 pd=3.3 as=0 ps=0 w=1 l=0.5
X3548 rr2t2r_0[23|12]/a_460_290# WL23 SL12 VSS sky130_fd_pr__nfet_g5v0d10v5 ad=0.65 pd=3.3 as=0 ps=0 w=1 l=0.5
X3549 BLP12 rr2t2r_0[23|12]/a_60_290# sky130_fd_pr_reram__reram_cell area_ox=0.0676
X3550 BLN12 rr2t2r_0[23|12]/a_460_290# sky130_fd_pr_reram__reram_cell area_ox=0.0676
X3551 rr2t2r_0[23|12]/a_60_290# WL23 SL12 VSS sky130_fd_pr__nfet_g5v0d10v5 ad=0.65 pd=3.3 as=0 ps=0 w=1 l=0.5
X3552 rr2t2r_0[24|12]/a_460_290# WL24 SL12 VSS sky130_fd_pr__nfet_g5v0d10v5 ad=0.65 pd=3.3 as=0 ps=0 w=1 l=0.5
X3553 BLP12 rr2t2r_0[24|12]/a_60_290# sky130_fd_pr_reram__reram_cell area_ox=0.0676
X3554 BLN12 rr2t2r_0[24|12]/a_460_290# sky130_fd_pr_reram__reram_cell area_ox=0.0676
X3555 rr2t2r_0[24|12]/a_60_290# WL24 SL12 VSS sky130_fd_pr__nfet_g5v0d10v5 ad=0.65 pd=3.3 as=0 ps=0 w=1 l=0.5
X3556 rr2t2r_0[25|12]/a_460_290# WL25 SL12 VSS sky130_fd_pr__nfet_g5v0d10v5 ad=0.65 pd=3.3 as=0 ps=0 w=1 l=0.5
X3557 BLP12 rr2t2r_0[25|12]/a_60_290# sky130_fd_pr_reram__reram_cell area_ox=0.0676
X3558 BLN12 rr2t2r_0[25|12]/a_460_290# sky130_fd_pr_reram__reram_cell area_ox=0.0676
X3559 rr2t2r_0[25|12]/a_60_290# WL25 SL12 VSS sky130_fd_pr__nfet_g5v0d10v5 ad=0.65 pd=3.3 as=0 ps=0 w=1 l=0.5
X3560 rr2t2r_0[26|12]/a_460_290# WL26 SL12 VSS sky130_fd_pr__nfet_g5v0d10v5 ad=0.65 pd=3.3 as=0 ps=0 w=1 l=0.5
X3561 BLP12 rr2t2r_0[26|12]/a_60_290# sky130_fd_pr_reram__reram_cell area_ox=0.0676
X3562 BLN12 rr2t2r_0[26|12]/a_460_290# sky130_fd_pr_reram__reram_cell area_ox=0.0676
X3563 rr2t2r_0[26|12]/a_60_290# WL26 SL12 VSS sky130_fd_pr__nfet_g5v0d10v5 ad=0.65 pd=3.3 as=0 ps=0 w=1 l=0.5
X3564 rr2t2r_0[27|12]/a_460_290# WL27 SL12 VSS sky130_fd_pr__nfet_g5v0d10v5 ad=0.65 pd=3.3 as=0 ps=0 w=1 l=0.5
X3565 BLP12 rr2t2r_0[27|12]/a_60_290# sky130_fd_pr_reram__reram_cell area_ox=0.0676
X3566 BLN12 rr2t2r_0[27|12]/a_460_290# sky130_fd_pr_reram__reram_cell area_ox=0.0676
X3567 rr2t2r_0[27|12]/a_60_290# WL27 SL12 VSS sky130_fd_pr__nfet_g5v0d10v5 ad=0.65 pd=3.3 as=0 ps=0 w=1 l=0.5
X3568 rr2t2r_0[28|12]/a_460_290# WL28 SL12 VSS sky130_fd_pr__nfet_g5v0d10v5 ad=0.65 pd=3.3 as=0 ps=0 w=1 l=0.5
X3569 BLP12 rr2t2r_0[28|12]/a_60_290# sky130_fd_pr_reram__reram_cell area_ox=0.0676
X3570 BLN12 rr2t2r_0[28|12]/a_460_290# sky130_fd_pr_reram__reram_cell area_ox=0.0676
X3571 rr2t2r_0[28|12]/a_60_290# WL28 SL12 VSS sky130_fd_pr__nfet_g5v0d10v5 ad=0.65 pd=3.3 as=0 ps=0 w=1 l=0.5
X3572 rr2t2r_0[29|12]/a_460_290# WL29 SL12 VSS sky130_fd_pr__nfet_g5v0d10v5 ad=0.65 pd=3.3 as=0 ps=0 w=1 l=0.5
X3573 BLP12 rr2t2r_0[29|12]/a_60_290# sky130_fd_pr_reram__reram_cell area_ox=0.0676
X3574 BLN12 rr2t2r_0[29|12]/a_460_290# sky130_fd_pr_reram__reram_cell area_ox=0.0676
X3575 rr2t2r_0[29|12]/a_60_290# WL29 SL12 VSS sky130_fd_pr__nfet_g5v0d10v5 ad=0.65 pd=3.3 as=0 ps=0 w=1 l=0.5
X3576 rr2t2r_0[30|12]/a_460_290# WL30 SL12 VSS sky130_fd_pr__nfet_g5v0d10v5 ad=0.65 pd=3.3 as=0 ps=0 w=1 l=0.5
X3577 BLP12 rr2t2r_0[30|12]/a_60_290# sky130_fd_pr_reram__reram_cell area_ox=0.0676
X3578 BLN12 rr2t2r_0[30|12]/a_460_290# sky130_fd_pr_reram__reram_cell area_ox=0.0676
X3579 rr2t2r_0[30|12]/a_60_290# WL30 SL12 VSS sky130_fd_pr__nfet_g5v0d10v5 ad=0.65 pd=3.3 as=0 ps=0 w=1 l=0.5
X3580 rr2t2r_0[31|12]/a_460_290# WL31 SL12 VSS sky130_fd_pr__nfet_g5v0d10v5 ad=0.65 pd=3.3 as=0 ps=0 w=1 l=0.5
X3581 BLP12 rr2t2r_0[31|12]/a_60_290# sky130_fd_pr_reram__reram_cell area_ox=0.0676
X3582 BLN12 rr2t2r_0[31|12]/a_460_290# sky130_fd_pr_reram__reram_cell area_ox=0.0676
X3583 rr2t2r_0[31|12]/a_60_290# WL31 SL12 VSS sky130_fd_pr__nfet_g5v0d10v5 ad=0.65 pd=3.3 as=0 ps=0 w=1 l=0.5
X3584 rr2t2r_0[32|12]/a_460_290# WL32 SL12 VSS sky130_fd_pr__nfet_g5v0d10v5 ad=0.65 pd=3.3 as=0 ps=0 w=1 l=0.5
X3585 BLP12 rr2t2r_0[32|12]/a_60_290# sky130_fd_pr_reram__reram_cell area_ox=0.0676
X3586 BLN12 rr2t2r_0[32|12]/a_460_290# sky130_fd_pr_reram__reram_cell area_ox=0.0676
X3587 rr2t2r_0[32|12]/a_60_290# WL32 SL12 VSS sky130_fd_pr__nfet_g5v0d10v5 ad=0.65 pd=3.3 as=0 ps=0 w=1 l=0.5
X3588 rr2t2r_0[33|12]/a_460_290# WL33 SL12 VSS sky130_fd_pr__nfet_g5v0d10v5 ad=0.65 pd=3.3 as=0 ps=0 w=1 l=0.5
X3589 BLP12 rr2t2r_0[33|12]/a_60_290# sky130_fd_pr_reram__reram_cell area_ox=0.0676
X3590 BLN12 rr2t2r_0[33|12]/a_460_290# sky130_fd_pr_reram__reram_cell area_ox=0.0676
X3591 rr2t2r_0[33|12]/a_60_290# WL33 SL12 VSS sky130_fd_pr__nfet_g5v0d10v5 ad=0.65 pd=3.3 as=0 ps=0 w=1 l=0.5
X3592 rr2t2r_0[34|12]/a_460_290# WL34 SL12 VSS sky130_fd_pr__nfet_g5v0d10v5 ad=0.65 pd=3.3 as=0 ps=0 w=1 l=0.5
X3593 BLP12 rr2t2r_0[34|12]/a_60_290# sky130_fd_pr_reram__reram_cell area_ox=0.0676
X3594 BLN12 rr2t2r_0[34|12]/a_460_290# sky130_fd_pr_reram__reram_cell area_ox=0.0676
X3595 rr2t2r_0[34|12]/a_60_290# WL34 SL12 VSS sky130_fd_pr__nfet_g5v0d10v5 ad=0.65 pd=3.3 as=0 ps=0 w=1 l=0.5
X3596 rr2t2r_0[35|12]/a_460_290# WL35 SL12 VSS sky130_fd_pr__nfet_g5v0d10v5 ad=0.65 pd=3.3 as=0 ps=0 w=1 l=0.5
X3597 BLP12 rr2t2r_0[35|12]/a_60_290# sky130_fd_pr_reram__reram_cell area_ox=0.0676
X3598 BLN12 rr2t2r_0[35|12]/a_460_290# sky130_fd_pr_reram__reram_cell area_ox=0.0676
X3599 rr2t2r_0[35|12]/a_60_290# WL35 SL12 VSS sky130_fd_pr__nfet_g5v0d10v5 ad=0.65 pd=3.3 as=0 ps=0 w=1 l=0.5
X3600 rr2t2r_0[36|12]/a_460_290# WL36 SL12 VSS sky130_fd_pr__nfet_g5v0d10v5 ad=0.65 pd=3.3 as=0 ps=0 w=1 l=0.5
X3601 BLP12 rr2t2r_0[36|12]/a_60_290# sky130_fd_pr_reram__reram_cell area_ox=0.0676
X3602 BLN12 rr2t2r_0[36|12]/a_460_290# sky130_fd_pr_reram__reram_cell area_ox=0.0676
X3603 rr2t2r_0[36|12]/a_60_290# WL36 SL12 VSS sky130_fd_pr__nfet_g5v0d10v5 ad=0.65 pd=3.3 as=0 ps=0 w=1 l=0.5
X3604 rr2t2r_0[37|12]/a_460_290# WL37 SL12 VSS sky130_fd_pr__nfet_g5v0d10v5 ad=0.65 pd=3.3 as=0 ps=0 w=1 l=0.5
X3605 BLP12 rr2t2r_0[37|12]/a_60_290# sky130_fd_pr_reram__reram_cell area_ox=0.0676
X3606 BLN12 rr2t2r_0[37|12]/a_460_290# sky130_fd_pr_reram__reram_cell area_ox=0.0676
X3607 rr2t2r_0[37|12]/a_60_290# WL37 SL12 VSS sky130_fd_pr__nfet_g5v0d10v5 ad=0.65 pd=3.3 as=0 ps=0 w=1 l=0.5
X3608 rr2t2r_0[38|12]/a_460_290# WL38 SL12 VSS sky130_fd_pr__nfet_g5v0d10v5 ad=0.65 pd=3.3 as=0 ps=0 w=1 l=0.5
X3609 BLP12 rr2t2r_0[38|12]/a_60_290# sky130_fd_pr_reram__reram_cell area_ox=0.0676
X3610 BLN12 rr2t2r_0[38|12]/a_460_290# sky130_fd_pr_reram__reram_cell area_ox=0.0676
X3611 rr2t2r_0[38|12]/a_60_290# WL38 SL12 VSS sky130_fd_pr__nfet_g5v0d10v5 ad=0.65 pd=3.3 as=0 ps=0 w=1 l=0.5
X3612 rr2t2r_0[39|12]/a_460_290# WL39 SL12 VSS sky130_fd_pr__nfet_g5v0d10v5 ad=0.65 pd=3.3 as=0 ps=0 w=1 l=0.5
X3613 BLP12 rr2t2r_0[39|12]/a_60_290# sky130_fd_pr_reram__reram_cell area_ox=0.0676
X3614 BLN12 rr2t2r_0[39|12]/a_460_290# sky130_fd_pr_reram__reram_cell area_ox=0.0676
X3615 rr2t2r_0[39|12]/a_60_290# WL39 SL12 VSS sky130_fd_pr__nfet_g5v0d10v5 ad=0.65 pd=3.3 as=0 ps=0 w=1 l=0.5
X3616 rr2t2r_0[40|12]/a_460_290# WL40 SL12 VSS sky130_fd_pr__nfet_g5v0d10v5 ad=0.65 pd=3.3 as=0 ps=0 w=1 l=0.5
X3617 BLP12 rr2t2r_0[40|12]/a_60_290# sky130_fd_pr_reram__reram_cell area_ox=0.0676
X3618 BLN12 rr2t2r_0[40|12]/a_460_290# sky130_fd_pr_reram__reram_cell area_ox=0.0676
X3619 rr2t2r_0[40|12]/a_60_290# WL40 SL12 VSS sky130_fd_pr__nfet_g5v0d10v5 ad=0.65 pd=3.3 as=0 ps=0 w=1 l=0.5
X3620 rr2t2r_0[41|12]/a_460_290# WL41 SL12 VSS sky130_fd_pr__nfet_g5v0d10v5 ad=0.65 pd=3.3 as=0 ps=0 w=1 l=0.5
X3621 BLP12 rr2t2r_0[41|12]/a_60_290# sky130_fd_pr_reram__reram_cell area_ox=0.0676
X3622 BLN12 rr2t2r_0[41|12]/a_460_290# sky130_fd_pr_reram__reram_cell area_ox=0.0676
X3623 rr2t2r_0[41|12]/a_60_290# WL41 SL12 VSS sky130_fd_pr__nfet_g5v0d10v5 ad=0.65 pd=3.3 as=0 ps=0 w=1 l=0.5
X3624 rr2t2r_0[42|12]/a_460_290# WL42 SL12 VSS sky130_fd_pr__nfet_g5v0d10v5 ad=0.65 pd=3.3 as=0 ps=0 w=1 l=0.5
X3625 BLP12 rr2t2r_0[42|12]/a_60_290# sky130_fd_pr_reram__reram_cell area_ox=0.0676
X3626 BLN12 rr2t2r_0[42|12]/a_460_290# sky130_fd_pr_reram__reram_cell area_ox=0.0676
X3627 rr2t2r_0[42|12]/a_60_290# WL42 SL12 VSS sky130_fd_pr__nfet_g5v0d10v5 ad=0.65 pd=3.3 as=0 ps=0 w=1 l=0.5
X3628 rr2t2r_0[43|12]/a_460_290# WL43 SL12 VSS sky130_fd_pr__nfet_g5v0d10v5 ad=0.65 pd=3.3 as=0 ps=0 w=1 l=0.5
X3629 BLP12 rr2t2r_0[43|12]/a_60_290# sky130_fd_pr_reram__reram_cell area_ox=0.0676
X3630 BLN12 rr2t2r_0[43|12]/a_460_290# sky130_fd_pr_reram__reram_cell area_ox=0.0676
X3631 rr2t2r_0[43|12]/a_60_290# WL43 SL12 VSS sky130_fd_pr__nfet_g5v0d10v5 ad=0.65 pd=3.3 as=0 ps=0 w=1 l=0.5
X3632 rr2t2r_0[44|12]/a_460_290# WL44 SL12 VSS sky130_fd_pr__nfet_g5v0d10v5 ad=0.65 pd=3.3 as=0 ps=0 w=1 l=0.5
X3633 BLP12 rr2t2r_0[44|12]/a_60_290# sky130_fd_pr_reram__reram_cell area_ox=0.0676
X3634 BLN12 rr2t2r_0[44|12]/a_460_290# sky130_fd_pr_reram__reram_cell area_ox=0.0676
X3635 rr2t2r_0[44|12]/a_60_290# WL44 SL12 VSS sky130_fd_pr__nfet_g5v0d10v5 ad=0.65 pd=3.3 as=0 ps=0 w=1 l=0.5
X3636 rr2t2r_0[45|12]/a_460_290# WL45 SL12 VSS sky130_fd_pr__nfet_g5v0d10v5 ad=0.65 pd=3.3 as=0 ps=0 w=1 l=0.5
X3637 BLP12 rr2t2r_0[45|12]/a_60_290# sky130_fd_pr_reram__reram_cell area_ox=0.0676
X3638 BLN12 rr2t2r_0[45|12]/a_460_290# sky130_fd_pr_reram__reram_cell area_ox=0.0676
X3639 rr2t2r_0[45|12]/a_60_290# WL45 SL12 VSS sky130_fd_pr__nfet_g5v0d10v5 ad=0.65 pd=3.3 as=0 ps=0 w=1 l=0.5
X3640 rr2t2r_0[46|12]/a_460_290# WL46 SL12 VSS sky130_fd_pr__nfet_g5v0d10v5 ad=0.65 pd=3.3 as=0 ps=0 w=1 l=0.5
X3641 BLP12 rr2t2r_0[46|12]/a_60_290# sky130_fd_pr_reram__reram_cell area_ox=0.0676
X3642 BLN12 rr2t2r_0[46|12]/a_460_290# sky130_fd_pr_reram__reram_cell area_ox=0.0676
X3643 rr2t2r_0[46|12]/a_60_290# WL46 SL12 VSS sky130_fd_pr__nfet_g5v0d10v5 ad=0.65 pd=3.3 as=0 ps=0 w=1 l=0.5
X3644 rr2t2r_0[47|12]/a_460_290# WL47 SL12 VSS sky130_fd_pr__nfet_g5v0d10v5 ad=0.65 pd=3.3 as=0 ps=0 w=1 l=0.5
X3645 BLP12 rr2t2r_0[47|12]/a_60_290# sky130_fd_pr_reram__reram_cell area_ox=0.0676
X3646 BLN12 rr2t2r_0[47|12]/a_460_290# sky130_fd_pr_reram__reram_cell area_ox=0.0676
X3647 rr2t2r_0[47|12]/a_60_290# WL47 SL12 VSS sky130_fd_pr__nfet_g5v0d10v5 ad=0.65 pd=3.3 as=0 ps=0 w=1 l=0.5
X3648 rr2t2r_0[48|12]/a_460_290# WL48 SL12 VSS sky130_fd_pr__nfet_g5v0d10v5 ad=0.65 pd=3.3 as=0 ps=0 w=1 l=0.5
X3649 BLP12 rr2t2r_0[48|12]/a_60_290# sky130_fd_pr_reram__reram_cell area_ox=0.0676
X3650 BLN12 rr2t2r_0[48|12]/a_460_290# sky130_fd_pr_reram__reram_cell area_ox=0.0676
X3651 rr2t2r_0[48|12]/a_60_290# WL48 SL12 VSS sky130_fd_pr__nfet_g5v0d10v5 ad=0.65 pd=3.3 as=0 ps=0 w=1 l=0.5
X3652 rr2t2r_0[49|12]/a_460_290# WL49 SL12 VSS sky130_fd_pr__nfet_g5v0d10v5 ad=0.65 pd=3.3 as=0 ps=0 w=1 l=0.5
X3653 BLP12 rr2t2r_0[49|12]/a_60_290# sky130_fd_pr_reram__reram_cell area_ox=0.0676
X3654 BLN12 rr2t2r_0[49|12]/a_460_290# sky130_fd_pr_reram__reram_cell area_ox=0.0676
X3655 rr2t2r_0[49|12]/a_60_290# WL49 SL12 VSS sky130_fd_pr__nfet_g5v0d10v5 ad=0.65 pd=3.3 as=0 ps=0 w=1 l=0.5
X3656 rr2t2r_0[50|12]/a_460_290# WL50 SL12 VSS sky130_fd_pr__nfet_g5v0d10v5 ad=0.65 pd=3.3 as=0 ps=0 w=1 l=0.5
X3657 BLP12 rr2t2r_0[50|12]/a_60_290# sky130_fd_pr_reram__reram_cell area_ox=0.0676
X3658 BLN12 rr2t2r_0[50|12]/a_460_290# sky130_fd_pr_reram__reram_cell area_ox=0.0676
X3659 rr2t2r_0[50|12]/a_60_290# WL50 SL12 VSS sky130_fd_pr__nfet_g5v0d10v5 ad=0.65 pd=3.3 as=0 ps=0 w=1 l=0.5
X3660 rr2t2r_0[51|12]/a_460_290# WL51 SL12 VSS sky130_fd_pr__nfet_g5v0d10v5 ad=0.65 pd=3.3 as=0 ps=0 w=1 l=0.5
X3661 BLP12 rr2t2r_0[51|12]/a_60_290# sky130_fd_pr_reram__reram_cell area_ox=0.0676
X3662 BLN12 rr2t2r_0[51|12]/a_460_290# sky130_fd_pr_reram__reram_cell area_ox=0.0676
X3663 rr2t2r_0[51|12]/a_60_290# WL51 SL12 VSS sky130_fd_pr__nfet_g5v0d10v5 ad=0.65 pd=3.3 as=0 ps=0 w=1 l=0.5
X3664 rr2t2r_0[52|12]/a_460_290# WL52 SL12 VSS sky130_fd_pr__nfet_g5v0d10v5 ad=0.65 pd=3.3 as=0 ps=0 w=1 l=0.5
X3665 BLP12 rr2t2r_0[52|12]/a_60_290# sky130_fd_pr_reram__reram_cell area_ox=0.0676
X3666 BLN12 rr2t2r_0[52|12]/a_460_290# sky130_fd_pr_reram__reram_cell area_ox=0.0676
X3667 rr2t2r_0[52|12]/a_60_290# WL52 SL12 VSS sky130_fd_pr__nfet_g5v0d10v5 ad=0.65 pd=3.3 as=0 ps=0 w=1 l=0.5
X3668 rr2t2r_0[53|12]/a_460_290# WL53 SL12 VSS sky130_fd_pr__nfet_g5v0d10v5 ad=0.65 pd=3.3 as=0 ps=0 w=1 l=0.5
X3669 BLP12 rr2t2r_0[53|12]/a_60_290# sky130_fd_pr_reram__reram_cell area_ox=0.0676
X3670 BLN12 rr2t2r_0[53|12]/a_460_290# sky130_fd_pr_reram__reram_cell area_ox=0.0676
X3671 rr2t2r_0[53|12]/a_60_290# WL53 SL12 VSS sky130_fd_pr__nfet_g5v0d10v5 ad=0.65 pd=3.3 as=0 ps=0 w=1 l=0.5
X3672 rr2t2r_0[54|12]/a_460_290# WL54 SL12 VSS sky130_fd_pr__nfet_g5v0d10v5 ad=0.65 pd=3.3 as=0 ps=0 w=1 l=0.5
X3673 BLP12 rr2t2r_0[54|12]/a_60_290# sky130_fd_pr_reram__reram_cell area_ox=0.0676
X3674 BLN12 rr2t2r_0[54|12]/a_460_290# sky130_fd_pr_reram__reram_cell area_ox=0.0676
X3675 rr2t2r_0[54|12]/a_60_290# WL54 SL12 VSS sky130_fd_pr__nfet_g5v0d10v5 ad=0.65 pd=3.3 as=0 ps=0 w=1 l=0.5
X3676 rr2t2r_0[55|12]/a_460_290# WL55 SL12 VSS sky130_fd_pr__nfet_g5v0d10v5 ad=0.65 pd=3.3 as=0 ps=0 w=1 l=0.5
X3677 BLP12 rr2t2r_0[55|12]/a_60_290# sky130_fd_pr_reram__reram_cell area_ox=0.0676
X3678 BLN12 rr2t2r_0[55|12]/a_460_290# sky130_fd_pr_reram__reram_cell area_ox=0.0676
X3679 rr2t2r_0[55|12]/a_60_290# WL55 SL12 VSS sky130_fd_pr__nfet_g5v0d10v5 ad=0.65 pd=3.3 as=0 ps=0 w=1 l=0.5
X3680 rr2t2r_0[56|12]/a_460_290# WL56 SL12 VSS sky130_fd_pr__nfet_g5v0d10v5 ad=0.65 pd=3.3 as=0 ps=0 w=1 l=0.5
X3681 BLP12 rr2t2r_0[56|12]/a_60_290# sky130_fd_pr_reram__reram_cell area_ox=0.0676
X3682 BLN12 rr2t2r_0[56|12]/a_460_290# sky130_fd_pr_reram__reram_cell area_ox=0.0676
X3683 rr2t2r_0[56|12]/a_60_290# WL56 SL12 VSS sky130_fd_pr__nfet_g5v0d10v5 ad=0.65 pd=3.3 as=0 ps=0 w=1 l=0.5
X3684 rr2t2r_0[57|12]/a_460_290# WL57 SL12 VSS sky130_fd_pr__nfet_g5v0d10v5 ad=0.65 pd=3.3 as=0 ps=0 w=1 l=0.5
X3685 BLP12 rr2t2r_0[57|12]/a_60_290# sky130_fd_pr_reram__reram_cell area_ox=0.0676
X3686 BLN12 rr2t2r_0[57|12]/a_460_290# sky130_fd_pr_reram__reram_cell area_ox=0.0676
X3687 rr2t2r_0[57|12]/a_60_290# WL57 SL12 VSS sky130_fd_pr__nfet_g5v0d10v5 ad=0.65 pd=3.3 as=0 ps=0 w=1 l=0.5
X3688 rr2t2r_0[58|12]/a_460_290# WL58 SL12 VSS sky130_fd_pr__nfet_g5v0d10v5 ad=0.65 pd=3.3 as=0 ps=0 w=1 l=0.5
X3689 BLP12 rr2t2r_0[58|12]/a_60_290# sky130_fd_pr_reram__reram_cell area_ox=0.0676
X3690 BLN12 rr2t2r_0[58|12]/a_460_290# sky130_fd_pr_reram__reram_cell area_ox=0.0676
X3691 rr2t2r_0[58|12]/a_60_290# WL58 SL12 VSS sky130_fd_pr__nfet_g5v0d10v5 ad=0.65 pd=3.3 as=0 ps=0 w=1 l=0.5
X3692 rr2t2r_0[59|12]/a_460_290# WL59 SL12 VSS sky130_fd_pr__nfet_g5v0d10v5 ad=0.65 pd=3.3 as=0 ps=0 w=1 l=0.5
X3693 BLP12 rr2t2r_0[59|12]/a_60_290# sky130_fd_pr_reram__reram_cell area_ox=0.0676
X3694 BLN12 rr2t2r_0[59|12]/a_460_290# sky130_fd_pr_reram__reram_cell area_ox=0.0676
X3695 rr2t2r_0[59|12]/a_60_290# WL59 SL12 VSS sky130_fd_pr__nfet_g5v0d10v5 ad=0.65 pd=3.3 as=0 ps=0 w=1 l=0.5
X3696 rr2t2r_0[60|12]/a_460_290# WL60 SL12 VSS sky130_fd_pr__nfet_g5v0d10v5 ad=0.65 pd=3.3 as=0 ps=0 w=1 l=0.5
X3697 BLP12 rr2t2r_0[60|12]/a_60_290# sky130_fd_pr_reram__reram_cell area_ox=0.0676
X3698 BLN12 rr2t2r_0[60|12]/a_460_290# sky130_fd_pr_reram__reram_cell area_ox=0.0676
X3699 rr2t2r_0[60|12]/a_60_290# WL60 SL12 VSS sky130_fd_pr__nfet_g5v0d10v5 ad=0.65 pd=3.3 as=0 ps=0 w=1 l=0.5
X3700 rr2t2r_0[61|12]/a_460_290# WL61 SL12 VSS sky130_fd_pr__nfet_g5v0d10v5 ad=0.65 pd=3.3 as=0 ps=0 w=1 l=0.5
X3701 BLP12 rr2t2r_0[61|12]/a_60_290# sky130_fd_pr_reram__reram_cell area_ox=0.0676
X3702 BLN12 rr2t2r_0[61|12]/a_460_290# sky130_fd_pr_reram__reram_cell area_ox=0.0676
X3703 rr2t2r_0[61|12]/a_60_290# WL61 SL12 VSS sky130_fd_pr__nfet_g5v0d10v5 ad=0.65 pd=3.3 as=0 ps=0 w=1 l=0.5
X3704 rr2t2r_0[62|12]/a_460_290# WL62 SL12 VSS sky130_fd_pr__nfet_g5v0d10v5 ad=0.65 pd=3.3 as=0 ps=0 w=1 l=0.5
X3705 BLP12 rr2t2r_0[62|12]/a_60_290# sky130_fd_pr_reram__reram_cell area_ox=0.0676
X3706 BLN12 rr2t2r_0[62|12]/a_460_290# sky130_fd_pr_reram__reram_cell area_ox=0.0676
X3707 rr2t2r_0[62|12]/a_60_290# WL62 SL12 VSS sky130_fd_pr__nfet_g5v0d10v5 ad=0.65 pd=3.3 as=0 ps=0 w=1 l=0.5
X3708 rr2t2r_0[63|12]/a_460_290# WL63 SL12 VSS sky130_fd_pr__nfet_g5v0d10v5 ad=0.65 pd=3.3 as=0 ps=0 w=1 l=0.5
X3709 BLP12 rr2t2r_0[63|12]/a_60_290# sky130_fd_pr_reram__reram_cell area_ox=0.0676
X3710 BLN12 rr2t2r_0[63|12]/a_460_290# sky130_fd_pr_reram__reram_cell area_ox=0.0676
X3711 rr2t2r_0[63|12]/a_60_290# WL63 SL12 VSS sky130_fd_pr__nfet_g5v0d10v5 ad=0.65 pd=3.3 as=0 ps=0 w=1 l=0.5
X3712 rr2t2r_0[64|12]/a_460_290# WL64 SL12 VSS sky130_fd_pr__nfet_g5v0d10v5 ad=0.65 pd=3.3 as=0 ps=0 w=1 l=0.5
X3713 BLP12 rr2t2r_0[64|12]/a_60_290# sky130_fd_pr_reram__reram_cell area_ox=0.0676
X3714 BLN12 rr2t2r_0[64|12]/a_460_290# sky130_fd_pr_reram__reram_cell area_ox=0.0676
X3715 rr2t2r_0[64|12]/a_60_290# WL64 SL12 VSS sky130_fd_pr__nfet_g5v0d10v5 ad=0.65 pd=3.3 as=0 ps=0 w=1 l=0.5
X3716 rr2t2r_0[65|12]/a_460_290# WL65 SL12 VSS sky130_fd_pr__nfet_g5v0d10v5 ad=0.65 pd=3.3 as=0 ps=0 w=1 l=0.5
X3717 BLP12 rr2t2r_0[65|12]/a_60_290# sky130_fd_pr_reram__reram_cell area_ox=0.0676
X3718 BLN12 rr2t2r_0[65|12]/a_460_290# sky130_fd_pr_reram__reram_cell area_ox=0.0676
X3719 rr2t2r_0[65|12]/a_60_290# WL65 SL12 VSS sky130_fd_pr__nfet_g5v0d10v5 ad=0.65 pd=3.3 as=0 ps=0 w=1 l=0.5
X3720 rr2t2r_0[66|12]/a_460_290# WL66 SL12 VSS sky130_fd_pr__nfet_g5v0d10v5 ad=0.65 pd=3.3 as=0 ps=0 w=1 l=0.5
X3721 BLP12 rr2t2r_0[66|12]/a_60_290# sky130_fd_pr_reram__reram_cell area_ox=0.0676
X3722 BLN12 rr2t2r_0[66|12]/a_460_290# sky130_fd_pr_reram__reram_cell area_ox=0.0676
X3723 rr2t2r_0[66|12]/a_60_290# WL66 SL12 VSS sky130_fd_pr__nfet_g5v0d10v5 ad=0.65 pd=3.3 as=0 ps=0 w=1 l=0.5
X3724 rr2t2r_0[67|12]/a_460_290# WL67 SL12 VSS sky130_fd_pr__nfet_g5v0d10v5 ad=0.65 pd=3.3 as=0 ps=0 w=1 l=0.5
X3725 BLP12 rr2t2r_0[67|12]/a_60_290# sky130_fd_pr_reram__reram_cell area_ox=0.0676
X3726 BLN12 rr2t2r_0[67|12]/a_460_290# sky130_fd_pr_reram__reram_cell area_ox=0.0676
X3727 rr2t2r_0[67|12]/a_60_290# WL67 SL12 VSS sky130_fd_pr__nfet_g5v0d10v5 ad=0.65 pd=3.3 as=0 ps=0 w=1 l=0.5
X3728 rr2t2r_0[68|12]/a_460_290# WL68 SL12 VSS sky130_fd_pr__nfet_g5v0d10v5 ad=0.65 pd=3.3 as=0 ps=0 w=1 l=0.5
X3729 BLP12 rr2t2r_0[68|12]/a_60_290# sky130_fd_pr_reram__reram_cell area_ox=0.0676
X3730 BLN12 rr2t2r_0[68|12]/a_460_290# sky130_fd_pr_reram__reram_cell area_ox=0.0676
X3731 rr2t2r_0[68|12]/a_60_290# WL68 SL12 VSS sky130_fd_pr__nfet_g5v0d10v5 ad=0.65 pd=3.3 as=0 ps=0 w=1 l=0.5
X3732 rr2t2r_0[69|12]/a_460_290# WL69 SL12 VSS sky130_fd_pr__nfet_g5v0d10v5 ad=0.65 pd=3.3 as=0 ps=0 w=1 l=0.5
X3733 BLP12 rr2t2r_0[69|12]/a_60_290# sky130_fd_pr_reram__reram_cell area_ox=0.0676
X3734 BLN12 rr2t2r_0[69|12]/a_460_290# sky130_fd_pr_reram__reram_cell area_ox=0.0676
X3735 rr2t2r_0[69|12]/a_60_290# WL69 SL12 VSS sky130_fd_pr__nfet_g5v0d10v5 ad=0.65 pd=3.3 as=0 ps=0 w=1 l=0.5
X3736 rr2t2r_0[70|12]/a_460_290# WL70 SL12 VSS sky130_fd_pr__nfet_g5v0d10v5 ad=0.65 pd=3.3 as=0 ps=0 w=1 l=0.5
X3737 BLP12 rr2t2r_0[70|12]/a_60_290# sky130_fd_pr_reram__reram_cell area_ox=0.0676
X3738 BLN12 rr2t2r_0[70|12]/a_460_290# sky130_fd_pr_reram__reram_cell area_ox=0.0676
X3739 rr2t2r_0[70|12]/a_60_290# WL70 SL12 VSS sky130_fd_pr__nfet_g5v0d10v5 ad=0.65 pd=3.3 as=0 ps=0 w=1 l=0.5
X3740 rr2t2r_0[71|12]/a_460_290# WL71 SL12 VSS sky130_fd_pr__nfet_g5v0d10v5 ad=0.65 pd=3.3 as=0 ps=0 w=1 l=0.5
X3741 BLP12 rr2t2r_0[71|12]/a_60_290# sky130_fd_pr_reram__reram_cell area_ox=0.0676
X3742 BLN12 rr2t2r_0[71|12]/a_460_290# sky130_fd_pr_reram__reram_cell area_ox=0.0676
X3743 rr2t2r_0[71|12]/a_60_290# WL71 SL12 VSS sky130_fd_pr__nfet_g5v0d10v5 ad=0.65 pd=3.3 as=0 ps=0 w=1 l=0.5
X3744 rr2t2r_0[0|13]/a_460_290# WL0 SL13 VSS sky130_fd_pr__nfet_g5v0d10v5 ad=0.65 pd=3.3 as=108 ps=504 w=1 l=0.5
X3745 BLP13 rr2t2r_0[0|13]/a_60_290# sky130_fd_pr_reram__reram_cell area_ox=0.0676
X3746 BLN13 rr2t2r_0[0|13]/a_460_290# sky130_fd_pr_reram__reram_cell area_ox=0.0676
X3747 rr2t2r_0[0|13]/a_60_290# WL0 SL13 VSS sky130_fd_pr__nfet_g5v0d10v5 ad=0.65 pd=3.3 as=0 ps=0 w=1 l=0.5
X3748 rr2t2r_0[1|13]/a_460_290# WL1 SL13 VSS sky130_fd_pr__nfet_g5v0d10v5 ad=0.65 pd=3.3 as=0 ps=0 w=1 l=0.5
X3749 BLP13 rr2t2r_0[1|13]/a_60_290# sky130_fd_pr_reram__reram_cell area_ox=0.0676
X3750 BLN13 rr2t2r_0[1|13]/a_460_290# sky130_fd_pr_reram__reram_cell area_ox=0.0676
X3751 rr2t2r_0[1|13]/a_60_290# WL1 SL13 VSS sky130_fd_pr__nfet_g5v0d10v5 ad=0.65 pd=3.3 as=0 ps=0 w=1 l=0.5
X3752 rr2t2r_0[2|13]/a_460_290# WL2 SL13 VSS sky130_fd_pr__nfet_g5v0d10v5 ad=0.65 pd=3.3 as=0 ps=0 w=1 l=0.5
X3753 BLP13 rr2t2r_0[2|13]/a_60_290# sky130_fd_pr_reram__reram_cell area_ox=0.0676
X3754 BLN13 rr2t2r_0[2|13]/a_460_290# sky130_fd_pr_reram__reram_cell area_ox=0.0676
X3755 rr2t2r_0[2|13]/a_60_290# WL2 SL13 VSS sky130_fd_pr__nfet_g5v0d10v5 ad=0.65 pd=3.3 as=0 ps=0 w=1 l=0.5
X3756 rr2t2r_0[3|13]/a_460_290# WL3 SL13 VSS sky130_fd_pr__nfet_g5v0d10v5 ad=0.65 pd=3.3 as=0 ps=0 w=1 l=0.5
X3757 BLP13 rr2t2r_0[3|13]/a_60_290# sky130_fd_pr_reram__reram_cell area_ox=0.0676
X3758 BLN13 rr2t2r_0[3|13]/a_460_290# sky130_fd_pr_reram__reram_cell area_ox=0.0676
X3759 rr2t2r_0[3|13]/a_60_290# WL3 SL13 VSS sky130_fd_pr__nfet_g5v0d10v5 ad=0.65 pd=3.3 as=0 ps=0 w=1 l=0.5
X3760 rr2t2r_0[4|13]/a_460_290# WL4 SL13 VSS sky130_fd_pr__nfet_g5v0d10v5 ad=0.65 pd=3.3 as=0 ps=0 w=1 l=0.5
X3761 BLP13 rr2t2r_0[4|13]/a_60_290# sky130_fd_pr_reram__reram_cell area_ox=0.0676
X3762 BLN13 rr2t2r_0[4|13]/a_460_290# sky130_fd_pr_reram__reram_cell area_ox=0.0676
X3763 rr2t2r_0[4|13]/a_60_290# WL4 SL13 VSS sky130_fd_pr__nfet_g5v0d10v5 ad=0.65 pd=3.3 as=0 ps=0 w=1 l=0.5
X3764 rr2t2r_0[5|13]/a_460_290# WL5 SL13 VSS sky130_fd_pr__nfet_g5v0d10v5 ad=0.65 pd=3.3 as=0 ps=0 w=1 l=0.5
X3765 BLP13 rr2t2r_0[5|13]/a_60_290# sky130_fd_pr_reram__reram_cell area_ox=0.0676
X3766 BLN13 rr2t2r_0[5|13]/a_460_290# sky130_fd_pr_reram__reram_cell area_ox=0.0676
X3767 rr2t2r_0[5|13]/a_60_290# WL5 SL13 VSS sky130_fd_pr__nfet_g5v0d10v5 ad=0.65 pd=3.3 as=0 ps=0 w=1 l=0.5
X3768 rr2t2r_0[6|13]/a_460_290# WL6 SL13 VSS sky130_fd_pr__nfet_g5v0d10v5 ad=0.65 pd=3.3 as=0 ps=0 w=1 l=0.5
X3769 BLP13 rr2t2r_0[6|13]/a_60_290# sky130_fd_pr_reram__reram_cell area_ox=0.0676
X3770 BLN13 rr2t2r_0[6|13]/a_460_290# sky130_fd_pr_reram__reram_cell area_ox=0.0676
X3771 rr2t2r_0[6|13]/a_60_290# WL6 SL13 VSS sky130_fd_pr__nfet_g5v0d10v5 ad=0.65 pd=3.3 as=0 ps=0 w=1 l=0.5
X3772 rr2t2r_0[7|13]/a_460_290# WL7 SL13 VSS sky130_fd_pr__nfet_g5v0d10v5 ad=0.65 pd=3.3 as=0 ps=0 w=1 l=0.5
X3773 BLP13 rr2t2r_0[7|13]/a_60_290# sky130_fd_pr_reram__reram_cell area_ox=0.0676
X3774 BLN13 rr2t2r_0[7|13]/a_460_290# sky130_fd_pr_reram__reram_cell area_ox=0.0676
X3775 rr2t2r_0[7|13]/a_60_290# WL7 SL13 VSS sky130_fd_pr__nfet_g5v0d10v5 ad=0.65 pd=3.3 as=0 ps=0 w=1 l=0.5
X3776 rr2t2r_0[8|13]/a_460_290# WL8 SL13 VSS sky130_fd_pr__nfet_g5v0d10v5 ad=0.65 pd=3.3 as=0 ps=0 w=1 l=0.5
X3777 BLP13 rr2t2r_0[8|13]/a_60_290# sky130_fd_pr_reram__reram_cell area_ox=0.0676
X3778 BLN13 rr2t2r_0[8|13]/a_460_290# sky130_fd_pr_reram__reram_cell area_ox=0.0676
X3779 rr2t2r_0[8|13]/a_60_290# WL8 SL13 VSS sky130_fd_pr__nfet_g5v0d10v5 ad=0.65 pd=3.3 as=0 ps=0 w=1 l=0.5
X3780 rr2t2r_0[9|13]/a_460_290# WL9 SL13 VSS sky130_fd_pr__nfet_g5v0d10v5 ad=0.65 pd=3.3 as=0 ps=0 w=1 l=0.5
X3781 BLP13 rr2t2r_0[9|13]/a_60_290# sky130_fd_pr_reram__reram_cell area_ox=0.0676
X3782 BLN13 rr2t2r_0[9|13]/a_460_290# sky130_fd_pr_reram__reram_cell area_ox=0.0676
X3783 rr2t2r_0[9|13]/a_60_290# WL9 SL13 VSS sky130_fd_pr__nfet_g5v0d10v5 ad=0.65 pd=3.3 as=0 ps=0 w=1 l=0.5
X3784 rr2t2r_0[10|13]/a_460_290# WL10 SL13 VSS sky130_fd_pr__nfet_g5v0d10v5 ad=0.65 pd=3.3 as=0 ps=0 w=1 l=0.5
X3785 BLP13 rr2t2r_0[10|13]/a_60_290# sky130_fd_pr_reram__reram_cell area_ox=0.0676
X3786 BLN13 rr2t2r_0[10|13]/a_460_290# sky130_fd_pr_reram__reram_cell area_ox=0.0676
X3787 rr2t2r_0[10|13]/a_60_290# WL10 SL13 VSS sky130_fd_pr__nfet_g5v0d10v5 ad=0.65 pd=3.3 as=0 ps=0 w=1 l=0.5
X3788 rr2t2r_0[11|13]/a_460_290# WL11 SL13 VSS sky130_fd_pr__nfet_g5v0d10v5 ad=0.65 pd=3.3 as=0 ps=0 w=1 l=0.5
X3789 BLP13 rr2t2r_0[11|13]/a_60_290# sky130_fd_pr_reram__reram_cell area_ox=0.0676
X3790 BLN13 rr2t2r_0[11|13]/a_460_290# sky130_fd_pr_reram__reram_cell area_ox=0.0676
X3791 rr2t2r_0[11|13]/a_60_290# WL11 SL13 VSS sky130_fd_pr__nfet_g5v0d10v5 ad=0.65 pd=3.3 as=0 ps=0 w=1 l=0.5
X3792 rr2t2r_0[12|13]/a_460_290# WL12 SL13 VSS sky130_fd_pr__nfet_g5v0d10v5 ad=0.65 pd=3.3 as=0 ps=0 w=1 l=0.5
X3793 BLP13 rr2t2r_0[12|13]/a_60_290# sky130_fd_pr_reram__reram_cell area_ox=0.0676
X3794 BLN13 rr2t2r_0[12|13]/a_460_290# sky130_fd_pr_reram__reram_cell area_ox=0.0676
X3795 rr2t2r_0[12|13]/a_60_290# WL12 SL13 VSS sky130_fd_pr__nfet_g5v0d10v5 ad=0.65 pd=3.3 as=0 ps=0 w=1 l=0.5
X3796 rr2t2r_0[13|13]/a_460_290# WL13 SL13 VSS sky130_fd_pr__nfet_g5v0d10v5 ad=0.65 pd=3.3 as=0 ps=0 w=1 l=0.5
X3797 BLP13 rr2t2r_0[13|13]/a_60_290# sky130_fd_pr_reram__reram_cell area_ox=0.0676
X3798 BLN13 rr2t2r_0[13|13]/a_460_290# sky130_fd_pr_reram__reram_cell area_ox=0.0676
X3799 rr2t2r_0[13|13]/a_60_290# WL13 SL13 VSS sky130_fd_pr__nfet_g5v0d10v5 ad=0.65 pd=3.3 as=0 ps=0 w=1 l=0.5
X3800 rr2t2r_0[14|13]/a_460_290# WL14 SL13 VSS sky130_fd_pr__nfet_g5v0d10v5 ad=0.65 pd=3.3 as=0 ps=0 w=1 l=0.5
X3801 BLP13 rr2t2r_0[14|13]/a_60_290# sky130_fd_pr_reram__reram_cell area_ox=0.0676
X3802 BLN13 rr2t2r_0[14|13]/a_460_290# sky130_fd_pr_reram__reram_cell area_ox=0.0676
X3803 rr2t2r_0[14|13]/a_60_290# WL14 SL13 VSS sky130_fd_pr__nfet_g5v0d10v5 ad=0.65 pd=3.3 as=0 ps=0 w=1 l=0.5
X3804 rr2t2r_0[15|13]/a_460_290# WL15 SL13 VSS sky130_fd_pr__nfet_g5v0d10v5 ad=0.65 pd=3.3 as=0 ps=0 w=1 l=0.5
X3805 BLP13 rr2t2r_0[15|13]/a_60_290# sky130_fd_pr_reram__reram_cell area_ox=0.0676
X3806 BLN13 rr2t2r_0[15|13]/a_460_290# sky130_fd_pr_reram__reram_cell area_ox=0.0676
X3807 rr2t2r_0[15|13]/a_60_290# WL15 SL13 VSS sky130_fd_pr__nfet_g5v0d10v5 ad=0.65 pd=3.3 as=0 ps=0 w=1 l=0.5
X3808 rr2t2r_0[16|13]/a_460_290# WL16 SL13 VSS sky130_fd_pr__nfet_g5v0d10v5 ad=0.65 pd=3.3 as=0 ps=0 w=1 l=0.5
X3809 BLP13 rr2t2r_0[16|13]/a_60_290# sky130_fd_pr_reram__reram_cell area_ox=0.0676
X3810 BLN13 rr2t2r_0[16|13]/a_460_290# sky130_fd_pr_reram__reram_cell area_ox=0.0676
X3811 rr2t2r_0[16|13]/a_60_290# WL16 SL13 VSS sky130_fd_pr__nfet_g5v0d10v5 ad=0.65 pd=3.3 as=0 ps=0 w=1 l=0.5
X3812 rr2t2r_0[17|13]/a_460_290# WL17 SL13 VSS sky130_fd_pr__nfet_g5v0d10v5 ad=0.65 pd=3.3 as=0 ps=0 w=1 l=0.5
X3813 BLP13 rr2t2r_0[17|13]/a_60_290# sky130_fd_pr_reram__reram_cell area_ox=0.0676
X3814 BLN13 rr2t2r_0[17|13]/a_460_290# sky130_fd_pr_reram__reram_cell area_ox=0.0676
X3815 rr2t2r_0[17|13]/a_60_290# WL17 SL13 VSS sky130_fd_pr__nfet_g5v0d10v5 ad=0.65 pd=3.3 as=0 ps=0 w=1 l=0.5
X3816 rr2t2r_0[18|13]/a_460_290# WL18 SL13 VSS sky130_fd_pr__nfet_g5v0d10v5 ad=0.65 pd=3.3 as=0 ps=0 w=1 l=0.5
X3817 BLP13 rr2t2r_0[18|13]/a_60_290# sky130_fd_pr_reram__reram_cell area_ox=0.0676
X3818 BLN13 rr2t2r_0[18|13]/a_460_290# sky130_fd_pr_reram__reram_cell area_ox=0.0676
X3819 rr2t2r_0[18|13]/a_60_290# WL18 SL13 VSS sky130_fd_pr__nfet_g5v0d10v5 ad=0.65 pd=3.3 as=0 ps=0 w=1 l=0.5
X3820 rr2t2r_0[19|13]/a_460_290# WL19 SL13 VSS sky130_fd_pr__nfet_g5v0d10v5 ad=0.65 pd=3.3 as=0 ps=0 w=1 l=0.5
X3821 BLP13 rr2t2r_0[19|13]/a_60_290# sky130_fd_pr_reram__reram_cell area_ox=0.0676
X3822 BLN13 rr2t2r_0[19|13]/a_460_290# sky130_fd_pr_reram__reram_cell area_ox=0.0676
X3823 rr2t2r_0[19|13]/a_60_290# WL19 SL13 VSS sky130_fd_pr__nfet_g5v0d10v5 ad=0.65 pd=3.3 as=0 ps=0 w=1 l=0.5
X3824 rr2t2r_0[20|13]/a_460_290# WL20 SL13 VSS sky130_fd_pr__nfet_g5v0d10v5 ad=0.65 pd=3.3 as=0 ps=0 w=1 l=0.5
X3825 BLP13 rr2t2r_0[20|13]/a_60_290# sky130_fd_pr_reram__reram_cell area_ox=0.0676
X3826 BLN13 rr2t2r_0[20|13]/a_460_290# sky130_fd_pr_reram__reram_cell area_ox=0.0676
X3827 rr2t2r_0[20|13]/a_60_290# WL20 SL13 VSS sky130_fd_pr__nfet_g5v0d10v5 ad=0.65 pd=3.3 as=0 ps=0 w=1 l=0.5
X3828 rr2t2r_0[21|13]/a_460_290# WL21 SL13 VSS sky130_fd_pr__nfet_g5v0d10v5 ad=0.65 pd=3.3 as=0 ps=0 w=1 l=0.5
X3829 BLP13 rr2t2r_0[21|13]/a_60_290# sky130_fd_pr_reram__reram_cell area_ox=0.0676
X3830 BLN13 rr2t2r_0[21|13]/a_460_290# sky130_fd_pr_reram__reram_cell area_ox=0.0676
X3831 rr2t2r_0[21|13]/a_60_290# WL21 SL13 VSS sky130_fd_pr__nfet_g5v0d10v5 ad=0.65 pd=3.3 as=0 ps=0 w=1 l=0.5
X3832 rr2t2r_0[22|13]/a_460_290# WL22 SL13 VSS sky130_fd_pr__nfet_g5v0d10v5 ad=0.65 pd=3.3 as=0 ps=0 w=1 l=0.5
X3833 BLP13 rr2t2r_0[22|13]/a_60_290# sky130_fd_pr_reram__reram_cell area_ox=0.0676
X3834 BLN13 rr2t2r_0[22|13]/a_460_290# sky130_fd_pr_reram__reram_cell area_ox=0.0676
X3835 rr2t2r_0[22|13]/a_60_290# WL22 SL13 VSS sky130_fd_pr__nfet_g5v0d10v5 ad=0.65 pd=3.3 as=0 ps=0 w=1 l=0.5
X3836 rr2t2r_0[23|13]/a_460_290# WL23 SL13 VSS sky130_fd_pr__nfet_g5v0d10v5 ad=0.65 pd=3.3 as=0 ps=0 w=1 l=0.5
X3837 BLP13 rr2t2r_0[23|13]/a_60_290# sky130_fd_pr_reram__reram_cell area_ox=0.0676
X3838 BLN13 rr2t2r_0[23|13]/a_460_290# sky130_fd_pr_reram__reram_cell area_ox=0.0676
X3839 rr2t2r_0[23|13]/a_60_290# WL23 SL13 VSS sky130_fd_pr__nfet_g5v0d10v5 ad=0.65 pd=3.3 as=0 ps=0 w=1 l=0.5
X3840 rr2t2r_0[24|13]/a_460_290# WL24 SL13 VSS sky130_fd_pr__nfet_g5v0d10v5 ad=0.65 pd=3.3 as=0 ps=0 w=1 l=0.5
X3841 BLP13 rr2t2r_0[24|13]/a_60_290# sky130_fd_pr_reram__reram_cell area_ox=0.0676
X3842 BLN13 rr2t2r_0[24|13]/a_460_290# sky130_fd_pr_reram__reram_cell area_ox=0.0676
X3843 rr2t2r_0[24|13]/a_60_290# WL24 SL13 VSS sky130_fd_pr__nfet_g5v0d10v5 ad=0.65 pd=3.3 as=0 ps=0 w=1 l=0.5
X3844 rr2t2r_0[25|13]/a_460_290# WL25 SL13 VSS sky130_fd_pr__nfet_g5v0d10v5 ad=0.65 pd=3.3 as=0 ps=0 w=1 l=0.5
X3845 BLP13 rr2t2r_0[25|13]/a_60_290# sky130_fd_pr_reram__reram_cell area_ox=0.0676
X3846 BLN13 rr2t2r_0[25|13]/a_460_290# sky130_fd_pr_reram__reram_cell area_ox=0.0676
X3847 rr2t2r_0[25|13]/a_60_290# WL25 SL13 VSS sky130_fd_pr__nfet_g5v0d10v5 ad=0.65 pd=3.3 as=0 ps=0 w=1 l=0.5
X3848 rr2t2r_0[26|13]/a_460_290# WL26 SL13 VSS sky130_fd_pr__nfet_g5v0d10v5 ad=0.65 pd=3.3 as=0 ps=0 w=1 l=0.5
X3849 BLP13 rr2t2r_0[26|13]/a_60_290# sky130_fd_pr_reram__reram_cell area_ox=0.0676
X3850 BLN13 rr2t2r_0[26|13]/a_460_290# sky130_fd_pr_reram__reram_cell area_ox=0.0676
X3851 rr2t2r_0[26|13]/a_60_290# WL26 SL13 VSS sky130_fd_pr__nfet_g5v0d10v5 ad=0.65 pd=3.3 as=0 ps=0 w=1 l=0.5
X3852 rr2t2r_0[27|13]/a_460_290# WL27 SL13 VSS sky130_fd_pr__nfet_g5v0d10v5 ad=0.65 pd=3.3 as=0 ps=0 w=1 l=0.5
X3853 BLP13 rr2t2r_0[27|13]/a_60_290# sky130_fd_pr_reram__reram_cell area_ox=0.0676
X3854 BLN13 rr2t2r_0[27|13]/a_460_290# sky130_fd_pr_reram__reram_cell area_ox=0.0676
X3855 rr2t2r_0[27|13]/a_60_290# WL27 SL13 VSS sky130_fd_pr__nfet_g5v0d10v5 ad=0.65 pd=3.3 as=0 ps=0 w=1 l=0.5
X3856 rr2t2r_0[28|13]/a_460_290# WL28 SL13 VSS sky130_fd_pr__nfet_g5v0d10v5 ad=0.65 pd=3.3 as=0 ps=0 w=1 l=0.5
X3857 BLP13 rr2t2r_0[28|13]/a_60_290# sky130_fd_pr_reram__reram_cell area_ox=0.0676
X3858 BLN13 rr2t2r_0[28|13]/a_460_290# sky130_fd_pr_reram__reram_cell area_ox=0.0676
X3859 rr2t2r_0[28|13]/a_60_290# WL28 SL13 VSS sky130_fd_pr__nfet_g5v0d10v5 ad=0.65 pd=3.3 as=0 ps=0 w=1 l=0.5
X3860 rr2t2r_0[29|13]/a_460_290# WL29 SL13 VSS sky130_fd_pr__nfet_g5v0d10v5 ad=0.65 pd=3.3 as=0 ps=0 w=1 l=0.5
X3861 BLP13 rr2t2r_0[29|13]/a_60_290# sky130_fd_pr_reram__reram_cell area_ox=0.0676
X3862 BLN13 rr2t2r_0[29|13]/a_460_290# sky130_fd_pr_reram__reram_cell area_ox=0.0676
X3863 rr2t2r_0[29|13]/a_60_290# WL29 SL13 VSS sky130_fd_pr__nfet_g5v0d10v5 ad=0.65 pd=3.3 as=0 ps=0 w=1 l=0.5
X3864 rr2t2r_0[30|13]/a_460_290# WL30 SL13 VSS sky130_fd_pr__nfet_g5v0d10v5 ad=0.65 pd=3.3 as=0 ps=0 w=1 l=0.5
X3865 BLP13 rr2t2r_0[30|13]/a_60_290# sky130_fd_pr_reram__reram_cell area_ox=0.0676
X3866 BLN13 rr2t2r_0[30|13]/a_460_290# sky130_fd_pr_reram__reram_cell area_ox=0.0676
X3867 rr2t2r_0[30|13]/a_60_290# WL30 SL13 VSS sky130_fd_pr__nfet_g5v0d10v5 ad=0.65 pd=3.3 as=0 ps=0 w=1 l=0.5
X3868 rr2t2r_0[31|13]/a_460_290# WL31 SL13 VSS sky130_fd_pr__nfet_g5v0d10v5 ad=0.65 pd=3.3 as=0 ps=0 w=1 l=0.5
X3869 BLP13 rr2t2r_0[31|13]/a_60_290# sky130_fd_pr_reram__reram_cell area_ox=0.0676
X3870 BLN13 rr2t2r_0[31|13]/a_460_290# sky130_fd_pr_reram__reram_cell area_ox=0.0676
X3871 rr2t2r_0[31|13]/a_60_290# WL31 SL13 VSS sky130_fd_pr__nfet_g5v0d10v5 ad=0.65 pd=3.3 as=0 ps=0 w=1 l=0.5
X3872 rr2t2r_0[32|13]/a_460_290# WL32 SL13 VSS sky130_fd_pr__nfet_g5v0d10v5 ad=0.65 pd=3.3 as=0 ps=0 w=1 l=0.5
X3873 BLP13 rr2t2r_0[32|13]/a_60_290# sky130_fd_pr_reram__reram_cell area_ox=0.0676
X3874 BLN13 rr2t2r_0[32|13]/a_460_290# sky130_fd_pr_reram__reram_cell area_ox=0.0676
X3875 rr2t2r_0[32|13]/a_60_290# WL32 SL13 VSS sky130_fd_pr__nfet_g5v0d10v5 ad=0.65 pd=3.3 as=0 ps=0 w=1 l=0.5
X3876 rr2t2r_0[33|13]/a_460_290# WL33 SL13 VSS sky130_fd_pr__nfet_g5v0d10v5 ad=0.65 pd=3.3 as=0 ps=0 w=1 l=0.5
X3877 BLP13 rr2t2r_0[33|13]/a_60_290# sky130_fd_pr_reram__reram_cell area_ox=0.0676
X3878 BLN13 rr2t2r_0[33|13]/a_460_290# sky130_fd_pr_reram__reram_cell area_ox=0.0676
X3879 rr2t2r_0[33|13]/a_60_290# WL33 SL13 VSS sky130_fd_pr__nfet_g5v0d10v5 ad=0.65 pd=3.3 as=0 ps=0 w=1 l=0.5
X3880 rr2t2r_0[34|13]/a_460_290# WL34 SL13 VSS sky130_fd_pr__nfet_g5v0d10v5 ad=0.65 pd=3.3 as=0 ps=0 w=1 l=0.5
X3881 BLP13 rr2t2r_0[34|13]/a_60_290# sky130_fd_pr_reram__reram_cell area_ox=0.0676
X3882 BLN13 rr2t2r_0[34|13]/a_460_290# sky130_fd_pr_reram__reram_cell area_ox=0.0676
X3883 rr2t2r_0[34|13]/a_60_290# WL34 SL13 VSS sky130_fd_pr__nfet_g5v0d10v5 ad=0.65 pd=3.3 as=0 ps=0 w=1 l=0.5
X3884 rr2t2r_0[35|13]/a_460_290# WL35 SL13 VSS sky130_fd_pr__nfet_g5v0d10v5 ad=0.65 pd=3.3 as=0 ps=0 w=1 l=0.5
X3885 BLP13 rr2t2r_0[35|13]/a_60_290# sky130_fd_pr_reram__reram_cell area_ox=0.0676
X3886 BLN13 rr2t2r_0[35|13]/a_460_290# sky130_fd_pr_reram__reram_cell area_ox=0.0676
X3887 rr2t2r_0[35|13]/a_60_290# WL35 SL13 VSS sky130_fd_pr__nfet_g5v0d10v5 ad=0.65 pd=3.3 as=0 ps=0 w=1 l=0.5
X3888 rr2t2r_0[36|13]/a_460_290# WL36 SL13 VSS sky130_fd_pr__nfet_g5v0d10v5 ad=0.65 pd=3.3 as=0 ps=0 w=1 l=0.5
X3889 BLP13 rr2t2r_0[36|13]/a_60_290# sky130_fd_pr_reram__reram_cell area_ox=0.0676
X3890 BLN13 rr2t2r_0[36|13]/a_460_290# sky130_fd_pr_reram__reram_cell area_ox=0.0676
X3891 rr2t2r_0[36|13]/a_60_290# WL36 SL13 VSS sky130_fd_pr__nfet_g5v0d10v5 ad=0.65 pd=3.3 as=0 ps=0 w=1 l=0.5
X3892 rr2t2r_0[37|13]/a_460_290# WL37 SL13 VSS sky130_fd_pr__nfet_g5v0d10v5 ad=0.65 pd=3.3 as=0 ps=0 w=1 l=0.5
X3893 BLP13 rr2t2r_0[37|13]/a_60_290# sky130_fd_pr_reram__reram_cell area_ox=0.0676
X3894 BLN13 rr2t2r_0[37|13]/a_460_290# sky130_fd_pr_reram__reram_cell area_ox=0.0676
X3895 rr2t2r_0[37|13]/a_60_290# WL37 SL13 VSS sky130_fd_pr__nfet_g5v0d10v5 ad=0.65 pd=3.3 as=0 ps=0 w=1 l=0.5
X3896 rr2t2r_0[38|13]/a_460_290# WL38 SL13 VSS sky130_fd_pr__nfet_g5v0d10v5 ad=0.65 pd=3.3 as=0 ps=0 w=1 l=0.5
X3897 BLP13 rr2t2r_0[38|13]/a_60_290# sky130_fd_pr_reram__reram_cell area_ox=0.0676
X3898 BLN13 rr2t2r_0[38|13]/a_460_290# sky130_fd_pr_reram__reram_cell area_ox=0.0676
X3899 rr2t2r_0[38|13]/a_60_290# WL38 SL13 VSS sky130_fd_pr__nfet_g5v0d10v5 ad=0.65 pd=3.3 as=0 ps=0 w=1 l=0.5
X3900 rr2t2r_0[39|13]/a_460_290# WL39 SL13 VSS sky130_fd_pr__nfet_g5v0d10v5 ad=0.65 pd=3.3 as=0 ps=0 w=1 l=0.5
X3901 BLP13 rr2t2r_0[39|13]/a_60_290# sky130_fd_pr_reram__reram_cell area_ox=0.0676
X3902 BLN13 rr2t2r_0[39|13]/a_460_290# sky130_fd_pr_reram__reram_cell area_ox=0.0676
X3903 rr2t2r_0[39|13]/a_60_290# WL39 SL13 VSS sky130_fd_pr__nfet_g5v0d10v5 ad=0.65 pd=3.3 as=0 ps=0 w=1 l=0.5
X3904 rr2t2r_0[40|13]/a_460_290# WL40 SL13 VSS sky130_fd_pr__nfet_g5v0d10v5 ad=0.65 pd=3.3 as=0 ps=0 w=1 l=0.5
X3905 BLP13 rr2t2r_0[40|13]/a_60_290# sky130_fd_pr_reram__reram_cell area_ox=0.0676
X3906 BLN13 rr2t2r_0[40|13]/a_460_290# sky130_fd_pr_reram__reram_cell area_ox=0.0676
X3907 rr2t2r_0[40|13]/a_60_290# WL40 SL13 VSS sky130_fd_pr__nfet_g5v0d10v5 ad=0.65 pd=3.3 as=0 ps=0 w=1 l=0.5
X3908 rr2t2r_0[41|13]/a_460_290# WL41 SL13 VSS sky130_fd_pr__nfet_g5v0d10v5 ad=0.65 pd=3.3 as=0 ps=0 w=1 l=0.5
X3909 BLP13 rr2t2r_0[41|13]/a_60_290# sky130_fd_pr_reram__reram_cell area_ox=0.0676
X3910 BLN13 rr2t2r_0[41|13]/a_460_290# sky130_fd_pr_reram__reram_cell area_ox=0.0676
X3911 rr2t2r_0[41|13]/a_60_290# WL41 SL13 VSS sky130_fd_pr__nfet_g5v0d10v5 ad=0.65 pd=3.3 as=0 ps=0 w=1 l=0.5
X3912 rr2t2r_0[42|13]/a_460_290# WL42 SL13 VSS sky130_fd_pr__nfet_g5v0d10v5 ad=0.65 pd=3.3 as=0 ps=0 w=1 l=0.5
X3913 BLP13 rr2t2r_0[42|13]/a_60_290# sky130_fd_pr_reram__reram_cell area_ox=0.0676
X3914 BLN13 rr2t2r_0[42|13]/a_460_290# sky130_fd_pr_reram__reram_cell area_ox=0.0676
X3915 rr2t2r_0[42|13]/a_60_290# WL42 SL13 VSS sky130_fd_pr__nfet_g5v0d10v5 ad=0.65 pd=3.3 as=0 ps=0 w=1 l=0.5
X3916 rr2t2r_0[43|13]/a_460_290# WL43 SL13 VSS sky130_fd_pr__nfet_g5v0d10v5 ad=0.65 pd=3.3 as=0 ps=0 w=1 l=0.5
X3917 BLP13 rr2t2r_0[43|13]/a_60_290# sky130_fd_pr_reram__reram_cell area_ox=0.0676
X3918 BLN13 rr2t2r_0[43|13]/a_460_290# sky130_fd_pr_reram__reram_cell area_ox=0.0676
X3919 rr2t2r_0[43|13]/a_60_290# WL43 SL13 VSS sky130_fd_pr__nfet_g5v0d10v5 ad=0.65 pd=3.3 as=0 ps=0 w=1 l=0.5
X3920 rr2t2r_0[44|13]/a_460_290# WL44 SL13 VSS sky130_fd_pr__nfet_g5v0d10v5 ad=0.65 pd=3.3 as=0 ps=0 w=1 l=0.5
X3921 BLP13 rr2t2r_0[44|13]/a_60_290# sky130_fd_pr_reram__reram_cell area_ox=0.0676
X3922 BLN13 rr2t2r_0[44|13]/a_460_290# sky130_fd_pr_reram__reram_cell area_ox=0.0676
X3923 rr2t2r_0[44|13]/a_60_290# WL44 SL13 VSS sky130_fd_pr__nfet_g5v0d10v5 ad=0.65 pd=3.3 as=0 ps=0 w=1 l=0.5
X3924 rr2t2r_0[45|13]/a_460_290# WL45 SL13 VSS sky130_fd_pr__nfet_g5v0d10v5 ad=0.65 pd=3.3 as=0 ps=0 w=1 l=0.5
X3925 BLP13 rr2t2r_0[45|13]/a_60_290# sky130_fd_pr_reram__reram_cell area_ox=0.0676
X3926 BLN13 rr2t2r_0[45|13]/a_460_290# sky130_fd_pr_reram__reram_cell area_ox=0.0676
X3927 rr2t2r_0[45|13]/a_60_290# WL45 SL13 VSS sky130_fd_pr__nfet_g5v0d10v5 ad=0.65 pd=3.3 as=0 ps=0 w=1 l=0.5
X3928 rr2t2r_0[46|13]/a_460_290# WL46 SL13 VSS sky130_fd_pr__nfet_g5v0d10v5 ad=0.65 pd=3.3 as=0 ps=0 w=1 l=0.5
X3929 BLP13 rr2t2r_0[46|13]/a_60_290# sky130_fd_pr_reram__reram_cell area_ox=0.0676
X3930 BLN13 rr2t2r_0[46|13]/a_460_290# sky130_fd_pr_reram__reram_cell area_ox=0.0676
X3931 rr2t2r_0[46|13]/a_60_290# WL46 SL13 VSS sky130_fd_pr__nfet_g5v0d10v5 ad=0.65 pd=3.3 as=0 ps=0 w=1 l=0.5
X3932 rr2t2r_0[47|13]/a_460_290# WL47 SL13 VSS sky130_fd_pr__nfet_g5v0d10v5 ad=0.65 pd=3.3 as=0 ps=0 w=1 l=0.5
X3933 BLP13 rr2t2r_0[47|13]/a_60_290# sky130_fd_pr_reram__reram_cell area_ox=0.0676
X3934 BLN13 rr2t2r_0[47|13]/a_460_290# sky130_fd_pr_reram__reram_cell area_ox=0.0676
X3935 rr2t2r_0[47|13]/a_60_290# WL47 SL13 VSS sky130_fd_pr__nfet_g5v0d10v5 ad=0.65 pd=3.3 as=0 ps=0 w=1 l=0.5
X3936 rr2t2r_0[48|13]/a_460_290# WL48 SL13 VSS sky130_fd_pr__nfet_g5v0d10v5 ad=0.65 pd=3.3 as=0 ps=0 w=1 l=0.5
X3937 BLP13 rr2t2r_0[48|13]/a_60_290# sky130_fd_pr_reram__reram_cell area_ox=0.0676
X3938 BLN13 rr2t2r_0[48|13]/a_460_290# sky130_fd_pr_reram__reram_cell area_ox=0.0676
X3939 rr2t2r_0[48|13]/a_60_290# WL48 SL13 VSS sky130_fd_pr__nfet_g5v0d10v5 ad=0.65 pd=3.3 as=0 ps=0 w=1 l=0.5
X3940 rr2t2r_0[49|13]/a_460_290# WL49 SL13 VSS sky130_fd_pr__nfet_g5v0d10v5 ad=0.65 pd=3.3 as=0 ps=0 w=1 l=0.5
X3941 BLP13 rr2t2r_0[49|13]/a_60_290# sky130_fd_pr_reram__reram_cell area_ox=0.0676
X3942 BLN13 rr2t2r_0[49|13]/a_460_290# sky130_fd_pr_reram__reram_cell area_ox=0.0676
X3943 rr2t2r_0[49|13]/a_60_290# WL49 SL13 VSS sky130_fd_pr__nfet_g5v0d10v5 ad=0.65 pd=3.3 as=0 ps=0 w=1 l=0.5
X3944 rr2t2r_0[50|13]/a_460_290# WL50 SL13 VSS sky130_fd_pr__nfet_g5v0d10v5 ad=0.65 pd=3.3 as=0 ps=0 w=1 l=0.5
X3945 BLP13 rr2t2r_0[50|13]/a_60_290# sky130_fd_pr_reram__reram_cell area_ox=0.0676
X3946 BLN13 rr2t2r_0[50|13]/a_460_290# sky130_fd_pr_reram__reram_cell area_ox=0.0676
X3947 rr2t2r_0[50|13]/a_60_290# WL50 SL13 VSS sky130_fd_pr__nfet_g5v0d10v5 ad=0.65 pd=3.3 as=0 ps=0 w=1 l=0.5
X3948 rr2t2r_0[51|13]/a_460_290# WL51 SL13 VSS sky130_fd_pr__nfet_g5v0d10v5 ad=0.65 pd=3.3 as=0 ps=0 w=1 l=0.5
X3949 BLP13 rr2t2r_0[51|13]/a_60_290# sky130_fd_pr_reram__reram_cell area_ox=0.0676
X3950 BLN13 rr2t2r_0[51|13]/a_460_290# sky130_fd_pr_reram__reram_cell area_ox=0.0676
X3951 rr2t2r_0[51|13]/a_60_290# WL51 SL13 VSS sky130_fd_pr__nfet_g5v0d10v5 ad=0.65 pd=3.3 as=0 ps=0 w=1 l=0.5
X3952 rr2t2r_0[52|13]/a_460_290# WL52 SL13 VSS sky130_fd_pr__nfet_g5v0d10v5 ad=0.65 pd=3.3 as=0 ps=0 w=1 l=0.5
X3953 BLP13 rr2t2r_0[52|13]/a_60_290# sky130_fd_pr_reram__reram_cell area_ox=0.0676
X3954 BLN13 rr2t2r_0[52|13]/a_460_290# sky130_fd_pr_reram__reram_cell area_ox=0.0676
X3955 rr2t2r_0[52|13]/a_60_290# WL52 SL13 VSS sky130_fd_pr__nfet_g5v0d10v5 ad=0.65 pd=3.3 as=0 ps=0 w=1 l=0.5
X3956 rr2t2r_0[53|13]/a_460_290# WL53 SL13 VSS sky130_fd_pr__nfet_g5v0d10v5 ad=0.65 pd=3.3 as=0 ps=0 w=1 l=0.5
X3957 BLP13 rr2t2r_0[53|13]/a_60_290# sky130_fd_pr_reram__reram_cell area_ox=0.0676
X3958 BLN13 rr2t2r_0[53|13]/a_460_290# sky130_fd_pr_reram__reram_cell area_ox=0.0676
X3959 rr2t2r_0[53|13]/a_60_290# WL53 SL13 VSS sky130_fd_pr__nfet_g5v0d10v5 ad=0.65 pd=3.3 as=0 ps=0 w=1 l=0.5
X3960 rr2t2r_0[54|13]/a_460_290# WL54 SL13 VSS sky130_fd_pr__nfet_g5v0d10v5 ad=0.65 pd=3.3 as=0 ps=0 w=1 l=0.5
X3961 BLP13 rr2t2r_0[54|13]/a_60_290# sky130_fd_pr_reram__reram_cell area_ox=0.0676
X3962 BLN13 rr2t2r_0[54|13]/a_460_290# sky130_fd_pr_reram__reram_cell area_ox=0.0676
X3963 rr2t2r_0[54|13]/a_60_290# WL54 SL13 VSS sky130_fd_pr__nfet_g5v0d10v5 ad=0.65 pd=3.3 as=0 ps=0 w=1 l=0.5
X3964 rr2t2r_0[55|13]/a_460_290# WL55 SL13 VSS sky130_fd_pr__nfet_g5v0d10v5 ad=0.65 pd=3.3 as=0 ps=0 w=1 l=0.5
X3965 BLP13 rr2t2r_0[55|13]/a_60_290# sky130_fd_pr_reram__reram_cell area_ox=0.0676
X3966 BLN13 rr2t2r_0[55|13]/a_460_290# sky130_fd_pr_reram__reram_cell area_ox=0.0676
X3967 rr2t2r_0[55|13]/a_60_290# WL55 SL13 VSS sky130_fd_pr__nfet_g5v0d10v5 ad=0.65 pd=3.3 as=0 ps=0 w=1 l=0.5
X3968 rr2t2r_0[56|13]/a_460_290# WL56 SL13 VSS sky130_fd_pr__nfet_g5v0d10v5 ad=0.65 pd=3.3 as=0 ps=0 w=1 l=0.5
X3969 BLP13 rr2t2r_0[56|13]/a_60_290# sky130_fd_pr_reram__reram_cell area_ox=0.0676
X3970 BLN13 rr2t2r_0[56|13]/a_460_290# sky130_fd_pr_reram__reram_cell area_ox=0.0676
X3971 rr2t2r_0[56|13]/a_60_290# WL56 SL13 VSS sky130_fd_pr__nfet_g5v0d10v5 ad=0.65 pd=3.3 as=0 ps=0 w=1 l=0.5
X3972 rr2t2r_0[57|13]/a_460_290# WL57 SL13 VSS sky130_fd_pr__nfet_g5v0d10v5 ad=0.65 pd=3.3 as=0 ps=0 w=1 l=0.5
X3973 BLP13 rr2t2r_0[57|13]/a_60_290# sky130_fd_pr_reram__reram_cell area_ox=0.0676
X3974 BLN13 rr2t2r_0[57|13]/a_460_290# sky130_fd_pr_reram__reram_cell area_ox=0.0676
X3975 rr2t2r_0[57|13]/a_60_290# WL57 SL13 VSS sky130_fd_pr__nfet_g5v0d10v5 ad=0.65 pd=3.3 as=0 ps=0 w=1 l=0.5
X3976 rr2t2r_0[58|13]/a_460_290# WL58 SL13 VSS sky130_fd_pr__nfet_g5v0d10v5 ad=0.65 pd=3.3 as=0 ps=0 w=1 l=0.5
X3977 BLP13 rr2t2r_0[58|13]/a_60_290# sky130_fd_pr_reram__reram_cell area_ox=0.0676
X3978 BLN13 rr2t2r_0[58|13]/a_460_290# sky130_fd_pr_reram__reram_cell area_ox=0.0676
X3979 rr2t2r_0[58|13]/a_60_290# WL58 SL13 VSS sky130_fd_pr__nfet_g5v0d10v5 ad=0.65 pd=3.3 as=0 ps=0 w=1 l=0.5
X3980 rr2t2r_0[59|13]/a_460_290# WL59 SL13 VSS sky130_fd_pr__nfet_g5v0d10v5 ad=0.65 pd=3.3 as=0 ps=0 w=1 l=0.5
X3981 BLP13 rr2t2r_0[59|13]/a_60_290# sky130_fd_pr_reram__reram_cell area_ox=0.0676
X3982 BLN13 rr2t2r_0[59|13]/a_460_290# sky130_fd_pr_reram__reram_cell area_ox=0.0676
X3983 rr2t2r_0[59|13]/a_60_290# WL59 SL13 VSS sky130_fd_pr__nfet_g5v0d10v5 ad=0.65 pd=3.3 as=0 ps=0 w=1 l=0.5
X3984 rr2t2r_0[60|13]/a_460_290# WL60 SL13 VSS sky130_fd_pr__nfet_g5v0d10v5 ad=0.65 pd=3.3 as=0 ps=0 w=1 l=0.5
X3985 BLP13 rr2t2r_0[60|13]/a_60_290# sky130_fd_pr_reram__reram_cell area_ox=0.0676
X3986 BLN13 rr2t2r_0[60|13]/a_460_290# sky130_fd_pr_reram__reram_cell area_ox=0.0676
X3987 rr2t2r_0[60|13]/a_60_290# WL60 SL13 VSS sky130_fd_pr__nfet_g5v0d10v5 ad=0.65 pd=3.3 as=0 ps=0 w=1 l=0.5
X3988 rr2t2r_0[61|13]/a_460_290# WL61 SL13 VSS sky130_fd_pr__nfet_g5v0d10v5 ad=0.65 pd=3.3 as=0 ps=0 w=1 l=0.5
X3989 BLP13 rr2t2r_0[61|13]/a_60_290# sky130_fd_pr_reram__reram_cell area_ox=0.0676
X3990 BLN13 rr2t2r_0[61|13]/a_460_290# sky130_fd_pr_reram__reram_cell area_ox=0.0676
X3991 rr2t2r_0[61|13]/a_60_290# WL61 SL13 VSS sky130_fd_pr__nfet_g5v0d10v5 ad=0.65 pd=3.3 as=0 ps=0 w=1 l=0.5
X3992 rr2t2r_0[62|13]/a_460_290# WL62 SL13 VSS sky130_fd_pr__nfet_g5v0d10v5 ad=0.65 pd=3.3 as=0 ps=0 w=1 l=0.5
X3993 BLP13 rr2t2r_0[62|13]/a_60_290# sky130_fd_pr_reram__reram_cell area_ox=0.0676
X3994 BLN13 rr2t2r_0[62|13]/a_460_290# sky130_fd_pr_reram__reram_cell area_ox=0.0676
X3995 rr2t2r_0[62|13]/a_60_290# WL62 SL13 VSS sky130_fd_pr__nfet_g5v0d10v5 ad=0.65 pd=3.3 as=0 ps=0 w=1 l=0.5
X3996 rr2t2r_0[63|13]/a_460_290# WL63 SL13 VSS sky130_fd_pr__nfet_g5v0d10v5 ad=0.65 pd=3.3 as=0 ps=0 w=1 l=0.5
X3997 BLP13 rr2t2r_0[63|13]/a_60_290# sky130_fd_pr_reram__reram_cell area_ox=0.0676
X3998 BLN13 rr2t2r_0[63|13]/a_460_290# sky130_fd_pr_reram__reram_cell area_ox=0.0676
X3999 rr2t2r_0[63|13]/a_60_290# WL63 SL13 VSS sky130_fd_pr__nfet_g5v0d10v5 ad=0.65 pd=3.3 as=0 ps=0 w=1 l=0.5
X4000 rr2t2r_0[64|13]/a_460_290# WL64 SL13 VSS sky130_fd_pr__nfet_g5v0d10v5 ad=0.65 pd=3.3 as=0 ps=0 w=1 l=0.5
X4001 BLP13 rr2t2r_0[64|13]/a_60_290# sky130_fd_pr_reram__reram_cell area_ox=0.0676
X4002 BLN13 rr2t2r_0[64|13]/a_460_290# sky130_fd_pr_reram__reram_cell area_ox=0.0676
X4003 rr2t2r_0[64|13]/a_60_290# WL64 SL13 VSS sky130_fd_pr__nfet_g5v0d10v5 ad=0.65 pd=3.3 as=0 ps=0 w=1 l=0.5
X4004 rr2t2r_0[65|13]/a_460_290# WL65 SL13 VSS sky130_fd_pr__nfet_g5v0d10v5 ad=0.65 pd=3.3 as=0 ps=0 w=1 l=0.5
X4005 BLP13 rr2t2r_0[65|13]/a_60_290# sky130_fd_pr_reram__reram_cell area_ox=0.0676
X4006 BLN13 rr2t2r_0[65|13]/a_460_290# sky130_fd_pr_reram__reram_cell area_ox=0.0676
X4007 rr2t2r_0[65|13]/a_60_290# WL65 SL13 VSS sky130_fd_pr__nfet_g5v0d10v5 ad=0.65 pd=3.3 as=0 ps=0 w=1 l=0.5
X4008 rr2t2r_0[66|13]/a_460_290# WL66 SL13 VSS sky130_fd_pr__nfet_g5v0d10v5 ad=0.65 pd=3.3 as=0 ps=0 w=1 l=0.5
X4009 BLP13 rr2t2r_0[66|13]/a_60_290# sky130_fd_pr_reram__reram_cell area_ox=0.0676
X4010 BLN13 rr2t2r_0[66|13]/a_460_290# sky130_fd_pr_reram__reram_cell area_ox=0.0676
X4011 rr2t2r_0[66|13]/a_60_290# WL66 SL13 VSS sky130_fd_pr__nfet_g5v0d10v5 ad=0.65 pd=3.3 as=0 ps=0 w=1 l=0.5
X4012 rr2t2r_0[67|13]/a_460_290# WL67 SL13 VSS sky130_fd_pr__nfet_g5v0d10v5 ad=0.65 pd=3.3 as=0 ps=0 w=1 l=0.5
X4013 BLP13 rr2t2r_0[67|13]/a_60_290# sky130_fd_pr_reram__reram_cell area_ox=0.0676
X4014 BLN13 rr2t2r_0[67|13]/a_460_290# sky130_fd_pr_reram__reram_cell area_ox=0.0676
X4015 rr2t2r_0[67|13]/a_60_290# WL67 SL13 VSS sky130_fd_pr__nfet_g5v0d10v5 ad=0.65 pd=3.3 as=0 ps=0 w=1 l=0.5
X4016 rr2t2r_0[68|13]/a_460_290# WL68 SL13 VSS sky130_fd_pr__nfet_g5v0d10v5 ad=0.65 pd=3.3 as=0 ps=0 w=1 l=0.5
X4017 BLP13 rr2t2r_0[68|13]/a_60_290# sky130_fd_pr_reram__reram_cell area_ox=0.0676
X4018 BLN13 rr2t2r_0[68|13]/a_460_290# sky130_fd_pr_reram__reram_cell area_ox=0.0676
X4019 rr2t2r_0[68|13]/a_60_290# WL68 SL13 VSS sky130_fd_pr__nfet_g5v0d10v5 ad=0.65 pd=3.3 as=0 ps=0 w=1 l=0.5
X4020 rr2t2r_0[69|13]/a_460_290# WL69 SL13 VSS sky130_fd_pr__nfet_g5v0d10v5 ad=0.65 pd=3.3 as=0 ps=0 w=1 l=0.5
X4021 BLP13 rr2t2r_0[69|13]/a_60_290# sky130_fd_pr_reram__reram_cell area_ox=0.0676
X4022 BLN13 rr2t2r_0[69|13]/a_460_290# sky130_fd_pr_reram__reram_cell area_ox=0.0676
X4023 rr2t2r_0[69|13]/a_60_290# WL69 SL13 VSS sky130_fd_pr__nfet_g5v0d10v5 ad=0.65 pd=3.3 as=0 ps=0 w=1 l=0.5
X4024 rr2t2r_0[70|13]/a_460_290# WL70 SL13 VSS sky130_fd_pr__nfet_g5v0d10v5 ad=0.65 pd=3.3 as=0 ps=0 w=1 l=0.5
X4025 BLP13 rr2t2r_0[70|13]/a_60_290# sky130_fd_pr_reram__reram_cell area_ox=0.0676
X4026 BLN13 rr2t2r_0[70|13]/a_460_290# sky130_fd_pr_reram__reram_cell area_ox=0.0676
X4027 rr2t2r_0[70|13]/a_60_290# WL70 SL13 VSS sky130_fd_pr__nfet_g5v0d10v5 ad=0.65 pd=3.3 as=0 ps=0 w=1 l=0.5
X4028 rr2t2r_0[71|13]/a_460_290# WL71 SL13 VSS sky130_fd_pr__nfet_g5v0d10v5 ad=0.65 pd=3.3 as=0 ps=0 w=1 l=0.5
X4029 BLP13 rr2t2r_0[71|13]/a_60_290# sky130_fd_pr_reram__reram_cell area_ox=0.0676
X4030 BLN13 rr2t2r_0[71|13]/a_460_290# sky130_fd_pr_reram__reram_cell area_ox=0.0676
X4031 rr2t2r_0[71|13]/a_60_290# WL71 SL13 VSS sky130_fd_pr__nfet_g5v0d10v5 ad=0.65 pd=3.3 as=0 ps=0 w=1 l=0.5
X4032 rr2t2r_0[0|14]/a_460_290# WL0 SL14 VSS sky130_fd_pr__nfet_g5v0d10v5 ad=0.65 pd=3.3 as=108 ps=504 w=1 l=0.5
X4033 BLP14 rr2t2r_0[0|14]/a_60_290# sky130_fd_pr_reram__reram_cell area_ox=0.0676
X4034 BLN14 rr2t2r_0[0|14]/a_460_290# sky130_fd_pr_reram__reram_cell area_ox=0.0676
X4035 rr2t2r_0[0|14]/a_60_290# WL0 SL14 VSS sky130_fd_pr__nfet_g5v0d10v5 ad=0.65 pd=3.3 as=0 ps=0 w=1 l=0.5
X4036 rr2t2r_0[1|14]/a_460_290# WL1 SL14 VSS sky130_fd_pr__nfet_g5v0d10v5 ad=0.65 pd=3.3 as=0 ps=0 w=1 l=0.5
X4037 BLP14 rr2t2r_0[1|14]/a_60_290# sky130_fd_pr_reram__reram_cell area_ox=0.0676
X4038 BLN14 rr2t2r_0[1|14]/a_460_290# sky130_fd_pr_reram__reram_cell area_ox=0.0676
X4039 rr2t2r_0[1|14]/a_60_290# WL1 SL14 VSS sky130_fd_pr__nfet_g5v0d10v5 ad=0.65 pd=3.3 as=0 ps=0 w=1 l=0.5
X4040 rr2t2r_0[2|14]/a_460_290# WL2 SL14 VSS sky130_fd_pr__nfet_g5v0d10v5 ad=0.65 pd=3.3 as=0 ps=0 w=1 l=0.5
X4041 BLP14 rr2t2r_0[2|14]/a_60_290# sky130_fd_pr_reram__reram_cell area_ox=0.0676
X4042 BLN14 rr2t2r_0[2|14]/a_460_290# sky130_fd_pr_reram__reram_cell area_ox=0.0676
X4043 rr2t2r_0[2|14]/a_60_290# WL2 SL14 VSS sky130_fd_pr__nfet_g5v0d10v5 ad=0.65 pd=3.3 as=0 ps=0 w=1 l=0.5
X4044 rr2t2r_0[3|14]/a_460_290# WL3 SL14 VSS sky130_fd_pr__nfet_g5v0d10v5 ad=0.65 pd=3.3 as=0 ps=0 w=1 l=0.5
X4045 BLP14 rr2t2r_0[3|14]/a_60_290# sky130_fd_pr_reram__reram_cell area_ox=0.0676
X4046 BLN14 rr2t2r_0[3|14]/a_460_290# sky130_fd_pr_reram__reram_cell area_ox=0.0676
X4047 rr2t2r_0[3|14]/a_60_290# WL3 SL14 VSS sky130_fd_pr__nfet_g5v0d10v5 ad=0.65 pd=3.3 as=0 ps=0 w=1 l=0.5
X4048 rr2t2r_0[4|14]/a_460_290# WL4 SL14 VSS sky130_fd_pr__nfet_g5v0d10v5 ad=0.65 pd=3.3 as=0 ps=0 w=1 l=0.5
X4049 BLP14 rr2t2r_0[4|14]/a_60_290# sky130_fd_pr_reram__reram_cell area_ox=0.0676
X4050 BLN14 rr2t2r_0[4|14]/a_460_290# sky130_fd_pr_reram__reram_cell area_ox=0.0676
X4051 rr2t2r_0[4|14]/a_60_290# WL4 SL14 VSS sky130_fd_pr__nfet_g5v0d10v5 ad=0.65 pd=3.3 as=0 ps=0 w=1 l=0.5
X4052 rr2t2r_0[5|14]/a_460_290# WL5 SL14 VSS sky130_fd_pr__nfet_g5v0d10v5 ad=0.65 pd=3.3 as=0 ps=0 w=1 l=0.5
X4053 BLP14 rr2t2r_0[5|14]/a_60_290# sky130_fd_pr_reram__reram_cell area_ox=0.0676
X4054 BLN14 rr2t2r_0[5|14]/a_460_290# sky130_fd_pr_reram__reram_cell area_ox=0.0676
X4055 rr2t2r_0[5|14]/a_60_290# WL5 SL14 VSS sky130_fd_pr__nfet_g5v0d10v5 ad=0.65 pd=3.3 as=0 ps=0 w=1 l=0.5
X4056 rr2t2r_0[6|14]/a_460_290# WL6 SL14 VSS sky130_fd_pr__nfet_g5v0d10v5 ad=0.65 pd=3.3 as=0 ps=0 w=1 l=0.5
X4057 BLP14 rr2t2r_0[6|14]/a_60_290# sky130_fd_pr_reram__reram_cell area_ox=0.0676
X4058 BLN14 rr2t2r_0[6|14]/a_460_290# sky130_fd_pr_reram__reram_cell area_ox=0.0676
X4059 rr2t2r_0[6|14]/a_60_290# WL6 SL14 VSS sky130_fd_pr__nfet_g5v0d10v5 ad=0.65 pd=3.3 as=0 ps=0 w=1 l=0.5
X4060 rr2t2r_0[7|14]/a_460_290# WL7 SL14 VSS sky130_fd_pr__nfet_g5v0d10v5 ad=0.65 pd=3.3 as=0 ps=0 w=1 l=0.5
X4061 BLP14 rr2t2r_0[7|14]/a_60_290# sky130_fd_pr_reram__reram_cell area_ox=0.0676
X4062 BLN14 rr2t2r_0[7|14]/a_460_290# sky130_fd_pr_reram__reram_cell area_ox=0.0676
X4063 rr2t2r_0[7|14]/a_60_290# WL7 SL14 VSS sky130_fd_pr__nfet_g5v0d10v5 ad=0.65 pd=3.3 as=0 ps=0 w=1 l=0.5
X4064 rr2t2r_0[8|14]/a_460_290# WL8 SL14 VSS sky130_fd_pr__nfet_g5v0d10v5 ad=0.65 pd=3.3 as=0 ps=0 w=1 l=0.5
X4065 BLP14 rr2t2r_0[8|14]/a_60_290# sky130_fd_pr_reram__reram_cell area_ox=0.0676
X4066 BLN14 rr2t2r_0[8|14]/a_460_290# sky130_fd_pr_reram__reram_cell area_ox=0.0676
X4067 rr2t2r_0[8|14]/a_60_290# WL8 SL14 VSS sky130_fd_pr__nfet_g5v0d10v5 ad=0.65 pd=3.3 as=0 ps=0 w=1 l=0.5
X4068 rr2t2r_0[9|14]/a_460_290# WL9 SL14 VSS sky130_fd_pr__nfet_g5v0d10v5 ad=0.65 pd=3.3 as=0 ps=0 w=1 l=0.5
X4069 BLP14 rr2t2r_0[9|14]/a_60_290# sky130_fd_pr_reram__reram_cell area_ox=0.0676
X4070 BLN14 rr2t2r_0[9|14]/a_460_290# sky130_fd_pr_reram__reram_cell area_ox=0.0676
X4071 rr2t2r_0[9|14]/a_60_290# WL9 SL14 VSS sky130_fd_pr__nfet_g5v0d10v5 ad=0.65 pd=3.3 as=0 ps=0 w=1 l=0.5
X4072 rr2t2r_0[10|14]/a_460_290# WL10 SL14 VSS sky130_fd_pr__nfet_g5v0d10v5 ad=0.65 pd=3.3 as=0 ps=0 w=1 l=0.5
X4073 BLP14 rr2t2r_0[10|14]/a_60_290# sky130_fd_pr_reram__reram_cell area_ox=0.0676
X4074 BLN14 rr2t2r_0[10|14]/a_460_290# sky130_fd_pr_reram__reram_cell area_ox=0.0676
X4075 rr2t2r_0[10|14]/a_60_290# WL10 SL14 VSS sky130_fd_pr__nfet_g5v0d10v5 ad=0.65 pd=3.3 as=0 ps=0 w=1 l=0.5
X4076 rr2t2r_0[11|14]/a_460_290# WL11 SL14 VSS sky130_fd_pr__nfet_g5v0d10v5 ad=0.65 pd=3.3 as=0 ps=0 w=1 l=0.5
X4077 BLP14 rr2t2r_0[11|14]/a_60_290# sky130_fd_pr_reram__reram_cell area_ox=0.0676
X4078 BLN14 rr2t2r_0[11|14]/a_460_290# sky130_fd_pr_reram__reram_cell area_ox=0.0676
X4079 rr2t2r_0[11|14]/a_60_290# WL11 SL14 VSS sky130_fd_pr__nfet_g5v0d10v5 ad=0.65 pd=3.3 as=0 ps=0 w=1 l=0.5
X4080 rr2t2r_0[12|14]/a_460_290# WL12 SL14 VSS sky130_fd_pr__nfet_g5v0d10v5 ad=0.65 pd=3.3 as=0 ps=0 w=1 l=0.5
X4081 BLP14 rr2t2r_0[12|14]/a_60_290# sky130_fd_pr_reram__reram_cell area_ox=0.0676
X4082 BLN14 rr2t2r_0[12|14]/a_460_290# sky130_fd_pr_reram__reram_cell area_ox=0.0676
X4083 rr2t2r_0[12|14]/a_60_290# WL12 SL14 VSS sky130_fd_pr__nfet_g5v0d10v5 ad=0.65 pd=3.3 as=0 ps=0 w=1 l=0.5
X4084 rr2t2r_0[13|14]/a_460_290# WL13 SL14 VSS sky130_fd_pr__nfet_g5v0d10v5 ad=0.65 pd=3.3 as=0 ps=0 w=1 l=0.5
X4085 BLP14 rr2t2r_0[13|14]/a_60_290# sky130_fd_pr_reram__reram_cell area_ox=0.0676
X4086 BLN14 rr2t2r_0[13|14]/a_460_290# sky130_fd_pr_reram__reram_cell area_ox=0.0676
X4087 rr2t2r_0[13|14]/a_60_290# WL13 SL14 VSS sky130_fd_pr__nfet_g5v0d10v5 ad=0.65 pd=3.3 as=0 ps=0 w=1 l=0.5
X4088 rr2t2r_0[14|14]/a_460_290# WL14 SL14 VSS sky130_fd_pr__nfet_g5v0d10v5 ad=0.65 pd=3.3 as=0 ps=0 w=1 l=0.5
X4089 BLP14 rr2t2r_0[14|14]/a_60_290# sky130_fd_pr_reram__reram_cell area_ox=0.0676
X4090 BLN14 rr2t2r_0[14|14]/a_460_290# sky130_fd_pr_reram__reram_cell area_ox=0.0676
X4091 rr2t2r_0[14|14]/a_60_290# WL14 SL14 VSS sky130_fd_pr__nfet_g5v0d10v5 ad=0.65 pd=3.3 as=0 ps=0 w=1 l=0.5
X4092 rr2t2r_0[15|14]/a_460_290# WL15 SL14 VSS sky130_fd_pr__nfet_g5v0d10v5 ad=0.65 pd=3.3 as=0 ps=0 w=1 l=0.5
X4093 BLP14 rr2t2r_0[15|14]/a_60_290# sky130_fd_pr_reram__reram_cell area_ox=0.0676
X4094 BLN14 rr2t2r_0[15|14]/a_460_290# sky130_fd_pr_reram__reram_cell area_ox=0.0676
X4095 rr2t2r_0[15|14]/a_60_290# WL15 SL14 VSS sky130_fd_pr__nfet_g5v0d10v5 ad=0.65 pd=3.3 as=0 ps=0 w=1 l=0.5
X4096 rr2t2r_0[16|14]/a_460_290# WL16 SL14 VSS sky130_fd_pr__nfet_g5v0d10v5 ad=0.65 pd=3.3 as=0 ps=0 w=1 l=0.5
X4097 BLP14 rr2t2r_0[16|14]/a_60_290# sky130_fd_pr_reram__reram_cell area_ox=0.0676
X4098 BLN14 rr2t2r_0[16|14]/a_460_290# sky130_fd_pr_reram__reram_cell area_ox=0.0676
X4099 rr2t2r_0[16|14]/a_60_290# WL16 SL14 VSS sky130_fd_pr__nfet_g5v0d10v5 ad=0.65 pd=3.3 as=0 ps=0 w=1 l=0.5
X4100 rr2t2r_0[17|14]/a_460_290# WL17 SL14 VSS sky130_fd_pr__nfet_g5v0d10v5 ad=0.65 pd=3.3 as=0 ps=0 w=1 l=0.5
X4101 BLP14 rr2t2r_0[17|14]/a_60_290# sky130_fd_pr_reram__reram_cell area_ox=0.0676
X4102 BLN14 rr2t2r_0[17|14]/a_460_290# sky130_fd_pr_reram__reram_cell area_ox=0.0676
X4103 rr2t2r_0[17|14]/a_60_290# WL17 SL14 VSS sky130_fd_pr__nfet_g5v0d10v5 ad=0.65 pd=3.3 as=0 ps=0 w=1 l=0.5
X4104 rr2t2r_0[18|14]/a_460_290# WL18 SL14 VSS sky130_fd_pr__nfet_g5v0d10v5 ad=0.65 pd=3.3 as=0 ps=0 w=1 l=0.5
X4105 BLP14 rr2t2r_0[18|14]/a_60_290# sky130_fd_pr_reram__reram_cell area_ox=0.0676
X4106 BLN14 rr2t2r_0[18|14]/a_460_290# sky130_fd_pr_reram__reram_cell area_ox=0.0676
X4107 rr2t2r_0[18|14]/a_60_290# WL18 SL14 VSS sky130_fd_pr__nfet_g5v0d10v5 ad=0.65 pd=3.3 as=0 ps=0 w=1 l=0.5
X4108 rr2t2r_0[19|14]/a_460_290# WL19 SL14 VSS sky130_fd_pr__nfet_g5v0d10v5 ad=0.65 pd=3.3 as=0 ps=0 w=1 l=0.5
X4109 BLP14 rr2t2r_0[19|14]/a_60_290# sky130_fd_pr_reram__reram_cell area_ox=0.0676
X4110 BLN14 rr2t2r_0[19|14]/a_460_290# sky130_fd_pr_reram__reram_cell area_ox=0.0676
X4111 rr2t2r_0[19|14]/a_60_290# WL19 SL14 VSS sky130_fd_pr__nfet_g5v0d10v5 ad=0.65 pd=3.3 as=0 ps=0 w=1 l=0.5
X4112 rr2t2r_0[20|14]/a_460_290# WL20 SL14 VSS sky130_fd_pr__nfet_g5v0d10v5 ad=0.65 pd=3.3 as=0 ps=0 w=1 l=0.5
X4113 BLP14 rr2t2r_0[20|14]/a_60_290# sky130_fd_pr_reram__reram_cell area_ox=0.0676
X4114 BLN14 rr2t2r_0[20|14]/a_460_290# sky130_fd_pr_reram__reram_cell area_ox=0.0676
X4115 rr2t2r_0[20|14]/a_60_290# WL20 SL14 VSS sky130_fd_pr__nfet_g5v0d10v5 ad=0.65 pd=3.3 as=0 ps=0 w=1 l=0.5
X4116 rr2t2r_0[21|14]/a_460_290# WL21 SL14 VSS sky130_fd_pr__nfet_g5v0d10v5 ad=0.65 pd=3.3 as=0 ps=0 w=1 l=0.5
X4117 BLP14 rr2t2r_0[21|14]/a_60_290# sky130_fd_pr_reram__reram_cell area_ox=0.0676
X4118 BLN14 rr2t2r_0[21|14]/a_460_290# sky130_fd_pr_reram__reram_cell area_ox=0.0676
X4119 rr2t2r_0[21|14]/a_60_290# WL21 SL14 VSS sky130_fd_pr__nfet_g5v0d10v5 ad=0.65 pd=3.3 as=0 ps=0 w=1 l=0.5
X4120 rr2t2r_0[22|14]/a_460_290# WL22 SL14 VSS sky130_fd_pr__nfet_g5v0d10v5 ad=0.65 pd=3.3 as=0 ps=0 w=1 l=0.5
X4121 BLP14 rr2t2r_0[22|14]/a_60_290# sky130_fd_pr_reram__reram_cell area_ox=0.0676
X4122 BLN14 rr2t2r_0[22|14]/a_460_290# sky130_fd_pr_reram__reram_cell area_ox=0.0676
X4123 rr2t2r_0[22|14]/a_60_290# WL22 SL14 VSS sky130_fd_pr__nfet_g5v0d10v5 ad=0.65 pd=3.3 as=0 ps=0 w=1 l=0.5
X4124 rr2t2r_0[23|14]/a_460_290# WL23 SL14 VSS sky130_fd_pr__nfet_g5v0d10v5 ad=0.65 pd=3.3 as=0 ps=0 w=1 l=0.5
X4125 BLP14 rr2t2r_0[23|14]/a_60_290# sky130_fd_pr_reram__reram_cell area_ox=0.0676
X4126 BLN14 rr2t2r_0[23|14]/a_460_290# sky130_fd_pr_reram__reram_cell area_ox=0.0676
X4127 rr2t2r_0[23|14]/a_60_290# WL23 SL14 VSS sky130_fd_pr__nfet_g5v0d10v5 ad=0.65 pd=3.3 as=0 ps=0 w=1 l=0.5
X4128 rr2t2r_0[24|14]/a_460_290# WL24 SL14 VSS sky130_fd_pr__nfet_g5v0d10v5 ad=0.65 pd=3.3 as=0 ps=0 w=1 l=0.5
X4129 BLP14 rr2t2r_0[24|14]/a_60_290# sky130_fd_pr_reram__reram_cell area_ox=0.0676
X4130 BLN14 rr2t2r_0[24|14]/a_460_290# sky130_fd_pr_reram__reram_cell area_ox=0.0676
X4131 rr2t2r_0[24|14]/a_60_290# WL24 SL14 VSS sky130_fd_pr__nfet_g5v0d10v5 ad=0.65 pd=3.3 as=0 ps=0 w=1 l=0.5
X4132 rr2t2r_0[25|14]/a_460_290# WL25 SL14 VSS sky130_fd_pr__nfet_g5v0d10v5 ad=0.65 pd=3.3 as=0 ps=0 w=1 l=0.5
X4133 BLP14 rr2t2r_0[25|14]/a_60_290# sky130_fd_pr_reram__reram_cell area_ox=0.0676
X4134 BLN14 rr2t2r_0[25|14]/a_460_290# sky130_fd_pr_reram__reram_cell area_ox=0.0676
X4135 rr2t2r_0[25|14]/a_60_290# WL25 SL14 VSS sky130_fd_pr__nfet_g5v0d10v5 ad=0.65 pd=3.3 as=0 ps=0 w=1 l=0.5
X4136 rr2t2r_0[26|14]/a_460_290# WL26 SL14 VSS sky130_fd_pr__nfet_g5v0d10v5 ad=0.65 pd=3.3 as=0 ps=0 w=1 l=0.5
X4137 BLP14 rr2t2r_0[26|14]/a_60_290# sky130_fd_pr_reram__reram_cell area_ox=0.0676
X4138 BLN14 rr2t2r_0[26|14]/a_460_290# sky130_fd_pr_reram__reram_cell area_ox=0.0676
X4139 rr2t2r_0[26|14]/a_60_290# WL26 SL14 VSS sky130_fd_pr__nfet_g5v0d10v5 ad=0.65 pd=3.3 as=0 ps=0 w=1 l=0.5
X4140 rr2t2r_0[27|14]/a_460_290# WL27 SL14 VSS sky130_fd_pr__nfet_g5v0d10v5 ad=0.65 pd=3.3 as=0 ps=0 w=1 l=0.5
X4141 BLP14 rr2t2r_0[27|14]/a_60_290# sky130_fd_pr_reram__reram_cell area_ox=0.0676
X4142 BLN14 rr2t2r_0[27|14]/a_460_290# sky130_fd_pr_reram__reram_cell area_ox=0.0676
X4143 rr2t2r_0[27|14]/a_60_290# WL27 SL14 VSS sky130_fd_pr__nfet_g5v0d10v5 ad=0.65 pd=3.3 as=0 ps=0 w=1 l=0.5
X4144 rr2t2r_0[28|14]/a_460_290# WL28 SL14 VSS sky130_fd_pr__nfet_g5v0d10v5 ad=0.65 pd=3.3 as=0 ps=0 w=1 l=0.5
X4145 BLP14 rr2t2r_0[28|14]/a_60_290# sky130_fd_pr_reram__reram_cell area_ox=0.0676
X4146 BLN14 rr2t2r_0[28|14]/a_460_290# sky130_fd_pr_reram__reram_cell area_ox=0.0676
X4147 rr2t2r_0[28|14]/a_60_290# WL28 SL14 VSS sky130_fd_pr__nfet_g5v0d10v5 ad=0.65 pd=3.3 as=0 ps=0 w=1 l=0.5
X4148 rr2t2r_0[29|14]/a_460_290# WL29 SL14 VSS sky130_fd_pr__nfet_g5v0d10v5 ad=0.65 pd=3.3 as=0 ps=0 w=1 l=0.5
X4149 BLP14 rr2t2r_0[29|14]/a_60_290# sky130_fd_pr_reram__reram_cell area_ox=0.0676
X4150 BLN14 rr2t2r_0[29|14]/a_460_290# sky130_fd_pr_reram__reram_cell area_ox=0.0676
X4151 rr2t2r_0[29|14]/a_60_290# WL29 SL14 VSS sky130_fd_pr__nfet_g5v0d10v5 ad=0.65 pd=3.3 as=0 ps=0 w=1 l=0.5
X4152 rr2t2r_0[30|14]/a_460_290# WL30 SL14 VSS sky130_fd_pr__nfet_g5v0d10v5 ad=0.65 pd=3.3 as=0 ps=0 w=1 l=0.5
X4153 BLP14 rr2t2r_0[30|14]/a_60_290# sky130_fd_pr_reram__reram_cell area_ox=0.0676
X4154 BLN14 rr2t2r_0[30|14]/a_460_290# sky130_fd_pr_reram__reram_cell area_ox=0.0676
X4155 rr2t2r_0[30|14]/a_60_290# WL30 SL14 VSS sky130_fd_pr__nfet_g5v0d10v5 ad=0.65 pd=3.3 as=0 ps=0 w=1 l=0.5
X4156 rr2t2r_0[31|14]/a_460_290# WL31 SL14 VSS sky130_fd_pr__nfet_g5v0d10v5 ad=0.65 pd=3.3 as=0 ps=0 w=1 l=0.5
X4157 BLP14 rr2t2r_0[31|14]/a_60_290# sky130_fd_pr_reram__reram_cell area_ox=0.0676
X4158 BLN14 rr2t2r_0[31|14]/a_460_290# sky130_fd_pr_reram__reram_cell area_ox=0.0676
X4159 rr2t2r_0[31|14]/a_60_290# WL31 SL14 VSS sky130_fd_pr__nfet_g5v0d10v5 ad=0.65 pd=3.3 as=0 ps=0 w=1 l=0.5
X4160 rr2t2r_0[32|14]/a_460_290# WL32 SL14 VSS sky130_fd_pr__nfet_g5v0d10v5 ad=0.65 pd=3.3 as=0 ps=0 w=1 l=0.5
X4161 BLP14 rr2t2r_0[32|14]/a_60_290# sky130_fd_pr_reram__reram_cell area_ox=0.0676
X4162 BLN14 rr2t2r_0[32|14]/a_460_290# sky130_fd_pr_reram__reram_cell area_ox=0.0676
X4163 rr2t2r_0[32|14]/a_60_290# WL32 SL14 VSS sky130_fd_pr__nfet_g5v0d10v5 ad=0.65 pd=3.3 as=0 ps=0 w=1 l=0.5
X4164 rr2t2r_0[33|14]/a_460_290# WL33 SL14 VSS sky130_fd_pr__nfet_g5v0d10v5 ad=0.65 pd=3.3 as=0 ps=0 w=1 l=0.5
X4165 BLP14 rr2t2r_0[33|14]/a_60_290# sky130_fd_pr_reram__reram_cell area_ox=0.0676
X4166 BLN14 rr2t2r_0[33|14]/a_460_290# sky130_fd_pr_reram__reram_cell area_ox=0.0676
X4167 rr2t2r_0[33|14]/a_60_290# WL33 SL14 VSS sky130_fd_pr__nfet_g5v0d10v5 ad=0.65 pd=3.3 as=0 ps=0 w=1 l=0.5
X4168 rr2t2r_0[34|14]/a_460_290# WL34 SL14 VSS sky130_fd_pr__nfet_g5v0d10v5 ad=0.65 pd=3.3 as=0 ps=0 w=1 l=0.5
X4169 BLP14 rr2t2r_0[34|14]/a_60_290# sky130_fd_pr_reram__reram_cell area_ox=0.0676
X4170 BLN14 rr2t2r_0[34|14]/a_460_290# sky130_fd_pr_reram__reram_cell area_ox=0.0676
X4171 rr2t2r_0[34|14]/a_60_290# WL34 SL14 VSS sky130_fd_pr__nfet_g5v0d10v5 ad=0.65 pd=3.3 as=0 ps=0 w=1 l=0.5
X4172 rr2t2r_0[35|14]/a_460_290# WL35 SL14 VSS sky130_fd_pr__nfet_g5v0d10v5 ad=0.65 pd=3.3 as=0 ps=0 w=1 l=0.5
X4173 BLP14 rr2t2r_0[35|14]/a_60_290# sky130_fd_pr_reram__reram_cell area_ox=0.0676
X4174 BLN14 rr2t2r_0[35|14]/a_460_290# sky130_fd_pr_reram__reram_cell area_ox=0.0676
X4175 rr2t2r_0[35|14]/a_60_290# WL35 SL14 VSS sky130_fd_pr__nfet_g5v0d10v5 ad=0.65 pd=3.3 as=0 ps=0 w=1 l=0.5
X4176 rr2t2r_0[36|14]/a_460_290# WL36 SL14 VSS sky130_fd_pr__nfet_g5v0d10v5 ad=0.65 pd=3.3 as=0 ps=0 w=1 l=0.5
X4177 BLP14 rr2t2r_0[36|14]/a_60_290# sky130_fd_pr_reram__reram_cell area_ox=0.0676
X4178 BLN14 rr2t2r_0[36|14]/a_460_290# sky130_fd_pr_reram__reram_cell area_ox=0.0676
X4179 rr2t2r_0[36|14]/a_60_290# WL36 SL14 VSS sky130_fd_pr__nfet_g5v0d10v5 ad=0.65 pd=3.3 as=0 ps=0 w=1 l=0.5
X4180 rr2t2r_0[37|14]/a_460_290# WL37 SL14 VSS sky130_fd_pr__nfet_g5v0d10v5 ad=0.65 pd=3.3 as=0 ps=0 w=1 l=0.5
X4181 BLP14 rr2t2r_0[37|14]/a_60_290# sky130_fd_pr_reram__reram_cell area_ox=0.0676
X4182 BLN14 rr2t2r_0[37|14]/a_460_290# sky130_fd_pr_reram__reram_cell area_ox=0.0676
X4183 rr2t2r_0[37|14]/a_60_290# WL37 SL14 VSS sky130_fd_pr__nfet_g5v0d10v5 ad=0.65 pd=3.3 as=0 ps=0 w=1 l=0.5
X4184 rr2t2r_0[38|14]/a_460_290# WL38 SL14 VSS sky130_fd_pr__nfet_g5v0d10v5 ad=0.65 pd=3.3 as=0 ps=0 w=1 l=0.5
X4185 BLP14 rr2t2r_0[38|14]/a_60_290# sky130_fd_pr_reram__reram_cell area_ox=0.0676
X4186 BLN14 rr2t2r_0[38|14]/a_460_290# sky130_fd_pr_reram__reram_cell area_ox=0.0676
X4187 rr2t2r_0[38|14]/a_60_290# WL38 SL14 VSS sky130_fd_pr__nfet_g5v0d10v5 ad=0.65 pd=3.3 as=0 ps=0 w=1 l=0.5
X4188 rr2t2r_0[39|14]/a_460_290# WL39 SL14 VSS sky130_fd_pr__nfet_g5v0d10v5 ad=0.65 pd=3.3 as=0 ps=0 w=1 l=0.5
X4189 BLP14 rr2t2r_0[39|14]/a_60_290# sky130_fd_pr_reram__reram_cell area_ox=0.0676
X4190 BLN14 rr2t2r_0[39|14]/a_460_290# sky130_fd_pr_reram__reram_cell area_ox=0.0676
X4191 rr2t2r_0[39|14]/a_60_290# WL39 SL14 VSS sky130_fd_pr__nfet_g5v0d10v5 ad=0.65 pd=3.3 as=0 ps=0 w=1 l=0.5
X4192 rr2t2r_0[40|14]/a_460_290# WL40 SL14 VSS sky130_fd_pr__nfet_g5v0d10v5 ad=0.65 pd=3.3 as=0 ps=0 w=1 l=0.5
X4193 BLP14 rr2t2r_0[40|14]/a_60_290# sky130_fd_pr_reram__reram_cell area_ox=0.0676
X4194 BLN14 rr2t2r_0[40|14]/a_460_290# sky130_fd_pr_reram__reram_cell area_ox=0.0676
X4195 rr2t2r_0[40|14]/a_60_290# WL40 SL14 VSS sky130_fd_pr__nfet_g5v0d10v5 ad=0.65 pd=3.3 as=0 ps=0 w=1 l=0.5
X4196 rr2t2r_0[41|14]/a_460_290# WL41 SL14 VSS sky130_fd_pr__nfet_g5v0d10v5 ad=0.65 pd=3.3 as=0 ps=0 w=1 l=0.5
X4197 BLP14 rr2t2r_0[41|14]/a_60_290# sky130_fd_pr_reram__reram_cell area_ox=0.0676
X4198 BLN14 rr2t2r_0[41|14]/a_460_290# sky130_fd_pr_reram__reram_cell area_ox=0.0676
X4199 rr2t2r_0[41|14]/a_60_290# WL41 SL14 VSS sky130_fd_pr__nfet_g5v0d10v5 ad=0.65 pd=3.3 as=0 ps=0 w=1 l=0.5
X4200 rr2t2r_0[42|14]/a_460_290# WL42 SL14 VSS sky130_fd_pr__nfet_g5v0d10v5 ad=0.65 pd=3.3 as=0 ps=0 w=1 l=0.5
X4201 BLP14 rr2t2r_0[42|14]/a_60_290# sky130_fd_pr_reram__reram_cell area_ox=0.0676
X4202 BLN14 rr2t2r_0[42|14]/a_460_290# sky130_fd_pr_reram__reram_cell area_ox=0.0676
X4203 rr2t2r_0[42|14]/a_60_290# WL42 SL14 VSS sky130_fd_pr__nfet_g5v0d10v5 ad=0.65 pd=3.3 as=0 ps=0 w=1 l=0.5
X4204 rr2t2r_0[43|14]/a_460_290# WL43 SL14 VSS sky130_fd_pr__nfet_g5v0d10v5 ad=0.65 pd=3.3 as=0 ps=0 w=1 l=0.5
X4205 BLP14 rr2t2r_0[43|14]/a_60_290# sky130_fd_pr_reram__reram_cell area_ox=0.0676
X4206 BLN14 rr2t2r_0[43|14]/a_460_290# sky130_fd_pr_reram__reram_cell area_ox=0.0676
X4207 rr2t2r_0[43|14]/a_60_290# WL43 SL14 VSS sky130_fd_pr__nfet_g5v0d10v5 ad=0.65 pd=3.3 as=0 ps=0 w=1 l=0.5
X4208 rr2t2r_0[44|14]/a_460_290# WL44 SL14 VSS sky130_fd_pr__nfet_g5v0d10v5 ad=0.65 pd=3.3 as=0 ps=0 w=1 l=0.5
X4209 BLP14 rr2t2r_0[44|14]/a_60_290# sky130_fd_pr_reram__reram_cell area_ox=0.0676
X4210 BLN14 rr2t2r_0[44|14]/a_460_290# sky130_fd_pr_reram__reram_cell area_ox=0.0676
X4211 rr2t2r_0[44|14]/a_60_290# WL44 SL14 VSS sky130_fd_pr__nfet_g5v0d10v5 ad=0.65 pd=3.3 as=0 ps=0 w=1 l=0.5
X4212 rr2t2r_0[45|14]/a_460_290# WL45 SL14 VSS sky130_fd_pr__nfet_g5v0d10v5 ad=0.65 pd=3.3 as=0 ps=0 w=1 l=0.5
X4213 BLP14 rr2t2r_0[45|14]/a_60_290# sky130_fd_pr_reram__reram_cell area_ox=0.0676
X4214 BLN14 rr2t2r_0[45|14]/a_460_290# sky130_fd_pr_reram__reram_cell area_ox=0.0676
X4215 rr2t2r_0[45|14]/a_60_290# WL45 SL14 VSS sky130_fd_pr__nfet_g5v0d10v5 ad=0.65 pd=3.3 as=0 ps=0 w=1 l=0.5
X4216 rr2t2r_0[46|14]/a_460_290# WL46 SL14 VSS sky130_fd_pr__nfet_g5v0d10v5 ad=0.65 pd=3.3 as=0 ps=0 w=1 l=0.5
X4217 BLP14 rr2t2r_0[46|14]/a_60_290# sky130_fd_pr_reram__reram_cell area_ox=0.0676
X4218 BLN14 rr2t2r_0[46|14]/a_460_290# sky130_fd_pr_reram__reram_cell area_ox=0.0676
X4219 rr2t2r_0[46|14]/a_60_290# WL46 SL14 VSS sky130_fd_pr__nfet_g5v0d10v5 ad=0.65 pd=3.3 as=0 ps=0 w=1 l=0.5
X4220 rr2t2r_0[47|14]/a_460_290# WL47 SL14 VSS sky130_fd_pr__nfet_g5v0d10v5 ad=0.65 pd=3.3 as=0 ps=0 w=1 l=0.5
X4221 BLP14 rr2t2r_0[47|14]/a_60_290# sky130_fd_pr_reram__reram_cell area_ox=0.0676
X4222 BLN14 rr2t2r_0[47|14]/a_460_290# sky130_fd_pr_reram__reram_cell area_ox=0.0676
X4223 rr2t2r_0[47|14]/a_60_290# WL47 SL14 VSS sky130_fd_pr__nfet_g5v0d10v5 ad=0.65 pd=3.3 as=0 ps=0 w=1 l=0.5
X4224 rr2t2r_0[48|14]/a_460_290# WL48 SL14 VSS sky130_fd_pr__nfet_g5v0d10v5 ad=0.65 pd=3.3 as=0 ps=0 w=1 l=0.5
X4225 BLP14 rr2t2r_0[48|14]/a_60_290# sky130_fd_pr_reram__reram_cell area_ox=0.0676
X4226 BLN14 rr2t2r_0[48|14]/a_460_290# sky130_fd_pr_reram__reram_cell area_ox=0.0676
X4227 rr2t2r_0[48|14]/a_60_290# WL48 SL14 VSS sky130_fd_pr__nfet_g5v0d10v5 ad=0.65 pd=3.3 as=0 ps=0 w=1 l=0.5
X4228 rr2t2r_0[49|14]/a_460_290# WL49 SL14 VSS sky130_fd_pr__nfet_g5v0d10v5 ad=0.65 pd=3.3 as=0 ps=0 w=1 l=0.5
X4229 BLP14 rr2t2r_0[49|14]/a_60_290# sky130_fd_pr_reram__reram_cell area_ox=0.0676
X4230 BLN14 rr2t2r_0[49|14]/a_460_290# sky130_fd_pr_reram__reram_cell area_ox=0.0676
X4231 rr2t2r_0[49|14]/a_60_290# WL49 SL14 VSS sky130_fd_pr__nfet_g5v0d10v5 ad=0.65 pd=3.3 as=0 ps=0 w=1 l=0.5
X4232 rr2t2r_0[50|14]/a_460_290# WL50 SL14 VSS sky130_fd_pr__nfet_g5v0d10v5 ad=0.65 pd=3.3 as=0 ps=0 w=1 l=0.5
X4233 BLP14 rr2t2r_0[50|14]/a_60_290# sky130_fd_pr_reram__reram_cell area_ox=0.0676
X4234 BLN14 rr2t2r_0[50|14]/a_460_290# sky130_fd_pr_reram__reram_cell area_ox=0.0676
X4235 rr2t2r_0[50|14]/a_60_290# WL50 SL14 VSS sky130_fd_pr__nfet_g5v0d10v5 ad=0.65 pd=3.3 as=0 ps=0 w=1 l=0.5
X4236 rr2t2r_0[51|14]/a_460_290# WL51 SL14 VSS sky130_fd_pr__nfet_g5v0d10v5 ad=0.65 pd=3.3 as=0 ps=0 w=1 l=0.5
X4237 BLP14 rr2t2r_0[51|14]/a_60_290# sky130_fd_pr_reram__reram_cell area_ox=0.0676
X4238 BLN14 rr2t2r_0[51|14]/a_460_290# sky130_fd_pr_reram__reram_cell area_ox=0.0676
X4239 rr2t2r_0[51|14]/a_60_290# WL51 SL14 VSS sky130_fd_pr__nfet_g5v0d10v5 ad=0.65 pd=3.3 as=0 ps=0 w=1 l=0.5
X4240 rr2t2r_0[52|14]/a_460_290# WL52 SL14 VSS sky130_fd_pr__nfet_g5v0d10v5 ad=0.65 pd=3.3 as=0 ps=0 w=1 l=0.5
X4241 BLP14 rr2t2r_0[52|14]/a_60_290# sky130_fd_pr_reram__reram_cell area_ox=0.0676
X4242 BLN14 rr2t2r_0[52|14]/a_460_290# sky130_fd_pr_reram__reram_cell area_ox=0.0676
X4243 rr2t2r_0[52|14]/a_60_290# WL52 SL14 VSS sky130_fd_pr__nfet_g5v0d10v5 ad=0.65 pd=3.3 as=0 ps=0 w=1 l=0.5
X4244 rr2t2r_0[53|14]/a_460_290# WL53 SL14 VSS sky130_fd_pr__nfet_g5v0d10v5 ad=0.65 pd=3.3 as=0 ps=0 w=1 l=0.5
X4245 BLP14 rr2t2r_0[53|14]/a_60_290# sky130_fd_pr_reram__reram_cell area_ox=0.0676
X4246 BLN14 rr2t2r_0[53|14]/a_460_290# sky130_fd_pr_reram__reram_cell area_ox=0.0676
X4247 rr2t2r_0[53|14]/a_60_290# WL53 SL14 VSS sky130_fd_pr__nfet_g5v0d10v5 ad=0.65 pd=3.3 as=0 ps=0 w=1 l=0.5
X4248 rr2t2r_0[54|14]/a_460_290# WL54 SL14 VSS sky130_fd_pr__nfet_g5v0d10v5 ad=0.65 pd=3.3 as=0 ps=0 w=1 l=0.5
X4249 BLP14 rr2t2r_0[54|14]/a_60_290# sky130_fd_pr_reram__reram_cell area_ox=0.0676
X4250 BLN14 rr2t2r_0[54|14]/a_460_290# sky130_fd_pr_reram__reram_cell area_ox=0.0676
X4251 rr2t2r_0[54|14]/a_60_290# WL54 SL14 VSS sky130_fd_pr__nfet_g5v0d10v5 ad=0.65 pd=3.3 as=0 ps=0 w=1 l=0.5
X4252 rr2t2r_0[55|14]/a_460_290# WL55 SL14 VSS sky130_fd_pr__nfet_g5v0d10v5 ad=0.65 pd=3.3 as=0 ps=0 w=1 l=0.5
X4253 BLP14 rr2t2r_0[55|14]/a_60_290# sky130_fd_pr_reram__reram_cell area_ox=0.0676
X4254 BLN14 rr2t2r_0[55|14]/a_460_290# sky130_fd_pr_reram__reram_cell area_ox=0.0676
X4255 rr2t2r_0[55|14]/a_60_290# WL55 SL14 VSS sky130_fd_pr__nfet_g5v0d10v5 ad=0.65 pd=3.3 as=0 ps=0 w=1 l=0.5
X4256 rr2t2r_0[56|14]/a_460_290# WL56 SL14 VSS sky130_fd_pr__nfet_g5v0d10v5 ad=0.65 pd=3.3 as=0 ps=0 w=1 l=0.5
X4257 BLP14 rr2t2r_0[56|14]/a_60_290# sky130_fd_pr_reram__reram_cell area_ox=0.0676
X4258 BLN14 rr2t2r_0[56|14]/a_460_290# sky130_fd_pr_reram__reram_cell area_ox=0.0676
X4259 rr2t2r_0[56|14]/a_60_290# WL56 SL14 VSS sky130_fd_pr__nfet_g5v0d10v5 ad=0.65 pd=3.3 as=0 ps=0 w=1 l=0.5
X4260 rr2t2r_0[57|14]/a_460_290# WL57 SL14 VSS sky130_fd_pr__nfet_g5v0d10v5 ad=0.65 pd=3.3 as=0 ps=0 w=1 l=0.5
X4261 BLP14 rr2t2r_0[57|14]/a_60_290# sky130_fd_pr_reram__reram_cell area_ox=0.0676
X4262 BLN14 rr2t2r_0[57|14]/a_460_290# sky130_fd_pr_reram__reram_cell area_ox=0.0676
X4263 rr2t2r_0[57|14]/a_60_290# WL57 SL14 VSS sky130_fd_pr__nfet_g5v0d10v5 ad=0.65 pd=3.3 as=0 ps=0 w=1 l=0.5
X4264 rr2t2r_0[58|14]/a_460_290# WL58 SL14 VSS sky130_fd_pr__nfet_g5v0d10v5 ad=0.65 pd=3.3 as=0 ps=0 w=1 l=0.5
X4265 BLP14 rr2t2r_0[58|14]/a_60_290# sky130_fd_pr_reram__reram_cell area_ox=0.0676
X4266 BLN14 rr2t2r_0[58|14]/a_460_290# sky130_fd_pr_reram__reram_cell area_ox=0.0676
X4267 rr2t2r_0[58|14]/a_60_290# WL58 SL14 VSS sky130_fd_pr__nfet_g5v0d10v5 ad=0.65 pd=3.3 as=0 ps=0 w=1 l=0.5
X4268 rr2t2r_0[59|14]/a_460_290# WL59 SL14 VSS sky130_fd_pr__nfet_g5v0d10v5 ad=0.65 pd=3.3 as=0 ps=0 w=1 l=0.5
X4269 BLP14 rr2t2r_0[59|14]/a_60_290# sky130_fd_pr_reram__reram_cell area_ox=0.0676
X4270 BLN14 rr2t2r_0[59|14]/a_460_290# sky130_fd_pr_reram__reram_cell area_ox=0.0676
X4271 rr2t2r_0[59|14]/a_60_290# WL59 SL14 VSS sky130_fd_pr__nfet_g5v0d10v5 ad=0.65 pd=3.3 as=0 ps=0 w=1 l=0.5
X4272 rr2t2r_0[60|14]/a_460_290# WL60 SL14 VSS sky130_fd_pr__nfet_g5v0d10v5 ad=0.65 pd=3.3 as=0 ps=0 w=1 l=0.5
X4273 BLP14 rr2t2r_0[60|14]/a_60_290# sky130_fd_pr_reram__reram_cell area_ox=0.0676
X4274 BLN14 rr2t2r_0[60|14]/a_460_290# sky130_fd_pr_reram__reram_cell area_ox=0.0676
X4275 rr2t2r_0[60|14]/a_60_290# WL60 SL14 VSS sky130_fd_pr__nfet_g5v0d10v5 ad=0.65 pd=3.3 as=0 ps=0 w=1 l=0.5
X4276 rr2t2r_0[61|14]/a_460_290# WL61 SL14 VSS sky130_fd_pr__nfet_g5v0d10v5 ad=0.65 pd=3.3 as=0 ps=0 w=1 l=0.5
X4277 BLP14 rr2t2r_0[61|14]/a_60_290# sky130_fd_pr_reram__reram_cell area_ox=0.0676
X4278 BLN14 rr2t2r_0[61|14]/a_460_290# sky130_fd_pr_reram__reram_cell area_ox=0.0676
X4279 rr2t2r_0[61|14]/a_60_290# WL61 SL14 VSS sky130_fd_pr__nfet_g5v0d10v5 ad=0.65 pd=3.3 as=0 ps=0 w=1 l=0.5
X4280 rr2t2r_0[62|14]/a_460_290# WL62 SL14 VSS sky130_fd_pr__nfet_g5v0d10v5 ad=0.65 pd=3.3 as=0 ps=0 w=1 l=0.5
X4281 BLP14 rr2t2r_0[62|14]/a_60_290# sky130_fd_pr_reram__reram_cell area_ox=0.0676
X4282 BLN14 rr2t2r_0[62|14]/a_460_290# sky130_fd_pr_reram__reram_cell area_ox=0.0676
X4283 rr2t2r_0[62|14]/a_60_290# WL62 SL14 VSS sky130_fd_pr__nfet_g5v0d10v5 ad=0.65 pd=3.3 as=0 ps=0 w=1 l=0.5
X4284 rr2t2r_0[63|14]/a_460_290# WL63 SL14 VSS sky130_fd_pr__nfet_g5v0d10v5 ad=0.65 pd=3.3 as=0 ps=0 w=1 l=0.5
X4285 BLP14 rr2t2r_0[63|14]/a_60_290# sky130_fd_pr_reram__reram_cell area_ox=0.0676
X4286 BLN14 rr2t2r_0[63|14]/a_460_290# sky130_fd_pr_reram__reram_cell area_ox=0.0676
X4287 rr2t2r_0[63|14]/a_60_290# WL63 SL14 VSS sky130_fd_pr__nfet_g5v0d10v5 ad=0.65 pd=3.3 as=0 ps=0 w=1 l=0.5
X4288 rr2t2r_0[64|14]/a_460_290# WL64 SL14 VSS sky130_fd_pr__nfet_g5v0d10v5 ad=0.65 pd=3.3 as=0 ps=0 w=1 l=0.5
X4289 BLP14 rr2t2r_0[64|14]/a_60_290# sky130_fd_pr_reram__reram_cell area_ox=0.0676
X4290 BLN14 rr2t2r_0[64|14]/a_460_290# sky130_fd_pr_reram__reram_cell area_ox=0.0676
X4291 rr2t2r_0[64|14]/a_60_290# WL64 SL14 VSS sky130_fd_pr__nfet_g5v0d10v5 ad=0.65 pd=3.3 as=0 ps=0 w=1 l=0.5
X4292 rr2t2r_0[65|14]/a_460_290# WL65 SL14 VSS sky130_fd_pr__nfet_g5v0d10v5 ad=0.65 pd=3.3 as=0 ps=0 w=1 l=0.5
X4293 BLP14 rr2t2r_0[65|14]/a_60_290# sky130_fd_pr_reram__reram_cell area_ox=0.0676
X4294 BLN14 rr2t2r_0[65|14]/a_460_290# sky130_fd_pr_reram__reram_cell area_ox=0.0676
X4295 rr2t2r_0[65|14]/a_60_290# WL65 SL14 VSS sky130_fd_pr__nfet_g5v0d10v5 ad=0.65 pd=3.3 as=0 ps=0 w=1 l=0.5
X4296 rr2t2r_0[66|14]/a_460_290# WL66 SL14 VSS sky130_fd_pr__nfet_g5v0d10v5 ad=0.65 pd=3.3 as=0 ps=0 w=1 l=0.5
X4297 BLP14 rr2t2r_0[66|14]/a_60_290# sky130_fd_pr_reram__reram_cell area_ox=0.0676
X4298 BLN14 rr2t2r_0[66|14]/a_460_290# sky130_fd_pr_reram__reram_cell area_ox=0.0676
X4299 rr2t2r_0[66|14]/a_60_290# WL66 SL14 VSS sky130_fd_pr__nfet_g5v0d10v5 ad=0.65 pd=3.3 as=0 ps=0 w=1 l=0.5
X4300 rr2t2r_0[67|14]/a_460_290# WL67 SL14 VSS sky130_fd_pr__nfet_g5v0d10v5 ad=0.65 pd=3.3 as=0 ps=0 w=1 l=0.5
X4301 BLP14 rr2t2r_0[67|14]/a_60_290# sky130_fd_pr_reram__reram_cell area_ox=0.0676
X4302 BLN14 rr2t2r_0[67|14]/a_460_290# sky130_fd_pr_reram__reram_cell area_ox=0.0676
X4303 rr2t2r_0[67|14]/a_60_290# WL67 SL14 VSS sky130_fd_pr__nfet_g5v0d10v5 ad=0.65 pd=3.3 as=0 ps=0 w=1 l=0.5
X4304 rr2t2r_0[68|14]/a_460_290# WL68 SL14 VSS sky130_fd_pr__nfet_g5v0d10v5 ad=0.65 pd=3.3 as=0 ps=0 w=1 l=0.5
X4305 BLP14 rr2t2r_0[68|14]/a_60_290# sky130_fd_pr_reram__reram_cell area_ox=0.0676
X4306 BLN14 rr2t2r_0[68|14]/a_460_290# sky130_fd_pr_reram__reram_cell area_ox=0.0676
X4307 rr2t2r_0[68|14]/a_60_290# WL68 SL14 VSS sky130_fd_pr__nfet_g5v0d10v5 ad=0.65 pd=3.3 as=0 ps=0 w=1 l=0.5
X4308 rr2t2r_0[69|14]/a_460_290# WL69 SL14 VSS sky130_fd_pr__nfet_g5v0d10v5 ad=0.65 pd=3.3 as=0 ps=0 w=1 l=0.5
X4309 BLP14 rr2t2r_0[69|14]/a_60_290# sky130_fd_pr_reram__reram_cell area_ox=0.0676
X4310 BLN14 rr2t2r_0[69|14]/a_460_290# sky130_fd_pr_reram__reram_cell area_ox=0.0676
X4311 rr2t2r_0[69|14]/a_60_290# WL69 SL14 VSS sky130_fd_pr__nfet_g5v0d10v5 ad=0.65 pd=3.3 as=0 ps=0 w=1 l=0.5
X4312 rr2t2r_0[70|14]/a_460_290# WL70 SL14 VSS sky130_fd_pr__nfet_g5v0d10v5 ad=0.65 pd=3.3 as=0 ps=0 w=1 l=0.5
X4313 BLP14 rr2t2r_0[70|14]/a_60_290# sky130_fd_pr_reram__reram_cell area_ox=0.0676
X4314 BLN14 rr2t2r_0[70|14]/a_460_290# sky130_fd_pr_reram__reram_cell area_ox=0.0676
X4315 rr2t2r_0[70|14]/a_60_290# WL70 SL14 VSS sky130_fd_pr__nfet_g5v0d10v5 ad=0.65 pd=3.3 as=0 ps=0 w=1 l=0.5
X4316 rr2t2r_0[71|14]/a_460_290# WL71 SL14 VSS sky130_fd_pr__nfet_g5v0d10v5 ad=0.65 pd=3.3 as=0 ps=0 w=1 l=0.5
X4317 BLP14 rr2t2r_0[71|14]/a_60_290# sky130_fd_pr_reram__reram_cell area_ox=0.0676
X4318 BLN14 rr2t2r_0[71|14]/a_460_290# sky130_fd_pr_reram__reram_cell area_ox=0.0676
X4319 rr2t2r_0[71|14]/a_60_290# WL71 SL14 VSS sky130_fd_pr__nfet_g5v0d10v5 ad=0.65 pd=3.3 as=0 ps=0 w=1 l=0.5
X4320 rr2t2r_0[0|15]/a_460_290# WL0 SL15 VSS sky130_fd_pr__nfet_g5v0d10v5 ad=0.65 pd=3.3 as=108 ps=504 w=1 l=0.5
X4321 BLP15 rr2t2r_0[0|15]/a_60_290# sky130_fd_pr_reram__reram_cell area_ox=0.0676
X4322 BLN15 rr2t2r_0[0|15]/a_460_290# sky130_fd_pr_reram__reram_cell area_ox=0.0676
X4323 rr2t2r_0[0|15]/a_60_290# WL0 SL15 VSS sky130_fd_pr__nfet_g5v0d10v5 ad=0.65 pd=3.3 as=0 ps=0 w=1 l=0.5
X4324 rr2t2r_0[1|15]/a_460_290# WL1 SL15 VSS sky130_fd_pr__nfet_g5v0d10v5 ad=0.65 pd=3.3 as=0 ps=0 w=1 l=0.5
X4325 BLP15 rr2t2r_0[1|15]/a_60_290# sky130_fd_pr_reram__reram_cell area_ox=0.0676
X4326 BLN15 rr2t2r_0[1|15]/a_460_290# sky130_fd_pr_reram__reram_cell area_ox=0.0676
X4327 rr2t2r_0[1|15]/a_60_290# WL1 SL15 VSS sky130_fd_pr__nfet_g5v0d10v5 ad=0.65 pd=3.3 as=0 ps=0 w=1 l=0.5
X4328 rr2t2r_0[2|15]/a_460_290# WL2 SL15 VSS sky130_fd_pr__nfet_g5v0d10v5 ad=0.65 pd=3.3 as=0 ps=0 w=1 l=0.5
X4329 BLP15 rr2t2r_0[2|15]/a_60_290# sky130_fd_pr_reram__reram_cell area_ox=0.0676
X4330 BLN15 rr2t2r_0[2|15]/a_460_290# sky130_fd_pr_reram__reram_cell area_ox=0.0676
X4331 rr2t2r_0[2|15]/a_60_290# WL2 SL15 VSS sky130_fd_pr__nfet_g5v0d10v5 ad=0.65 pd=3.3 as=0 ps=0 w=1 l=0.5
X4332 rr2t2r_0[3|15]/a_460_290# WL3 SL15 VSS sky130_fd_pr__nfet_g5v0d10v5 ad=0.65 pd=3.3 as=0 ps=0 w=1 l=0.5
X4333 BLP15 rr2t2r_0[3|15]/a_60_290# sky130_fd_pr_reram__reram_cell area_ox=0.0676
X4334 BLN15 rr2t2r_0[3|15]/a_460_290# sky130_fd_pr_reram__reram_cell area_ox=0.0676
X4335 rr2t2r_0[3|15]/a_60_290# WL3 SL15 VSS sky130_fd_pr__nfet_g5v0d10v5 ad=0.65 pd=3.3 as=0 ps=0 w=1 l=0.5
X4336 rr2t2r_0[4|15]/a_460_290# WL4 SL15 VSS sky130_fd_pr__nfet_g5v0d10v5 ad=0.65 pd=3.3 as=0 ps=0 w=1 l=0.5
X4337 BLP15 rr2t2r_0[4|15]/a_60_290# sky130_fd_pr_reram__reram_cell area_ox=0.0676
X4338 BLN15 rr2t2r_0[4|15]/a_460_290# sky130_fd_pr_reram__reram_cell area_ox=0.0676
X4339 rr2t2r_0[4|15]/a_60_290# WL4 SL15 VSS sky130_fd_pr__nfet_g5v0d10v5 ad=0.65 pd=3.3 as=0 ps=0 w=1 l=0.5
X4340 rr2t2r_0[5|15]/a_460_290# WL5 SL15 VSS sky130_fd_pr__nfet_g5v0d10v5 ad=0.65 pd=3.3 as=0 ps=0 w=1 l=0.5
X4341 BLP15 rr2t2r_0[5|15]/a_60_290# sky130_fd_pr_reram__reram_cell area_ox=0.0676
X4342 BLN15 rr2t2r_0[5|15]/a_460_290# sky130_fd_pr_reram__reram_cell area_ox=0.0676
X4343 rr2t2r_0[5|15]/a_60_290# WL5 SL15 VSS sky130_fd_pr__nfet_g5v0d10v5 ad=0.65 pd=3.3 as=0 ps=0 w=1 l=0.5
X4344 rr2t2r_0[6|15]/a_460_290# WL6 SL15 VSS sky130_fd_pr__nfet_g5v0d10v5 ad=0.65 pd=3.3 as=0 ps=0 w=1 l=0.5
X4345 BLP15 rr2t2r_0[6|15]/a_60_290# sky130_fd_pr_reram__reram_cell area_ox=0.0676
X4346 BLN15 rr2t2r_0[6|15]/a_460_290# sky130_fd_pr_reram__reram_cell area_ox=0.0676
X4347 rr2t2r_0[6|15]/a_60_290# WL6 SL15 VSS sky130_fd_pr__nfet_g5v0d10v5 ad=0.65 pd=3.3 as=0 ps=0 w=1 l=0.5
X4348 rr2t2r_0[7|15]/a_460_290# WL7 SL15 VSS sky130_fd_pr__nfet_g5v0d10v5 ad=0.65 pd=3.3 as=0 ps=0 w=1 l=0.5
X4349 BLP15 rr2t2r_0[7|15]/a_60_290# sky130_fd_pr_reram__reram_cell area_ox=0.0676
X4350 BLN15 rr2t2r_0[7|15]/a_460_290# sky130_fd_pr_reram__reram_cell area_ox=0.0676
X4351 rr2t2r_0[7|15]/a_60_290# WL7 SL15 VSS sky130_fd_pr__nfet_g5v0d10v5 ad=0.65 pd=3.3 as=0 ps=0 w=1 l=0.5
X4352 rr2t2r_0[8|15]/a_460_290# WL8 SL15 VSS sky130_fd_pr__nfet_g5v0d10v5 ad=0.65 pd=3.3 as=0 ps=0 w=1 l=0.5
X4353 BLP15 rr2t2r_0[8|15]/a_60_290# sky130_fd_pr_reram__reram_cell area_ox=0.0676
X4354 BLN15 rr2t2r_0[8|15]/a_460_290# sky130_fd_pr_reram__reram_cell area_ox=0.0676
X4355 rr2t2r_0[8|15]/a_60_290# WL8 SL15 VSS sky130_fd_pr__nfet_g5v0d10v5 ad=0.65 pd=3.3 as=0 ps=0 w=1 l=0.5
X4356 rr2t2r_0[9|15]/a_460_290# WL9 SL15 VSS sky130_fd_pr__nfet_g5v0d10v5 ad=0.65 pd=3.3 as=0 ps=0 w=1 l=0.5
X4357 BLP15 rr2t2r_0[9|15]/a_60_290# sky130_fd_pr_reram__reram_cell area_ox=0.0676
X4358 BLN15 rr2t2r_0[9|15]/a_460_290# sky130_fd_pr_reram__reram_cell area_ox=0.0676
X4359 rr2t2r_0[9|15]/a_60_290# WL9 SL15 VSS sky130_fd_pr__nfet_g5v0d10v5 ad=0.65 pd=3.3 as=0 ps=0 w=1 l=0.5
X4360 rr2t2r_0[10|15]/a_460_290# WL10 SL15 VSS sky130_fd_pr__nfet_g5v0d10v5 ad=0.65 pd=3.3 as=0 ps=0 w=1 l=0.5
X4361 BLP15 rr2t2r_0[10|15]/a_60_290# sky130_fd_pr_reram__reram_cell area_ox=0.0676
X4362 BLN15 rr2t2r_0[10|15]/a_460_290# sky130_fd_pr_reram__reram_cell area_ox=0.0676
X4363 rr2t2r_0[10|15]/a_60_290# WL10 SL15 VSS sky130_fd_pr__nfet_g5v0d10v5 ad=0.65 pd=3.3 as=0 ps=0 w=1 l=0.5
X4364 rr2t2r_0[11|15]/a_460_290# WL11 SL15 VSS sky130_fd_pr__nfet_g5v0d10v5 ad=0.65 pd=3.3 as=0 ps=0 w=1 l=0.5
X4365 BLP15 rr2t2r_0[11|15]/a_60_290# sky130_fd_pr_reram__reram_cell area_ox=0.0676
X4366 BLN15 rr2t2r_0[11|15]/a_460_290# sky130_fd_pr_reram__reram_cell area_ox=0.0676
X4367 rr2t2r_0[11|15]/a_60_290# WL11 SL15 VSS sky130_fd_pr__nfet_g5v0d10v5 ad=0.65 pd=3.3 as=0 ps=0 w=1 l=0.5
X4368 rr2t2r_0[12|15]/a_460_290# WL12 SL15 VSS sky130_fd_pr__nfet_g5v0d10v5 ad=0.65 pd=3.3 as=0 ps=0 w=1 l=0.5
X4369 BLP15 rr2t2r_0[12|15]/a_60_290# sky130_fd_pr_reram__reram_cell area_ox=0.0676
X4370 BLN15 rr2t2r_0[12|15]/a_460_290# sky130_fd_pr_reram__reram_cell area_ox=0.0676
X4371 rr2t2r_0[12|15]/a_60_290# WL12 SL15 VSS sky130_fd_pr__nfet_g5v0d10v5 ad=0.65 pd=3.3 as=0 ps=0 w=1 l=0.5
X4372 rr2t2r_0[13|15]/a_460_290# WL13 SL15 VSS sky130_fd_pr__nfet_g5v0d10v5 ad=0.65 pd=3.3 as=0 ps=0 w=1 l=0.5
X4373 BLP15 rr2t2r_0[13|15]/a_60_290# sky130_fd_pr_reram__reram_cell area_ox=0.0676
X4374 BLN15 rr2t2r_0[13|15]/a_460_290# sky130_fd_pr_reram__reram_cell area_ox=0.0676
X4375 rr2t2r_0[13|15]/a_60_290# WL13 SL15 VSS sky130_fd_pr__nfet_g5v0d10v5 ad=0.65 pd=3.3 as=0 ps=0 w=1 l=0.5
X4376 rr2t2r_0[14|15]/a_460_290# WL14 SL15 VSS sky130_fd_pr__nfet_g5v0d10v5 ad=0.65 pd=3.3 as=0 ps=0 w=1 l=0.5
X4377 BLP15 rr2t2r_0[14|15]/a_60_290# sky130_fd_pr_reram__reram_cell area_ox=0.0676
X4378 BLN15 rr2t2r_0[14|15]/a_460_290# sky130_fd_pr_reram__reram_cell area_ox=0.0676
X4379 rr2t2r_0[14|15]/a_60_290# WL14 SL15 VSS sky130_fd_pr__nfet_g5v0d10v5 ad=0.65 pd=3.3 as=0 ps=0 w=1 l=0.5
X4380 rr2t2r_0[15|15]/a_460_290# WL15 SL15 VSS sky130_fd_pr__nfet_g5v0d10v5 ad=0.65 pd=3.3 as=0 ps=0 w=1 l=0.5
X4381 BLP15 rr2t2r_0[15|15]/a_60_290# sky130_fd_pr_reram__reram_cell area_ox=0.0676
X4382 BLN15 rr2t2r_0[15|15]/a_460_290# sky130_fd_pr_reram__reram_cell area_ox=0.0676
X4383 rr2t2r_0[15|15]/a_60_290# WL15 SL15 VSS sky130_fd_pr__nfet_g5v0d10v5 ad=0.65 pd=3.3 as=0 ps=0 w=1 l=0.5
X4384 rr2t2r_0[16|15]/a_460_290# WL16 SL15 VSS sky130_fd_pr__nfet_g5v0d10v5 ad=0.65 pd=3.3 as=0 ps=0 w=1 l=0.5
X4385 BLP15 rr2t2r_0[16|15]/a_60_290# sky130_fd_pr_reram__reram_cell area_ox=0.0676
X4386 BLN15 rr2t2r_0[16|15]/a_460_290# sky130_fd_pr_reram__reram_cell area_ox=0.0676
X4387 rr2t2r_0[16|15]/a_60_290# WL16 SL15 VSS sky130_fd_pr__nfet_g5v0d10v5 ad=0.65 pd=3.3 as=0 ps=0 w=1 l=0.5
X4388 rr2t2r_0[17|15]/a_460_290# WL17 SL15 VSS sky130_fd_pr__nfet_g5v0d10v5 ad=0.65 pd=3.3 as=0 ps=0 w=1 l=0.5
X4389 BLP15 rr2t2r_0[17|15]/a_60_290# sky130_fd_pr_reram__reram_cell area_ox=0.0676
X4390 BLN15 rr2t2r_0[17|15]/a_460_290# sky130_fd_pr_reram__reram_cell area_ox=0.0676
X4391 rr2t2r_0[17|15]/a_60_290# WL17 SL15 VSS sky130_fd_pr__nfet_g5v0d10v5 ad=0.65 pd=3.3 as=0 ps=0 w=1 l=0.5
X4392 rr2t2r_0[18|15]/a_460_290# WL18 SL15 VSS sky130_fd_pr__nfet_g5v0d10v5 ad=0.65 pd=3.3 as=0 ps=0 w=1 l=0.5
X4393 BLP15 rr2t2r_0[18|15]/a_60_290# sky130_fd_pr_reram__reram_cell area_ox=0.0676
X4394 BLN15 rr2t2r_0[18|15]/a_460_290# sky130_fd_pr_reram__reram_cell area_ox=0.0676
X4395 rr2t2r_0[18|15]/a_60_290# WL18 SL15 VSS sky130_fd_pr__nfet_g5v0d10v5 ad=0.65 pd=3.3 as=0 ps=0 w=1 l=0.5
X4396 rr2t2r_0[19|15]/a_460_290# WL19 SL15 VSS sky130_fd_pr__nfet_g5v0d10v5 ad=0.65 pd=3.3 as=0 ps=0 w=1 l=0.5
X4397 BLP15 rr2t2r_0[19|15]/a_60_290# sky130_fd_pr_reram__reram_cell area_ox=0.0676
X4398 BLN15 rr2t2r_0[19|15]/a_460_290# sky130_fd_pr_reram__reram_cell area_ox=0.0676
X4399 rr2t2r_0[19|15]/a_60_290# WL19 SL15 VSS sky130_fd_pr__nfet_g5v0d10v5 ad=0.65 pd=3.3 as=0 ps=0 w=1 l=0.5
X4400 rr2t2r_0[20|15]/a_460_290# WL20 SL15 VSS sky130_fd_pr__nfet_g5v0d10v5 ad=0.65 pd=3.3 as=0 ps=0 w=1 l=0.5
X4401 BLP15 rr2t2r_0[20|15]/a_60_290# sky130_fd_pr_reram__reram_cell area_ox=0.0676
X4402 BLN15 rr2t2r_0[20|15]/a_460_290# sky130_fd_pr_reram__reram_cell area_ox=0.0676
X4403 rr2t2r_0[20|15]/a_60_290# WL20 SL15 VSS sky130_fd_pr__nfet_g5v0d10v5 ad=0.65 pd=3.3 as=0 ps=0 w=1 l=0.5
X4404 rr2t2r_0[21|15]/a_460_290# WL21 SL15 VSS sky130_fd_pr__nfet_g5v0d10v5 ad=0.65 pd=3.3 as=0 ps=0 w=1 l=0.5
X4405 BLP15 rr2t2r_0[21|15]/a_60_290# sky130_fd_pr_reram__reram_cell area_ox=0.0676
X4406 BLN15 rr2t2r_0[21|15]/a_460_290# sky130_fd_pr_reram__reram_cell area_ox=0.0676
X4407 rr2t2r_0[21|15]/a_60_290# WL21 SL15 VSS sky130_fd_pr__nfet_g5v0d10v5 ad=0.65 pd=3.3 as=0 ps=0 w=1 l=0.5
X4408 rr2t2r_0[22|15]/a_460_290# WL22 SL15 VSS sky130_fd_pr__nfet_g5v0d10v5 ad=0.65 pd=3.3 as=0 ps=0 w=1 l=0.5
X4409 BLP15 rr2t2r_0[22|15]/a_60_290# sky130_fd_pr_reram__reram_cell area_ox=0.0676
X4410 BLN15 rr2t2r_0[22|15]/a_460_290# sky130_fd_pr_reram__reram_cell area_ox=0.0676
X4411 rr2t2r_0[22|15]/a_60_290# WL22 SL15 VSS sky130_fd_pr__nfet_g5v0d10v5 ad=0.65 pd=3.3 as=0 ps=0 w=1 l=0.5
X4412 rr2t2r_0[23|15]/a_460_290# WL23 SL15 VSS sky130_fd_pr__nfet_g5v0d10v5 ad=0.65 pd=3.3 as=0 ps=0 w=1 l=0.5
X4413 BLP15 rr2t2r_0[23|15]/a_60_290# sky130_fd_pr_reram__reram_cell area_ox=0.0676
X4414 BLN15 rr2t2r_0[23|15]/a_460_290# sky130_fd_pr_reram__reram_cell area_ox=0.0676
X4415 rr2t2r_0[23|15]/a_60_290# WL23 SL15 VSS sky130_fd_pr__nfet_g5v0d10v5 ad=0.65 pd=3.3 as=0 ps=0 w=1 l=0.5
X4416 rr2t2r_0[24|15]/a_460_290# WL24 SL15 VSS sky130_fd_pr__nfet_g5v0d10v5 ad=0.65 pd=3.3 as=0 ps=0 w=1 l=0.5
X4417 BLP15 rr2t2r_0[24|15]/a_60_290# sky130_fd_pr_reram__reram_cell area_ox=0.0676
X4418 BLN15 rr2t2r_0[24|15]/a_460_290# sky130_fd_pr_reram__reram_cell area_ox=0.0676
X4419 rr2t2r_0[24|15]/a_60_290# WL24 SL15 VSS sky130_fd_pr__nfet_g5v0d10v5 ad=0.65 pd=3.3 as=0 ps=0 w=1 l=0.5
X4420 rr2t2r_0[25|15]/a_460_290# WL25 SL15 VSS sky130_fd_pr__nfet_g5v0d10v5 ad=0.65 pd=3.3 as=0 ps=0 w=1 l=0.5
X4421 BLP15 rr2t2r_0[25|15]/a_60_290# sky130_fd_pr_reram__reram_cell area_ox=0.0676
X4422 BLN15 rr2t2r_0[25|15]/a_460_290# sky130_fd_pr_reram__reram_cell area_ox=0.0676
X4423 rr2t2r_0[25|15]/a_60_290# WL25 SL15 VSS sky130_fd_pr__nfet_g5v0d10v5 ad=0.65 pd=3.3 as=0 ps=0 w=1 l=0.5
X4424 rr2t2r_0[26|15]/a_460_290# WL26 SL15 VSS sky130_fd_pr__nfet_g5v0d10v5 ad=0.65 pd=3.3 as=0 ps=0 w=1 l=0.5
X4425 BLP15 rr2t2r_0[26|15]/a_60_290# sky130_fd_pr_reram__reram_cell area_ox=0.0676
X4426 BLN15 rr2t2r_0[26|15]/a_460_290# sky130_fd_pr_reram__reram_cell area_ox=0.0676
X4427 rr2t2r_0[26|15]/a_60_290# WL26 SL15 VSS sky130_fd_pr__nfet_g5v0d10v5 ad=0.65 pd=3.3 as=0 ps=0 w=1 l=0.5
X4428 rr2t2r_0[27|15]/a_460_290# WL27 SL15 VSS sky130_fd_pr__nfet_g5v0d10v5 ad=0.65 pd=3.3 as=0 ps=0 w=1 l=0.5
X4429 BLP15 rr2t2r_0[27|15]/a_60_290# sky130_fd_pr_reram__reram_cell area_ox=0.0676
X4430 BLN15 rr2t2r_0[27|15]/a_460_290# sky130_fd_pr_reram__reram_cell area_ox=0.0676
X4431 rr2t2r_0[27|15]/a_60_290# WL27 SL15 VSS sky130_fd_pr__nfet_g5v0d10v5 ad=0.65 pd=3.3 as=0 ps=0 w=1 l=0.5
X4432 rr2t2r_0[28|15]/a_460_290# WL28 SL15 VSS sky130_fd_pr__nfet_g5v0d10v5 ad=0.65 pd=3.3 as=0 ps=0 w=1 l=0.5
X4433 BLP15 rr2t2r_0[28|15]/a_60_290# sky130_fd_pr_reram__reram_cell area_ox=0.0676
X4434 BLN15 rr2t2r_0[28|15]/a_460_290# sky130_fd_pr_reram__reram_cell area_ox=0.0676
X4435 rr2t2r_0[28|15]/a_60_290# WL28 SL15 VSS sky130_fd_pr__nfet_g5v0d10v5 ad=0.65 pd=3.3 as=0 ps=0 w=1 l=0.5
X4436 rr2t2r_0[29|15]/a_460_290# WL29 SL15 VSS sky130_fd_pr__nfet_g5v0d10v5 ad=0.65 pd=3.3 as=0 ps=0 w=1 l=0.5
X4437 BLP15 rr2t2r_0[29|15]/a_60_290# sky130_fd_pr_reram__reram_cell area_ox=0.0676
X4438 BLN15 rr2t2r_0[29|15]/a_460_290# sky130_fd_pr_reram__reram_cell area_ox=0.0676
X4439 rr2t2r_0[29|15]/a_60_290# WL29 SL15 VSS sky130_fd_pr__nfet_g5v0d10v5 ad=0.65 pd=3.3 as=0 ps=0 w=1 l=0.5
X4440 rr2t2r_0[30|15]/a_460_290# WL30 SL15 VSS sky130_fd_pr__nfet_g5v0d10v5 ad=0.65 pd=3.3 as=0 ps=0 w=1 l=0.5
X4441 BLP15 rr2t2r_0[30|15]/a_60_290# sky130_fd_pr_reram__reram_cell area_ox=0.0676
X4442 BLN15 rr2t2r_0[30|15]/a_460_290# sky130_fd_pr_reram__reram_cell area_ox=0.0676
X4443 rr2t2r_0[30|15]/a_60_290# WL30 SL15 VSS sky130_fd_pr__nfet_g5v0d10v5 ad=0.65 pd=3.3 as=0 ps=0 w=1 l=0.5
X4444 rr2t2r_0[31|15]/a_460_290# WL31 SL15 VSS sky130_fd_pr__nfet_g5v0d10v5 ad=0.65 pd=3.3 as=0 ps=0 w=1 l=0.5
X4445 BLP15 rr2t2r_0[31|15]/a_60_290# sky130_fd_pr_reram__reram_cell area_ox=0.0676
X4446 BLN15 rr2t2r_0[31|15]/a_460_290# sky130_fd_pr_reram__reram_cell area_ox=0.0676
X4447 rr2t2r_0[31|15]/a_60_290# WL31 SL15 VSS sky130_fd_pr__nfet_g5v0d10v5 ad=0.65 pd=3.3 as=0 ps=0 w=1 l=0.5
X4448 rr2t2r_0[32|15]/a_460_290# WL32 SL15 VSS sky130_fd_pr__nfet_g5v0d10v5 ad=0.65 pd=3.3 as=0 ps=0 w=1 l=0.5
X4449 BLP15 rr2t2r_0[32|15]/a_60_290# sky130_fd_pr_reram__reram_cell area_ox=0.0676
X4450 BLN15 rr2t2r_0[32|15]/a_460_290# sky130_fd_pr_reram__reram_cell area_ox=0.0676
X4451 rr2t2r_0[32|15]/a_60_290# WL32 SL15 VSS sky130_fd_pr__nfet_g5v0d10v5 ad=0.65 pd=3.3 as=0 ps=0 w=1 l=0.5
X4452 rr2t2r_0[33|15]/a_460_290# WL33 SL15 VSS sky130_fd_pr__nfet_g5v0d10v5 ad=0.65 pd=3.3 as=0 ps=0 w=1 l=0.5
X4453 BLP15 rr2t2r_0[33|15]/a_60_290# sky130_fd_pr_reram__reram_cell area_ox=0.0676
X4454 BLN15 rr2t2r_0[33|15]/a_460_290# sky130_fd_pr_reram__reram_cell area_ox=0.0676
X4455 rr2t2r_0[33|15]/a_60_290# WL33 SL15 VSS sky130_fd_pr__nfet_g5v0d10v5 ad=0.65 pd=3.3 as=0 ps=0 w=1 l=0.5
X4456 rr2t2r_0[34|15]/a_460_290# WL34 SL15 VSS sky130_fd_pr__nfet_g5v0d10v5 ad=0.65 pd=3.3 as=0 ps=0 w=1 l=0.5
X4457 BLP15 rr2t2r_0[34|15]/a_60_290# sky130_fd_pr_reram__reram_cell area_ox=0.0676
X4458 BLN15 rr2t2r_0[34|15]/a_460_290# sky130_fd_pr_reram__reram_cell area_ox=0.0676
X4459 rr2t2r_0[34|15]/a_60_290# WL34 SL15 VSS sky130_fd_pr__nfet_g5v0d10v5 ad=0.65 pd=3.3 as=0 ps=0 w=1 l=0.5
X4460 rr2t2r_0[35|15]/a_460_290# WL35 SL15 VSS sky130_fd_pr__nfet_g5v0d10v5 ad=0.65 pd=3.3 as=0 ps=0 w=1 l=0.5
X4461 BLP15 rr2t2r_0[35|15]/a_60_290# sky130_fd_pr_reram__reram_cell area_ox=0.0676
X4462 BLN15 rr2t2r_0[35|15]/a_460_290# sky130_fd_pr_reram__reram_cell area_ox=0.0676
X4463 rr2t2r_0[35|15]/a_60_290# WL35 SL15 VSS sky130_fd_pr__nfet_g5v0d10v5 ad=0.65 pd=3.3 as=0 ps=0 w=1 l=0.5
X4464 rr2t2r_0[36|15]/a_460_290# WL36 SL15 VSS sky130_fd_pr__nfet_g5v0d10v5 ad=0.65 pd=3.3 as=0 ps=0 w=1 l=0.5
X4465 BLP15 rr2t2r_0[36|15]/a_60_290# sky130_fd_pr_reram__reram_cell area_ox=0.0676
X4466 BLN15 rr2t2r_0[36|15]/a_460_290# sky130_fd_pr_reram__reram_cell area_ox=0.0676
X4467 rr2t2r_0[36|15]/a_60_290# WL36 SL15 VSS sky130_fd_pr__nfet_g5v0d10v5 ad=0.65 pd=3.3 as=0 ps=0 w=1 l=0.5
X4468 rr2t2r_0[37|15]/a_460_290# WL37 SL15 VSS sky130_fd_pr__nfet_g5v0d10v5 ad=0.65 pd=3.3 as=0 ps=0 w=1 l=0.5
X4469 BLP15 rr2t2r_0[37|15]/a_60_290# sky130_fd_pr_reram__reram_cell area_ox=0.0676
X4470 BLN15 rr2t2r_0[37|15]/a_460_290# sky130_fd_pr_reram__reram_cell area_ox=0.0676
X4471 rr2t2r_0[37|15]/a_60_290# WL37 SL15 VSS sky130_fd_pr__nfet_g5v0d10v5 ad=0.65 pd=3.3 as=0 ps=0 w=1 l=0.5
X4472 rr2t2r_0[38|15]/a_460_290# WL38 SL15 VSS sky130_fd_pr__nfet_g5v0d10v5 ad=0.65 pd=3.3 as=0 ps=0 w=1 l=0.5
X4473 BLP15 rr2t2r_0[38|15]/a_60_290# sky130_fd_pr_reram__reram_cell area_ox=0.0676
X4474 BLN15 rr2t2r_0[38|15]/a_460_290# sky130_fd_pr_reram__reram_cell area_ox=0.0676
X4475 rr2t2r_0[38|15]/a_60_290# WL38 SL15 VSS sky130_fd_pr__nfet_g5v0d10v5 ad=0.65 pd=3.3 as=0 ps=0 w=1 l=0.5
X4476 rr2t2r_0[39|15]/a_460_290# WL39 SL15 VSS sky130_fd_pr__nfet_g5v0d10v5 ad=0.65 pd=3.3 as=0 ps=0 w=1 l=0.5
X4477 BLP15 rr2t2r_0[39|15]/a_60_290# sky130_fd_pr_reram__reram_cell area_ox=0.0676
X4478 BLN15 rr2t2r_0[39|15]/a_460_290# sky130_fd_pr_reram__reram_cell area_ox=0.0676
X4479 rr2t2r_0[39|15]/a_60_290# WL39 SL15 VSS sky130_fd_pr__nfet_g5v0d10v5 ad=0.65 pd=3.3 as=0 ps=0 w=1 l=0.5
X4480 rr2t2r_0[40|15]/a_460_290# WL40 SL15 VSS sky130_fd_pr__nfet_g5v0d10v5 ad=0.65 pd=3.3 as=0 ps=0 w=1 l=0.5
X4481 BLP15 rr2t2r_0[40|15]/a_60_290# sky130_fd_pr_reram__reram_cell area_ox=0.0676
X4482 BLN15 rr2t2r_0[40|15]/a_460_290# sky130_fd_pr_reram__reram_cell area_ox=0.0676
X4483 rr2t2r_0[40|15]/a_60_290# WL40 SL15 VSS sky130_fd_pr__nfet_g5v0d10v5 ad=0.65 pd=3.3 as=0 ps=0 w=1 l=0.5
X4484 rr2t2r_0[41|15]/a_460_290# WL41 SL15 VSS sky130_fd_pr__nfet_g5v0d10v5 ad=0.65 pd=3.3 as=0 ps=0 w=1 l=0.5
X4485 BLP15 rr2t2r_0[41|15]/a_60_290# sky130_fd_pr_reram__reram_cell area_ox=0.0676
X4486 BLN15 rr2t2r_0[41|15]/a_460_290# sky130_fd_pr_reram__reram_cell area_ox=0.0676
X4487 rr2t2r_0[41|15]/a_60_290# WL41 SL15 VSS sky130_fd_pr__nfet_g5v0d10v5 ad=0.65 pd=3.3 as=0 ps=0 w=1 l=0.5
X4488 rr2t2r_0[42|15]/a_460_290# WL42 SL15 VSS sky130_fd_pr__nfet_g5v0d10v5 ad=0.65 pd=3.3 as=0 ps=0 w=1 l=0.5
X4489 BLP15 rr2t2r_0[42|15]/a_60_290# sky130_fd_pr_reram__reram_cell area_ox=0.0676
X4490 BLN15 rr2t2r_0[42|15]/a_460_290# sky130_fd_pr_reram__reram_cell area_ox=0.0676
X4491 rr2t2r_0[42|15]/a_60_290# WL42 SL15 VSS sky130_fd_pr__nfet_g5v0d10v5 ad=0.65 pd=3.3 as=0 ps=0 w=1 l=0.5
X4492 rr2t2r_0[43|15]/a_460_290# WL43 SL15 VSS sky130_fd_pr__nfet_g5v0d10v5 ad=0.65 pd=3.3 as=0 ps=0 w=1 l=0.5
X4493 BLP15 rr2t2r_0[43|15]/a_60_290# sky130_fd_pr_reram__reram_cell area_ox=0.0676
X4494 BLN15 rr2t2r_0[43|15]/a_460_290# sky130_fd_pr_reram__reram_cell area_ox=0.0676
X4495 rr2t2r_0[43|15]/a_60_290# WL43 SL15 VSS sky130_fd_pr__nfet_g5v0d10v5 ad=0.65 pd=3.3 as=0 ps=0 w=1 l=0.5
X4496 rr2t2r_0[44|15]/a_460_290# WL44 SL15 VSS sky130_fd_pr__nfet_g5v0d10v5 ad=0.65 pd=3.3 as=0 ps=0 w=1 l=0.5
X4497 BLP15 rr2t2r_0[44|15]/a_60_290# sky130_fd_pr_reram__reram_cell area_ox=0.0676
X4498 BLN15 rr2t2r_0[44|15]/a_460_290# sky130_fd_pr_reram__reram_cell area_ox=0.0676
X4499 rr2t2r_0[44|15]/a_60_290# WL44 SL15 VSS sky130_fd_pr__nfet_g5v0d10v5 ad=0.65 pd=3.3 as=0 ps=0 w=1 l=0.5
X4500 rr2t2r_0[45|15]/a_460_290# WL45 SL15 VSS sky130_fd_pr__nfet_g5v0d10v5 ad=0.65 pd=3.3 as=0 ps=0 w=1 l=0.5
X4501 BLP15 rr2t2r_0[45|15]/a_60_290# sky130_fd_pr_reram__reram_cell area_ox=0.0676
X4502 BLN15 rr2t2r_0[45|15]/a_460_290# sky130_fd_pr_reram__reram_cell area_ox=0.0676
X4503 rr2t2r_0[45|15]/a_60_290# WL45 SL15 VSS sky130_fd_pr__nfet_g5v0d10v5 ad=0.65 pd=3.3 as=0 ps=0 w=1 l=0.5
X4504 rr2t2r_0[46|15]/a_460_290# WL46 SL15 VSS sky130_fd_pr__nfet_g5v0d10v5 ad=0.65 pd=3.3 as=0 ps=0 w=1 l=0.5
X4505 BLP15 rr2t2r_0[46|15]/a_60_290# sky130_fd_pr_reram__reram_cell area_ox=0.0676
X4506 BLN15 rr2t2r_0[46|15]/a_460_290# sky130_fd_pr_reram__reram_cell area_ox=0.0676
X4507 rr2t2r_0[46|15]/a_60_290# WL46 SL15 VSS sky130_fd_pr__nfet_g5v0d10v5 ad=0.65 pd=3.3 as=0 ps=0 w=1 l=0.5
X4508 rr2t2r_0[47|15]/a_460_290# WL47 SL15 VSS sky130_fd_pr__nfet_g5v0d10v5 ad=0.65 pd=3.3 as=0 ps=0 w=1 l=0.5
X4509 BLP15 rr2t2r_0[47|15]/a_60_290# sky130_fd_pr_reram__reram_cell area_ox=0.0676
X4510 BLN15 rr2t2r_0[47|15]/a_460_290# sky130_fd_pr_reram__reram_cell area_ox=0.0676
X4511 rr2t2r_0[47|15]/a_60_290# WL47 SL15 VSS sky130_fd_pr__nfet_g5v0d10v5 ad=0.65 pd=3.3 as=0 ps=0 w=1 l=0.5
X4512 rr2t2r_0[48|15]/a_460_290# WL48 SL15 VSS sky130_fd_pr__nfet_g5v0d10v5 ad=0.65 pd=3.3 as=0 ps=0 w=1 l=0.5
X4513 BLP15 rr2t2r_0[48|15]/a_60_290# sky130_fd_pr_reram__reram_cell area_ox=0.0676
X4514 BLN15 rr2t2r_0[48|15]/a_460_290# sky130_fd_pr_reram__reram_cell area_ox=0.0676
X4515 rr2t2r_0[48|15]/a_60_290# WL48 SL15 VSS sky130_fd_pr__nfet_g5v0d10v5 ad=0.65 pd=3.3 as=0 ps=0 w=1 l=0.5
X4516 rr2t2r_0[49|15]/a_460_290# WL49 SL15 VSS sky130_fd_pr__nfet_g5v0d10v5 ad=0.65 pd=3.3 as=0 ps=0 w=1 l=0.5
X4517 BLP15 rr2t2r_0[49|15]/a_60_290# sky130_fd_pr_reram__reram_cell area_ox=0.0676
X4518 BLN15 rr2t2r_0[49|15]/a_460_290# sky130_fd_pr_reram__reram_cell area_ox=0.0676
X4519 rr2t2r_0[49|15]/a_60_290# WL49 SL15 VSS sky130_fd_pr__nfet_g5v0d10v5 ad=0.65 pd=3.3 as=0 ps=0 w=1 l=0.5
X4520 rr2t2r_0[50|15]/a_460_290# WL50 SL15 VSS sky130_fd_pr__nfet_g5v0d10v5 ad=0.65 pd=3.3 as=0 ps=0 w=1 l=0.5
X4521 BLP15 rr2t2r_0[50|15]/a_60_290# sky130_fd_pr_reram__reram_cell area_ox=0.0676
X4522 BLN15 rr2t2r_0[50|15]/a_460_290# sky130_fd_pr_reram__reram_cell area_ox=0.0676
X4523 rr2t2r_0[50|15]/a_60_290# WL50 SL15 VSS sky130_fd_pr__nfet_g5v0d10v5 ad=0.65 pd=3.3 as=0 ps=0 w=1 l=0.5
X4524 rr2t2r_0[51|15]/a_460_290# WL51 SL15 VSS sky130_fd_pr__nfet_g5v0d10v5 ad=0.65 pd=3.3 as=0 ps=0 w=1 l=0.5
X4525 BLP15 rr2t2r_0[51|15]/a_60_290# sky130_fd_pr_reram__reram_cell area_ox=0.0676
X4526 BLN15 rr2t2r_0[51|15]/a_460_290# sky130_fd_pr_reram__reram_cell area_ox=0.0676
X4527 rr2t2r_0[51|15]/a_60_290# WL51 SL15 VSS sky130_fd_pr__nfet_g5v0d10v5 ad=0.65 pd=3.3 as=0 ps=0 w=1 l=0.5
X4528 rr2t2r_0[52|15]/a_460_290# WL52 SL15 VSS sky130_fd_pr__nfet_g5v0d10v5 ad=0.65 pd=3.3 as=0 ps=0 w=1 l=0.5
X4529 BLP15 rr2t2r_0[52|15]/a_60_290# sky130_fd_pr_reram__reram_cell area_ox=0.0676
X4530 BLN15 rr2t2r_0[52|15]/a_460_290# sky130_fd_pr_reram__reram_cell area_ox=0.0676
X4531 rr2t2r_0[52|15]/a_60_290# WL52 SL15 VSS sky130_fd_pr__nfet_g5v0d10v5 ad=0.65 pd=3.3 as=0 ps=0 w=1 l=0.5
X4532 rr2t2r_0[53|15]/a_460_290# WL53 SL15 VSS sky130_fd_pr__nfet_g5v0d10v5 ad=0.65 pd=3.3 as=0 ps=0 w=1 l=0.5
X4533 BLP15 rr2t2r_0[53|15]/a_60_290# sky130_fd_pr_reram__reram_cell area_ox=0.0676
X4534 BLN15 rr2t2r_0[53|15]/a_460_290# sky130_fd_pr_reram__reram_cell area_ox=0.0676
X4535 rr2t2r_0[53|15]/a_60_290# WL53 SL15 VSS sky130_fd_pr__nfet_g5v0d10v5 ad=0.65 pd=3.3 as=0 ps=0 w=1 l=0.5
X4536 rr2t2r_0[54|15]/a_460_290# WL54 SL15 VSS sky130_fd_pr__nfet_g5v0d10v5 ad=0.65 pd=3.3 as=0 ps=0 w=1 l=0.5
X4537 BLP15 rr2t2r_0[54|15]/a_60_290# sky130_fd_pr_reram__reram_cell area_ox=0.0676
X4538 BLN15 rr2t2r_0[54|15]/a_460_290# sky130_fd_pr_reram__reram_cell area_ox=0.0676
X4539 rr2t2r_0[54|15]/a_60_290# WL54 SL15 VSS sky130_fd_pr__nfet_g5v0d10v5 ad=0.65 pd=3.3 as=0 ps=0 w=1 l=0.5
X4540 rr2t2r_0[55|15]/a_460_290# WL55 SL15 VSS sky130_fd_pr__nfet_g5v0d10v5 ad=0.65 pd=3.3 as=0 ps=0 w=1 l=0.5
X4541 BLP15 rr2t2r_0[55|15]/a_60_290# sky130_fd_pr_reram__reram_cell area_ox=0.0676
X4542 BLN15 rr2t2r_0[55|15]/a_460_290# sky130_fd_pr_reram__reram_cell area_ox=0.0676
X4543 rr2t2r_0[55|15]/a_60_290# WL55 SL15 VSS sky130_fd_pr__nfet_g5v0d10v5 ad=0.65 pd=3.3 as=0 ps=0 w=1 l=0.5
X4544 rr2t2r_0[56|15]/a_460_290# WL56 SL15 VSS sky130_fd_pr__nfet_g5v0d10v5 ad=0.65 pd=3.3 as=0 ps=0 w=1 l=0.5
X4545 BLP15 rr2t2r_0[56|15]/a_60_290# sky130_fd_pr_reram__reram_cell area_ox=0.0676
X4546 BLN15 rr2t2r_0[56|15]/a_460_290# sky130_fd_pr_reram__reram_cell area_ox=0.0676
X4547 rr2t2r_0[56|15]/a_60_290# WL56 SL15 VSS sky130_fd_pr__nfet_g5v0d10v5 ad=0.65 pd=3.3 as=0 ps=0 w=1 l=0.5
X4548 rr2t2r_0[57|15]/a_460_290# WL57 SL15 VSS sky130_fd_pr__nfet_g5v0d10v5 ad=0.65 pd=3.3 as=0 ps=0 w=1 l=0.5
X4549 BLP15 rr2t2r_0[57|15]/a_60_290# sky130_fd_pr_reram__reram_cell area_ox=0.0676
X4550 BLN15 rr2t2r_0[57|15]/a_460_290# sky130_fd_pr_reram__reram_cell area_ox=0.0676
X4551 rr2t2r_0[57|15]/a_60_290# WL57 SL15 VSS sky130_fd_pr__nfet_g5v0d10v5 ad=0.65 pd=3.3 as=0 ps=0 w=1 l=0.5
X4552 rr2t2r_0[58|15]/a_460_290# WL58 SL15 VSS sky130_fd_pr__nfet_g5v0d10v5 ad=0.65 pd=3.3 as=0 ps=0 w=1 l=0.5
X4553 BLP15 rr2t2r_0[58|15]/a_60_290# sky130_fd_pr_reram__reram_cell area_ox=0.0676
X4554 BLN15 rr2t2r_0[58|15]/a_460_290# sky130_fd_pr_reram__reram_cell area_ox=0.0676
X4555 rr2t2r_0[58|15]/a_60_290# WL58 SL15 VSS sky130_fd_pr__nfet_g5v0d10v5 ad=0.65 pd=3.3 as=0 ps=0 w=1 l=0.5
X4556 rr2t2r_0[59|15]/a_460_290# WL59 SL15 VSS sky130_fd_pr__nfet_g5v0d10v5 ad=0.65 pd=3.3 as=0 ps=0 w=1 l=0.5
X4557 BLP15 rr2t2r_0[59|15]/a_60_290# sky130_fd_pr_reram__reram_cell area_ox=0.0676
X4558 BLN15 rr2t2r_0[59|15]/a_460_290# sky130_fd_pr_reram__reram_cell area_ox=0.0676
X4559 rr2t2r_0[59|15]/a_60_290# WL59 SL15 VSS sky130_fd_pr__nfet_g5v0d10v5 ad=0.65 pd=3.3 as=0 ps=0 w=1 l=0.5
X4560 rr2t2r_0[60|15]/a_460_290# WL60 SL15 VSS sky130_fd_pr__nfet_g5v0d10v5 ad=0.65 pd=3.3 as=0 ps=0 w=1 l=0.5
X4561 BLP15 rr2t2r_0[60|15]/a_60_290# sky130_fd_pr_reram__reram_cell area_ox=0.0676
X4562 BLN15 rr2t2r_0[60|15]/a_460_290# sky130_fd_pr_reram__reram_cell area_ox=0.0676
X4563 rr2t2r_0[60|15]/a_60_290# WL60 SL15 VSS sky130_fd_pr__nfet_g5v0d10v5 ad=0.65 pd=3.3 as=0 ps=0 w=1 l=0.5
X4564 rr2t2r_0[61|15]/a_460_290# WL61 SL15 VSS sky130_fd_pr__nfet_g5v0d10v5 ad=0.65 pd=3.3 as=0 ps=0 w=1 l=0.5
X4565 BLP15 rr2t2r_0[61|15]/a_60_290# sky130_fd_pr_reram__reram_cell area_ox=0.0676
X4566 BLN15 rr2t2r_0[61|15]/a_460_290# sky130_fd_pr_reram__reram_cell area_ox=0.0676
X4567 rr2t2r_0[61|15]/a_60_290# WL61 SL15 VSS sky130_fd_pr__nfet_g5v0d10v5 ad=0.65 pd=3.3 as=0 ps=0 w=1 l=0.5
X4568 rr2t2r_0[62|15]/a_460_290# WL62 SL15 VSS sky130_fd_pr__nfet_g5v0d10v5 ad=0.65 pd=3.3 as=0 ps=0 w=1 l=0.5
X4569 BLP15 rr2t2r_0[62|15]/a_60_290# sky130_fd_pr_reram__reram_cell area_ox=0.0676
X4570 BLN15 rr2t2r_0[62|15]/a_460_290# sky130_fd_pr_reram__reram_cell area_ox=0.0676
X4571 rr2t2r_0[62|15]/a_60_290# WL62 SL15 VSS sky130_fd_pr__nfet_g5v0d10v5 ad=0.65 pd=3.3 as=0 ps=0 w=1 l=0.5
X4572 rr2t2r_0[63|15]/a_460_290# WL63 SL15 VSS sky130_fd_pr__nfet_g5v0d10v5 ad=0.65 pd=3.3 as=0 ps=0 w=1 l=0.5
X4573 BLP15 rr2t2r_0[63|15]/a_60_290# sky130_fd_pr_reram__reram_cell area_ox=0.0676
X4574 BLN15 rr2t2r_0[63|15]/a_460_290# sky130_fd_pr_reram__reram_cell area_ox=0.0676
X4575 rr2t2r_0[63|15]/a_60_290# WL63 SL15 VSS sky130_fd_pr__nfet_g5v0d10v5 ad=0.65 pd=3.3 as=0 ps=0 w=1 l=0.5
X4576 rr2t2r_0[64|15]/a_460_290# WL64 SL15 VSS sky130_fd_pr__nfet_g5v0d10v5 ad=0.65 pd=3.3 as=0 ps=0 w=1 l=0.5
X4577 BLP15 rr2t2r_0[64|15]/a_60_290# sky130_fd_pr_reram__reram_cell area_ox=0.0676
X4578 BLN15 rr2t2r_0[64|15]/a_460_290# sky130_fd_pr_reram__reram_cell area_ox=0.0676
X4579 rr2t2r_0[64|15]/a_60_290# WL64 SL15 VSS sky130_fd_pr__nfet_g5v0d10v5 ad=0.65 pd=3.3 as=0 ps=0 w=1 l=0.5
X4580 rr2t2r_0[65|15]/a_460_290# WL65 SL15 VSS sky130_fd_pr__nfet_g5v0d10v5 ad=0.65 pd=3.3 as=0 ps=0 w=1 l=0.5
X4581 BLP15 rr2t2r_0[65|15]/a_60_290# sky130_fd_pr_reram__reram_cell area_ox=0.0676
X4582 BLN15 rr2t2r_0[65|15]/a_460_290# sky130_fd_pr_reram__reram_cell area_ox=0.0676
X4583 rr2t2r_0[65|15]/a_60_290# WL65 SL15 VSS sky130_fd_pr__nfet_g5v0d10v5 ad=0.65 pd=3.3 as=0 ps=0 w=1 l=0.5
X4584 rr2t2r_0[66|15]/a_460_290# WL66 SL15 VSS sky130_fd_pr__nfet_g5v0d10v5 ad=0.65 pd=3.3 as=0 ps=0 w=1 l=0.5
X4585 BLP15 rr2t2r_0[66|15]/a_60_290# sky130_fd_pr_reram__reram_cell area_ox=0.0676
X4586 BLN15 rr2t2r_0[66|15]/a_460_290# sky130_fd_pr_reram__reram_cell area_ox=0.0676
X4587 rr2t2r_0[66|15]/a_60_290# WL66 SL15 VSS sky130_fd_pr__nfet_g5v0d10v5 ad=0.65 pd=3.3 as=0 ps=0 w=1 l=0.5
X4588 rr2t2r_0[67|15]/a_460_290# WL67 SL15 VSS sky130_fd_pr__nfet_g5v0d10v5 ad=0.65 pd=3.3 as=0 ps=0 w=1 l=0.5
X4589 BLP15 rr2t2r_0[67|15]/a_60_290# sky130_fd_pr_reram__reram_cell area_ox=0.0676
X4590 BLN15 rr2t2r_0[67|15]/a_460_290# sky130_fd_pr_reram__reram_cell area_ox=0.0676
X4591 rr2t2r_0[67|15]/a_60_290# WL67 SL15 VSS sky130_fd_pr__nfet_g5v0d10v5 ad=0.65 pd=3.3 as=0 ps=0 w=1 l=0.5
X4592 rr2t2r_0[68|15]/a_460_290# WL68 SL15 VSS sky130_fd_pr__nfet_g5v0d10v5 ad=0.65 pd=3.3 as=0 ps=0 w=1 l=0.5
X4593 BLP15 rr2t2r_0[68|15]/a_60_290# sky130_fd_pr_reram__reram_cell area_ox=0.0676
X4594 BLN15 rr2t2r_0[68|15]/a_460_290# sky130_fd_pr_reram__reram_cell area_ox=0.0676
X4595 rr2t2r_0[68|15]/a_60_290# WL68 SL15 VSS sky130_fd_pr__nfet_g5v0d10v5 ad=0.65 pd=3.3 as=0 ps=0 w=1 l=0.5
X4596 rr2t2r_0[69|15]/a_460_290# WL69 SL15 VSS sky130_fd_pr__nfet_g5v0d10v5 ad=0.65 pd=3.3 as=0 ps=0 w=1 l=0.5
X4597 BLP15 rr2t2r_0[69|15]/a_60_290# sky130_fd_pr_reram__reram_cell area_ox=0.0676
X4598 BLN15 rr2t2r_0[69|15]/a_460_290# sky130_fd_pr_reram__reram_cell area_ox=0.0676
X4599 rr2t2r_0[69|15]/a_60_290# WL69 SL15 VSS sky130_fd_pr__nfet_g5v0d10v5 ad=0.65 pd=3.3 as=0 ps=0 w=1 l=0.5
X4600 rr2t2r_0[70|15]/a_460_290# WL70 SL15 VSS sky130_fd_pr__nfet_g5v0d10v5 ad=0.65 pd=3.3 as=0 ps=0 w=1 l=0.5
X4601 BLP15 rr2t2r_0[70|15]/a_60_290# sky130_fd_pr_reram__reram_cell area_ox=0.0676
X4602 BLN15 rr2t2r_0[70|15]/a_460_290# sky130_fd_pr_reram__reram_cell area_ox=0.0676
X4603 rr2t2r_0[70|15]/a_60_290# WL70 SL15 VSS sky130_fd_pr__nfet_g5v0d10v5 ad=0.65 pd=3.3 as=0 ps=0 w=1 l=0.5
X4604 rr2t2r_0[71|15]/a_460_290# WL71 SL15 VSS sky130_fd_pr__nfet_g5v0d10v5 ad=0.65 pd=3.3 as=0 ps=0 w=1 l=0.5
X4605 BLP15 rr2t2r_0[71|15]/a_60_290# sky130_fd_pr_reram__reram_cell area_ox=0.0676
X4606 BLN15 rr2t2r_0[71|15]/a_460_290# sky130_fd_pr_reram__reram_cell area_ox=0.0676
X4607 rr2t2r_0[71|15]/a_60_290# WL71 SL15 VSS sky130_fd_pr__nfet_g5v0d10v5 ad=0.65 pd=3.3 as=0 ps=0 w=1 l=0.5
X4608 rr2t2r_0[0|16]/a_460_290# WL0 SL16 VSS sky130_fd_pr__nfet_g5v0d10v5 ad=0.65 pd=3.3 as=108 ps=504 w=1 l=0.5
X4609 BLP16 rr2t2r_0[0|16]/a_60_290# sky130_fd_pr_reram__reram_cell area_ox=0.0676
X4610 BLN16 rr2t2r_0[0|16]/a_460_290# sky130_fd_pr_reram__reram_cell area_ox=0.0676
X4611 rr2t2r_0[0|16]/a_60_290# WL0 SL16 VSS sky130_fd_pr__nfet_g5v0d10v5 ad=0.65 pd=3.3 as=0 ps=0 w=1 l=0.5
X4612 rr2t2r_0[1|16]/a_460_290# WL1 SL16 VSS sky130_fd_pr__nfet_g5v0d10v5 ad=0.65 pd=3.3 as=0 ps=0 w=1 l=0.5
X4613 BLP16 rr2t2r_0[1|16]/a_60_290# sky130_fd_pr_reram__reram_cell area_ox=0.0676
X4614 BLN16 rr2t2r_0[1|16]/a_460_290# sky130_fd_pr_reram__reram_cell area_ox=0.0676
X4615 rr2t2r_0[1|16]/a_60_290# WL1 SL16 VSS sky130_fd_pr__nfet_g5v0d10v5 ad=0.65 pd=3.3 as=0 ps=0 w=1 l=0.5
X4616 rr2t2r_0[2|16]/a_460_290# WL2 SL16 VSS sky130_fd_pr__nfet_g5v0d10v5 ad=0.65 pd=3.3 as=0 ps=0 w=1 l=0.5
X4617 BLP16 rr2t2r_0[2|16]/a_60_290# sky130_fd_pr_reram__reram_cell area_ox=0.0676
X4618 BLN16 rr2t2r_0[2|16]/a_460_290# sky130_fd_pr_reram__reram_cell area_ox=0.0676
X4619 rr2t2r_0[2|16]/a_60_290# WL2 SL16 VSS sky130_fd_pr__nfet_g5v0d10v5 ad=0.65 pd=3.3 as=0 ps=0 w=1 l=0.5
X4620 rr2t2r_0[3|16]/a_460_290# WL3 SL16 VSS sky130_fd_pr__nfet_g5v0d10v5 ad=0.65 pd=3.3 as=0 ps=0 w=1 l=0.5
X4621 BLP16 rr2t2r_0[3|16]/a_60_290# sky130_fd_pr_reram__reram_cell area_ox=0.0676
X4622 BLN16 rr2t2r_0[3|16]/a_460_290# sky130_fd_pr_reram__reram_cell area_ox=0.0676
X4623 rr2t2r_0[3|16]/a_60_290# WL3 SL16 VSS sky130_fd_pr__nfet_g5v0d10v5 ad=0.65 pd=3.3 as=0 ps=0 w=1 l=0.5
X4624 rr2t2r_0[4|16]/a_460_290# WL4 SL16 VSS sky130_fd_pr__nfet_g5v0d10v5 ad=0.65 pd=3.3 as=0 ps=0 w=1 l=0.5
X4625 BLP16 rr2t2r_0[4|16]/a_60_290# sky130_fd_pr_reram__reram_cell area_ox=0.0676
X4626 BLN16 rr2t2r_0[4|16]/a_460_290# sky130_fd_pr_reram__reram_cell area_ox=0.0676
X4627 rr2t2r_0[4|16]/a_60_290# WL4 SL16 VSS sky130_fd_pr__nfet_g5v0d10v5 ad=0.65 pd=3.3 as=0 ps=0 w=1 l=0.5
X4628 rr2t2r_0[5|16]/a_460_290# WL5 SL16 VSS sky130_fd_pr__nfet_g5v0d10v5 ad=0.65 pd=3.3 as=0 ps=0 w=1 l=0.5
X4629 BLP16 rr2t2r_0[5|16]/a_60_290# sky130_fd_pr_reram__reram_cell area_ox=0.0676
X4630 BLN16 rr2t2r_0[5|16]/a_460_290# sky130_fd_pr_reram__reram_cell area_ox=0.0676
X4631 rr2t2r_0[5|16]/a_60_290# WL5 SL16 VSS sky130_fd_pr__nfet_g5v0d10v5 ad=0.65 pd=3.3 as=0 ps=0 w=1 l=0.5
X4632 rr2t2r_0[6|16]/a_460_290# WL6 SL16 VSS sky130_fd_pr__nfet_g5v0d10v5 ad=0.65 pd=3.3 as=0 ps=0 w=1 l=0.5
X4633 BLP16 rr2t2r_0[6|16]/a_60_290# sky130_fd_pr_reram__reram_cell area_ox=0.0676
X4634 BLN16 rr2t2r_0[6|16]/a_460_290# sky130_fd_pr_reram__reram_cell area_ox=0.0676
X4635 rr2t2r_0[6|16]/a_60_290# WL6 SL16 VSS sky130_fd_pr__nfet_g5v0d10v5 ad=0.65 pd=3.3 as=0 ps=0 w=1 l=0.5
X4636 rr2t2r_0[7|16]/a_460_290# WL7 SL16 VSS sky130_fd_pr__nfet_g5v0d10v5 ad=0.65 pd=3.3 as=0 ps=0 w=1 l=0.5
X4637 BLP16 rr2t2r_0[7|16]/a_60_290# sky130_fd_pr_reram__reram_cell area_ox=0.0676
X4638 BLN16 rr2t2r_0[7|16]/a_460_290# sky130_fd_pr_reram__reram_cell area_ox=0.0676
X4639 rr2t2r_0[7|16]/a_60_290# WL7 SL16 VSS sky130_fd_pr__nfet_g5v0d10v5 ad=0.65 pd=3.3 as=0 ps=0 w=1 l=0.5
X4640 rr2t2r_0[8|16]/a_460_290# WL8 SL16 VSS sky130_fd_pr__nfet_g5v0d10v5 ad=0.65 pd=3.3 as=0 ps=0 w=1 l=0.5
X4641 BLP16 rr2t2r_0[8|16]/a_60_290# sky130_fd_pr_reram__reram_cell area_ox=0.0676
X4642 BLN16 rr2t2r_0[8|16]/a_460_290# sky130_fd_pr_reram__reram_cell area_ox=0.0676
X4643 rr2t2r_0[8|16]/a_60_290# WL8 SL16 VSS sky130_fd_pr__nfet_g5v0d10v5 ad=0.65 pd=3.3 as=0 ps=0 w=1 l=0.5
X4644 rr2t2r_0[9|16]/a_460_290# WL9 SL16 VSS sky130_fd_pr__nfet_g5v0d10v5 ad=0.65 pd=3.3 as=0 ps=0 w=1 l=0.5
X4645 BLP16 rr2t2r_0[9|16]/a_60_290# sky130_fd_pr_reram__reram_cell area_ox=0.0676
X4646 BLN16 rr2t2r_0[9|16]/a_460_290# sky130_fd_pr_reram__reram_cell area_ox=0.0676
X4647 rr2t2r_0[9|16]/a_60_290# WL9 SL16 VSS sky130_fd_pr__nfet_g5v0d10v5 ad=0.65 pd=3.3 as=0 ps=0 w=1 l=0.5
X4648 rr2t2r_0[10|16]/a_460_290# WL10 SL16 VSS sky130_fd_pr__nfet_g5v0d10v5 ad=0.65 pd=3.3 as=0 ps=0 w=1 l=0.5
X4649 BLP16 rr2t2r_0[10|16]/a_60_290# sky130_fd_pr_reram__reram_cell area_ox=0.0676
X4650 BLN16 rr2t2r_0[10|16]/a_460_290# sky130_fd_pr_reram__reram_cell area_ox=0.0676
X4651 rr2t2r_0[10|16]/a_60_290# WL10 SL16 VSS sky130_fd_pr__nfet_g5v0d10v5 ad=0.65 pd=3.3 as=0 ps=0 w=1 l=0.5
X4652 rr2t2r_0[11|16]/a_460_290# WL11 SL16 VSS sky130_fd_pr__nfet_g5v0d10v5 ad=0.65 pd=3.3 as=0 ps=0 w=1 l=0.5
X4653 BLP16 rr2t2r_0[11|16]/a_60_290# sky130_fd_pr_reram__reram_cell area_ox=0.0676
X4654 BLN16 rr2t2r_0[11|16]/a_460_290# sky130_fd_pr_reram__reram_cell area_ox=0.0676
X4655 rr2t2r_0[11|16]/a_60_290# WL11 SL16 VSS sky130_fd_pr__nfet_g5v0d10v5 ad=0.65 pd=3.3 as=0 ps=0 w=1 l=0.5
X4656 rr2t2r_0[12|16]/a_460_290# WL12 SL16 VSS sky130_fd_pr__nfet_g5v0d10v5 ad=0.65 pd=3.3 as=0 ps=0 w=1 l=0.5
X4657 BLP16 rr2t2r_0[12|16]/a_60_290# sky130_fd_pr_reram__reram_cell area_ox=0.0676
X4658 BLN16 rr2t2r_0[12|16]/a_460_290# sky130_fd_pr_reram__reram_cell area_ox=0.0676
X4659 rr2t2r_0[12|16]/a_60_290# WL12 SL16 VSS sky130_fd_pr__nfet_g5v0d10v5 ad=0.65 pd=3.3 as=0 ps=0 w=1 l=0.5
X4660 rr2t2r_0[13|16]/a_460_290# WL13 SL16 VSS sky130_fd_pr__nfet_g5v0d10v5 ad=0.65 pd=3.3 as=0 ps=0 w=1 l=0.5
X4661 BLP16 rr2t2r_0[13|16]/a_60_290# sky130_fd_pr_reram__reram_cell area_ox=0.0676
X4662 BLN16 rr2t2r_0[13|16]/a_460_290# sky130_fd_pr_reram__reram_cell area_ox=0.0676
X4663 rr2t2r_0[13|16]/a_60_290# WL13 SL16 VSS sky130_fd_pr__nfet_g5v0d10v5 ad=0.65 pd=3.3 as=0 ps=0 w=1 l=0.5
X4664 rr2t2r_0[14|16]/a_460_290# WL14 SL16 VSS sky130_fd_pr__nfet_g5v0d10v5 ad=0.65 pd=3.3 as=0 ps=0 w=1 l=0.5
X4665 BLP16 rr2t2r_0[14|16]/a_60_290# sky130_fd_pr_reram__reram_cell area_ox=0.0676
X4666 BLN16 rr2t2r_0[14|16]/a_460_290# sky130_fd_pr_reram__reram_cell area_ox=0.0676
X4667 rr2t2r_0[14|16]/a_60_290# WL14 SL16 VSS sky130_fd_pr__nfet_g5v0d10v5 ad=0.65 pd=3.3 as=0 ps=0 w=1 l=0.5
X4668 rr2t2r_0[15|16]/a_460_290# WL15 SL16 VSS sky130_fd_pr__nfet_g5v0d10v5 ad=0.65 pd=3.3 as=0 ps=0 w=1 l=0.5
X4669 BLP16 rr2t2r_0[15|16]/a_60_290# sky130_fd_pr_reram__reram_cell area_ox=0.0676
X4670 BLN16 rr2t2r_0[15|16]/a_460_290# sky130_fd_pr_reram__reram_cell area_ox=0.0676
X4671 rr2t2r_0[15|16]/a_60_290# WL15 SL16 VSS sky130_fd_pr__nfet_g5v0d10v5 ad=0.65 pd=3.3 as=0 ps=0 w=1 l=0.5
X4672 rr2t2r_0[16|16]/a_460_290# WL16 SL16 VSS sky130_fd_pr__nfet_g5v0d10v5 ad=0.65 pd=3.3 as=0 ps=0 w=1 l=0.5
X4673 BLP16 rr2t2r_0[16|16]/a_60_290# sky130_fd_pr_reram__reram_cell area_ox=0.0676
X4674 BLN16 rr2t2r_0[16|16]/a_460_290# sky130_fd_pr_reram__reram_cell area_ox=0.0676
X4675 rr2t2r_0[16|16]/a_60_290# WL16 SL16 VSS sky130_fd_pr__nfet_g5v0d10v5 ad=0.65 pd=3.3 as=0 ps=0 w=1 l=0.5
X4676 rr2t2r_0[17|16]/a_460_290# WL17 SL16 VSS sky130_fd_pr__nfet_g5v0d10v5 ad=0.65 pd=3.3 as=0 ps=0 w=1 l=0.5
X4677 BLP16 rr2t2r_0[17|16]/a_60_290# sky130_fd_pr_reram__reram_cell area_ox=0.0676
X4678 BLN16 rr2t2r_0[17|16]/a_460_290# sky130_fd_pr_reram__reram_cell area_ox=0.0676
X4679 rr2t2r_0[17|16]/a_60_290# WL17 SL16 VSS sky130_fd_pr__nfet_g5v0d10v5 ad=0.65 pd=3.3 as=0 ps=0 w=1 l=0.5
X4680 rr2t2r_0[18|16]/a_460_290# WL18 SL16 VSS sky130_fd_pr__nfet_g5v0d10v5 ad=0.65 pd=3.3 as=0 ps=0 w=1 l=0.5
X4681 BLP16 rr2t2r_0[18|16]/a_60_290# sky130_fd_pr_reram__reram_cell area_ox=0.0676
X4682 BLN16 rr2t2r_0[18|16]/a_460_290# sky130_fd_pr_reram__reram_cell area_ox=0.0676
X4683 rr2t2r_0[18|16]/a_60_290# WL18 SL16 VSS sky130_fd_pr__nfet_g5v0d10v5 ad=0.65 pd=3.3 as=0 ps=0 w=1 l=0.5
X4684 rr2t2r_0[19|16]/a_460_290# WL19 SL16 VSS sky130_fd_pr__nfet_g5v0d10v5 ad=0.65 pd=3.3 as=0 ps=0 w=1 l=0.5
X4685 BLP16 rr2t2r_0[19|16]/a_60_290# sky130_fd_pr_reram__reram_cell area_ox=0.0676
X4686 BLN16 rr2t2r_0[19|16]/a_460_290# sky130_fd_pr_reram__reram_cell area_ox=0.0676
X4687 rr2t2r_0[19|16]/a_60_290# WL19 SL16 VSS sky130_fd_pr__nfet_g5v0d10v5 ad=0.65 pd=3.3 as=0 ps=0 w=1 l=0.5
X4688 rr2t2r_0[20|16]/a_460_290# WL20 SL16 VSS sky130_fd_pr__nfet_g5v0d10v5 ad=0.65 pd=3.3 as=0 ps=0 w=1 l=0.5
X4689 BLP16 rr2t2r_0[20|16]/a_60_290# sky130_fd_pr_reram__reram_cell area_ox=0.0676
X4690 BLN16 rr2t2r_0[20|16]/a_460_290# sky130_fd_pr_reram__reram_cell area_ox=0.0676
X4691 rr2t2r_0[20|16]/a_60_290# WL20 SL16 VSS sky130_fd_pr__nfet_g5v0d10v5 ad=0.65 pd=3.3 as=0 ps=0 w=1 l=0.5
X4692 rr2t2r_0[21|16]/a_460_290# WL21 SL16 VSS sky130_fd_pr__nfet_g5v0d10v5 ad=0.65 pd=3.3 as=0 ps=0 w=1 l=0.5
X4693 BLP16 rr2t2r_0[21|16]/a_60_290# sky130_fd_pr_reram__reram_cell area_ox=0.0676
X4694 BLN16 rr2t2r_0[21|16]/a_460_290# sky130_fd_pr_reram__reram_cell area_ox=0.0676
X4695 rr2t2r_0[21|16]/a_60_290# WL21 SL16 VSS sky130_fd_pr__nfet_g5v0d10v5 ad=0.65 pd=3.3 as=0 ps=0 w=1 l=0.5
X4696 rr2t2r_0[22|16]/a_460_290# WL22 SL16 VSS sky130_fd_pr__nfet_g5v0d10v5 ad=0.65 pd=3.3 as=0 ps=0 w=1 l=0.5
X4697 BLP16 rr2t2r_0[22|16]/a_60_290# sky130_fd_pr_reram__reram_cell area_ox=0.0676
X4698 BLN16 rr2t2r_0[22|16]/a_460_290# sky130_fd_pr_reram__reram_cell area_ox=0.0676
X4699 rr2t2r_0[22|16]/a_60_290# WL22 SL16 VSS sky130_fd_pr__nfet_g5v0d10v5 ad=0.65 pd=3.3 as=0 ps=0 w=1 l=0.5
X4700 rr2t2r_0[23|16]/a_460_290# WL23 SL16 VSS sky130_fd_pr__nfet_g5v0d10v5 ad=0.65 pd=3.3 as=0 ps=0 w=1 l=0.5
X4701 BLP16 rr2t2r_0[23|16]/a_60_290# sky130_fd_pr_reram__reram_cell area_ox=0.0676
X4702 BLN16 rr2t2r_0[23|16]/a_460_290# sky130_fd_pr_reram__reram_cell area_ox=0.0676
X4703 rr2t2r_0[23|16]/a_60_290# WL23 SL16 VSS sky130_fd_pr__nfet_g5v0d10v5 ad=0.65 pd=3.3 as=0 ps=0 w=1 l=0.5
X4704 rr2t2r_0[24|16]/a_460_290# WL24 SL16 VSS sky130_fd_pr__nfet_g5v0d10v5 ad=0.65 pd=3.3 as=0 ps=0 w=1 l=0.5
X4705 BLP16 rr2t2r_0[24|16]/a_60_290# sky130_fd_pr_reram__reram_cell area_ox=0.0676
X4706 BLN16 rr2t2r_0[24|16]/a_460_290# sky130_fd_pr_reram__reram_cell area_ox=0.0676
X4707 rr2t2r_0[24|16]/a_60_290# WL24 SL16 VSS sky130_fd_pr__nfet_g5v0d10v5 ad=0.65 pd=3.3 as=0 ps=0 w=1 l=0.5
X4708 rr2t2r_0[25|16]/a_460_290# WL25 SL16 VSS sky130_fd_pr__nfet_g5v0d10v5 ad=0.65 pd=3.3 as=0 ps=0 w=1 l=0.5
X4709 BLP16 rr2t2r_0[25|16]/a_60_290# sky130_fd_pr_reram__reram_cell area_ox=0.0676
X4710 BLN16 rr2t2r_0[25|16]/a_460_290# sky130_fd_pr_reram__reram_cell area_ox=0.0676
X4711 rr2t2r_0[25|16]/a_60_290# WL25 SL16 VSS sky130_fd_pr__nfet_g5v0d10v5 ad=0.65 pd=3.3 as=0 ps=0 w=1 l=0.5
X4712 rr2t2r_0[26|16]/a_460_290# WL26 SL16 VSS sky130_fd_pr__nfet_g5v0d10v5 ad=0.65 pd=3.3 as=0 ps=0 w=1 l=0.5
X4713 BLP16 rr2t2r_0[26|16]/a_60_290# sky130_fd_pr_reram__reram_cell area_ox=0.0676
X4714 BLN16 rr2t2r_0[26|16]/a_460_290# sky130_fd_pr_reram__reram_cell area_ox=0.0676
X4715 rr2t2r_0[26|16]/a_60_290# WL26 SL16 VSS sky130_fd_pr__nfet_g5v0d10v5 ad=0.65 pd=3.3 as=0 ps=0 w=1 l=0.5
X4716 rr2t2r_0[27|16]/a_460_290# WL27 SL16 VSS sky130_fd_pr__nfet_g5v0d10v5 ad=0.65 pd=3.3 as=0 ps=0 w=1 l=0.5
X4717 BLP16 rr2t2r_0[27|16]/a_60_290# sky130_fd_pr_reram__reram_cell area_ox=0.0676
X4718 BLN16 rr2t2r_0[27|16]/a_460_290# sky130_fd_pr_reram__reram_cell area_ox=0.0676
X4719 rr2t2r_0[27|16]/a_60_290# WL27 SL16 VSS sky130_fd_pr__nfet_g5v0d10v5 ad=0.65 pd=3.3 as=0 ps=0 w=1 l=0.5
X4720 rr2t2r_0[28|16]/a_460_290# WL28 SL16 VSS sky130_fd_pr__nfet_g5v0d10v5 ad=0.65 pd=3.3 as=0 ps=0 w=1 l=0.5
X4721 BLP16 rr2t2r_0[28|16]/a_60_290# sky130_fd_pr_reram__reram_cell area_ox=0.0676
X4722 BLN16 rr2t2r_0[28|16]/a_460_290# sky130_fd_pr_reram__reram_cell area_ox=0.0676
X4723 rr2t2r_0[28|16]/a_60_290# WL28 SL16 VSS sky130_fd_pr__nfet_g5v0d10v5 ad=0.65 pd=3.3 as=0 ps=0 w=1 l=0.5
X4724 rr2t2r_0[29|16]/a_460_290# WL29 SL16 VSS sky130_fd_pr__nfet_g5v0d10v5 ad=0.65 pd=3.3 as=0 ps=0 w=1 l=0.5
X4725 BLP16 rr2t2r_0[29|16]/a_60_290# sky130_fd_pr_reram__reram_cell area_ox=0.0676
X4726 BLN16 rr2t2r_0[29|16]/a_460_290# sky130_fd_pr_reram__reram_cell area_ox=0.0676
X4727 rr2t2r_0[29|16]/a_60_290# WL29 SL16 VSS sky130_fd_pr__nfet_g5v0d10v5 ad=0.65 pd=3.3 as=0 ps=0 w=1 l=0.5
X4728 rr2t2r_0[30|16]/a_460_290# WL30 SL16 VSS sky130_fd_pr__nfet_g5v0d10v5 ad=0.65 pd=3.3 as=0 ps=0 w=1 l=0.5
X4729 BLP16 rr2t2r_0[30|16]/a_60_290# sky130_fd_pr_reram__reram_cell area_ox=0.0676
X4730 BLN16 rr2t2r_0[30|16]/a_460_290# sky130_fd_pr_reram__reram_cell area_ox=0.0676
X4731 rr2t2r_0[30|16]/a_60_290# WL30 SL16 VSS sky130_fd_pr__nfet_g5v0d10v5 ad=0.65 pd=3.3 as=0 ps=0 w=1 l=0.5
X4732 rr2t2r_0[31|16]/a_460_290# WL31 SL16 VSS sky130_fd_pr__nfet_g5v0d10v5 ad=0.65 pd=3.3 as=0 ps=0 w=1 l=0.5
X4733 BLP16 rr2t2r_0[31|16]/a_60_290# sky130_fd_pr_reram__reram_cell area_ox=0.0676
X4734 BLN16 rr2t2r_0[31|16]/a_460_290# sky130_fd_pr_reram__reram_cell area_ox=0.0676
X4735 rr2t2r_0[31|16]/a_60_290# WL31 SL16 VSS sky130_fd_pr__nfet_g5v0d10v5 ad=0.65 pd=3.3 as=0 ps=0 w=1 l=0.5
X4736 rr2t2r_0[32|16]/a_460_290# WL32 SL16 VSS sky130_fd_pr__nfet_g5v0d10v5 ad=0.65 pd=3.3 as=0 ps=0 w=1 l=0.5
X4737 BLP16 rr2t2r_0[32|16]/a_60_290# sky130_fd_pr_reram__reram_cell area_ox=0.0676
X4738 BLN16 rr2t2r_0[32|16]/a_460_290# sky130_fd_pr_reram__reram_cell area_ox=0.0676
X4739 rr2t2r_0[32|16]/a_60_290# WL32 SL16 VSS sky130_fd_pr__nfet_g5v0d10v5 ad=0.65 pd=3.3 as=0 ps=0 w=1 l=0.5
X4740 rr2t2r_0[33|16]/a_460_290# WL33 SL16 VSS sky130_fd_pr__nfet_g5v0d10v5 ad=0.65 pd=3.3 as=0 ps=0 w=1 l=0.5
X4741 BLP16 rr2t2r_0[33|16]/a_60_290# sky130_fd_pr_reram__reram_cell area_ox=0.0676
X4742 BLN16 rr2t2r_0[33|16]/a_460_290# sky130_fd_pr_reram__reram_cell area_ox=0.0676
X4743 rr2t2r_0[33|16]/a_60_290# WL33 SL16 VSS sky130_fd_pr__nfet_g5v0d10v5 ad=0.65 pd=3.3 as=0 ps=0 w=1 l=0.5
X4744 rr2t2r_0[34|16]/a_460_290# WL34 SL16 VSS sky130_fd_pr__nfet_g5v0d10v5 ad=0.65 pd=3.3 as=0 ps=0 w=1 l=0.5
X4745 BLP16 rr2t2r_0[34|16]/a_60_290# sky130_fd_pr_reram__reram_cell area_ox=0.0676
X4746 BLN16 rr2t2r_0[34|16]/a_460_290# sky130_fd_pr_reram__reram_cell area_ox=0.0676
X4747 rr2t2r_0[34|16]/a_60_290# WL34 SL16 VSS sky130_fd_pr__nfet_g5v0d10v5 ad=0.65 pd=3.3 as=0 ps=0 w=1 l=0.5
X4748 rr2t2r_0[35|16]/a_460_290# WL35 SL16 VSS sky130_fd_pr__nfet_g5v0d10v5 ad=0.65 pd=3.3 as=0 ps=0 w=1 l=0.5
X4749 BLP16 rr2t2r_0[35|16]/a_60_290# sky130_fd_pr_reram__reram_cell area_ox=0.0676
X4750 BLN16 rr2t2r_0[35|16]/a_460_290# sky130_fd_pr_reram__reram_cell area_ox=0.0676
X4751 rr2t2r_0[35|16]/a_60_290# WL35 SL16 VSS sky130_fd_pr__nfet_g5v0d10v5 ad=0.65 pd=3.3 as=0 ps=0 w=1 l=0.5
X4752 rr2t2r_0[36|16]/a_460_290# WL36 SL16 VSS sky130_fd_pr__nfet_g5v0d10v5 ad=0.65 pd=3.3 as=0 ps=0 w=1 l=0.5
X4753 BLP16 rr2t2r_0[36|16]/a_60_290# sky130_fd_pr_reram__reram_cell area_ox=0.0676
X4754 BLN16 rr2t2r_0[36|16]/a_460_290# sky130_fd_pr_reram__reram_cell area_ox=0.0676
X4755 rr2t2r_0[36|16]/a_60_290# WL36 SL16 VSS sky130_fd_pr__nfet_g5v0d10v5 ad=0.65 pd=3.3 as=0 ps=0 w=1 l=0.5
X4756 rr2t2r_0[37|16]/a_460_290# WL37 SL16 VSS sky130_fd_pr__nfet_g5v0d10v5 ad=0.65 pd=3.3 as=0 ps=0 w=1 l=0.5
X4757 BLP16 rr2t2r_0[37|16]/a_60_290# sky130_fd_pr_reram__reram_cell area_ox=0.0676
X4758 BLN16 rr2t2r_0[37|16]/a_460_290# sky130_fd_pr_reram__reram_cell area_ox=0.0676
X4759 rr2t2r_0[37|16]/a_60_290# WL37 SL16 VSS sky130_fd_pr__nfet_g5v0d10v5 ad=0.65 pd=3.3 as=0 ps=0 w=1 l=0.5
X4760 rr2t2r_0[38|16]/a_460_290# WL38 SL16 VSS sky130_fd_pr__nfet_g5v0d10v5 ad=0.65 pd=3.3 as=0 ps=0 w=1 l=0.5
X4761 BLP16 rr2t2r_0[38|16]/a_60_290# sky130_fd_pr_reram__reram_cell area_ox=0.0676
X4762 BLN16 rr2t2r_0[38|16]/a_460_290# sky130_fd_pr_reram__reram_cell area_ox=0.0676
X4763 rr2t2r_0[38|16]/a_60_290# WL38 SL16 VSS sky130_fd_pr__nfet_g5v0d10v5 ad=0.65 pd=3.3 as=0 ps=0 w=1 l=0.5
X4764 rr2t2r_0[39|16]/a_460_290# WL39 SL16 VSS sky130_fd_pr__nfet_g5v0d10v5 ad=0.65 pd=3.3 as=0 ps=0 w=1 l=0.5
X4765 BLP16 rr2t2r_0[39|16]/a_60_290# sky130_fd_pr_reram__reram_cell area_ox=0.0676
X4766 BLN16 rr2t2r_0[39|16]/a_460_290# sky130_fd_pr_reram__reram_cell area_ox=0.0676
X4767 rr2t2r_0[39|16]/a_60_290# WL39 SL16 VSS sky130_fd_pr__nfet_g5v0d10v5 ad=0.65 pd=3.3 as=0 ps=0 w=1 l=0.5
X4768 rr2t2r_0[40|16]/a_460_290# WL40 SL16 VSS sky130_fd_pr__nfet_g5v0d10v5 ad=0.65 pd=3.3 as=0 ps=0 w=1 l=0.5
X4769 BLP16 rr2t2r_0[40|16]/a_60_290# sky130_fd_pr_reram__reram_cell area_ox=0.0676
X4770 BLN16 rr2t2r_0[40|16]/a_460_290# sky130_fd_pr_reram__reram_cell area_ox=0.0676
X4771 rr2t2r_0[40|16]/a_60_290# WL40 SL16 VSS sky130_fd_pr__nfet_g5v0d10v5 ad=0.65 pd=3.3 as=0 ps=0 w=1 l=0.5
X4772 rr2t2r_0[41|16]/a_460_290# WL41 SL16 VSS sky130_fd_pr__nfet_g5v0d10v5 ad=0.65 pd=3.3 as=0 ps=0 w=1 l=0.5
X4773 BLP16 rr2t2r_0[41|16]/a_60_290# sky130_fd_pr_reram__reram_cell area_ox=0.0676
X4774 BLN16 rr2t2r_0[41|16]/a_460_290# sky130_fd_pr_reram__reram_cell area_ox=0.0676
X4775 rr2t2r_0[41|16]/a_60_290# WL41 SL16 VSS sky130_fd_pr__nfet_g5v0d10v5 ad=0.65 pd=3.3 as=0 ps=0 w=1 l=0.5
X4776 rr2t2r_0[42|16]/a_460_290# WL42 SL16 VSS sky130_fd_pr__nfet_g5v0d10v5 ad=0.65 pd=3.3 as=0 ps=0 w=1 l=0.5
X4777 BLP16 rr2t2r_0[42|16]/a_60_290# sky130_fd_pr_reram__reram_cell area_ox=0.0676
X4778 BLN16 rr2t2r_0[42|16]/a_460_290# sky130_fd_pr_reram__reram_cell area_ox=0.0676
X4779 rr2t2r_0[42|16]/a_60_290# WL42 SL16 VSS sky130_fd_pr__nfet_g5v0d10v5 ad=0.65 pd=3.3 as=0 ps=0 w=1 l=0.5
X4780 rr2t2r_0[43|16]/a_460_290# WL43 SL16 VSS sky130_fd_pr__nfet_g5v0d10v5 ad=0.65 pd=3.3 as=0 ps=0 w=1 l=0.5
X4781 BLP16 rr2t2r_0[43|16]/a_60_290# sky130_fd_pr_reram__reram_cell area_ox=0.0676
X4782 BLN16 rr2t2r_0[43|16]/a_460_290# sky130_fd_pr_reram__reram_cell area_ox=0.0676
X4783 rr2t2r_0[43|16]/a_60_290# WL43 SL16 VSS sky130_fd_pr__nfet_g5v0d10v5 ad=0.65 pd=3.3 as=0 ps=0 w=1 l=0.5
X4784 rr2t2r_0[44|16]/a_460_290# WL44 SL16 VSS sky130_fd_pr__nfet_g5v0d10v5 ad=0.65 pd=3.3 as=0 ps=0 w=1 l=0.5
X4785 BLP16 rr2t2r_0[44|16]/a_60_290# sky130_fd_pr_reram__reram_cell area_ox=0.0676
X4786 BLN16 rr2t2r_0[44|16]/a_460_290# sky130_fd_pr_reram__reram_cell area_ox=0.0676
X4787 rr2t2r_0[44|16]/a_60_290# WL44 SL16 VSS sky130_fd_pr__nfet_g5v0d10v5 ad=0.65 pd=3.3 as=0 ps=0 w=1 l=0.5
X4788 rr2t2r_0[45|16]/a_460_290# WL45 SL16 VSS sky130_fd_pr__nfet_g5v0d10v5 ad=0.65 pd=3.3 as=0 ps=0 w=1 l=0.5
X4789 BLP16 rr2t2r_0[45|16]/a_60_290# sky130_fd_pr_reram__reram_cell area_ox=0.0676
X4790 BLN16 rr2t2r_0[45|16]/a_460_290# sky130_fd_pr_reram__reram_cell area_ox=0.0676
X4791 rr2t2r_0[45|16]/a_60_290# WL45 SL16 VSS sky130_fd_pr__nfet_g5v0d10v5 ad=0.65 pd=3.3 as=0 ps=0 w=1 l=0.5
X4792 rr2t2r_0[46|16]/a_460_290# WL46 SL16 VSS sky130_fd_pr__nfet_g5v0d10v5 ad=0.65 pd=3.3 as=0 ps=0 w=1 l=0.5
X4793 BLP16 rr2t2r_0[46|16]/a_60_290# sky130_fd_pr_reram__reram_cell area_ox=0.0676
X4794 BLN16 rr2t2r_0[46|16]/a_460_290# sky130_fd_pr_reram__reram_cell area_ox=0.0676
X4795 rr2t2r_0[46|16]/a_60_290# WL46 SL16 VSS sky130_fd_pr__nfet_g5v0d10v5 ad=0.65 pd=3.3 as=0 ps=0 w=1 l=0.5
X4796 rr2t2r_0[47|16]/a_460_290# WL47 SL16 VSS sky130_fd_pr__nfet_g5v0d10v5 ad=0.65 pd=3.3 as=0 ps=0 w=1 l=0.5
X4797 BLP16 rr2t2r_0[47|16]/a_60_290# sky130_fd_pr_reram__reram_cell area_ox=0.0676
X4798 BLN16 rr2t2r_0[47|16]/a_460_290# sky130_fd_pr_reram__reram_cell area_ox=0.0676
X4799 rr2t2r_0[47|16]/a_60_290# WL47 SL16 VSS sky130_fd_pr__nfet_g5v0d10v5 ad=0.65 pd=3.3 as=0 ps=0 w=1 l=0.5
X4800 rr2t2r_0[48|16]/a_460_290# WL48 SL16 VSS sky130_fd_pr__nfet_g5v0d10v5 ad=0.65 pd=3.3 as=0 ps=0 w=1 l=0.5
X4801 BLP16 rr2t2r_0[48|16]/a_60_290# sky130_fd_pr_reram__reram_cell area_ox=0.0676
X4802 BLN16 rr2t2r_0[48|16]/a_460_290# sky130_fd_pr_reram__reram_cell area_ox=0.0676
X4803 rr2t2r_0[48|16]/a_60_290# WL48 SL16 VSS sky130_fd_pr__nfet_g5v0d10v5 ad=0.65 pd=3.3 as=0 ps=0 w=1 l=0.5
X4804 rr2t2r_0[49|16]/a_460_290# WL49 SL16 VSS sky130_fd_pr__nfet_g5v0d10v5 ad=0.65 pd=3.3 as=0 ps=0 w=1 l=0.5
X4805 BLP16 rr2t2r_0[49|16]/a_60_290# sky130_fd_pr_reram__reram_cell area_ox=0.0676
X4806 BLN16 rr2t2r_0[49|16]/a_460_290# sky130_fd_pr_reram__reram_cell area_ox=0.0676
X4807 rr2t2r_0[49|16]/a_60_290# WL49 SL16 VSS sky130_fd_pr__nfet_g5v0d10v5 ad=0.65 pd=3.3 as=0 ps=0 w=1 l=0.5
X4808 rr2t2r_0[50|16]/a_460_290# WL50 SL16 VSS sky130_fd_pr__nfet_g5v0d10v5 ad=0.65 pd=3.3 as=0 ps=0 w=1 l=0.5
X4809 BLP16 rr2t2r_0[50|16]/a_60_290# sky130_fd_pr_reram__reram_cell area_ox=0.0676
X4810 BLN16 rr2t2r_0[50|16]/a_460_290# sky130_fd_pr_reram__reram_cell area_ox=0.0676
X4811 rr2t2r_0[50|16]/a_60_290# WL50 SL16 VSS sky130_fd_pr__nfet_g5v0d10v5 ad=0.65 pd=3.3 as=0 ps=0 w=1 l=0.5
X4812 rr2t2r_0[51|16]/a_460_290# WL51 SL16 VSS sky130_fd_pr__nfet_g5v0d10v5 ad=0.65 pd=3.3 as=0 ps=0 w=1 l=0.5
X4813 BLP16 rr2t2r_0[51|16]/a_60_290# sky130_fd_pr_reram__reram_cell area_ox=0.0676
X4814 BLN16 rr2t2r_0[51|16]/a_460_290# sky130_fd_pr_reram__reram_cell area_ox=0.0676
X4815 rr2t2r_0[51|16]/a_60_290# WL51 SL16 VSS sky130_fd_pr__nfet_g5v0d10v5 ad=0.65 pd=3.3 as=0 ps=0 w=1 l=0.5
X4816 rr2t2r_0[52|16]/a_460_290# WL52 SL16 VSS sky130_fd_pr__nfet_g5v0d10v5 ad=0.65 pd=3.3 as=0 ps=0 w=1 l=0.5
X4817 BLP16 rr2t2r_0[52|16]/a_60_290# sky130_fd_pr_reram__reram_cell area_ox=0.0676
X4818 BLN16 rr2t2r_0[52|16]/a_460_290# sky130_fd_pr_reram__reram_cell area_ox=0.0676
X4819 rr2t2r_0[52|16]/a_60_290# WL52 SL16 VSS sky130_fd_pr__nfet_g5v0d10v5 ad=0.65 pd=3.3 as=0 ps=0 w=1 l=0.5
X4820 rr2t2r_0[53|16]/a_460_290# WL53 SL16 VSS sky130_fd_pr__nfet_g5v0d10v5 ad=0.65 pd=3.3 as=0 ps=0 w=1 l=0.5
X4821 BLP16 rr2t2r_0[53|16]/a_60_290# sky130_fd_pr_reram__reram_cell area_ox=0.0676
X4822 BLN16 rr2t2r_0[53|16]/a_460_290# sky130_fd_pr_reram__reram_cell area_ox=0.0676
X4823 rr2t2r_0[53|16]/a_60_290# WL53 SL16 VSS sky130_fd_pr__nfet_g5v0d10v5 ad=0.65 pd=3.3 as=0 ps=0 w=1 l=0.5
X4824 rr2t2r_0[54|16]/a_460_290# WL54 SL16 VSS sky130_fd_pr__nfet_g5v0d10v5 ad=0.65 pd=3.3 as=0 ps=0 w=1 l=0.5
X4825 BLP16 rr2t2r_0[54|16]/a_60_290# sky130_fd_pr_reram__reram_cell area_ox=0.0676
X4826 BLN16 rr2t2r_0[54|16]/a_460_290# sky130_fd_pr_reram__reram_cell area_ox=0.0676
X4827 rr2t2r_0[54|16]/a_60_290# WL54 SL16 VSS sky130_fd_pr__nfet_g5v0d10v5 ad=0.65 pd=3.3 as=0 ps=0 w=1 l=0.5
X4828 rr2t2r_0[55|16]/a_460_290# WL55 SL16 VSS sky130_fd_pr__nfet_g5v0d10v5 ad=0.65 pd=3.3 as=0 ps=0 w=1 l=0.5
X4829 BLP16 rr2t2r_0[55|16]/a_60_290# sky130_fd_pr_reram__reram_cell area_ox=0.0676
X4830 BLN16 rr2t2r_0[55|16]/a_460_290# sky130_fd_pr_reram__reram_cell area_ox=0.0676
X4831 rr2t2r_0[55|16]/a_60_290# WL55 SL16 VSS sky130_fd_pr__nfet_g5v0d10v5 ad=0.65 pd=3.3 as=0 ps=0 w=1 l=0.5
X4832 rr2t2r_0[56|16]/a_460_290# WL56 SL16 VSS sky130_fd_pr__nfet_g5v0d10v5 ad=0.65 pd=3.3 as=0 ps=0 w=1 l=0.5
X4833 BLP16 rr2t2r_0[56|16]/a_60_290# sky130_fd_pr_reram__reram_cell area_ox=0.0676
X4834 BLN16 rr2t2r_0[56|16]/a_460_290# sky130_fd_pr_reram__reram_cell area_ox=0.0676
X4835 rr2t2r_0[56|16]/a_60_290# WL56 SL16 VSS sky130_fd_pr__nfet_g5v0d10v5 ad=0.65 pd=3.3 as=0 ps=0 w=1 l=0.5
X4836 rr2t2r_0[57|16]/a_460_290# WL57 SL16 VSS sky130_fd_pr__nfet_g5v0d10v5 ad=0.65 pd=3.3 as=0 ps=0 w=1 l=0.5
X4837 BLP16 rr2t2r_0[57|16]/a_60_290# sky130_fd_pr_reram__reram_cell area_ox=0.0676
X4838 BLN16 rr2t2r_0[57|16]/a_460_290# sky130_fd_pr_reram__reram_cell area_ox=0.0676
X4839 rr2t2r_0[57|16]/a_60_290# WL57 SL16 VSS sky130_fd_pr__nfet_g5v0d10v5 ad=0.65 pd=3.3 as=0 ps=0 w=1 l=0.5
X4840 rr2t2r_0[58|16]/a_460_290# WL58 SL16 VSS sky130_fd_pr__nfet_g5v0d10v5 ad=0.65 pd=3.3 as=0 ps=0 w=1 l=0.5
X4841 BLP16 rr2t2r_0[58|16]/a_60_290# sky130_fd_pr_reram__reram_cell area_ox=0.0676
X4842 BLN16 rr2t2r_0[58|16]/a_460_290# sky130_fd_pr_reram__reram_cell area_ox=0.0676
X4843 rr2t2r_0[58|16]/a_60_290# WL58 SL16 VSS sky130_fd_pr__nfet_g5v0d10v5 ad=0.65 pd=3.3 as=0 ps=0 w=1 l=0.5
X4844 rr2t2r_0[59|16]/a_460_290# WL59 SL16 VSS sky130_fd_pr__nfet_g5v0d10v5 ad=0.65 pd=3.3 as=0 ps=0 w=1 l=0.5
X4845 BLP16 rr2t2r_0[59|16]/a_60_290# sky130_fd_pr_reram__reram_cell area_ox=0.0676
X4846 BLN16 rr2t2r_0[59|16]/a_460_290# sky130_fd_pr_reram__reram_cell area_ox=0.0676
X4847 rr2t2r_0[59|16]/a_60_290# WL59 SL16 VSS sky130_fd_pr__nfet_g5v0d10v5 ad=0.65 pd=3.3 as=0 ps=0 w=1 l=0.5
X4848 rr2t2r_0[60|16]/a_460_290# WL60 SL16 VSS sky130_fd_pr__nfet_g5v0d10v5 ad=0.65 pd=3.3 as=0 ps=0 w=1 l=0.5
X4849 BLP16 rr2t2r_0[60|16]/a_60_290# sky130_fd_pr_reram__reram_cell area_ox=0.0676
X4850 BLN16 rr2t2r_0[60|16]/a_460_290# sky130_fd_pr_reram__reram_cell area_ox=0.0676
X4851 rr2t2r_0[60|16]/a_60_290# WL60 SL16 VSS sky130_fd_pr__nfet_g5v0d10v5 ad=0.65 pd=3.3 as=0 ps=0 w=1 l=0.5
X4852 rr2t2r_0[61|16]/a_460_290# WL61 SL16 VSS sky130_fd_pr__nfet_g5v0d10v5 ad=0.65 pd=3.3 as=0 ps=0 w=1 l=0.5
X4853 BLP16 rr2t2r_0[61|16]/a_60_290# sky130_fd_pr_reram__reram_cell area_ox=0.0676
X4854 BLN16 rr2t2r_0[61|16]/a_460_290# sky130_fd_pr_reram__reram_cell area_ox=0.0676
X4855 rr2t2r_0[61|16]/a_60_290# WL61 SL16 VSS sky130_fd_pr__nfet_g5v0d10v5 ad=0.65 pd=3.3 as=0 ps=0 w=1 l=0.5
X4856 rr2t2r_0[62|16]/a_460_290# WL62 SL16 VSS sky130_fd_pr__nfet_g5v0d10v5 ad=0.65 pd=3.3 as=0 ps=0 w=1 l=0.5
X4857 BLP16 rr2t2r_0[62|16]/a_60_290# sky130_fd_pr_reram__reram_cell area_ox=0.0676
X4858 BLN16 rr2t2r_0[62|16]/a_460_290# sky130_fd_pr_reram__reram_cell area_ox=0.0676
X4859 rr2t2r_0[62|16]/a_60_290# WL62 SL16 VSS sky130_fd_pr__nfet_g5v0d10v5 ad=0.65 pd=3.3 as=0 ps=0 w=1 l=0.5
X4860 rr2t2r_0[63|16]/a_460_290# WL63 SL16 VSS sky130_fd_pr__nfet_g5v0d10v5 ad=0.65 pd=3.3 as=0 ps=0 w=1 l=0.5
X4861 BLP16 rr2t2r_0[63|16]/a_60_290# sky130_fd_pr_reram__reram_cell area_ox=0.0676
X4862 BLN16 rr2t2r_0[63|16]/a_460_290# sky130_fd_pr_reram__reram_cell area_ox=0.0676
X4863 rr2t2r_0[63|16]/a_60_290# WL63 SL16 VSS sky130_fd_pr__nfet_g5v0d10v5 ad=0.65 pd=3.3 as=0 ps=0 w=1 l=0.5
X4864 rr2t2r_0[64|16]/a_460_290# WL64 SL16 VSS sky130_fd_pr__nfet_g5v0d10v5 ad=0.65 pd=3.3 as=0 ps=0 w=1 l=0.5
X4865 BLP16 rr2t2r_0[64|16]/a_60_290# sky130_fd_pr_reram__reram_cell area_ox=0.0676
X4866 BLN16 rr2t2r_0[64|16]/a_460_290# sky130_fd_pr_reram__reram_cell area_ox=0.0676
X4867 rr2t2r_0[64|16]/a_60_290# WL64 SL16 VSS sky130_fd_pr__nfet_g5v0d10v5 ad=0.65 pd=3.3 as=0 ps=0 w=1 l=0.5
X4868 rr2t2r_0[65|16]/a_460_290# WL65 SL16 VSS sky130_fd_pr__nfet_g5v0d10v5 ad=0.65 pd=3.3 as=0 ps=0 w=1 l=0.5
X4869 BLP16 rr2t2r_0[65|16]/a_60_290# sky130_fd_pr_reram__reram_cell area_ox=0.0676
X4870 BLN16 rr2t2r_0[65|16]/a_460_290# sky130_fd_pr_reram__reram_cell area_ox=0.0676
X4871 rr2t2r_0[65|16]/a_60_290# WL65 SL16 VSS sky130_fd_pr__nfet_g5v0d10v5 ad=0.65 pd=3.3 as=0 ps=0 w=1 l=0.5
X4872 rr2t2r_0[66|16]/a_460_290# WL66 SL16 VSS sky130_fd_pr__nfet_g5v0d10v5 ad=0.65 pd=3.3 as=0 ps=0 w=1 l=0.5
X4873 BLP16 rr2t2r_0[66|16]/a_60_290# sky130_fd_pr_reram__reram_cell area_ox=0.0676
X4874 BLN16 rr2t2r_0[66|16]/a_460_290# sky130_fd_pr_reram__reram_cell area_ox=0.0676
X4875 rr2t2r_0[66|16]/a_60_290# WL66 SL16 VSS sky130_fd_pr__nfet_g5v0d10v5 ad=0.65 pd=3.3 as=0 ps=0 w=1 l=0.5
X4876 rr2t2r_0[67|16]/a_460_290# WL67 SL16 VSS sky130_fd_pr__nfet_g5v0d10v5 ad=0.65 pd=3.3 as=0 ps=0 w=1 l=0.5
X4877 BLP16 rr2t2r_0[67|16]/a_60_290# sky130_fd_pr_reram__reram_cell area_ox=0.0676
X4878 BLN16 rr2t2r_0[67|16]/a_460_290# sky130_fd_pr_reram__reram_cell area_ox=0.0676
X4879 rr2t2r_0[67|16]/a_60_290# WL67 SL16 VSS sky130_fd_pr__nfet_g5v0d10v5 ad=0.65 pd=3.3 as=0 ps=0 w=1 l=0.5
X4880 rr2t2r_0[68|16]/a_460_290# WL68 SL16 VSS sky130_fd_pr__nfet_g5v0d10v5 ad=0.65 pd=3.3 as=0 ps=0 w=1 l=0.5
X4881 BLP16 rr2t2r_0[68|16]/a_60_290# sky130_fd_pr_reram__reram_cell area_ox=0.0676
X4882 BLN16 rr2t2r_0[68|16]/a_460_290# sky130_fd_pr_reram__reram_cell area_ox=0.0676
X4883 rr2t2r_0[68|16]/a_60_290# WL68 SL16 VSS sky130_fd_pr__nfet_g5v0d10v5 ad=0.65 pd=3.3 as=0 ps=0 w=1 l=0.5
X4884 rr2t2r_0[69|16]/a_460_290# WL69 SL16 VSS sky130_fd_pr__nfet_g5v0d10v5 ad=0.65 pd=3.3 as=0 ps=0 w=1 l=0.5
X4885 BLP16 rr2t2r_0[69|16]/a_60_290# sky130_fd_pr_reram__reram_cell area_ox=0.0676
X4886 BLN16 rr2t2r_0[69|16]/a_460_290# sky130_fd_pr_reram__reram_cell area_ox=0.0676
X4887 rr2t2r_0[69|16]/a_60_290# WL69 SL16 VSS sky130_fd_pr__nfet_g5v0d10v5 ad=0.65 pd=3.3 as=0 ps=0 w=1 l=0.5
X4888 rr2t2r_0[70|16]/a_460_290# WL70 SL16 VSS sky130_fd_pr__nfet_g5v0d10v5 ad=0.65 pd=3.3 as=0 ps=0 w=1 l=0.5
X4889 BLP16 rr2t2r_0[70|16]/a_60_290# sky130_fd_pr_reram__reram_cell area_ox=0.0676
X4890 BLN16 rr2t2r_0[70|16]/a_460_290# sky130_fd_pr_reram__reram_cell area_ox=0.0676
X4891 rr2t2r_0[70|16]/a_60_290# WL70 SL16 VSS sky130_fd_pr__nfet_g5v0d10v5 ad=0.65 pd=3.3 as=0 ps=0 w=1 l=0.5
X4892 rr2t2r_0[71|16]/a_460_290# WL71 SL16 VSS sky130_fd_pr__nfet_g5v0d10v5 ad=0.65 pd=3.3 as=0 ps=0 w=1 l=0.5
X4893 BLP16 rr2t2r_0[71|16]/a_60_290# sky130_fd_pr_reram__reram_cell area_ox=0.0676
X4894 BLN16 rr2t2r_0[71|16]/a_460_290# sky130_fd_pr_reram__reram_cell area_ox=0.0676
X4895 rr2t2r_0[71|16]/a_60_290# WL71 SL16 VSS sky130_fd_pr__nfet_g5v0d10v5 ad=0.65 pd=3.3 as=0 ps=0 w=1 l=0.5
X4896 rr2t2r_0[0|17]/a_460_290# WL0 SL17 VSS sky130_fd_pr__nfet_g5v0d10v5 ad=0.65 pd=3.3 as=108 ps=504 w=1 l=0.5
X4897 BLP17 rr2t2r_0[0|17]/a_60_290# sky130_fd_pr_reram__reram_cell area_ox=0.0676
X4898 BLN17 rr2t2r_0[0|17]/a_460_290# sky130_fd_pr_reram__reram_cell area_ox=0.0676
X4899 rr2t2r_0[0|17]/a_60_290# WL0 SL17 VSS sky130_fd_pr__nfet_g5v0d10v5 ad=0.65 pd=3.3 as=0 ps=0 w=1 l=0.5
X4900 rr2t2r_0[1|17]/a_460_290# WL1 SL17 VSS sky130_fd_pr__nfet_g5v0d10v5 ad=0.65 pd=3.3 as=0 ps=0 w=1 l=0.5
X4901 BLP17 rr2t2r_0[1|17]/a_60_290# sky130_fd_pr_reram__reram_cell area_ox=0.0676
X4902 BLN17 rr2t2r_0[1|17]/a_460_290# sky130_fd_pr_reram__reram_cell area_ox=0.0676
X4903 rr2t2r_0[1|17]/a_60_290# WL1 SL17 VSS sky130_fd_pr__nfet_g5v0d10v5 ad=0.65 pd=3.3 as=0 ps=0 w=1 l=0.5
X4904 rr2t2r_0[2|17]/a_460_290# WL2 SL17 VSS sky130_fd_pr__nfet_g5v0d10v5 ad=0.65 pd=3.3 as=0 ps=0 w=1 l=0.5
X4905 BLP17 rr2t2r_0[2|17]/a_60_290# sky130_fd_pr_reram__reram_cell area_ox=0.0676
X4906 BLN17 rr2t2r_0[2|17]/a_460_290# sky130_fd_pr_reram__reram_cell area_ox=0.0676
X4907 rr2t2r_0[2|17]/a_60_290# WL2 SL17 VSS sky130_fd_pr__nfet_g5v0d10v5 ad=0.65 pd=3.3 as=0 ps=0 w=1 l=0.5
X4908 rr2t2r_0[3|17]/a_460_290# WL3 SL17 VSS sky130_fd_pr__nfet_g5v0d10v5 ad=0.65 pd=3.3 as=0 ps=0 w=1 l=0.5
X4909 BLP17 rr2t2r_0[3|17]/a_60_290# sky130_fd_pr_reram__reram_cell area_ox=0.0676
X4910 BLN17 rr2t2r_0[3|17]/a_460_290# sky130_fd_pr_reram__reram_cell area_ox=0.0676
X4911 rr2t2r_0[3|17]/a_60_290# WL3 SL17 VSS sky130_fd_pr__nfet_g5v0d10v5 ad=0.65 pd=3.3 as=0 ps=0 w=1 l=0.5
X4912 rr2t2r_0[4|17]/a_460_290# WL4 SL17 VSS sky130_fd_pr__nfet_g5v0d10v5 ad=0.65 pd=3.3 as=0 ps=0 w=1 l=0.5
X4913 BLP17 rr2t2r_0[4|17]/a_60_290# sky130_fd_pr_reram__reram_cell area_ox=0.0676
X4914 BLN17 rr2t2r_0[4|17]/a_460_290# sky130_fd_pr_reram__reram_cell area_ox=0.0676
X4915 rr2t2r_0[4|17]/a_60_290# WL4 SL17 VSS sky130_fd_pr__nfet_g5v0d10v5 ad=0.65 pd=3.3 as=0 ps=0 w=1 l=0.5
X4916 rr2t2r_0[5|17]/a_460_290# WL5 SL17 VSS sky130_fd_pr__nfet_g5v0d10v5 ad=0.65 pd=3.3 as=0 ps=0 w=1 l=0.5
X4917 BLP17 rr2t2r_0[5|17]/a_60_290# sky130_fd_pr_reram__reram_cell area_ox=0.0676
X4918 BLN17 rr2t2r_0[5|17]/a_460_290# sky130_fd_pr_reram__reram_cell area_ox=0.0676
X4919 rr2t2r_0[5|17]/a_60_290# WL5 SL17 VSS sky130_fd_pr__nfet_g5v0d10v5 ad=0.65 pd=3.3 as=0 ps=0 w=1 l=0.5
X4920 rr2t2r_0[6|17]/a_460_290# WL6 SL17 VSS sky130_fd_pr__nfet_g5v0d10v5 ad=0.65 pd=3.3 as=0 ps=0 w=1 l=0.5
X4921 BLP17 rr2t2r_0[6|17]/a_60_290# sky130_fd_pr_reram__reram_cell area_ox=0.0676
X4922 BLN17 rr2t2r_0[6|17]/a_460_290# sky130_fd_pr_reram__reram_cell area_ox=0.0676
X4923 rr2t2r_0[6|17]/a_60_290# WL6 SL17 VSS sky130_fd_pr__nfet_g5v0d10v5 ad=0.65 pd=3.3 as=0 ps=0 w=1 l=0.5
X4924 rr2t2r_0[7|17]/a_460_290# WL7 SL17 VSS sky130_fd_pr__nfet_g5v0d10v5 ad=0.65 pd=3.3 as=0 ps=0 w=1 l=0.5
X4925 BLP17 rr2t2r_0[7|17]/a_60_290# sky130_fd_pr_reram__reram_cell area_ox=0.0676
X4926 BLN17 rr2t2r_0[7|17]/a_460_290# sky130_fd_pr_reram__reram_cell area_ox=0.0676
X4927 rr2t2r_0[7|17]/a_60_290# WL7 SL17 VSS sky130_fd_pr__nfet_g5v0d10v5 ad=0.65 pd=3.3 as=0 ps=0 w=1 l=0.5
X4928 rr2t2r_0[8|17]/a_460_290# WL8 SL17 VSS sky130_fd_pr__nfet_g5v0d10v5 ad=0.65 pd=3.3 as=0 ps=0 w=1 l=0.5
X4929 BLP17 rr2t2r_0[8|17]/a_60_290# sky130_fd_pr_reram__reram_cell area_ox=0.0676
X4930 BLN17 rr2t2r_0[8|17]/a_460_290# sky130_fd_pr_reram__reram_cell area_ox=0.0676
X4931 rr2t2r_0[8|17]/a_60_290# WL8 SL17 VSS sky130_fd_pr__nfet_g5v0d10v5 ad=0.65 pd=3.3 as=0 ps=0 w=1 l=0.5
X4932 rr2t2r_0[9|17]/a_460_290# WL9 SL17 VSS sky130_fd_pr__nfet_g5v0d10v5 ad=0.65 pd=3.3 as=0 ps=0 w=1 l=0.5
X4933 BLP17 rr2t2r_0[9|17]/a_60_290# sky130_fd_pr_reram__reram_cell area_ox=0.0676
X4934 BLN17 rr2t2r_0[9|17]/a_460_290# sky130_fd_pr_reram__reram_cell area_ox=0.0676
X4935 rr2t2r_0[9|17]/a_60_290# WL9 SL17 VSS sky130_fd_pr__nfet_g5v0d10v5 ad=0.65 pd=3.3 as=0 ps=0 w=1 l=0.5
X4936 rr2t2r_0[10|17]/a_460_290# WL10 SL17 VSS sky130_fd_pr__nfet_g5v0d10v5 ad=0.65 pd=3.3 as=0 ps=0 w=1 l=0.5
X4937 BLP17 rr2t2r_0[10|17]/a_60_290# sky130_fd_pr_reram__reram_cell area_ox=0.0676
X4938 BLN17 rr2t2r_0[10|17]/a_460_290# sky130_fd_pr_reram__reram_cell area_ox=0.0676
X4939 rr2t2r_0[10|17]/a_60_290# WL10 SL17 VSS sky130_fd_pr__nfet_g5v0d10v5 ad=0.65 pd=3.3 as=0 ps=0 w=1 l=0.5
X4940 rr2t2r_0[11|17]/a_460_290# WL11 SL17 VSS sky130_fd_pr__nfet_g5v0d10v5 ad=0.65 pd=3.3 as=0 ps=0 w=1 l=0.5
X4941 BLP17 rr2t2r_0[11|17]/a_60_290# sky130_fd_pr_reram__reram_cell area_ox=0.0676
X4942 BLN17 rr2t2r_0[11|17]/a_460_290# sky130_fd_pr_reram__reram_cell area_ox=0.0676
X4943 rr2t2r_0[11|17]/a_60_290# WL11 SL17 VSS sky130_fd_pr__nfet_g5v0d10v5 ad=0.65 pd=3.3 as=0 ps=0 w=1 l=0.5
X4944 rr2t2r_0[12|17]/a_460_290# WL12 SL17 VSS sky130_fd_pr__nfet_g5v0d10v5 ad=0.65 pd=3.3 as=0 ps=0 w=1 l=0.5
X4945 BLP17 rr2t2r_0[12|17]/a_60_290# sky130_fd_pr_reram__reram_cell area_ox=0.0676
X4946 BLN17 rr2t2r_0[12|17]/a_460_290# sky130_fd_pr_reram__reram_cell area_ox=0.0676
X4947 rr2t2r_0[12|17]/a_60_290# WL12 SL17 VSS sky130_fd_pr__nfet_g5v0d10v5 ad=0.65 pd=3.3 as=0 ps=0 w=1 l=0.5
X4948 rr2t2r_0[13|17]/a_460_290# WL13 SL17 VSS sky130_fd_pr__nfet_g5v0d10v5 ad=0.65 pd=3.3 as=0 ps=0 w=1 l=0.5
X4949 BLP17 rr2t2r_0[13|17]/a_60_290# sky130_fd_pr_reram__reram_cell area_ox=0.0676
X4950 BLN17 rr2t2r_0[13|17]/a_460_290# sky130_fd_pr_reram__reram_cell area_ox=0.0676
X4951 rr2t2r_0[13|17]/a_60_290# WL13 SL17 VSS sky130_fd_pr__nfet_g5v0d10v5 ad=0.65 pd=3.3 as=0 ps=0 w=1 l=0.5
X4952 rr2t2r_0[14|17]/a_460_290# WL14 SL17 VSS sky130_fd_pr__nfet_g5v0d10v5 ad=0.65 pd=3.3 as=0 ps=0 w=1 l=0.5
X4953 BLP17 rr2t2r_0[14|17]/a_60_290# sky130_fd_pr_reram__reram_cell area_ox=0.0676
X4954 BLN17 rr2t2r_0[14|17]/a_460_290# sky130_fd_pr_reram__reram_cell area_ox=0.0676
X4955 rr2t2r_0[14|17]/a_60_290# WL14 SL17 VSS sky130_fd_pr__nfet_g5v0d10v5 ad=0.65 pd=3.3 as=0 ps=0 w=1 l=0.5
X4956 rr2t2r_0[15|17]/a_460_290# WL15 SL17 VSS sky130_fd_pr__nfet_g5v0d10v5 ad=0.65 pd=3.3 as=0 ps=0 w=1 l=0.5
X4957 BLP17 rr2t2r_0[15|17]/a_60_290# sky130_fd_pr_reram__reram_cell area_ox=0.0676
X4958 BLN17 rr2t2r_0[15|17]/a_460_290# sky130_fd_pr_reram__reram_cell area_ox=0.0676
X4959 rr2t2r_0[15|17]/a_60_290# WL15 SL17 VSS sky130_fd_pr__nfet_g5v0d10v5 ad=0.65 pd=3.3 as=0 ps=0 w=1 l=0.5
X4960 rr2t2r_0[16|17]/a_460_290# WL16 SL17 VSS sky130_fd_pr__nfet_g5v0d10v5 ad=0.65 pd=3.3 as=0 ps=0 w=1 l=0.5
X4961 BLP17 rr2t2r_0[16|17]/a_60_290# sky130_fd_pr_reram__reram_cell area_ox=0.0676
X4962 BLN17 rr2t2r_0[16|17]/a_460_290# sky130_fd_pr_reram__reram_cell area_ox=0.0676
X4963 rr2t2r_0[16|17]/a_60_290# WL16 SL17 VSS sky130_fd_pr__nfet_g5v0d10v5 ad=0.65 pd=3.3 as=0 ps=0 w=1 l=0.5
X4964 rr2t2r_0[17|17]/a_460_290# WL17 SL17 VSS sky130_fd_pr__nfet_g5v0d10v5 ad=0.65 pd=3.3 as=0 ps=0 w=1 l=0.5
X4965 BLP17 rr2t2r_0[17|17]/a_60_290# sky130_fd_pr_reram__reram_cell area_ox=0.0676
X4966 BLN17 rr2t2r_0[17|17]/a_460_290# sky130_fd_pr_reram__reram_cell area_ox=0.0676
X4967 rr2t2r_0[17|17]/a_60_290# WL17 SL17 VSS sky130_fd_pr__nfet_g5v0d10v5 ad=0.65 pd=3.3 as=0 ps=0 w=1 l=0.5
X4968 rr2t2r_0[18|17]/a_460_290# WL18 SL17 VSS sky130_fd_pr__nfet_g5v0d10v5 ad=0.65 pd=3.3 as=0 ps=0 w=1 l=0.5
X4969 BLP17 rr2t2r_0[18|17]/a_60_290# sky130_fd_pr_reram__reram_cell area_ox=0.0676
X4970 BLN17 rr2t2r_0[18|17]/a_460_290# sky130_fd_pr_reram__reram_cell area_ox=0.0676
X4971 rr2t2r_0[18|17]/a_60_290# WL18 SL17 VSS sky130_fd_pr__nfet_g5v0d10v5 ad=0.65 pd=3.3 as=0 ps=0 w=1 l=0.5
X4972 rr2t2r_0[19|17]/a_460_290# WL19 SL17 VSS sky130_fd_pr__nfet_g5v0d10v5 ad=0.65 pd=3.3 as=0 ps=0 w=1 l=0.5
X4973 BLP17 rr2t2r_0[19|17]/a_60_290# sky130_fd_pr_reram__reram_cell area_ox=0.0676
X4974 BLN17 rr2t2r_0[19|17]/a_460_290# sky130_fd_pr_reram__reram_cell area_ox=0.0676
X4975 rr2t2r_0[19|17]/a_60_290# WL19 SL17 VSS sky130_fd_pr__nfet_g5v0d10v5 ad=0.65 pd=3.3 as=0 ps=0 w=1 l=0.5
X4976 rr2t2r_0[20|17]/a_460_290# WL20 SL17 VSS sky130_fd_pr__nfet_g5v0d10v5 ad=0.65 pd=3.3 as=0 ps=0 w=1 l=0.5
X4977 BLP17 rr2t2r_0[20|17]/a_60_290# sky130_fd_pr_reram__reram_cell area_ox=0.0676
X4978 BLN17 rr2t2r_0[20|17]/a_460_290# sky130_fd_pr_reram__reram_cell area_ox=0.0676
X4979 rr2t2r_0[20|17]/a_60_290# WL20 SL17 VSS sky130_fd_pr__nfet_g5v0d10v5 ad=0.65 pd=3.3 as=0 ps=0 w=1 l=0.5
X4980 rr2t2r_0[21|17]/a_460_290# WL21 SL17 VSS sky130_fd_pr__nfet_g5v0d10v5 ad=0.65 pd=3.3 as=0 ps=0 w=1 l=0.5
X4981 BLP17 rr2t2r_0[21|17]/a_60_290# sky130_fd_pr_reram__reram_cell area_ox=0.0676
X4982 BLN17 rr2t2r_0[21|17]/a_460_290# sky130_fd_pr_reram__reram_cell area_ox=0.0676
X4983 rr2t2r_0[21|17]/a_60_290# WL21 SL17 VSS sky130_fd_pr__nfet_g5v0d10v5 ad=0.65 pd=3.3 as=0 ps=0 w=1 l=0.5
X4984 rr2t2r_0[22|17]/a_460_290# WL22 SL17 VSS sky130_fd_pr__nfet_g5v0d10v5 ad=0.65 pd=3.3 as=0 ps=0 w=1 l=0.5
X4985 BLP17 rr2t2r_0[22|17]/a_60_290# sky130_fd_pr_reram__reram_cell area_ox=0.0676
X4986 BLN17 rr2t2r_0[22|17]/a_460_290# sky130_fd_pr_reram__reram_cell area_ox=0.0676
X4987 rr2t2r_0[22|17]/a_60_290# WL22 SL17 VSS sky130_fd_pr__nfet_g5v0d10v5 ad=0.65 pd=3.3 as=0 ps=0 w=1 l=0.5
X4988 rr2t2r_0[23|17]/a_460_290# WL23 SL17 VSS sky130_fd_pr__nfet_g5v0d10v5 ad=0.65 pd=3.3 as=0 ps=0 w=1 l=0.5
X4989 BLP17 rr2t2r_0[23|17]/a_60_290# sky130_fd_pr_reram__reram_cell area_ox=0.0676
X4990 BLN17 rr2t2r_0[23|17]/a_460_290# sky130_fd_pr_reram__reram_cell area_ox=0.0676
X4991 rr2t2r_0[23|17]/a_60_290# WL23 SL17 VSS sky130_fd_pr__nfet_g5v0d10v5 ad=0.65 pd=3.3 as=0 ps=0 w=1 l=0.5
X4992 rr2t2r_0[24|17]/a_460_290# WL24 SL17 VSS sky130_fd_pr__nfet_g5v0d10v5 ad=0.65 pd=3.3 as=0 ps=0 w=1 l=0.5
X4993 BLP17 rr2t2r_0[24|17]/a_60_290# sky130_fd_pr_reram__reram_cell area_ox=0.0676
X4994 BLN17 rr2t2r_0[24|17]/a_460_290# sky130_fd_pr_reram__reram_cell area_ox=0.0676
X4995 rr2t2r_0[24|17]/a_60_290# WL24 SL17 VSS sky130_fd_pr__nfet_g5v0d10v5 ad=0.65 pd=3.3 as=0 ps=0 w=1 l=0.5
X4996 rr2t2r_0[25|17]/a_460_290# WL25 SL17 VSS sky130_fd_pr__nfet_g5v0d10v5 ad=0.65 pd=3.3 as=0 ps=0 w=1 l=0.5
X4997 BLP17 rr2t2r_0[25|17]/a_60_290# sky130_fd_pr_reram__reram_cell area_ox=0.0676
X4998 BLN17 rr2t2r_0[25|17]/a_460_290# sky130_fd_pr_reram__reram_cell area_ox=0.0676
X4999 rr2t2r_0[25|17]/a_60_290# WL25 SL17 VSS sky130_fd_pr__nfet_g5v0d10v5 ad=0.65 pd=3.3 as=0 ps=0 w=1 l=0.5
X5000 rr2t2r_0[26|17]/a_460_290# WL26 SL17 VSS sky130_fd_pr__nfet_g5v0d10v5 ad=0.65 pd=3.3 as=0 ps=0 w=1 l=0.5
X5001 BLP17 rr2t2r_0[26|17]/a_60_290# sky130_fd_pr_reram__reram_cell area_ox=0.0676
X5002 BLN17 rr2t2r_0[26|17]/a_460_290# sky130_fd_pr_reram__reram_cell area_ox=0.0676
X5003 rr2t2r_0[26|17]/a_60_290# WL26 SL17 VSS sky130_fd_pr__nfet_g5v0d10v5 ad=0.65 pd=3.3 as=0 ps=0 w=1 l=0.5
X5004 rr2t2r_0[27|17]/a_460_290# WL27 SL17 VSS sky130_fd_pr__nfet_g5v0d10v5 ad=0.65 pd=3.3 as=0 ps=0 w=1 l=0.5
X5005 BLP17 rr2t2r_0[27|17]/a_60_290# sky130_fd_pr_reram__reram_cell area_ox=0.0676
X5006 BLN17 rr2t2r_0[27|17]/a_460_290# sky130_fd_pr_reram__reram_cell area_ox=0.0676
X5007 rr2t2r_0[27|17]/a_60_290# WL27 SL17 VSS sky130_fd_pr__nfet_g5v0d10v5 ad=0.65 pd=3.3 as=0 ps=0 w=1 l=0.5
X5008 rr2t2r_0[28|17]/a_460_290# WL28 SL17 VSS sky130_fd_pr__nfet_g5v0d10v5 ad=0.65 pd=3.3 as=0 ps=0 w=1 l=0.5
X5009 BLP17 rr2t2r_0[28|17]/a_60_290# sky130_fd_pr_reram__reram_cell area_ox=0.0676
X5010 BLN17 rr2t2r_0[28|17]/a_460_290# sky130_fd_pr_reram__reram_cell area_ox=0.0676
X5011 rr2t2r_0[28|17]/a_60_290# WL28 SL17 VSS sky130_fd_pr__nfet_g5v0d10v5 ad=0.65 pd=3.3 as=0 ps=0 w=1 l=0.5
X5012 rr2t2r_0[29|17]/a_460_290# WL29 SL17 VSS sky130_fd_pr__nfet_g5v0d10v5 ad=0.65 pd=3.3 as=0 ps=0 w=1 l=0.5
X5013 BLP17 rr2t2r_0[29|17]/a_60_290# sky130_fd_pr_reram__reram_cell area_ox=0.0676
X5014 BLN17 rr2t2r_0[29|17]/a_460_290# sky130_fd_pr_reram__reram_cell area_ox=0.0676
X5015 rr2t2r_0[29|17]/a_60_290# WL29 SL17 VSS sky130_fd_pr__nfet_g5v0d10v5 ad=0.65 pd=3.3 as=0 ps=0 w=1 l=0.5
X5016 rr2t2r_0[30|17]/a_460_290# WL30 SL17 VSS sky130_fd_pr__nfet_g5v0d10v5 ad=0.65 pd=3.3 as=0 ps=0 w=1 l=0.5
X5017 BLP17 rr2t2r_0[30|17]/a_60_290# sky130_fd_pr_reram__reram_cell area_ox=0.0676
X5018 BLN17 rr2t2r_0[30|17]/a_460_290# sky130_fd_pr_reram__reram_cell area_ox=0.0676
X5019 rr2t2r_0[30|17]/a_60_290# WL30 SL17 VSS sky130_fd_pr__nfet_g5v0d10v5 ad=0.65 pd=3.3 as=0 ps=0 w=1 l=0.5
X5020 rr2t2r_0[31|17]/a_460_290# WL31 SL17 VSS sky130_fd_pr__nfet_g5v0d10v5 ad=0.65 pd=3.3 as=0 ps=0 w=1 l=0.5
X5021 BLP17 rr2t2r_0[31|17]/a_60_290# sky130_fd_pr_reram__reram_cell area_ox=0.0676
X5022 BLN17 rr2t2r_0[31|17]/a_460_290# sky130_fd_pr_reram__reram_cell area_ox=0.0676
X5023 rr2t2r_0[31|17]/a_60_290# WL31 SL17 VSS sky130_fd_pr__nfet_g5v0d10v5 ad=0.65 pd=3.3 as=0 ps=0 w=1 l=0.5
X5024 rr2t2r_0[32|17]/a_460_290# WL32 SL17 VSS sky130_fd_pr__nfet_g5v0d10v5 ad=0.65 pd=3.3 as=0 ps=0 w=1 l=0.5
X5025 BLP17 rr2t2r_0[32|17]/a_60_290# sky130_fd_pr_reram__reram_cell area_ox=0.0676
X5026 BLN17 rr2t2r_0[32|17]/a_460_290# sky130_fd_pr_reram__reram_cell area_ox=0.0676
X5027 rr2t2r_0[32|17]/a_60_290# WL32 SL17 VSS sky130_fd_pr__nfet_g5v0d10v5 ad=0.65 pd=3.3 as=0 ps=0 w=1 l=0.5
X5028 rr2t2r_0[33|17]/a_460_290# WL33 SL17 VSS sky130_fd_pr__nfet_g5v0d10v5 ad=0.65 pd=3.3 as=0 ps=0 w=1 l=0.5
X5029 BLP17 rr2t2r_0[33|17]/a_60_290# sky130_fd_pr_reram__reram_cell area_ox=0.0676
X5030 BLN17 rr2t2r_0[33|17]/a_460_290# sky130_fd_pr_reram__reram_cell area_ox=0.0676
X5031 rr2t2r_0[33|17]/a_60_290# WL33 SL17 VSS sky130_fd_pr__nfet_g5v0d10v5 ad=0.65 pd=3.3 as=0 ps=0 w=1 l=0.5
X5032 rr2t2r_0[34|17]/a_460_290# WL34 SL17 VSS sky130_fd_pr__nfet_g5v0d10v5 ad=0.65 pd=3.3 as=0 ps=0 w=1 l=0.5
X5033 BLP17 rr2t2r_0[34|17]/a_60_290# sky130_fd_pr_reram__reram_cell area_ox=0.0676
X5034 BLN17 rr2t2r_0[34|17]/a_460_290# sky130_fd_pr_reram__reram_cell area_ox=0.0676
X5035 rr2t2r_0[34|17]/a_60_290# WL34 SL17 VSS sky130_fd_pr__nfet_g5v0d10v5 ad=0.65 pd=3.3 as=0 ps=0 w=1 l=0.5
X5036 rr2t2r_0[35|17]/a_460_290# WL35 SL17 VSS sky130_fd_pr__nfet_g5v0d10v5 ad=0.65 pd=3.3 as=0 ps=0 w=1 l=0.5
X5037 BLP17 rr2t2r_0[35|17]/a_60_290# sky130_fd_pr_reram__reram_cell area_ox=0.0676
X5038 BLN17 rr2t2r_0[35|17]/a_460_290# sky130_fd_pr_reram__reram_cell area_ox=0.0676
X5039 rr2t2r_0[35|17]/a_60_290# WL35 SL17 VSS sky130_fd_pr__nfet_g5v0d10v5 ad=0.65 pd=3.3 as=0 ps=0 w=1 l=0.5
X5040 rr2t2r_0[36|17]/a_460_290# WL36 SL17 VSS sky130_fd_pr__nfet_g5v0d10v5 ad=0.65 pd=3.3 as=0 ps=0 w=1 l=0.5
X5041 BLP17 rr2t2r_0[36|17]/a_60_290# sky130_fd_pr_reram__reram_cell area_ox=0.0676
X5042 BLN17 rr2t2r_0[36|17]/a_460_290# sky130_fd_pr_reram__reram_cell area_ox=0.0676
X5043 rr2t2r_0[36|17]/a_60_290# WL36 SL17 VSS sky130_fd_pr__nfet_g5v0d10v5 ad=0.65 pd=3.3 as=0 ps=0 w=1 l=0.5
X5044 rr2t2r_0[37|17]/a_460_290# WL37 SL17 VSS sky130_fd_pr__nfet_g5v0d10v5 ad=0.65 pd=3.3 as=0 ps=0 w=1 l=0.5
X5045 BLP17 rr2t2r_0[37|17]/a_60_290# sky130_fd_pr_reram__reram_cell area_ox=0.0676
X5046 BLN17 rr2t2r_0[37|17]/a_460_290# sky130_fd_pr_reram__reram_cell area_ox=0.0676
X5047 rr2t2r_0[37|17]/a_60_290# WL37 SL17 VSS sky130_fd_pr__nfet_g5v0d10v5 ad=0.65 pd=3.3 as=0 ps=0 w=1 l=0.5
X5048 rr2t2r_0[38|17]/a_460_290# WL38 SL17 VSS sky130_fd_pr__nfet_g5v0d10v5 ad=0.65 pd=3.3 as=0 ps=0 w=1 l=0.5
X5049 BLP17 rr2t2r_0[38|17]/a_60_290# sky130_fd_pr_reram__reram_cell area_ox=0.0676
X5050 BLN17 rr2t2r_0[38|17]/a_460_290# sky130_fd_pr_reram__reram_cell area_ox=0.0676
X5051 rr2t2r_0[38|17]/a_60_290# WL38 SL17 VSS sky130_fd_pr__nfet_g5v0d10v5 ad=0.65 pd=3.3 as=0 ps=0 w=1 l=0.5
X5052 rr2t2r_0[39|17]/a_460_290# WL39 SL17 VSS sky130_fd_pr__nfet_g5v0d10v5 ad=0.65 pd=3.3 as=0 ps=0 w=1 l=0.5
X5053 BLP17 rr2t2r_0[39|17]/a_60_290# sky130_fd_pr_reram__reram_cell area_ox=0.0676
X5054 BLN17 rr2t2r_0[39|17]/a_460_290# sky130_fd_pr_reram__reram_cell area_ox=0.0676
X5055 rr2t2r_0[39|17]/a_60_290# WL39 SL17 VSS sky130_fd_pr__nfet_g5v0d10v5 ad=0.65 pd=3.3 as=0 ps=0 w=1 l=0.5
X5056 rr2t2r_0[40|17]/a_460_290# WL40 SL17 VSS sky130_fd_pr__nfet_g5v0d10v5 ad=0.65 pd=3.3 as=0 ps=0 w=1 l=0.5
X5057 BLP17 rr2t2r_0[40|17]/a_60_290# sky130_fd_pr_reram__reram_cell area_ox=0.0676
X5058 BLN17 rr2t2r_0[40|17]/a_460_290# sky130_fd_pr_reram__reram_cell area_ox=0.0676
X5059 rr2t2r_0[40|17]/a_60_290# WL40 SL17 VSS sky130_fd_pr__nfet_g5v0d10v5 ad=0.65 pd=3.3 as=0 ps=0 w=1 l=0.5
X5060 rr2t2r_0[41|17]/a_460_290# WL41 SL17 VSS sky130_fd_pr__nfet_g5v0d10v5 ad=0.65 pd=3.3 as=0 ps=0 w=1 l=0.5
X5061 BLP17 rr2t2r_0[41|17]/a_60_290# sky130_fd_pr_reram__reram_cell area_ox=0.0676
X5062 BLN17 rr2t2r_0[41|17]/a_460_290# sky130_fd_pr_reram__reram_cell area_ox=0.0676
X5063 rr2t2r_0[41|17]/a_60_290# WL41 SL17 VSS sky130_fd_pr__nfet_g5v0d10v5 ad=0.65 pd=3.3 as=0 ps=0 w=1 l=0.5
X5064 rr2t2r_0[42|17]/a_460_290# WL42 SL17 VSS sky130_fd_pr__nfet_g5v0d10v5 ad=0.65 pd=3.3 as=0 ps=0 w=1 l=0.5
X5065 BLP17 rr2t2r_0[42|17]/a_60_290# sky130_fd_pr_reram__reram_cell area_ox=0.0676
X5066 BLN17 rr2t2r_0[42|17]/a_460_290# sky130_fd_pr_reram__reram_cell area_ox=0.0676
X5067 rr2t2r_0[42|17]/a_60_290# WL42 SL17 VSS sky130_fd_pr__nfet_g5v0d10v5 ad=0.65 pd=3.3 as=0 ps=0 w=1 l=0.5
X5068 rr2t2r_0[43|17]/a_460_290# WL43 SL17 VSS sky130_fd_pr__nfet_g5v0d10v5 ad=0.65 pd=3.3 as=0 ps=0 w=1 l=0.5
X5069 BLP17 rr2t2r_0[43|17]/a_60_290# sky130_fd_pr_reram__reram_cell area_ox=0.0676
X5070 BLN17 rr2t2r_0[43|17]/a_460_290# sky130_fd_pr_reram__reram_cell area_ox=0.0676
X5071 rr2t2r_0[43|17]/a_60_290# WL43 SL17 VSS sky130_fd_pr__nfet_g5v0d10v5 ad=0.65 pd=3.3 as=0 ps=0 w=1 l=0.5
X5072 rr2t2r_0[44|17]/a_460_290# WL44 SL17 VSS sky130_fd_pr__nfet_g5v0d10v5 ad=0.65 pd=3.3 as=0 ps=0 w=1 l=0.5
X5073 BLP17 rr2t2r_0[44|17]/a_60_290# sky130_fd_pr_reram__reram_cell area_ox=0.0676
X5074 BLN17 rr2t2r_0[44|17]/a_460_290# sky130_fd_pr_reram__reram_cell area_ox=0.0676
X5075 rr2t2r_0[44|17]/a_60_290# WL44 SL17 VSS sky130_fd_pr__nfet_g5v0d10v5 ad=0.65 pd=3.3 as=0 ps=0 w=1 l=0.5
X5076 rr2t2r_0[45|17]/a_460_290# WL45 SL17 VSS sky130_fd_pr__nfet_g5v0d10v5 ad=0.65 pd=3.3 as=0 ps=0 w=1 l=0.5
X5077 BLP17 rr2t2r_0[45|17]/a_60_290# sky130_fd_pr_reram__reram_cell area_ox=0.0676
X5078 BLN17 rr2t2r_0[45|17]/a_460_290# sky130_fd_pr_reram__reram_cell area_ox=0.0676
X5079 rr2t2r_0[45|17]/a_60_290# WL45 SL17 VSS sky130_fd_pr__nfet_g5v0d10v5 ad=0.65 pd=3.3 as=0 ps=0 w=1 l=0.5
X5080 rr2t2r_0[46|17]/a_460_290# WL46 SL17 VSS sky130_fd_pr__nfet_g5v0d10v5 ad=0.65 pd=3.3 as=0 ps=0 w=1 l=0.5
X5081 BLP17 rr2t2r_0[46|17]/a_60_290# sky130_fd_pr_reram__reram_cell area_ox=0.0676
X5082 BLN17 rr2t2r_0[46|17]/a_460_290# sky130_fd_pr_reram__reram_cell area_ox=0.0676
X5083 rr2t2r_0[46|17]/a_60_290# WL46 SL17 VSS sky130_fd_pr__nfet_g5v0d10v5 ad=0.65 pd=3.3 as=0 ps=0 w=1 l=0.5
X5084 rr2t2r_0[47|17]/a_460_290# WL47 SL17 VSS sky130_fd_pr__nfet_g5v0d10v5 ad=0.65 pd=3.3 as=0 ps=0 w=1 l=0.5
X5085 BLP17 rr2t2r_0[47|17]/a_60_290# sky130_fd_pr_reram__reram_cell area_ox=0.0676
X5086 BLN17 rr2t2r_0[47|17]/a_460_290# sky130_fd_pr_reram__reram_cell area_ox=0.0676
X5087 rr2t2r_0[47|17]/a_60_290# WL47 SL17 VSS sky130_fd_pr__nfet_g5v0d10v5 ad=0.65 pd=3.3 as=0 ps=0 w=1 l=0.5
X5088 rr2t2r_0[48|17]/a_460_290# WL48 SL17 VSS sky130_fd_pr__nfet_g5v0d10v5 ad=0.65 pd=3.3 as=0 ps=0 w=1 l=0.5
X5089 BLP17 rr2t2r_0[48|17]/a_60_290# sky130_fd_pr_reram__reram_cell area_ox=0.0676
X5090 BLN17 rr2t2r_0[48|17]/a_460_290# sky130_fd_pr_reram__reram_cell area_ox=0.0676
X5091 rr2t2r_0[48|17]/a_60_290# WL48 SL17 VSS sky130_fd_pr__nfet_g5v0d10v5 ad=0.65 pd=3.3 as=0 ps=0 w=1 l=0.5
X5092 rr2t2r_0[49|17]/a_460_290# WL49 SL17 VSS sky130_fd_pr__nfet_g5v0d10v5 ad=0.65 pd=3.3 as=0 ps=0 w=1 l=0.5
X5093 BLP17 rr2t2r_0[49|17]/a_60_290# sky130_fd_pr_reram__reram_cell area_ox=0.0676
X5094 BLN17 rr2t2r_0[49|17]/a_460_290# sky130_fd_pr_reram__reram_cell area_ox=0.0676
X5095 rr2t2r_0[49|17]/a_60_290# WL49 SL17 VSS sky130_fd_pr__nfet_g5v0d10v5 ad=0.65 pd=3.3 as=0 ps=0 w=1 l=0.5
X5096 rr2t2r_0[50|17]/a_460_290# WL50 SL17 VSS sky130_fd_pr__nfet_g5v0d10v5 ad=0.65 pd=3.3 as=0 ps=0 w=1 l=0.5
X5097 BLP17 rr2t2r_0[50|17]/a_60_290# sky130_fd_pr_reram__reram_cell area_ox=0.0676
X5098 BLN17 rr2t2r_0[50|17]/a_460_290# sky130_fd_pr_reram__reram_cell area_ox=0.0676
X5099 rr2t2r_0[50|17]/a_60_290# WL50 SL17 VSS sky130_fd_pr__nfet_g5v0d10v5 ad=0.65 pd=3.3 as=0 ps=0 w=1 l=0.5
X5100 rr2t2r_0[51|17]/a_460_290# WL51 SL17 VSS sky130_fd_pr__nfet_g5v0d10v5 ad=0.65 pd=3.3 as=0 ps=0 w=1 l=0.5
X5101 BLP17 rr2t2r_0[51|17]/a_60_290# sky130_fd_pr_reram__reram_cell area_ox=0.0676
X5102 BLN17 rr2t2r_0[51|17]/a_460_290# sky130_fd_pr_reram__reram_cell area_ox=0.0676
X5103 rr2t2r_0[51|17]/a_60_290# WL51 SL17 VSS sky130_fd_pr__nfet_g5v0d10v5 ad=0.65 pd=3.3 as=0 ps=0 w=1 l=0.5
X5104 rr2t2r_0[52|17]/a_460_290# WL52 SL17 VSS sky130_fd_pr__nfet_g5v0d10v5 ad=0.65 pd=3.3 as=0 ps=0 w=1 l=0.5
X5105 BLP17 rr2t2r_0[52|17]/a_60_290# sky130_fd_pr_reram__reram_cell area_ox=0.0676
X5106 BLN17 rr2t2r_0[52|17]/a_460_290# sky130_fd_pr_reram__reram_cell area_ox=0.0676
X5107 rr2t2r_0[52|17]/a_60_290# WL52 SL17 VSS sky130_fd_pr__nfet_g5v0d10v5 ad=0.65 pd=3.3 as=0 ps=0 w=1 l=0.5
X5108 rr2t2r_0[53|17]/a_460_290# WL53 SL17 VSS sky130_fd_pr__nfet_g5v0d10v5 ad=0.65 pd=3.3 as=0 ps=0 w=1 l=0.5
X5109 BLP17 rr2t2r_0[53|17]/a_60_290# sky130_fd_pr_reram__reram_cell area_ox=0.0676
X5110 BLN17 rr2t2r_0[53|17]/a_460_290# sky130_fd_pr_reram__reram_cell area_ox=0.0676
X5111 rr2t2r_0[53|17]/a_60_290# WL53 SL17 VSS sky130_fd_pr__nfet_g5v0d10v5 ad=0.65 pd=3.3 as=0 ps=0 w=1 l=0.5
X5112 rr2t2r_0[54|17]/a_460_290# WL54 SL17 VSS sky130_fd_pr__nfet_g5v0d10v5 ad=0.65 pd=3.3 as=0 ps=0 w=1 l=0.5
X5113 BLP17 rr2t2r_0[54|17]/a_60_290# sky130_fd_pr_reram__reram_cell area_ox=0.0676
X5114 BLN17 rr2t2r_0[54|17]/a_460_290# sky130_fd_pr_reram__reram_cell area_ox=0.0676
X5115 rr2t2r_0[54|17]/a_60_290# WL54 SL17 VSS sky130_fd_pr__nfet_g5v0d10v5 ad=0.65 pd=3.3 as=0 ps=0 w=1 l=0.5
X5116 rr2t2r_0[55|17]/a_460_290# WL55 SL17 VSS sky130_fd_pr__nfet_g5v0d10v5 ad=0.65 pd=3.3 as=0 ps=0 w=1 l=0.5
X5117 BLP17 rr2t2r_0[55|17]/a_60_290# sky130_fd_pr_reram__reram_cell area_ox=0.0676
X5118 BLN17 rr2t2r_0[55|17]/a_460_290# sky130_fd_pr_reram__reram_cell area_ox=0.0676
X5119 rr2t2r_0[55|17]/a_60_290# WL55 SL17 VSS sky130_fd_pr__nfet_g5v0d10v5 ad=0.65 pd=3.3 as=0 ps=0 w=1 l=0.5
X5120 rr2t2r_0[56|17]/a_460_290# WL56 SL17 VSS sky130_fd_pr__nfet_g5v0d10v5 ad=0.65 pd=3.3 as=0 ps=0 w=1 l=0.5
X5121 BLP17 rr2t2r_0[56|17]/a_60_290# sky130_fd_pr_reram__reram_cell area_ox=0.0676
X5122 BLN17 rr2t2r_0[56|17]/a_460_290# sky130_fd_pr_reram__reram_cell area_ox=0.0676
X5123 rr2t2r_0[56|17]/a_60_290# WL56 SL17 VSS sky130_fd_pr__nfet_g5v0d10v5 ad=0.65 pd=3.3 as=0 ps=0 w=1 l=0.5
X5124 rr2t2r_0[57|17]/a_460_290# WL57 SL17 VSS sky130_fd_pr__nfet_g5v0d10v5 ad=0.65 pd=3.3 as=0 ps=0 w=1 l=0.5
X5125 BLP17 rr2t2r_0[57|17]/a_60_290# sky130_fd_pr_reram__reram_cell area_ox=0.0676
X5126 BLN17 rr2t2r_0[57|17]/a_460_290# sky130_fd_pr_reram__reram_cell area_ox=0.0676
X5127 rr2t2r_0[57|17]/a_60_290# WL57 SL17 VSS sky130_fd_pr__nfet_g5v0d10v5 ad=0.65 pd=3.3 as=0 ps=0 w=1 l=0.5
X5128 rr2t2r_0[58|17]/a_460_290# WL58 SL17 VSS sky130_fd_pr__nfet_g5v0d10v5 ad=0.65 pd=3.3 as=0 ps=0 w=1 l=0.5
X5129 BLP17 rr2t2r_0[58|17]/a_60_290# sky130_fd_pr_reram__reram_cell area_ox=0.0676
X5130 BLN17 rr2t2r_0[58|17]/a_460_290# sky130_fd_pr_reram__reram_cell area_ox=0.0676
X5131 rr2t2r_0[58|17]/a_60_290# WL58 SL17 VSS sky130_fd_pr__nfet_g5v0d10v5 ad=0.65 pd=3.3 as=0 ps=0 w=1 l=0.5
X5132 rr2t2r_0[59|17]/a_460_290# WL59 SL17 VSS sky130_fd_pr__nfet_g5v0d10v5 ad=0.65 pd=3.3 as=0 ps=0 w=1 l=0.5
X5133 BLP17 rr2t2r_0[59|17]/a_60_290# sky130_fd_pr_reram__reram_cell area_ox=0.0676
X5134 BLN17 rr2t2r_0[59|17]/a_460_290# sky130_fd_pr_reram__reram_cell area_ox=0.0676
X5135 rr2t2r_0[59|17]/a_60_290# WL59 SL17 VSS sky130_fd_pr__nfet_g5v0d10v5 ad=0.65 pd=3.3 as=0 ps=0 w=1 l=0.5
X5136 rr2t2r_0[60|17]/a_460_290# WL60 SL17 VSS sky130_fd_pr__nfet_g5v0d10v5 ad=0.65 pd=3.3 as=0 ps=0 w=1 l=0.5
X5137 BLP17 rr2t2r_0[60|17]/a_60_290# sky130_fd_pr_reram__reram_cell area_ox=0.0676
X5138 BLN17 rr2t2r_0[60|17]/a_460_290# sky130_fd_pr_reram__reram_cell area_ox=0.0676
X5139 rr2t2r_0[60|17]/a_60_290# WL60 SL17 VSS sky130_fd_pr__nfet_g5v0d10v5 ad=0.65 pd=3.3 as=0 ps=0 w=1 l=0.5
X5140 rr2t2r_0[61|17]/a_460_290# WL61 SL17 VSS sky130_fd_pr__nfet_g5v0d10v5 ad=0.65 pd=3.3 as=0 ps=0 w=1 l=0.5
X5141 BLP17 rr2t2r_0[61|17]/a_60_290# sky130_fd_pr_reram__reram_cell area_ox=0.0676
X5142 BLN17 rr2t2r_0[61|17]/a_460_290# sky130_fd_pr_reram__reram_cell area_ox=0.0676
X5143 rr2t2r_0[61|17]/a_60_290# WL61 SL17 VSS sky130_fd_pr__nfet_g5v0d10v5 ad=0.65 pd=3.3 as=0 ps=0 w=1 l=0.5
X5144 rr2t2r_0[62|17]/a_460_290# WL62 SL17 VSS sky130_fd_pr__nfet_g5v0d10v5 ad=0.65 pd=3.3 as=0 ps=0 w=1 l=0.5
X5145 BLP17 rr2t2r_0[62|17]/a_60_290# sky130_fd_pr_reram__reram_cell area_ox=0.0676
X5146 BLN17 rr2t2r_0[62|17]/a_460_290# sky130_fd_pr_reram__reram_cell area_ox=0.0676
X5147 rr2t2r_0[62|17]/a_60_290# WL62 SL17 VSS sky130_fd_pr__nfet_g5v0d10v5 ad=0.65 pd=3.3 as=0 ps=0 w=1 l=0.5
X5148 rr2t2r_0[63|17]/a_460_290# WL63 SL17 VSS sky130_fd_pr__nfet_g5v0d10v5 ad=0.65 pd=3.3 as=0 ps=0 w=1 l=0.5
X5149 BLP17 rr2t2r_0[63|17]/a_60_290# sky130_fd_pr_reram__reram_cell area_ox=0.0676
X5150 BLN17 rr2t2r_0[63|17]/a_460_290# sky130_fd_pr_reram__reram_cell area_ox=0.0676
X5151 rr2t2r_0[63|17]/a_60_290# WL63 SL17 VSS sky130_fd_pr__nfet_g5v0d10v5 ad=0.65 pd=3.3 as=0 ps=0 w=1 l=0.5
X5152 rr2t2r_0[64|17]/a_460_290# WL64 SL17 VSS sky130_fd_pr__nfet_g5v0d10v5 ad=0.65 pd=3.3 as=0 ps=0 w=1 l=0.5
X5153 BLP17 rr2t2r_0[64|17]/a_60_290# sky130_fd_pr_reram__reram_cell area_ox=0.0676
X5154 BLN17 rr2t2r_0[64|17]/a_460_290# sky130_fd_pr_reram__reram_cell area_ox=0.0676
X5155 rr2t2r_0[64|17]/a_60_290# WL64 SL17 VSS sky130_fd_pr__nfet_g5v0d10v5 ad=0.65 pd=3.3 as=0 ps=0 w=1 l=0.5
X5156 rr2t2r_0[65|17]/a_460_290# WL65 SL17 VSS sky130_fd_pr__nfet_g5v0d10v5 ad=0.65 pd=3.3 as=0 ps=0 w=1 l=0.5
X5157 BLP17 rr2t2r_0[65|17]/a_60_290# sky130_fd_pr_reram__reram_cell area_ox=0.0676
X5158 BLN17 rr2t2r_0[65|17]/a_460_290# sky130_fd_pr_reram__reram_cell area_ox=0.0676
X5159 rr2t2r_0[65|17]/a_60_290# WL65 SL17 VSS sky130_fd_pr__nfet_g5v0d10v5 ad=0.65 pd=3.3 as=0 ps=0 w=1 l=0.5
X5160 rr2t2r_0[66|17]/a_460_290# WL66 SL17 VSS sky130_fd_pr__nfet_g5v0d10v5 ad=0.65 pd=3.3 as=0 ps=0 w=1 l=0.5
X5161 BLP17 rr2t2r_0[66|17]/a_60_290# sky130_fd_pr_reram__reram_cell area_ox=0.0676
X5162 BLN17 rr2t2r_0[66|17]/a_460_290# sky130_fd_pr_reram__reram_cell area_ox=0.0676
X5163 rr2t2r_0[66|17]/a_60_290# WL66 SL17 VSS sky130_fd_pr__nfet_g5v0d10v5 ad=0.65 pd=3.3 as=0 ps=0 w=1 l=0.5
X5164 rr2t2r_0[67|17]/a_460_290# WL67 SL17 VSS sky130_fd_pr__nfet_g5v0d10v5 ad=0.65 pd=3.3 as=0 ps=0 w=1 l=0.5
X5165 BLP17 rr2t2r_0[67|17]/a_60_290# sky130_fd_pr_reram__reram_cell area_ox=0.0676
X5166 BLN17 rr2t2r_0[67|17]/a_460_290# sky130_fd_pr_reram__reram_cell area_ox=0.0676
X5167 rr2t2r_0[67|17]/a_60_290# WL67 SL17 VSS sky130_fd_pr__nfet_g5v0d10v5 ad=0.65 pd=3.3 as=0 ps=0 w=1 l=0.5
X5168 rr2t2r_0[68|17]/a_460_290# WL68 SL17 VSS sky130_fd_pr__nfet_g5v0d10v5 ad=0.65 pd=3.3 as=0 ps=0 w=1 l=0.5
X5169 BLP17 rr2t2r_0[68|17]/a_60_290# sky130_fd_pr_reram__reram_cell area_ox=0.0676
X5170 BLN17 rr2t2r_0[68|17]/a_460_290# sky130_fd_pr_reram__reram_cell area_ox=0.0676
X5171 rr2t2r_0[68|17]/a_60_290# WL68 SL17 VSS sky130_fd_pr__nfet_g5v0d10v5 ad=0.65 pd=3.3 as=0 ps=0 w=1 l=0.5
X5172 rr2t2r_0[69|17]/a_460_290# WL69 SL17 VSS sky130_fd_pr__nfet_g5v0d10v5 ad=0.65 pd=3.3 as=0 ps=0 w=1 l=0.5
X5173 BLP17 rr2t2r_0[69|17]/a_60_290# sky130_fd_pr_reram__reram_cell area_ox=0.0676
X5174 BLN17 rr2t2r_0[69|17]/a_460_290# sky130_fd_pr_reram__reram_cell area_ox=0.0676
X5175 rr2t2r_0[69|17]/a_60_290# WL69 SL17 VSS sky130_fd_pr__nfet_g5v0d10v5 ad=0.65 pd=3.3 as=0 ps=0 w=1 l=0.5
X5176 rr2t2r_0[70|17]/a_460_290# WL70 SL17 VSS sky130_fd_pr__nfet_g5v0d10v5 ad=0.65 pd=3.3 as=0 ps=0 w=1 l=0.5
X5177 BLP17 rr2t2r_0[70|17]/a_60_290# sky130_fd_pr_reram__reram_cell area_ox=0.0676
X5178 BLN17 rr2t2r_0[70|17]/a_460_290# sky130_fd_pr_reram__reram_cell area_ox=0.0676
X5179 rr2t2r_0[70|17]/a_60_290# WL70 SL17 VSS sky130_fd_pr__nfet_g5v0d10v5 ad=0.65 pd=3.3 as=0 ps=0 w=1 l=0.5
X5180 rr2t2r_0[71|17]/a_460_290# WL71 SL17 VSS sky130_fd_pr__nfet_g5v0d10v5 ad=0.65 pd=3.3 as=0 ps=0 w=1 l=0.5
X5181 BLP17 rr2t2r_0[71|17]/a_60_290# sky130_fd_pr_reram__reram_cell area_ox=0.0676
X5182 BLN17 rr2t2r_0[71|17]/a_460_290# sky130_fd_pr_reram__reram_cell area_ox=0.0676
X5183 rr2t2r_0[71|17]/a_60_290# WL71 SL17 VSS sky130_fd_pr__nfet_g5v0d10v5 ad=0.65 pd=3.3 as=0 ps=0 w=1 l=0.5
X5184 rr2t2r_0[0|18]/a_460_290# WL0 SL18 VSS sky130_fd_pr__nfet_g5v0d10v5 ad=0.65 pd=3.3 as=108 ps=504 w=1 l=0.5
X5185 BLP18 rr2t2r_0[0|18]/a_60_290# sky130_fd_pr_reram__reram_cell area_ox=0.0676
X5186 BLN18 rr2t2r_0[0|18]/a_460_290# sky130_fd_pr_reram__reram_cell area_ox=0.0676
X5187 rr2t2r_0[0|18]/a_60_290# WL0 SL18 VSS sky130_fd_pr__nfet_g5v0d10v5 ad=0.65 pd=3.3 as=0 ps=0 w=1 l=0.5
X5188 rr2t2r_0[1|18]/a_460_290# WL1 SL18 VSS sky130_fd_pr__nfet_g5v0d10v5 ad=0.65 pd=3.3 as=0 ps=0 w=1 l=0.5
X5189 BLP18 rr2t2r_0[1|18]/a_60_290# sky130_fd_pr_reram__reram_cell area_ox=0.0676
X5190 BLN18 rr2t2r_0[1|18]/a_460_290# sky130_fd_pr_reram__reram_cell area_ox=0.0676
X5191 rr2t2r_0[1|18]/a_60_290# WL1 SL18 VSS sky130_fd_pr__nfet_g5v0d10v5 ad=0.65 pd=3.3 as=0 ps=0 w=1 l=0.5
X5192 rr2t2r_0[2|18]/a_460_290# WL2 SL18 VSS sky130_fd_pr__nfet_g5v0d10v5 ad=0.65 pd=3.3 as=0 ps=0 w=1 l=0.5
X5193 BLP18 rr2t2r_0[2|18]/a_60_290# sky130_fd_pr_reram__reram_cell area_ox=0.0676
X5194 BLN18 rr2t2r_0[2|18]/a_460_290# sky130_fd_pr_reram__reram_cell area_ox=0.0676
X5195 rr2t2r_0[2|18]/a_60_290# WL2 SL18 VSS sky130_fd_pr__nfet_g5v0d10v5 ad=0.65 pd=3.3 as=0 ps=0 w=1 l=0.5
X5196 rr2t2r_0[3|18]/a_460_290# WL3 SL18 VSS sky130_fd_pr__nfet_g5v0d10v5 ad=0.65 pd=3.3 as=0 ps=0 w=1 l=0.5
X5197 BLP18 rr2t2r_0[3|18]/a_60_290# sky130_fd_pr_reram__reram_cell area_ox=0.0676
X5198 BLN18 rr2t2r_0[3|18]/a_460_290# sky130_fd_pr_reram__reram_cell area_ox=0.0676
X5199 rr2t2r_0[3|18]/a_60_290# WL3 SL18 VSS sky130_fd_pr__nfet_g5v0d10v5 ad=0.65 pd=3.3 as=0 ps=0 w=1 l=0.5
X5200 rr2t2r_0[4|18]/a_460_290# WL4 SL18 VSS sky130_fd_pr__nfet_g5v0d10v5 ad=0.65 pd=3.3 as=0 ps=0 w=1 l=0.5
X5201 BLP18 rr2t2r_0[4|18]/a_60_290# sky130_fd_pr_reram__reram_cell area_ox=0.0676
X5202 BLN18 rr2t2r_0[4|18]/a_460_290# sky130_fd_pr_reram__reram_cell area_ox=0.0676
X5203 rr2t2r_0[4|18]/a_60_290# WL4 SL18 VSS sky130_fd_pr__nfet_g5v0d10v5 ad=0.65 pd=3.3 as=0 ps=0 w=1 l=0.5
X5204 rr2t2r_0[5|18]/a_460_290# WL5 SL18 VSS sky130_fd_pr__nfet_g5v0d10v5 ad=0.65 pd=3.3 as=0 ps=0 w=1 l=0.5
X5205 BLP18 rr2t2r_0[5|18]/a_60_290# sky130_fd_pr_reram__reram_cell area_ox=0.0676
X5206 BLN18 rr2t2r_0[5|18]/a_460_290# sky130_fd_pr_reram__reram_cell area_ox=0.0676
X5207 rr2t2r_0[5|18]/a_60_290# WL5 SL18 VSS sky130_fd_pr__nfet_g5v0d10v5 ad=0.65 pd=3.3 as=0 ps=0 w=1 l=0.5
X5208 rr2t2r_0[6|18]/a_460_290# WL6 SL18 VSS sky130_fd_pr__nfet_g5v0d10v5 ad=0.65 pd=3.3 as=0 ps=0 w=1 l=0.5
X5209 BLP18 rr2t2r_0[6|18]/a_60_290# sky130_fd_pr_reram__reram_cell area_ox=0.0676
X5210 BLN18 rr2t2r_0[6|18]/a_460_290# sky130_fd_pr_reram__reram_cell area_ox=0.0676
X5211 rr2t2r_0[6|18]/a_60_290# WL6 SL18 VSS sky130_fd_pr__nfet_g5v0d10v5 ad=0.65 pd=3.3 as=0 ps=0 w=1 l=0.5
X5212 rr2t2r_0[7|18]/a_460_290# WL7 SL18 VSS sky130_fd_pr__nfet_g5v0d10v5 ad=0.65 pd=3.3 as=0 ps=0 w=1 l=0.5
X5213 BLP18 rr2t2r_0[7|18]/a_60_290# sky130_fd_pr_reram__reram_cell area_ox=0.0676
X5214 BLN18 rr2t2r_0[7|18]/a_460_290# sky130_fd_pr_reram__reram_cell area_ox=0.0676
X5215 rr2t2r_0[7|18]/a_60_290# WL7 SL18 VSS sky130_fd_pr__nfet_g5v0d10v5 ad=0.65 pd=3.3 as=0 ps=0 w=1 l=0.5
X5216 rr2t2r_0[8|18]/a_460_290# WL8 SL18 VSS sky130_fd_pr__nfet_g5v0d10v5 ad=0.65 pd=3.3 as=0 ps=0 w=1 l=0.5
X5217 BLP18 rr2t2r_0[8|18]/a_60_290# sky130_fd_pr_reram__reram_cell area_ox=0.0676
X5218 BLN18 rr2t2r_0[8|18]/a_460_290# sky130_fd_pr_reram__reram_cell area_ox=0.0676
X5219 rr2t2r_0[8|18]/a_60_290# WL8 SL18 VSS sky130_fd_pr__nfet_g5v0d10v5 ad=0.65 pd=3.3 as=0 ps=0 w=1 l=0.5
X5220 rr2t2r_0[9|18]/a_460_290# WL9 SL18 VSS sky130_fd_pr__nfet_g5v0d10v5 ad=0.65 pd=3.3 as=0 ps=0 w=1 l=0.5
X5221 BLP18 rr2t2r_0[9|18]/a_60_290# sky130_fd_pr_reram__reram_cell area_ox=0.0676
X5222 BLN18 rr2t2r_0[9|18]/a_460_290# sky130_fd_pr_reram__reram_cell area_ox=0.0676
X5223 rr2t2r_0[9|18]/a_60_290# WL9 SL18 VSS sky130_fd_pr__nfet_g5v0d10v5 ad=0.65 pd=3.3 as=0 ps=0 w=1 l=0.5
X5224 rr2t2r_0[10|18]/a_460_290# WL10 SL18 VSS sky130_fd_pr__nfet_g5v0d10v5 ad=0.65 pd=3.3 as=0 ps=0 w=1 l=0.5
X5225 BLP18 rr2t2r_0[10|18]/a_60_290# sky130_fd_pr_reram__reram_cell area_ox=0.0676
X5226 BLN18 rr2t2r_0[10|18]/a_460_290# sky130_fd_pr_reram__reram_cell area_ox=0.0676
X5227 rr2t2r_0[10|18]/a_60_290# WL10 SL18 VSS sky130_fd_pr__nfet_g5v0d10v5 ad=0.65 pd=3.3 as=0 ps=0 w=1 l=0.5
X5228 rr2t2r_0[11|18]/a_460_290# WL11 SL18 VSS sky130_fd_pr__nfet_g5v0d10v5 ad=0.65 pd=3.3 as=0 ps=0 w=1 l=0.5
X5229 BLP18 rr2t2r_0[11|18]/a_60_290# sky130_fd_pr_reram__reram_cell area_ox=0.0676
X5230 BLN18 rr2t2r_0[11|18]/a_460_290# sky130_fd_pr_reram__reram_cell area_ox=0.0676
X5231 rr2t2r_0[11|18]/a_60_290# WL11 SL18 VSS sky130_fd_pr__nfet_g5v0d10v5 ad=0.65 pd=3.3 as=0 ps=0 w=1 l=0.5
X5232 rr2t2r_0[12|18]/a_460_290# WL12 SL18 VSS sky130_fd_pr__nfet_g5v0d10v5 ad=0.65 pd=3.3 as=0 ps=0 w=1 l=0.5
X5233 BLP18 rr2t2r_0[12|18]/a_60_290# sky130_fd_pr_reram__reram_cell area_ox=0.0676
X5234 BLN18 rr2t2r_0[12|18]/a_460_290# sky130_fd_pr_reram__reram_cell area_ox=0.0676
X5235 rr2t2r_0[12|18]/a_60_290# WL12 SL18 VSS sky130_fd_pr__nfet_g5v0d10v5 ad=0.65 pd=3.3 as=0 ps=0 w=1 l=0.5
X5236 rr2t2r_0[13|18]/a_460_290# WL13 SL18 VSS sky130_fd_pr__nfet_g5v0d10v5 ad=0.65 pd=3.3 as=0 ps=0 w=1 l=0.5
X5237 BLP18 rr2t2r_0[13|18]/a_60_290# sky130_fd_pr_reram__reram_cell area_ox=0.0676
X5238 BLN18 rr2t2r_0[13|18]/a_460_290# sky130_fd_pr_reram__reram_cell area_ox=0.0676
X5239 rr2t2r_0[13|18]/a_60_290# WL13 SL18 VSS sky130_fd_pr__nfet_g5v0d10v5 ad=0.65 pd=3.3 as=0 ps=0 w=1 l=0.5
X5240 rr2t2r_0[14|18]/a_460_290# WL14 SL18 VSS sky130_fd_pr__nfet_g5v0d10v5 ad=0.65 pd=3.3 as=0 ps=0 w=1 l=0.5
X5241 BLP18 rr2t2r_0[14|18]/a_60_290# sky130_fd_pr_reram__reram_cell area_ox=0.0676
X5242 BLN18 rr2t2r_0[14|18]/a_460_290# sky130_fd_pr_reram__reram_cell area_ox=0.0676
X5243 rr2t2r_0[14|18]/a_60_290# WL14 SL18 VSS sky130_fd_pr__nfet_g5v0d10v5 ad=0.65 pd=3.3 as=0 ps=0 w=1 l=0.5
X5244 rr2t2r_0[15|18]/a_460_290# WL15 SL18 VSS sky130_fd_pr__nfet_g5v0d10v5 ad=0.65 pd=3.3 as=0 ps=0 w=1 l=0.5
X5245 BLP18 rr2t2r_0[15|18]/a_60_290# sky130_fd_pr_reram__reram_cell area_ox=0.0676
X5246 BLN18 rr2t2r_0[15|18]/a_460_290# sky130_fd_pr_reram__reram_cell area_ox=0.0676
X5247 rr2t2r_0[15|18]/a_60_290# WL15 SL18 VSS sky130_fd_pr__nfet_g5v0d10v5 ad=0.65 pd=3.3 as=0 ps=0 w=1 l=0.5
X5248 rr2t2r_0[16|18]/a_460_290# WL16 SL18 VSS sky130_fd_pr__nfet_g5v0d10v5 ad=0.65 pd=3.3 as=0 ps=0 w=1 l=0.5
X5249 BLP18 rr2t2r_0[16|18]/a_60_290# sky130_fd_pr_reram__reram_cell area_ox=0.0676
X5250 BLN18 rr2t2r_0[16|18]/a_460_290# sky130_fd_pr_reram__reram_cell area_ox=0.0676
X5251 rr2t2r_0[16|18]/a_60_290# WL16 SL18 VSS sky130_fd_pr__nfet_g5v0d10v5 ad=0.65 pd=3.3 as=0 ps=0 w=1 l=0.5
X5252 rr2t2r_0[17|18]/a_460_290# WL17 SL18 VSS sky130_fd_pr__nfet_g5v0d10v5 ad=0.65 pd=3.3 as=0 ps=0 w=1 l=0.5
X5253 BLP18 rr2t2r_0[17|18]/a_60_290# sky130_fd_pr_reram__reram_cell area_ox=0.0676
X5254 BLN18 rr2t2r_0[17|18]/a_460_290# sky130_fd_pr_reram__reram_cell area_ox=0.0676
X5255 rr2t2r_0[17|18]/a_60_290# WL17 SL18 VSS sky130_fd_pr__nfet_g5v0d10v5 ad=0.65 pd=3.3 as=0 ps=0 w=1 l=0.5
X5256 rr2t2r_0[18|18]/a_460_290# WL18 SL18 VSS sky130_fd_pr__nfet_g5v0d10v5 ad=0.65 pd=3.3 as=0 ps=0 w=1 l=0.5
X5257 BLP18 rr2t2r_0[18|18]/a_60_290# sky130_fd_pr_reram__reram_cell area_ox=0.0676
X5258 BLN18 rr2t2r_0[18|18]/a_460_290# sky130_fd_pr_reram__reram_cell area_ox=0.0676
X5259 rr2t2r_0[18|18]/a_60_290# WL18 SL18 VSS sky130_fd_pr__nfet_g5v0d10v5 ad=0.65 pd=3.3 as=0 ps=0 w=1 l=0.5
X5260 rr2t2r_0[19|18]/a_460_290# WL19 SL18 VSS sky130_fd_pr__nfet_g5v0d10v5 ad=0.65 pd=3.3 as=0 ps=0 w=1 l=0.5
X5261 BLP18 rr2t2r_0[19|18]/a_60_290# sky130_fd_pr_reram__reram_cell area_ox=0.0676
X5262 BLN18 rr2t2r_0[19|18]/a_460_290# sky130_fd_pr_reram__reram_cell area_ox=0.0676
X5263 rr2t2r_0[19|18]/a_60_290# WL19 SL18 VSS sky130_fd_pr__nfet_g5v0d10v5 ad=0.65 pd=3.3 as=0 ps=0 w=1 l=0.5
X5264 rr2t2r_0[20|18]/a_460_290# WL20 SL18 VSS sky130_fd_pr__nfet_g5v0d10v5 ad=0.65 pd=3.3 as=0 ps=0 w=1 l=0.5
X5265 BLP18 rr2t2r_0[20|18]/a_60_290# sky130_fd_pr_reram__reram_cell area_ox=0.0676
X5266 BLN18 rr2t2r_0[20|18]/a_460_290# sky130_fd_pr_reram__reram_cell area_ox=0.0676
X5267 rr2t2r_0[20|18]/a_60_290# WL20 SL18 VSS sky130_fd_pr__nfet_g5v0d10v5 ad=0.65 pd=3.3 as=0 ps=0 w=1 l=0.5
X5268 rr2t2r_0[21|18]/a_460_290# WL21 SL18 VSS sky130_fd_pr__nfet_g5v0d10v5 ad=0.65 pd=3.3 as=0 ps=0 w=1 l=0.5
X5269 BLP18 rr2t2r_0[21|18]/a_60_290# sky130_fd_pr_reram__reram_cell area_ox=0.0676
X5270 BLN18 rr2t2r_0[21|18]/a_460_290# sky130_fd_pr_reram__reram_cell area_ox=0.0676
X5271 rr2t2r_0[21|18]/a_60_290# WL21 SL18 VSS sky130_fd_pr__nfet_g5v0d10v5 ad=0.65 pd=3.3 as=0 ps=0 w=1 l=0.5
X5272 rr2t2r_0[22|18]/a_460_290# WL22 SL18 VSS sky130_fd_pr__nfet_g5v0d10v5 ad=0.65 pd=3.3 as=0 ps=0 w=1 l=0.5
X5273 BLP18 rr2t2r_0[22|18]/a_60_290# sky130_fd_pr_reram__reram_cell area_ox=0.0676
X5274 BLN18 rr2t2r_0[22|18]/a_460_290# sky130_fd_pr_reram__reram_cell area_ox=0.0676
X5275 rr2t2r_0[22|18]/a_60_290# WL22 SL18 VSS sky130_fd_pr__nfet_g5v0d10v5 ad=0.65 pd=3.3 as=0 ps=0 w=1 l=0.5
X5276 rr2t2r_0[23|18]/a_460_290# WL23 SL18 VSS sky130_fd_pr__nfet_g5v0d10v5 ad=0.65 pd=3.3 as=0 ps=0 w=1 l=0.5
X5277 BLP18 rr2t2r_0[23|18]/a_60_290# sky130_fd_pr_reram__reram_cell area_ox=0.0676
X5278 BLN18 rr2t2r_0[23|18]/a_460_290# sky130_fd_pr_reram__reram_cell area_ox=0.0676
X5279 rr2t2r_0[23|18]/a_60_290# WL23 SL18 VSS sky130_fd_pr__nfet_g5v0d10v5 ad=0.65 pd=3.3 as=0 ps=0 w=1 l=0.5
X5280 rr2t2r_0[24|18]/a_460_290# WL24 SL18 VSS sky130_fd_pr__nfet_g5v0d10v5 ad=0.65 pd=3.3 as=0 ps=0 w=1 l=0.5
X5281 BLP18 rr2t2r_0[24|18]/a_60_290# sky130_fd_pr_reram__reram_cell area_ox=0.0676
X5282 BLN18 rr2t2r_0[24|18]/a_460_290# sky130_fd_pr_reram__reram_cell area_ox=0.0676
X5283 rr2t2r_0[24|18]/a_60_290# WL24 SL18 VSS sky130_fd_pr__nfet_g5v0d10v5 ad=0.65 pd=3.3 as=0 ps=0 w=1 l=0.5
X5284 rr2t2r_0[25|18]/a_460_290# WL25 SL18 VSS sky130_fd_pr__nfet_g5v0d10v5 ad=0.65 pd=3.3 as=0 ps=0 w=1 l=0.5
X5285 BLP18 rr2t2r_0[25|18]/a_60_290# sky130_fd_pr_reram__reram_cell area_ox=0.0676
X5286 BLN18 rr2t2r_0[25|18]/a_460_290# sky130_fd_pr_reram__reram_cell area_ox=0.0676
X5287 rr2t2r_0[25|18]/a_60_290# WL25 SL18 VSS sky130_fd_pr__nfet_g5v0d10v5 ad=0.65 pd=3.3 as=0 ps=0 w=1 l=0.5
X5288 rr2t2r_0[26|18]/a_460_290# WL26 SL18 VSS sky130_fd_pr__nfet_g5v0d10v5 ad=0.65 pd=3.3 as=0 ps=0 w=1 l=0.5
X5289 BLP18 rr2t2r_0[26|18]/a_60_290# sky130_fd_pr_reram__reram_cell area_ox=0.0676
X5290 BLN18 rr2t2r_0[26|18]/a_460_290# sky130_fd_pr_reram__reram_cell area_ox=0.0676
X5291 rr2t2r_0[26|18]/a_60_290# WL26 SL18 VSS sky130_fd_pr__nfet_g5v0d10v5 ad=0.65 pd=3.3 as=0 ps=0 w=1 l=0.5
X5292 rr2t2r_0[27|18]/a_460_290# WL27 SL18 VSS sky130_fd_pr__nfet_g5v0d10v5 ad=0.65 pd=3.3 as=0 ps=0 w=1 l=0.5
X5293 BLP18 rr2t2r_0[27|18]/a_60_290# sky130_fd_pr_reram__reram_cell area_ox=0.0676
X5294 BLN18 rr2t2r_0[27|18]/a_460_290# sky130_fd_pr_reram__reram_cell area_ox=0.0676
X5295 rr2t2r_0[27|18]/a_60_290# WL27 SL18 VSS sky130_fd_pr__nfet_g5v0d10v5 ad=0.65 pd=3.3 as=0 ps=0 w=1 l=0.5
X5296 rr2t2r_0[28|18]/a_460_290# WL28 SL18 VSS sky130_fd_pr__nfet_g5v0d10v5 ad=0.65 pd=3.3 as=0 ps=0 w=1 l=0.5
X5297 BLP18 rr2t2r_0[28|18]/a_60_290# sky130_fd_pr_reram__reram_cell area_ox=0.0676
X5298 BLN18 rr2t2r_0[28|18]/a_460_290# sky130_fd_pr_reram__reram_cell area_ox=0.0676
X5299 rr2t2r_0[28|18]/a_60_290# WL28 SL18 VSS sky130_fd_pr__nfet_g5v0d10v5 ad=0.65 pd=3.3 as=0 ps=0 w=1 l=0.5
X5300 rr2t2r_0[29|18]/a_460_290# WL29 SL18 VSS sky130_fd_pr__nfet_g5v0d10v5 ad=0.65 pd=3.3 as=0 ps=0 w=1 l=0.5
X5301 BLP18 rr2t2r_0[29|18]/a_60_290# sky130_fd_pr_reram__reram_cell area_ox=0.0676
X5302 BLN18 rr2t2r_0[29|18]/a_460_290# sky130_fd_pr_reram__reram_cell area_ox=0.0676
X5303 rr2t2r_0[29|18]/a_60_290# WL29 SL18 VSS sky130_fd_pr__nfet_g5v0d10v5 ad=0.65 pd=3.3 as=0 ps=0 w=1 l=0.5
X5304 rr2t2r_0[30|18]/a_460_290# WL30 SL18 VSS sky130_fd_pr__nfet_g5v0d10v5 ad=0.65 pd=3.3 as=0 ps=0 w=1 l=0.5
X5305 BLP18 rr2t2r_0[30|18]/a_60_290# sky130_fd_pr_reram__reram_cell area_ox=0.0676
X5306 BLN18 rr2t2r_0[30|18]/a_460_290# sky130_fd_pr_reram__reram_cell area_ox=0.0676
X5307 rr2t2r_0[30|18]/a_60_290# WL30 SL18 VSS sky130_fd_pr__nfet_g5v0d10v5 ad=0.65 pd=3.3 as=0 ps=0 w=1 l=0.5
X5308 rr2t2r_0[31|18]/a_460_290# WL31 SL18 VSS sky130_fd_pr__nfet_g5v0d10v5 ad=0.65 pd=3.3 as=0 ps=0 w=1 l=0.5
X5309 BLP18 rr2t2r_0[31|18]/a_60_290# sky130_fd_pr_reram__reram_cell area_ox=0.0676
X5310 BLN18 rr2t2r_0[31|18]/a_460_290# sky130_fd_pr_reram__reram_cell area_ox=0.0676
X5311 rr2t2r_0[31|18]/a_60_290# WL31 SL18 VSS sky130_fd_pr__nfet_g5v0d10v5 ad=0.65 pd=3.3 as=0 ps=0 w=1 l=0.5
X5312 rr2t2r_0[32|18]/a_460_290# WL32 SL18 VSS sky130_fd_pr__nfet_g5v0d10v5 ad=0.65 pd=3.3 as=0 ps=0 w=1 l=0.5
X5313 BLP18 rr2t2r_0[32|18]/a_60_290# sky130_fd_pr_reram__reram_cell area_ox=0.0676
X5314 BLN18 rr2t2r_0[32|18]/a_460_290# sky130_fd_pr_reram__reram_cell area_ox=0.0676
X5315 rr2t2r_0[32|18]/a_60_290# WL32 SL18 VSS sky130_fd_pr__nfet_g5v0d10v5 ad=0.65 pd=3.3 as=0 ps=0 w=1 l=0.5
X5316 rr2t2r_0[33|18]/a_460_290# WL33 SL18 VSS sky130_fd_pr__nfet_g5v0d10v5 ad=0.65 pd=3.3 as=0 ps=0 w=1 l=0.5
X5317 BLP18 rr2t2r_0[33|18]/a_60_290# sky130_fd_pr_reram__reram_cell area_ox=0.0676
X5318 BLN18 rr2t2r_0[33|18]/a_460_290# sky130_fd_pr_reram__reram_cell area_ox=0.0676
X5319 rr2t2r_0[33|18]/a_60_290# WL33 SL18 VSS sky130_fd_pr__nfet_g5v0d10v5 ad=0.65 pd=3.3 as=0 ps=0 w=1 l=0.5
X5320 rr2t2r_0[34|18]/a_460_290# WL34 SL18 VSS sky130_fd_pr__nfet_g5v0d10v5 ad=0.65 pd=3.3 as=0 ps=0 w=1 l=0.5
X5321 BLP18 rr2t2r_0[34|18]/a_60_290# sky130_fd_pr_reram__reram_cell area_ox=0.0676
X5322 BLN18 rr2t2r_0[34|18]/a_460_290# sky130_fd_pr_reram__reram_cell area_ox=0.0676
X5323 rr2t2r_0[34|18]/a_60_290# WL34 SL18 VSS sky130_fd_pr__nfet_g5v0d10v5 ad=0.65 pd=3.3 as=0 ps=0 w=1 l=0.5
X5324 rr2t2r_0[35|18]/a_460_290# WL35 SL18 VSS sky130_fd_pr__nfet_g5v0d10v5 ad=0.65 pd=3.3 as=0 ps=0 w=1 l=0.5
X5325 BLP18 rr2t2r_0[35|18]/a_60_290# sky130_fd_pr_reram__reram_cell area_ox=0.0676
X5326 BLN18 rr2t2r_0[35|18]/a_460_290# sky130_fd_pr_reram__reram_cell area_ox=0.0676
X5327 rr2t2r_0[35|18]/a_60_290# WL35 SL18 VSS sky130_fd_pr__nfet_g5v0d10v5 ad=0.65 pd=3.3 as=0 ps=0 w=1 l=0.5
X5328 rr2t2r_0[36|18]/a_460_290# WL36 SL18 VSS sky130_fd_pr__nfet_g5v0d10v5 ad=0.65 pd=3.3 as=0 ps=0 w=1 l=0.5
X5329 BLP18 rr2t2r_0[36|18]/a_60_290# sky130_fd_pr_reram__reram_cell area_ox=0.0676
X5330 BLN18 rr2t2r_0[36|18]/a_460_290# sky130_fd_pr_reram__reram_cell area_ox=0.0676
X5331 rr2t2r_0[36|18]/a_60_290# WL36 SL18 VSS sky130_fd_pr__nfet_g5v0d10v5 ad=0.65 pd=3.3 as=0 ps=0 w=1 l=0.5
X5332 rr2t2r_0[37|18]/a_460_290# WL37 SL18 VSS sky130_fd_pr__nfet_g5v0d10v5 ad=0.65 pd=3.3 as=0 ps=0 w=1 l=0.5
X5333 BLP18 rr2t2r_0[37|18]/a_60_290# sky130_fd_pr_reram__reram_cell area_ox=0.0676
X5334 BLN18 rr2t2r_0[37|18]/a_460_290# sky130_fd_pr_reram__reram_cell area_ox=0.0676
X5335 rr2t2r_0[37|18]/a_60_290# WL37 SL18 VSS sky130_fd_pr__nfet_g5v0d10v5 ad=0.65 pd=3.3 as=0 ps=0 w=1 l=0.5
X5336 rr2t2r_0[38|18]/a_460_290# WL38 SL18 VSS sky130_fd_pr__nfet_g5v0d10v5 ad=0.65 pd=3.3 as=0 ps=0 w=1 l=0.5
X5337 BLP18 rr2t2r_0[38|18]/a_60_290# sky130_fd_pr_reram__reram_cell area_ox=0.0676
X5338 BLN18 rr2t2r_0[38|18]/a_460_290# sky130_fd_pr_reram__reram_cell area_ox=0.0676
X5339 rr2t2r_0[38|18]/a_60_290# WL38 SL18 VSS sky130_fd_pr__nfet_g5v0d10v5 ad=0.65 pd=3.3 as=0 ps=0 w=1 l=0.5
X5340 rr2t2r_0[39|18]/a_460_290# WL39 SL18 VSS sky130_fd_pr__nfet_g5v0d10v5 ad=0.65 pd=3.3 as=0 ps=0 w=1 l=0.5
X5341 BLP18 rr2t2r_0[39|18]/a_60_290# sky130_fd_pr_reram__reram_cell area_ox=0.0676
X5342 BLN18 rr2t2r_0[39|18]/a_460_290# sky130_fd_pr_reram__reram_cell area_ox=0.0676
X5343 rr2t2r_0[39|18]/a_60_290# WL39 SL18 VSS sky130_fd_pr__nfet_g5v0d10v5 ad=0.65 pd=3.3 as=0 ps=0 w=1 l=0.5
X5344 rr2t2r_0[40|18]/a_460_290# WL40 SL18 VSS sky130_fd_pr__nfet_g5v0d10v5 ad=0.65 pd=3.3 as=0 ps=0 w=1 l=0.5
X5345 BLP18 rr2t2r_0[40|18]/a_60_290# sky130_fd_pr_reram__reram_cell area_ox=0.0676
X5346 BLN18 rr2t2r_0[40|18]/a_460_290# sky130_fd_pr_reram__reram_cell area_ox=0.0676
X5347 rr2t2r_0[40|18]/a_60_290# WL40 SL18 VSS sky130_fd_pr__nfet_g5v0d10v5 ad=0.65 pd=3.3 as=0 ps=0 w=1 l=0.5
X5348 rr2t2r_0[41|18]/a_460_290# WL41 SL18 VSS sky130_fd_pr__nfet_g5v0d10v5 ad=0.65 pd=3.3 as=0 ps=0 w=1 l=0.5
X5349 BLP18 rr2t2r_0[41|18]/a_60_290# sky130_fd_pr_reram__reram_cell area_ox=0.0676
X5350 BLN18 rr2t2r_0[41|18]/a_460_290# sky130_fd_pr_reram__reram_cell area_ox=0.0676
X5351 rr2t2r_0[41|18]/a_60_290# WL41 SL18 VSS sky130_fd_pr__nfet_g5v0d10v5 ad=0.65 pd=3.3 as=0 ps=0 w=1 l=0.5
X5352 rr2t2r_0[42|18]/a_460_290# WL42 SL18 VSS sky130_fd_pr__nfet_g5v0d10v5 ad=0.65 pd=3.3 as=0 ps=0 w=1 l=0.5
X5353 BLP18 rr2t2r_0[42|18]/a_60_290# sky130_fd_pr_reram__reram_cell area_ox=0.0676
X5354 BLN18 rr2t2r_0[42|18]/a_460_290# sky130_fd_pr_reram__reram_cell area_ox=0.0676
X5355 rr2t2r_0[42|18]/a_60_290# WL42 SL18 VSS sky130_fd_pr__nfet_g5v0d10v5 ad=0.65 pd=3.3 as=0 ps=0 w=1 l=0.5
X5356 rr2t2r_0[43|18]/a_460_290# WL43 SL18 VSS sky130_fd_pr__nfet_g5v0d10v5 ad=0.65 pd=3.3 as=0 ps=0 w=1 l=0.5
X5357 BLP18 rr2t2r_0[43|18]/a_60_290# sky130_fd_pr_reram__reram_cell area_ox=0.0676
X5358 BLN18 rr2t2r_0[43|18]/a_460_290# sky130_fd_pr_reram__reram_cell area_ox=0.0676
X5359 rr2t2r_0[43|18]/a_60_290# WL43 SL18 VSS sky130_fd_pr__nfet_g5v0d10v5 ad=0.65 pd=3.3 as=0 ps=0 w=1 l=0.5
X5360 rr2t2r_0[44|18]/a_460_290# WL44 SL18 VSS sky130_fd_pr__nfet_g5v0d10v5 ad=0.65 pd=3.3 as=0 ps=0 w=1 l=0.5
X5361 BLP18 rr2t2r_0[44|18]/a_60_290# sky130_fd_pr_reram__reram_cell area_ox=0.0676
X5362 BLN18 rr2t2r_0[44|18]/a_460_290# sky130_fd_pr_reram__reram_cell area_ox=0.0676
X5363 rr2t2r_0[44|18]/a_60_290# WL44 SL18 VSS sky130_fd_pr__nfet_g5v0d10v5 ad=0.65 pd=3.3 as=0 ps=0 w=1 l=0.5
X5364 rr2t2r_0[45|18]/a_460_290# WL45 SL18 VSS sky130_fd_pr__nfet_g5v0d10v5 ad=0.65 pd=3.3 as=0 ps=0 w=1 l=0.5
X5365 BLP18 rr2t2r_0[45|18]/a_60_290# sky130_fd_pr_reram__reram_cell area_ox=0.0676
X5366 BLN18 rr2t2r_0[45|18]/a_460_290# sky130_fd_pr_reram__reram_cell area_ox=0.0676
X5367 rr2t2r_0[45|18]/a_60_290# WL45 SL18 VSS sky130_fd_pr__nfet_g5v0d10v5 ad=0.65 pd=3.3 as=0 ps=0 w=1 l=0.5
X5368 rr2t2r_0[46|18]/a_460_290# WL46 SL18 VSS sky130_fd_pr__nfet_g5v0d10v5 ad=0.65 pd=3.3 as=0 ps=0 w=1 l=0.5
X5369 BLP18 rr2t2r_0[46|18]/a_60_290# sky130_fd_pr_reram__reram_cell area_ox=0.0676
X5370 BLN18 rr2t2r_0[46|18]/a_460_290# sky130_fd_pr_reram__reram_cell area_ox=0.0676
X5371 rr2t2r_0[46|18]/a_60_290# WL46 SL18 VSS sky130_fd_pr__nfet_g5v0d10v5 ad=0.65 pd=3.3 as=0 ps=0 w=1 l=0.5
X5372 rr2t2r_0[47|18]/a_460_290# WL47 SL18 VSS sky130_fd_pr__nfet_g5v0d10v5 ad=0.65 pd=3.3 as=0 ps=0 w=1 l=0.5
X5373 BLP18 rr2t2r_0[47|18]/a_60_290# sky130_fd_pr_reram__reram_cell area_ox=0.0676
X5374 BLN18 rr2t2r_0[47|18]/a_460_290# sky130_fd_pr_reram__reram_cell area_ox=0.0676
X5375 rr2t2r_0[47|18]/a_60_290# WL47 SL18 VSS sky130_fd_pr__nfet_g5v0d10v5 ad=0.65 pd=3.3 as=0 ps=0 w=1 l=0.5
X5376 rr2t2r_0[48|18]/a_460_290# WL48 SL18 VSS sky130_fd_pr__nfet_g5v0d10v5 ad=0.65 pd=3.3 as=0 ps=0 w=1 l=0.5
X5377 BLP18 rr2t2r_0[48|18]/a_60_290# sky130_fd_pr_reram__reram_cell area_ox=0.0676
X5378 BLN18 rr2t2r_0[48|18]/a_460_290# sky130_fd_pr_reram__reram_cell area_ox=0.0676
X5379 rr2t2r_0[48|18]/a_60_290# WL48 SL18 VSS sky130_fd_pr__nfet_g5v0d10v5 ad=0.65 pd=3.3 as=0 ps=0 w=1 l=0.5
X5380 rr2t2r_0[49|18]/a_460_290# WL49 SL18 VSS sky130_fd_pr__nfet_g5v0d10v5 ad=0.65 pd=3.3 as=0 ps=0 w=1 l=0.5
X5381 BLP18 rr2t2r_0[49|18]/a_60_290# sky130_fd_pr_reram__reram_cell area_ox=0.0676
X5382 BLN18 rr2t2r_0[49|18]/a_460_290# sky130_fd_pr_reram__reram_cell area_ox=0.0676
X5383 rr2t2r_0[49|18]/a_60_290# WL49 SL18 VSS sky130_fd_pr__nfet_g5v0d10v5 ad=0.65 pd=3.3 as=0 ps=0 w=1 l=0.5
X5384 rr2t2r_0[50|18]/a_460_290# WL50 SL18 VSS sky130_fd_pr__nfet_g5v0d10v5 ad=0.65 pd=3.3 as=0 ps=0 w=1 l=0.5
X5385 BLP18 rr2t2r_0[50|18]/a_60_290# sky130_fd_pr_reram__reram_cell area_ox=0.0676
X5386 BLN18 rr2t2r_0[50|18]/a_460_290# sky130_fd_pr_reram__reram_cell area_ox=0.0676
X5387 rr2t2r_0[50|18]/a_60_290# WL50 SL18 VSS sky130_fd_pr__nfet_g5v0d10v5 ad=0.65 pd=3.3 as=0 ps=0 w=1 l=0.5
X5388 rr2t2r_0[51|18]/a_460_290# WL51 SL18 VSS sky130_fd_pr__nfet_g5v0d10v5 ad=0.65 pd=3.3 as=0 ps=0 w=1 l=0.5
X5389 BLP18 rr2t2r_0[51|18]/a_60_290# sky130_fd_pr_reram__reram_cell area_ox=0.0676
X5390 BLN18 rr2t2r_0[51|18]/a_460_290# sky130_fd_pr_reram__reram_cell area_ox=0.0676
X5391 rr2t2r_0[51|18]/a_60_290# WL51 SL18 VSS sky130_fd_pr__nfet_g5v0d10v5 ad=0.65 pd=3.3 as=0 ps=0 w=1 l=0.5
X5392 rr2t2r_0[52|18]/a_460_290# WL52 SL18 VSS sky130_fd_pr__nfet_g5v0d10v5 ad=0.65 pd=3.3 as=0 ps=0 w=1 l=0.5
X5393 BLP18 rr2t2r_0[52|18]/a_60_290# sky130_fd_pr_reram__reram_cell area_ox=0.0676
X5394 BLN18 rr2t2r_0[52|18]/a_460_290# sky130_fd_pr_reram__reram_cell area_ox=0.0676
X5395 rr2t2r_0[52|18]/a_60_290# WL52 SL18 VSS sky130_fd_pr__nfet_g5v0d10v5 ad=0.65 pd=3.3 as=0 ps=0 w=1 l=0.5
X5396 rr2t2r_0[53|18]/a_460_290# WL53 SL18 VSS sky130_fd_pr__nfet_g5v0d10v5 ad=0.65 pd=3.3 as=0 ps=0 w=1 l=0.5
X5397 BLP18 rr2t2r_0[53|18]/a_60_290# sky130_fd_pr_reram__reram_cell area_ox=0.0676
X5398 BLN18 rr2t2r_0[53|18]/a_460_290# sky130_fd_pr_reram__reram_cell area_ox=0.0676
X5399 rr2t2r_0[53|18]/a_60_290# WL53 SL18 VSS sky130_fd_pr__nfet_g5v0d10v5 ad=0.65 pd=3.3 as=0 ps=0 w=1 l=0.5
X5400 rr2t2r_0[54|18]/a_460_290# WL54 SL18 VSS sky130_fd_pr__nfet_g5v0d10v5 ad=0.65 pd=3.3 as=0 ps=0 w=1 l=0.5
X5401 BLP18 rr2t2r_0[54|18]/a_60_290# sky130_fd_pr_reram__reram_cell area_ox=0.0676
X5402 BLN18 rr2t2r_0[54|18]/a_460_290# sky130_fd_pr_reram__reram_cell area_ox=0.0676
X5403 rr2t2r_0[54|18]/a_60_290# WL54 SL18 VSS sky130_fd_pr__nfet_g5v0d10v5 ad=0.65 pd=3.3 as=0 ps=0 w=1 l=0.5
X5404 rr2t2r_0[55|18]/a_460_290# WL55 SL18 VSS sky130_fd_pr__nfet_g5v0d10v5 ad=0.65 pd=3.3 as=0 ps=0 w=1 l=0.5
X5405 BLP18 rr2t2r_0[55|18]/a_60_290# sky130_fd_pr_reram__reram_cell area_ox=0.0676
X5406 BLN18 rr2t2r_0[55|18]/a_460_290# sky130_fd_pr_reram__reram_cell area_ox=0.0676
X5407 rr2t2r_0[55|18]/a_60_290# WL55 SL18 VSS sky130_fd_pr__nfet_g5v0d10v5 ad=0.65 pd=3.3 as=0 ps=0 w=1 l=0.5
X5408 rr2t2r_0[56|18]/a_460_290# WL56 SL18 VSS sky130_fd_pr__nfet_g5v0d10v5 ad=0.65 pd=3.3 as=0 ps=0 w=1 l=0.5
X5409 BLP18 rr2t2r_0[56|18]/a_60_290# sky130_fd_pr_reram__reram_cell area_ox=0.0676
X5410 BLN18 rr2t2r_0[56|18]/a_460_290# sky130_fd_pr_reram__reram_cell area_ox=0.0676
X5411 rr2t2r_0[56|18]/a_60_290# WL56 SL18 VSS sky130_fd_pr__nfet_g5v0d10v5 ad=0.65 pd=3.3 as=0 ps=0 w=1 l=0.5
X5412 rr2t2r_0[57|18]/a_460_290# WL57 SL18 VSS sky130_fd_pr__nfet_g5v0d10v5 ad=0.65 pd=3.3 as=0 ps=0 w=1 l=0.5
X5413 BLP18 rr2t2r_0[57|18]/a_60_290# sky130_fd_pr_reram__reram_cell area_ox=0.0676
X5414 BLN18 rr2t2r_0[57|18]/a_460_290# sky130_fd_pr_reram__reram_cell area_ox=0.0676
X5415 rr2t2r_0[57|18]/a_60_290# WL57 SL18 VSS sky130_fd_pr__nfet_g5v0d10v5 ad=0.65 pd=3.3 as=0 ps=0 w=1 l=0.5
X5416 rr2t2r_0[58|18]/a_460_290# WL58 SL18 VSS sky130_fd_pr__nfet_g5v0d10v5 ad=0.65 pd=3.3 as=0 ps=0 w=1 l=0.5
X5417 BLP18 rr2t2r_0[58|18]/a_60_290# sky130_fd_pr_reram__reram_cell area_ox=0.0676
X5418 BLN18 rr2t2r_0[58|18]/a_460_290# sky130_fd_pr_reram__reram_cell area_ox=0.0676
X5419 rr2t2r_0[58|18]/a_60_290# WL58 SL18 VSS sky130_fd_pr__nfet_g5v0d10v5 ad=0.65 pd=3.3 as=0 ps=0 w=1 l=0.5
X5420 rr2t2r_0[59|18]/a_460_290# WL59 SL18 VSS sky130_fd_pr__nfet_g5v0d10v5 ad=0.65 pd=3.3 as=0 ps=0 w=1 l=0.5
X5421 BLP18 rr2t2r_0[59|18]/a_60_290# sky130_fd_pr_reram__reram_cell area_ox=0.0676
X5422 BLN18 rr2t2r_0[59|18]/a_460_290# sky130_fd_pr_reram__reram_cell area_ox=0.0676
X5423 rr2t2r_0[59|18]/a_60_290# WL59 SL18 VSS sky130_fd_pr__nfet_g5v0d10v5 ad=0.65 pd=3.3 as=0 ps=0 w=1 l=0.5
X5424 rr2t2r_0[60|18]/a_460_290# WL60 SL18 VSS sky130_fd_pr__nfet_g5v0d10v5 ad=0.65 pd=3.3 as=0 ps=0 w=1 l=0.5
X5425 BLP18 rr2t2r_0[60|18]/a_60_290# sky130_fd_pr_reram__reram_cell area_ox=0.0676
X5426 BLN18 rr2t2r_0[60|18]/a_460_290# sky130_fd_pr_reram__reram_cell area_ox=0.0676
X5427 rr2t2r_0[60|18]/a_60_290# WL60 SL18 VSS sky130_fd_pr__nfet_g5v0d10v5 ad=0.65 pd=3.3 as=0 ps=0 w=1 l=0.5
X5428 rr2t2r_0[61|18]/a_460_290# WL61 SL18 VSS sky130_fd_pr__nfet_g5v0d10v5 ad=0.65 pd=3.3 as=0 ps=0 w=1 l=0.5
X5429 BLP18 rr2t2r_0[61|18]/a_60_290# sky130_fd_pr_reram__reram_cell area_ox=0.0676
X5430 BLN18 rr2t2r_0[61|18]/a_460_290# sky130_fd_pr_reram__reram_cell area_ox=0.0676
X5431 rr2t2r_0[61|18]/a_60_290# WL61 SL18 VSS sky130_fd_pr__nfet_g5v0d10v5 ad=0.65 pd=3.3 as=0 ps=0 w=1 l=0.5
X5432 rr2t2r_0[62|18]/a_460_290# WL62 SL18 VSS sky130_fd_pr__nfet_g5v0d10v5 ad=0.65 pd=3.3 as=0 ps=0 w=1 l=0.5
X5433 BLP18 rr2t2r_0[62|18]/a_60_290# sky130_fd_pr_reram__reram_cell area_ox=0.0676
X5434 BLN18 rr2t2r_0[62|18]/a_460_290# sky130_fd_pr_reram__reram_cell area_ox=0.0676
X5435 rr2t2r_0[62|18]/a_60_290# WL62 SL18 VSS sky130_fd_pr__nfet_g5v0d10v5 ad=0.65 pd=3.3 as=0 ps=0 w=1 l=0.5
X5436 rr2t2r_0[63|18]/a_460_290# WL63 SL18 VSS sky130_fd_pr__nfet_g5v0d10v5 ad=0.65 pd=3.3 as=0 ps=0 w=1 l=0.5
X5437 BLP18 rr2t2r_0[63|18]/a_60_290# sky130_fd_pr_reram__reram_cell area_ox=0.0676
X5438 BLN18 rr2t2r_0[63|18]/a_460_290# sky130_fd_pr_reram__reram_cell area_ox=0.0676
X5439 rr2t2r_0[63|18]/a_60_290# WL63 SL18 VSS sky130_fd_pr__nfet_g5v0d10v5 ad=0.65 pd=3.3 as=0 ps=0 w=1 l=0.5
X5440 rr2t2r_0[64|18]/a_460_290# WL64 SL18 VSS sky130_fd_pr__nfet_g5v0d10v5 ad=0.65 pd=3.3 as=0 ps=0 w=1 l=0.5
X5441 BLP18 rr2t2r_0[64|18]/a_60_290# sky130_fd_pr_reram__reram_cell area_ox=0.0676
X5442 BLN18 rr2t2r_0[64|18]/a_460_290# sky130_fd_pr_reram__reram_cell area_ox=0.0676
X5443 rr2t2r_0[64|18]/a_60_290# WL64 SL18 VSS sky130_fd_pr__nfet_g5v0d10v5 ad=0.65 pd=3.3 as=0 ps=0 w=1 l=0.5
X5444 rr2t2r_0[65|18]/a_460_290# WL65 SL18 VSS sky130_fd_pr__nfet_g5v0d10v5 ad=0.65 pd=3.3 as=0 ps=0 w=1 l=0.5
X5445 BLP18 rr2t2r_0[65|18]/a_60_290# sky130_fd_pr_reram__reram_cell area_ox=0.0676
X5446 BLN18 rr2t2r_0[65|18]/a_460_290# sky130_fd_pr_reram__reram_cell area_ox=0.0676
X5447 rr2t2r_0[65|18]/a_60_290# WL65 SL18 VSS sky130_fd_pr__nfet_g5v0d10v5 ad=0.65 pd=3.3 as=0 ps=0 w=1 l=0.5
X5448 rr2t2r_0[66|18]/a_460_290# WL66 SL18 VSS sky130_fd_pr__nfet_g5v0d10v5 ad=0.65 pd=3.3 as=0 ps=0 w=1 l=0.5
X5449 BLP18 rr2t2r_0[66|18]/a_60_290# sky130_fd_pr_reram__reram_cell area_ox=0.0676
X5450 BLN18 rr2t2r_0[66|18]/a_460_290# sky130_fd_pr_reram__reram_cell area_ox=0.0676
X5451 rr2t2r_0[66|18]/a_60_290# WL66 SL18 VSS sky130_fd_pr__nfet_g5v0d10v5 ad=0.65 pd=3.3 as=0 ps=0 w=1 l=0.5
X5452 rr2t2r_0[67|18]/a_460_290# WL67 SL18 VSS sky130_fd_pr__nfet_g5v0d10v5 ad=0.65 pd=3.3 as=0 ps=0 w=1 l=0.5
X5453 BLP18 rr2t2r_0[67|18]/a_60_290# sky130_fd_pr_reram__reram_cell area_ox=0.0676
X5454 BLN18 rr2t2r_0[67|18]/a_460_290# sky130_fd_pr_reram__reram_cell area_ox=0.0676
X5455 rr2t2r_0[67|18]/a_60_290# WL67 SL18 VSS sky130_fd_pr__nfet_g5v0d10v5 ad=0.65 pd=3.3 as=0 ps=0 w=1 l=0.5
X5456 rr2t2r_0[68|18]/a_460_290# WL68 SL18 VSS sky130_fd_pr__nfet_g5v0d10v5 ad=0.65 pd=3.3 as=0 ps=0 w=1 l=0.5
X5457 BLP18 rr2t2r_0[68|18]/a_60_290# sky130_fd_pr_reram__reram_cell area_ox=0.0676
X5458 BLN18 rr2t2r_0[68|18]/a_460_290# sky130_fd_pr_reram__reram_cell area_ox=0.0676
X5459 rr2t2r_0[68|18]/a_60_290# WL68 SL18 VSS sky130_fd_pr__nfet_g5v0d10v5 ad=0.65 pd=3.3 as=0 ps=0 w=1 l=0.5
X5460 rr2t2r_0[69|18]/a_460_290# WL69 SL18 VSS sky130_fd_pr__nfet_g5v0d10v5 ad=0.65 pd=3.3 as=0 ps=0 w=1 l=0.5
X5461 BLP18 rr2t2r_0[69|18]/a_60_290# sky130_fd_pr_reram__reram_cell area_ox=0.0676
X5462 BLN18 rr2t2r_0[69|18]/a_460_290# sky130_fd_pr_reram__reram_cell area_ox=0.0676
X5463 rr2t2r_0[69|18]/a_60_290# WL69 SL18 VSS sky130_fd_pr__nfet_g5v0d10v5 ad=0.65 pd=3.3 as=0 ps=0 w=1 l=0.5
X5464 rr2t2r_0[70|18]/a_460_290# WL70 SL18 VSS sky130_fd_pr__nfet_g5v0d10v5 ad=0.65 pd=3.3 as=0 ps=0 w=1 l=0.5
X5465 BLP18 rr2t2r_0[70|18]/a_60_290# sky130_fd_pr_reram__reram_cell area_ox=0.0676
X5466 BLN18 rr2t2r_0[70|18]/a_460_290# sky130_fd_pr_reram__reram_cell area_ox=0.0676
X5467 rr2t2r_0[70|18]/a_60_290# WL70 SL18 VSS sky130_fd_pr__nfet_g5v0d10v5 ad=0.65 pd=3.3 as=0 ps=0 w=1 l=0.5
X5468 rr2t2r_0[71|18]/a_460_290# WL71 SL18 VSS sky130_fd_pr__nfet_g5v0d10v5 ad=0.65 pd=3.3 as=0 ps=0 w=1 l=0.5
X5469 BLP18 rr2t2r_0[71|18]/a_60_290# sky130_fd_pr_reram__reram_cell area_ox=0.0676
X5470 BLN18 rr2t2r_0[71|18]/a_460_290# sky130_fd_pr_reram__reram_cell area_ox=0.0676
X5471 rr2t2r_0[71|18]/a_60_290# WL71 SL18 VSS sky130_fd_pr__nfet_g5v0d10v5 ad=0.65 pd=3.3 as=0 ps=0 w=1 l=0.5
X5472 rr2t2r_0[0|19]/a_460_290# WL0 SL19 VSS sky130_fd_pr__nfet_g5v0d10v5 ad=0.65 pd=3.3 as=108 ps=504 w=1 l=0.5
X5473 BLP19 rr2t2r_0[0|19]/a_60_290# sky130_fd_pr_reram__reram_cell area_ox=0.0676
X5474 BLN19 rr2t2r_0[0|19]/a_460_290# sky130_fd_pr_reram__reram_cell area_ox=0.0676
X5475 rr2t2r_0[0|19]/a_60_290# WL0 SL19 VSS sky130_fd_pr__nfet_g5v0d10v5 ad=0.65 pd=3.3 as=0 ps=0 w=1 l=0.5
X5476 rr2t2r_0[1|19]/a_460_290# WL1 SL19 VSS sky130_fd_pr__nfet_g5v0d10v5 ad=0.65 pd=3.3 as=0 ps=0 w=1 l=0.5
X5477 BLP19 rr2t2r_0[1|19]/a_60_290# sky130_fd_pr_reram__reram_cell area_ox=0.0676
X5478 BLN19 rr2t2r_0[1|19]/a_460_290# sky130_fd_pr_reram__reram_cell area_ox=0.0676
X5479 rr2t2r_0[1|19]/a_60_290# WL1 SL19 VSS sky130_fd_pr__nfet_g5v0d10v5 ad=0.65 pd=3.3 as=0 ps=0 w=1 l=0.5
X5480 rr2t2r_0[2|19]/a_460_290# WL2 SL19 VSS sky130_fd_pr__nfet_g5v0d10v5 ad=0.65 pd=3.3 as=0 ps=0 w=1 l=0.5
X5481 BLP19 rr2t2r_0[2|19]/a_60_290# sky130_fd_pr_reram__reram_cell area_ox=0.0676
X5482 BLN19 rr2t2r_0[2|19]/a_460_290# sky130_fd_pr_reram__reram_cell area_ox=0.0676
X5483 rr2t2r_0[2|19]/a_60_290# WL2 SL19 VSS sky130_fd_pr__nfet_g5v0d10v5 ad=0.65 pd=3.3 as=0 ps=0 w=1 l=0.5
X5484 rr2t2r_0[3|19]/a_460_290# WL3 SL19 VSS sky130_fd_pr__nfet_g5v0d10v5 ad=0.65 pd=3.3 as=0 ps=0 w=1 l=0.5
X5485 BLP19 rr2t2r_0[3|19]/a_60_290# sky130_fd_pr_reram__reram_cell area_ox=0.0676
X5486 BLN19 rr2t2r_0[3|19]/a_460_290# sky130_fd_pr_reram__reram_cell area_ox=0.0676
X5487 rr2t2r_0[3|19]/a_60_290# WL3 SL19 VSS sky130_fd_pr__nfet_g5v0d10v5 ad=0.65 pd=3.3 as=0 ps=0 w=1 l=0.5
X5488 rr2t2r_0[4|19]/a_460_290# WL4 SL19 VSS sky130_fd_pr__nfet_g5v0d10v5 ad=0.65 pd=3.3 as=0 ps=0 w=1 l=0.5
X5489 BLP19 rr2t2r_0[4|19]/a_60_290# sky130_fd_pr_reram__reram_cell area_ox=0.0676
X5490 BLN19 rr2t2r_0[4|19]/a_460_290# sky130_fd_pr_reram__reram_cell area_ox=0.0676
X5491 rr2t2r_0[4|19]/a_60_290# WL4 SL19 VSS sky130_fd_pr__nfet_g5v0d10v5 ad=0.65 pd=3.3 as=0 ps=0 w=1 l=0.5
X5492 rr2t2r_0[5|19]/a_460_290# WL5 SL19 VSS sky130_fd_pr__nfet_g5v0d10v5 ad=0.65 pd=3.3 as=0 ps=0 w=1 l=0.5
X5493 BLP19 rr2t2r_0[5|19]/a_60_290# sky130_fd_pr_reram__reram_cell area_ox=0.0676
X5494 BLN19 rr2t2r_0[5|19]/a_460_290# sky130_fd_pr_reram__reram_cell area_ox=0.0676
X5495 rr2t2r_0[5|19]/a_60_290# WL5 SL19 VSS sky130_fd_pr__nfet_g5v0d10v5 ad=0.65 pd=3.3 as=0 ps=0 w=1 l=0.5
X5496 rr2t2r_0[6|19]/a_460_290# WL6 SL19 VSS sky130_fd_pr__nfet_g5v0d10v5 ad=0.65 pd=3.3 as=0 ps=0 w=1 l=0.5
X5497 BLP19 rr2t2r_0[6|19]/a_60_290# sky130_fd_pr_reram__reram_cell area_ox=0.0676
X5498 BLN19 rr2t2r_0[6|19]/a_460_290# sky130_fd_pr_reram__reram_cell area_ox=0.0676
X5499 rr2t2r_0[6|19]/a_60_290# WL6 SL19 VSS sky130_fd_pr__nfet_g5v0d10v5 ad=0.65 pd=3.3 as=0 ps=0 w=1 l=0.5
X5500 rr2t2r_0[7|19]/a_460_290# WL7 SL19 VSS sky130_fd_pr__nfet_g5v0d10v5 ad=0.65 pd=3.3 as=0 ps=0 w=1 l=0.5
X5501 BLP19 rr2t2r_0[7|19]/a_60_290# sky130_fd_pr_reram__reram_cell area_ox=0.0676
X5502 BLN19 rr2t2r_0[7|19]/a_460_290# sky130_fd_pr_reram__reram_cell area_ox=0.0676
X5503 rr2t2r_0[7|19]/a_60_290# WL7 SL19 VSS sky130_fd_pr__nfet_g5v0d10v5 ad=0.65 pd=3.3 as=0 ps=0 w=1 l=0.5
X5504 rr2t2r_0[8|19]/a_460_290# WL8 SL19 VSS sky130_fd_pr__nfet_g5v0d10v5 ad=0.65 pd=3.3 as=0 ps=0 w=1 l=0.5
X5505 BLP19 rr2t2r_0[8|19]/a_60_290# sky130_fd_pr_reram__reram_cell area_ox=0.0676
X5506 BLN19 rr2t2r_0[8|19]/a_460_290# sky130_fd_pr_reram__reram_cell area_ox=0.0676
X5507 rr2t2r_0[8|19]/a_60_290# WL8 SL19 VSS sky130_fd_pr__nfet_g5v0d10v5 ad=0.65 pd=3.3 as=0 ps=0 w=1 l=0.5
X5508 rr2t2r_0[9|19]/a_460_290# WL9 SL19 VSS sky130_fd_pr__nfet_g5v0d10v5 ad=0.65 pd=3.3 as=0 ps=0 w=1 l=0.5
X5509 BLP19 rr2t2r_0[9|19]/a_60_290# sky130_fd_pr_reram__reram_cell area_ox=0.0676
X5510 BLN19 rr2t2r_0[9|19]/a_460_290# sky130_fd_pr_reram__reram_cell area_ox=0.0676
X5511 rr2t2r_0[9|19]/a_60_290# WL9 SL19 VSS sky130_fd_pr__nfet_g5v0d10v5 ad=0.65 pd=3.3 as=0 ps=0 w=1 l=0.5
X5512 rr2t2r_0[10|19]/a_460_290# WL10 SL19 VSS sky130_fd_pr__nfet_g5v0d10v5 ad=0.65 pd=3.3 as=0 ps=0 w=1 l=0.5
X5513 BLP19 rr2t2r_0[10|19]/a_60_290# sky130_fd_pr_reram__reram_cell area_ox=0.0676
X5514 BLN19 rr2t2r_0[10|19]/a_460_290# sky130_fd_pr_reram__reram_cell area_ox=0.0676
X5515 rr2t2r_0[10|19]/a_60_290# WL10 SL19 VSS sky130_fd_pr__nfet_g5v0d10v5 ad=0.65 pd=3.3 as=0 ps=0 w=1 l=0.5
X5516 rr2t2r_0[11|19]/a_460_290# WL11 SL19 VSS sky130_fd_pr__nfet_g5v0d10v5 ad=0.65 pd=3.3 as=0 ps=0 w=1 l=0.5
X5517 BLP19 rr2t2r_0[11|19]/a_60_290# sky130_fd_pr_reram__reram_cell area_ox=0.0676
X5518 BLN19 rr2t2r_0[11|19]/a_460_290# sky130_fd_pr_reram__reram_cell area_ox=0.0676
X5519 rr2t2r_0[11|19]/a_60_290# WL11 SL19 VSS sky130_fd_pr__nfet_g5v0d10v5 ad=0.65 pd=3.3 as=0 ps=0 w=1 l=0.5
X5520 rr2t2r_0[12|19]/a_460_290# WL12 SL19 VSS sky130_fd_pr__nfet_g5v0d10v5 ad=0.65 pd=3.3 as=0 ps=0 w=1 l=0.5
X5521 BLP19 rr2t2r_0[12|19]/a_60_290# sky130_fd_pr_reram__reram_cell area_ox=0.0676
X5522 BLN19 rr2t2r_0[12|19]/a_460_290# sky130_fd_pr_reram__reram_cell area_ox=0.0676
X5523 rr2t2r_0[12|19]/a_60_290# WL12 SL19 VSS sky130_fd_pr__nfet_g5v0d10v5 ad=0.65 pd=3.3 as=0 ps=0 w=1 l=0.5
X5524 rr2t2r_0[13|19]/a_460_290# WL13 SL19 VSS sky130_fd_pr__nfet_g5v0d10v5 ad=0.65 pd=3.3 as=0 ps=0 w=1 l=0.5
X5525 BLP19 rr2t2r_0[13|19]/a_60_290# sky130_fd_pr_reram__reram_cell area_ox=0.0676
X5526 BLN19 rr2t2r_0[13|19]/a_460_290# sky130_fd_pr_reram__reram_cell area_ox=0.0676
X5527 rr2t2r_0[13|19]/a_60_290# WL13 SL19 VSS sky130_fd_pr__nfet_g5v0d10v5 ad=0.65 pd=3.3 as=0 ps=0 w=1 l=0.5
X5528 rr2t2r_0[14|19]/a_460_290# WL14 SL19 VSS sky130_fd_pr__nfet_g5v0d10v5 ad=0.65 pd=3.3 as=0 ps=0 w=1 l=0.5
X5529 BLP19 rr2t2r_0[14|19]/a_60_290# sky130_fd_pr_reram__reram_cell area_ox=0.0676
X5530 BLN19 rr2t2r_0[14|19]/a_460_290# sky130_fd_pr_reram__reram_cell area_ox=0.0676
X5531 rr2t2r_0[14|19]/a_60_290# WL14 SL19 VSS sky130_fd_pr__nfet_g5v0d10v5 ad=0.65 pd=3.3 as=0 ps=0 w=1 l=0.5
X5532 rr2t2r_0[15|19]/a_460_290# WL15 SL19 VSS sky130_fd_pr__nfet_g5v0d10v5 ad=0.65 pd=3.3 as=0 ps=0 w=1 l=0.5
X5533 BLP19 rr2t2r_0[15|19]/a_60_290# sky130_fd_pr_reram__reram_cell area_ox=0.0676
X5534 BLN19 rr2t2r_0[15|19]/a_460_290# sky130_fd_pr_reram__reram_cell area_ox=0.0676
X5535 rr2t2r_0[15|19]/a_60_290# WL15 SL19 VSS sky130_fd_pr__nfet_g5v0d10v5 ad=0.65 pd=3.3 as=0 ps=0 w=1 l=0.5
X5536 rr2t2r_0[16|19]/a_460_290# WL16 SL19 VSS sky130_fd_pr__nfet_g5v0d10v5 ad=0.65 pd=3.3 as=0 ps=0 w=1 l=0.5
X5537 BLP19 rr2t2r_0[16|19]/a_60_290# sky130_fd_pr_reram__reram_cell area_ox=0.0676
X5538 BLN19 rr2t2r_0[16|19]/a_460_290# sky130_fd_pr_reram__reram_cell area_ox=0.0676
X5539 rr2t2r_0[16|19]/a_60_290# WL16 SL19 VSS sky130_fd_pr__nfet_g5v0d10v5 ad=0.65 pd=3.3 as=0 ps=0 w=1 l=0.5
X5540 rr2t2r_0[17|19]/a_460_290# WL17 SL19 VSS sky130_fd_pr__nfet_g5v0d10v5 ad=0.65 pd=3.3 as=0 ps=0 w=1 l=0.5
X5541 BLP19 rr2t2r_0[17|19]/a_60_290# sky130_fd_pr_reram__reram_cell area_ox=0.0676
X5542 BLN19 rr2t2r_0[17|19]/a_460_290# sky130_fd_pr_reram__reram_cell area_ox=0.0676
X5543 rr2t2r_0[17|19]/a_60_290# WL17 SL19 VSS sky130_fd_pr__nfet_g5v0d10v5 ad=0.65 pd=3.3 as=0 ps=0 w=1 l=0.5
X5544 rr2t2r_0[18|19]/a_460_290# WL18 SL19 VSS sky130_fd_pr__nfet_g5v0d10v5 ad=0.65 pd=3.3 as=0 ps=0 w=1 l=0.5
X5545 BLP19 rr2t2r_0[18|19]/a_60_290# sky130_fd_pr_reram__reram_cell area_ox=0.0676
X5546 BLN19 rr2t2r_0[18|19]/a_460_290# sky130_fd_pr_reram__reram_cell area_ox=0.0676
X5547 rr2t2r_0[18|19]/a_60_290# WL18 SL19 VSS sky130_fd_pr__nfet_g5v0d10v5 ad=0.65 pd=3.3 as=0 ps=0 w=1 l=0.5
X5548 rr2t2r_0[19|19]/a_460_290# WL19 SL19 VSS sky130_fd_pr__nfet_g5v0d10v5 ad=0.65 pd=3.3 as=0 ps=0 w=1 l=0.5
X5549 BLP19 rr2t2r_0[19|19]/a_60_290# sky130_fd_pr_reram__reram_cell area_ox=0.0676
X5550 BLN19 rr2t2r_0[19|19]/a_460_290# sky130_fd_pr_reram__reram_cell area_ox=0.0676
X5551 rr2t2r_0[19|19]/a_60_290# WL19 SL19 VSS sky130_fd_pr__nfet_g5v0d10v5 ad=0.65 pd=3.3 as=0 ps=0 w=1 l=0.5
X5552 rr2t2r_0[20|19]/a_460_290# WL20 SL19 VSS sky130_fd_pr__nfet_g5v0d10v5 ad=0.65 pd=3.3 as=0 ps=0 w=1 l=0.5
X5553 BLP19 rr2t2r_0[20|19]/a_60_290# sky130_fd_pr_reram__reram_cell area_ox=0.0676
X5554 BLN19 rr2t2r_0[20|19]/a_460_290# sky130_fd_pr_reram__reram_cell area_ox=0.0676
X5555 rr2t2r_0[20|19]/a_60_290# WL20 SL19 VSS sky130_fd_pr__nfet_g5v0d10v5 ad=0.65 pd=3.3 as=0 ps=0 w=1 l=0.5
X5556 rr2t2r_0[21|19]/a_460_290# WL21 SL19 VSS sky130_fd_pr__nfet_g5v0d10v5 ad=0.65 pd=3.3 as=0 ps=0 w=1 l=0.5
X5557 BLP19 rr2t2r_0[21|19]/a_60_290# sky130_fd_pr_reram__reram_cell area_ox=0.0676
X5558 BLN19 rr2t2r_0[21|19]/a_460_290# sky130_fd_pr_reram__reram_cell area_ox=0.0676
X5559 rr2t2r_0[21|19]/a_60_290# WL21 SL19 VSS sky130_fd_pr__nfet_g5v0d10v5 ad=0.65 pd=3.3 as=0 ps=0 w=1 l=0.5
X5560 rr2t2r_0[22|19]/a_460_290# WL22 SL19 VSS sky130_fd_pr__nfet_g5v0d10v5 ad=0.65 pd=3.3 as=0 ps=0 w=1 l=0.5
X5561 BLP19 rr2t2r_0[22|19]/a_60_290# sky130_fd_pr_reram__reram_cell area_ox=0.0676
X5562 BLN19 rr2t2r_0[22|19]/a_460_290# sky130_fd_pr_reram__reram_cell area_ox=0.0676
X5563 rr2t2r_0[22|19]/a_60_290# WL22 SL19 VSS sky130_fd_pr__nfet_g5v0d10v5 ad=0.65 pd=3.3 as=0 ps=0 w=1 l=0.5
X5564 rr2t2r_0[23|19]/a_460_290# WL23 SL19 VSS sky130_fd_pr__nfet_g5v0d10v5 ad=0.65 pd=3.3 as=0 ps=0 w=1 l=0.5
X5565 BLP19 rr2t2r_0[23|19]/a_60_290# sky130_fd_pr_reram__reram_cell area_ox=0.0676
X5566 BLN19 rr2t2r_0[23|19]/a_460_290# sky130_fd_pr_reram__reram_cell area_ox=0.0676
X5567 rr2t2r_0[23|19]/a_60_290# WL23 SL19 VSS sky130_fd_pr__nfet_g5v0d10v5 ad=0.65 pd=3.3 as=0 ps=0 w=1 l=0.5
X5568 rr2t2r_0[24|19]/a_460_290# WL24 SL19 VSS sky130_fd_pr__nfet_g5v0d10v5 ad=0.65 pd=3.3 as=0 ps=0 w=1 l=0.5
X5569 BLP19 rr2t2r_0[24|19]/a_60_290# sky130_fd_pr_reram__reram_cell area_ox=0.0676
X5570 BLN19 rr2t2r_0[24|19]/a_460_290# sky130_fd_pr_reram__reram_cell area_ox=0.0676
X5571 rr2t2r_0[24|19]/a_60_290# WL24 SL19 VSS sky130_fd_pr__nfet_g5v0d10v5 ad=0.65 pd=3.3 as=0 ps=0 w=1 l=0.5
X5572 rr2t2r_0[25|19]/a_460_290# WL25 SL19 VSS sky130_fd_pr__nfet_g5v0d10v5 ad=0.65 pd=3.3 as=0 ps=0 w=1 l=0.5
X5573 BLP19 rr2t2r_0[25|19]/a_60_290# sky130_fd_pr_reram__reram_cell area_ox=0.0676
X5574 BLN19 rr2t2r_0[25|19]/a_460_290# sky130_fd_pr_reram__reram_cell area_ox=0.0676
X5575 rr2t2r_0[25|19]/a_60_290# WL25 SL19 VSS sky130_fd_pr__nfet_g5v0d10v5 ad=0.65 pd=3.3 as=0 ps=0 w=1 l=0.5
X5576 rr2t2r_0[26|19]/a_460_290# WL26 SL19 VSS sky130_fd_pr__nfet_g5v0d10v5 ad=0.65 pd=3.3 as=0 ps=0 w=1 l=0.5
X5577 BLP19 rr2t2r_0[26|19]/a_60_290# sky130_fd_pr_reram__reram_cell area_ox=0.0676
X5578 BLN19 rr2t2r_0[26|19]/a_460_290# sky130_fd_pr_reram__reram_cell area_ox=0.0676
X5579 rr2t2r_0[26|19]/a_60_290# WL26 SL19 VSS sky130_fd_pr__nfet_g5v0d10v5 ad=0.65 pd=3.3 as=0 ps=0 w=1 l=0.5
X5580 rr2t2r_0[27|19]/a_460_290# WL27 SL19 VSS sky130_fd_pr__nfet_g5v0d10v5 ad=0.65 pd=3.3 as=0 ps=0 w=1 l=0.5
X5581 BLP19 rr2t2r_0[27|19]/a_60_290# sky130_fd_pr_reram__reram_cell area_ox=0.0676
X5582 BLN19 rr2t2r_0[27|19]/a_460_290# sky130_fd_pr_reram__reram_cell area_ox=0.0676
X5583 rr2t2r_0[27|19]/a_60_290# WL27 SL19 VSS sky130_fd_pr__nfet_g5v0d10v5 ad=0.65 pd=3.3 as=0 ps=0 w=1 l=0.5
X5584 rr2t2r_0[28|19]/a_460_290# WL28 SL19 VSS sky130_fd_pr__nfet_g5v0d10v5 ad=0.65 pd=3.3 as=0 ps=0 w=1 l=0.5
X5585 BLP19 rr2t2r_0[28|19]/a_60_290# sky130_fd_pr_reram__reram_cell area_ox=0.0676
X5586 BLN19 rr2t2r_0[28|19]/a_460_290# sky130_fd_pr_reram__reram_cell area_ox=0.0676
X5587 rr2t2r_0[28|19]/a_60_290# WL28 SL19 VSS sky130_fd_pr__nfet_g5v0d10v5 ad=0.65 pd=3.3 as=0 ps=0 w=1 l=0.5
X5588 rr2t2r_0[29|19]/a_460_290# WL29 SL19 VSS sky130_fd_pr__nfet_g5v0d10v5 ad=0.65 pd=3.3 as=0 ps=0 w=1 l=0.5
X5589 BLP19 rr2t2r_0[29|19]/a_60_290# sky130_fd_pr_reram__reram_cell area_ox=0.0676
X5590 BLN19 rr2t2r_0[29|19]/a_460_290# sky130_fd_pr_reram__reram_cell area_ox=0.0676
X5591 rr2t2r_0[29|19]/a_60_290# WL29 SL19 VSS sky130_fd_pr__nfet_g5v0d10v5 ad=0.65 pd=3.3 as=0 ps=0 w=1 l=0.5
X5592 rr2t2r_0[30|19]/a_460_290# WL30 SL19 VSS sky130_fd_pr__nfet_g5v0d10v5 ad=0.65 pd=3.3 as=0 ps=0 w=1 l=0.5
X5593 BLP19 rr2t2r_0[30|19]/a_60_290# sky130_fd_pr_reram__reram_cell area_ox=0.0676
X5594 BLN19 rr2t2r_0[30|19]/a_460_290# sky130_fd_pr_reram__reram_cell area_ox=0.0676
X5595 rr2t2r_0[30|19]/a_60_290# WL30 SL19 VSS sky130_fd_pr__nfet_g5v0d10v5 ad=0.65 pd=3.3 as=0 ps=0 w=1 l=0.5
X5596 rr2t2r_0[31|19]/a_460_290# WL31 SL19 VSS sky130_fd_pr__nfet_g5v0d10v5 ad=0.65 pd=3.3 as=0 ps=0 w=1 l=0.5
X5597 BLP19 rr2t2r_0[31|19]/a_60_290# sky130_fd_pr_reram__reram_cell area_ox=0.0676
X5598 BLN19 rr2t2r_0[31|19]/a_460_290# sky130_fd_pr_reram__reram_cell area_ox=0.0676
X5599 rr2t2r_0[31|19]/a_60_290# WL31 SL19 VSS sky130_fd_pr__nfet_g5v0d10v5 ad=0.65 pd=3.3 as=0 ps=0 w=1 l=0.5
X5600 rr2t2r_0[32|19]/a_460_290# WL32 SL19 VSS sky130_fd_pr__nfet_g5v0d10v5 ad=0.65 pd=3.3 as=0 ps=0 w=1 l=0.5
X5601 BLP19 rr2t2r_0[32|19]/a_60_290# sky130_fd_pr_reram__reram_cell area_ox=0.0676
X5602 BLN19 rr2t2r_0[32|19]/a_460_290# sky130_fd_pr_reram__reram_cell area_ox=0.0676
X5603 rr2t2r_0[32|19]/a_60_290# WL32 SL19 VSS sky130_fd_pr__nfet_g5v0d10v5 ad=0.65 pd=3.3 as=0 ps=0 w=1 l=0.5
X5604 rr2t2r_0[33|19]/a_460_290# WL33 SL19 VSS sky130_fd_pr__nfet_g5v0d10v5 ad=0.65 pd=3.3 as=0 ps=0 w=1 l=0.5
X5605 BLP19 rr2t2r_0[33|19]/a_60_290# sky130_fd_pr_reram__reram_cell area_ox=0.0676
X5606 BLN19 rr2t2r_0[33|19]/a_460_290# sky130_fd_pr_reram__reram_cell area_ox=0.0676
X5607 rr2t2r_0[33|19]/a_60_290# WL33 SL19 VSS sky130_fd_pr__nfet_g5v0d10v5 ad=0.65 pd=3.3 as=0 ps=0 w=1 l=0.5
X5608 rr2t2r_0[34|19]/a_460_290# WL34 SL19 VSS sky130_fd_pr__nfet_g5v0d10v5 ad=0.65 pd=3.3 as=0 ps=0 w=1 l=0.5
X5609 BLP19 rr2t2r_0[34|19]/a_60_290# sky130_fd_pr_reram__reram_cell area_ox=0.0676
X5610 BLN19 rr2t2r_0[34|19]/a_460_290# sky130_fd_pr_reram__reram_cell area_ox=0.0676
X5611 rr2t2r_0[34|19]/a_60_290# WL34 SL19 VSS sky130_fd_pr__nfet_g5v0d10v5 ad=0.65 pd=3.3 as=0 ps=0 w=1 l=0.5
X5612 rr2t2r_0[35|19]/a_460_290# WL35 SL19 VSS sky130_fd_pr__nfet_g5v0d10v5 ad=0.65 pd=3.3 as=0 ps=0 w=1 l=0.5
X5613 BLP19 rr2t2r_0[35|19]/a_60_290# sky130_fd_pr_reram__reram_cell area_ox=0.0676
X5614 BLN19 rr2t2r_0[35|19]/a_460_290# sky130_fd_pr_reram__reram_cell area_ox=0.0676
X5615 rr2t2r_0[35|19]/a_60_290# WL35 SL19 VSS sky130_fd_pr__nfet_g5v0d10v5 ad=0.65 pd=3.3 as=0 ps=0 w=1 l=0.5
X5616 rr2t2r_0[36|19]/a_460_290# WL36 SL19 VSS sky130_fd_pr__nfet_g5v0d10v5 ad=0.65 pd=3.3 as=0 ps=0 w=1 l=0.5
X5617 BLP19 rr2t2r_0[36|19]/a_60_290# sky130_fd_pr_reram__reram_cell area_ox=0.0676
X5618 BLN19 rr2t2r_0[36|19]/a_460_290# sky130_fd_pr_reram__reram_cell area_ox=0.0676
X5619 rr2t2r_0[36|19]/a_60_290# WL36 SL19 VSS sky130_fd_pr__nfet_g5v0d10v5 ad=0.65 pd=3.3 as=0 ps=0 w=1 l=0.5
X5620 rr2t2r_0[37|19]/a_460_290# WL37 SL19 VSS sky130_fd_pr__nfet_g5v0d10v5 ad=0.65 pd=3.3 as=0 ps=0 w=1 l=0.5
X5621 BLP19 rr2t2r_0[37|19]/a_60_290# sky130_fd_pr_reram__reram_cell area_ox=0.0676
X5622 BLN19 rr2t2r_0[37|19]/a_460_290# sky130_fd_pr_reram__reram_cell area_ox=0.0676
X5623 rr2t2r_0[37|19]/a_60_290# WL37 SL19 VSS sky130_fd_pr__nfet_g5v0d10v5 ad=0.65 pd=3.3 as=0 ps=0 w=1 l=0.5
X5624 rr2t2r_0[38|19]/a_460_290# WL38 SL19 VSS sky130_fd_pr__nfet_g5v0d10v5 ad=0.65 pd=3.3 as=0 ps=0 w=1 l=0.5
X5625 BLP19 rr2t2r_0[38|19]/a_60_290# sky130_fd_pr_reram__reram_cell area_ox=0.0676
X5626 BLN19 rr2t2r_0[38|19]/a_460_290# sky130_fd_pr_reram__reram_cell area_ox=0.0676
X5627 rr2t2r_0[38|19]/a_60_290# WL38 SL19 VSS sky130_fd_pr__nfet_g5v0d10v5 ad=0.65 pd=3.3 as=0 ps=0 w=1 l=0.5
X5628 rr2t2r_0[39|19]/a_460_290# WL39 SL19 VSS sky130_fd_pr__nfet_g5v0d10v5 ad=0.65 pd=3.3 as=0 ps=0 w=1 l=0.5
X5629 BLP19 rr2t2r_0[39|19]/a_60_290# sky130_fd_pr_reram__reram_cell area_ox=0.0676
X5630 BLN19 rr2t2r_0[39|19]/a_460_290# sky130_fd_pr_reram__reram_cell area_ox=0.0676
X5631 rr2t2r_0[39|19]/a_60_290# WL39 SL19 VSS sky130_fd_pr__nfet_g5v0d10v5 ad=0.65 pd=3.3 as=0 ps=0 w=1 l=0.5
X5632 rr2t2r_0[40|19]/a_460_290# WL40 SL19 VSS sky130_fd_pr__nfet_g5v0d10v5 ad=0.65 pd=3.3 as=0 ps=0 w=1 l=0.5
X5633 BLP19 rr2t2r_0[40|19]/a_60_290# sky130_fd_pr_reram__reram_cell area_ox=0.0676
X5634 BLN19 rr2t2r_0[40|19]/a_460_290# sky130_fd_pr_reram__reram_cell area_ox=0.0676
X5635 rr2t2r_0[40|19]/a_60_290# WL40 SL19 VSS sky130_fd_pr__nfet_g5v0d10v5 ad=0.65 pd=3.3 as=0 ps=0 w=1 l=0.5
X5636 rr2t2r_0[41|19]/a_460_290# WL41 SL19 VSS sky130_fd_pr__nfet_g5v0d10v5 ad=0.65 pd=3.3 as=0 ps=0 w=1 l=0.5
X5637 BLP19 rr2t2r_0[41|19]/a_60_290# sky130_fd_pr_reram__reram_cell area_ox=0.0676
X5638 BLN19 rr2t2r_0[41|19]/a_460_290# sky130_fd_pr_reram__reram_cell area_ox=0.0676
X5639 rr2t2r_0[41|19]/a_60_290# WL41 SL19 VSS sky130_fd_pr__nfet_g5v0d10v5 ad=0.65 pd=3.3 as=0 ps=0 w=1 l=0.5
X5640 rr2t2r_0[42|19]/a_460_290# WL42 SL19 VSS sky130_fd_pr__nfet_g5v0d10v5 ad=0.65 pd=3.3 as=0 ps=0 w=1 l=0.5
X5641 BLP19 rr2t2r_0[42|19]/a_60_290# sky130_fd_pr_reram__reram_cell area_ox=0.0676
X5642 BLN19 rr2t2r_0[42|19]/a_460_290# sky130_fd_pr_reram__reram_cell area_ox=0.0676
X5643 rr2t2r_0[42|19]/a_60_290# WL42 SL19 VSS sky130_fd_pr__nfet_g5v0d10v5 ad=0.65 pd=3.3 as=0 ps=0 w=1 l=0.5
X5644 rr2t2r_0[43|19]/a_460_290# WL43 SL19 VSS sky130_fd_pr__nfet_g5v0d10v5 ad=0.65 pd=3.3 as=0 ps=0 w=1 l=0.5
X5645 BLP19 rr2t2r_0[43|19]/a_60_290# sky130_fd_pr_reram__reram_cell area_ox=0.0676
X5646 BLN19 rr2t2r_0[43|19]/a_460_290# sky130_fd_pr_reram__reram_cell area_ox=0.0676
X5647 rr2t2r_0[43|19]/a_60_290# WL43 SL19 VSS sky130_fd_pr__nfet_g5v0d10v5 ad=0.65 pd=3.3 as=0 ps=0 w=1 l=0.5
X5648 rr2t2r_0[44|19]/a_460_290# WL44 SL19 VSS sky130_fd_pr__nfet_g5v0d10v5 ad=0.65 pd=3.3 as=0 ps=0 w=1 l=0.5
X5649 BLP19 rr2t2r_0[44|19]/a_60_290# sky130_fd_pr_reram__reram_cell area_ox=0.0676
X5650 BLN19 rr2t2r_0[44|19]/a_460_290# sky130_fd_pr_reram__reram_cell area_ox=0.0676
X5651 rr2t2r_0[44|19]/a_60_290# WL44 SL19 VSS sky130_fd_pr__nfet_g5v0d10v5 ad=0.65 pd=3.3 as=0 ps=0 w=1 l=0.5
X5652 rr2t2r_0[45|19]/a_460_290# WL45 SL19 VSS sky130_fd_pr__nfet_g5v0d10v5 ad=0.65 pd=3.3 as=0 ps=0 w=1 l=0.5
X5653 BLP19 rr2t2r_0[45|19]/a_60_290# sky130_fd_pr_reram__reram_cell area_ox=0.0676
X5654 BLN19 rr2t2r_0[45|19]/a_460_290# sky130_fd_pr_reram__reram_cell area_ox=0.0676
X5655 rr2t2r_0[45|19]/a_60_290# WL45 SL19 VSS sky130_fd_pr__nfet_g5v0d10v5 ad=0.65 pd=3.3 as=0 ps=0 w=1 l=0.5
X5656 rr2t2r_0[46|19]/a_460_290# WL46 SL19 VSS sky130_fd_pr__nfet_g5v0d10v5 ad=0.65 pd=3.3 as=0 ps=0 w=1 l=0.5
X5657 BLP19 rr2t2r_0[46|19]/a_60_290# sky130_fd_pr_reram__reram_cell area_ox=0.0676
X5658 BLN19 rr2t2r_0[46|19]/a_460_290# sky130_fd_pr_reram__reram_cell area_ox=0.0676
X5659 rr2t2r_0[46|19]/a_60_290# WL46 SL19 VSS sky130_fd_pr__nfet_g5v0d10v5 ad=0.65 pd=3.3 as=0 ps=0 w=1 l=0.5
X5660 rr2t2r_0[47|19]/a_460_290# WL47 SL19 VSS sky130_fd_pr__nfet_g5v0d10v5 ad=0.65 pd=3.3 as=0 ps=0 w=1 l=0.5
X5661 BLP19 rr2t2r_0[47|19]/a_60_290# sky130_fd_pr_reram__reram_cell area_ox=0.0676
X5662 BLN19 rr2t2r_0[47|19]/a_460_290# sky130_fd_pr_reram__reram_cell area_ox=0.0676
X5663 rr2t2r_0[47|19]/a_60_290# WL47 SL19 VSS sky130_fd_pr__nfet_g5v0d10v5 ad=0.65 pd=3.3 as=0 ps=0 w=1 l=0.5
X5664 rr2t2r_0[48|19]/a_460_290# WL48 SL19 VSS sky130_fd_pr__nfet_g5v0d10v5 ad=0.65 pd=3.3 as=0 ps=0 w=1 l=0.5
X5665 BLP19 rr2t2r_0[48|19]/a_60_290# sky130_fd_pr_reram__reram_cell area_ox=0.0676
X5666 BLN19 rr2t2r_0[48|19]/a_460_290# sky130_fd_pr_reram__reram_cell area_ox=0.0676
X5667 rr2t2r_0[48|19]/a_60_290# WL48 SL19 VSS sky130_fd_pr__nfet_g5v0d10v5 ad=0.65 pd=3.3 as=0 ps=0 w=1 l=0.5
X5668 rr2t2r_0[49|19]/a_460_290# WL49 SL19 VSS sky130_fd_pr__nfet_g5v0d10v5 ad=0.65 pd=3.3 as=0 ps=0 w=1 l=0.5
X5669 BLP19 rr2t2r_0[49|19]/a_60_290# sky130_fd_pr_reram__reram_cell area_ox=0.0676
X5670 BLN19 rr2t2r_0[49|19]/a_460_290# sky130_fd_pr_reram__reram_cell area_ox=0.0676
X5671 rr2t2r_0[49|19]/a_60_290# WL49 SL19 VSS sky130_fd_pr__nfet_g5v0d10v5 ad=0.65 pd=3.3 as=0 ps=0 w=1 l=0.5
X5672 rr2t2r_0[50|19]/a_460_290# WL50 SL19 VSS sky130_fd_pr__nfet_g5v0d10v5 ad=0.65 pd=3.3 as=0 ps=0 w=1 l=0.5
X5673 BLP19 rr2t2r_0[50|19]/a_60_290# sky130_fd_pr_reram__reram_cell area_ox=0.0676
X5674 BLN19 rr2t2r_0[50|19]/a_460_290# sky130_fd_pr_reram__reram_cell area_ox=0.0676
X5675 rr2t2r_0[50|19]/a_60_290# WL50 SL19 VSS sky130_fd_pr__nfet_g5v0d10v5 ad=0.65 pd=3.3 as=0 ps=0 w=1 l=0.5
X5676 rr2t2r_0[51|19]/a_460_290# WL51 SL19 VSS sky130_fd_pr__nfet_g5v0d10v5 ad=0.65 pd=3.3 as=0 ps=0 w=1 l=0.5
X5677 BLP19 rr2t2r_0[51|19]/a_60_290# sky130_fd_pr_reram__reram_cell area_ox=0.0676
X5678 BLN19 rr2t2r_0[51|19]/a_460_290# sky130_fd_pr_reram__reram_cell area_ox=0.0676
X5679 rr2t2r_0[51|19]/a_60_290# WL51 SL19 VSS sky130_fd_pr__nfet_g5v0d10v5 ad=0.65 pd=3.3 as=0 ps=0 w=1 l=0.5
X5680 rr2t2r_0[52|19]/a_460_290# WL52 SL19 VSS sky130_fd_pr__nfet_g5v0d10v5 ad=0.65 pd=3.3 as=0 ps=0 w=1 l=0.5
X5681 BLP19 rr2t2r_0[52|19]/a_60_290# sky130_fd_pr_reram__reram_cell area_ox=0.0676
X5682 BLN19 rr2t2r_0[52|19]/a_460_290# sky130_fd_pr_reram__reram_cell area_ox=0.0676
X5683 rr2t2r_0[52|19]/a_60_290# WL52 SL19 VSS sky130_fd_pr__nfet_g5v0d10v5 ad=0.65 pd=3.3 as=0 ps=0 w=1 l=0.5
X5684 rr2t2r_0[53|19]/a_460_290# WL53 SL19 VSS sky130_fd_pr__nfet_g5v0d10v5 ad=0.65 pd=3.3 as=0 ps=0 w=1 l=0.5
X5685 BLP19 rr2t2r_0[53|19]/a_60_290# sky130_fd_pr_reram__reram_cell area_ox=0.0676
X5686 BLN19 rr2t2r_0[53|19]/a_460_290# sky130_fd_pr_reram__reram_cell area_ox=0.0676
X5687 rr2t2r_0[53|19]/a_60_290# WL53 SL19 VSS sky130_fd_pr__nfet_g5v0d10v5 ad=0.65 pd=3.3 as=0 ps=0 w=1 l=0.5
X5688 rr2t2r_0[54|19]/a_460_290# WL54 SL19 VSS sky130_fd_pr__nfet_g5v0d10v5 ad=0.65 pd=3.3 as=0 ps=0 w=1 l=0.5
X5689 BLP19 rr2t2r_0[54|19]/a_60_290# sky130_fd_pr_reram__reram_cell area_ox=0.0676
X5690 BLN19 rr2t2r_0[54|19]/a_460_290# sky130_fd_pr_reram__reram_cell area_ox=0.0676
X5691 rr2t2r_0[54|19]/a_60_290# WL54 SL19 VSS sky130_fd_pr__nfet_g5v0d10v5 ad=0.65 pd=3.3 as=0 ps=0 w=1 l=0.5
X5692 rr2t2r_0[55|19]/a_460_290# WL55 SL19 VSS sky130_fd_pr__nfet_g5v0d10v5 ad=0.65 pd=3.3 as=0 ps=0 w=1 l=0.5
X5693 BLP19 rr2t2r_0[55|19]/a_60_290# sky130_fd_pr_reram__reram_cell area_ox=0.0676
X5694 BLN19 rr2t2r_0[55|19]/a_460_290# sky130_fd_pr_reram__reram_cell area_ox=0.0676
X5695 rr2t2r_0[55|19]/a_60_290# WL55 SL19 VSS sky130_fd_pr__nfet_g5v0d10v5 ad=0.65 pd=3.3 as=0 ps=0 w=1 l=0.5
X5696 rr2t2r_0[56|19]/a_460_290# WL56 SL19 VSS sky130_fd_pr__nfet_g5v0d10v5 ad=0.65 pd=3.3 as=0 ps=0 w=1 l=0.5
X5697 BLP19 rr2t2r_0[56|19]/a_60_290# sky130_fd_pr_reram__reram_cell area_ox=0.0676
X5698 BLN19 rr2t2r_0[56|19]/a_460_290# sky130_fd_pr_reram__reram_cell area_ox=0.0676
X5699 rr2t2r_0[56|19]/a_60_290# WL56 SL19 VSS sky130_fd_pr__nfet_g5v0d10v5 ad=0.65 pd=3.3 as=0 ps=0 w=1 l=0.5
X5700 rr2t2r_0[57|19]/a_460_290# WL57 SL19 VSS sky130_fd_pr__nfet_g5v0d10v5 ad=0.65 pd=3.3 as=0 ps=0 w=1 l=0.5
X5701 BLP19 rr2t2r_0[57|19]/a_60_290# sky130_fd_pr_reram__reram_cell area_ox=0.0676
X5702 BLN19 rr2t2r_0[57|19]/a_460_290# sky130_fd_pr_reram__reram_cell area_ox=0.0676
X5703 rr2t2r_0[57|19]/a_60_290# WL57 SL19 VSS sky130_fd_pr__nfet_g5v0d10v5 ad=0.65 pd=3.3 as=0 ps=0 w=1 l=0.5
X5704 rr2t2r_0[58|19]/a_460_290# WL58 SL19 VSS sky130_fd_pr__nfet_g5v0d10v5 ad=0.65 pd=3.3 as=0 ps=0 w=1 l=0.5
X5705 BLP19 rr2t2r_0[58|19]/a_60_290# sky130_fd_pr_reram__reram_cell area_ox=0.0676
X5706 BLN19 rr2t2r_0[58|19]/a_460_290# sky130_fd_pr_reram__reram_cell area_ox=0.0676
X5707 rr2t2r_0[58|19]/a_60_290# WL58 SL19 VSS sky130_fd_pr__nfet_g5v0d10v5 ad=0.65 pd=3.3 as=0 ps=0 w=1 l=0.5
X5708 rr2t2r_0[59|19]/a_460_290# WL59 SL19 VSS sky130_fd_pr__nfet_g5v0d10v5 ad=0.65 pd=3.3 as=0 ps=0 w=1 l=0.5
X5709 BLP19 rr2t2r_0[59|19]/a_60_290# sky130_fd_pr_reram__reram_cell area_ox=0.0676
X5710 BLN19 rr2t2r_0[59|19]/a_460_290# sky130_fd_pr_reram__reram_cell area_ox=0.0676
X5711 rr2t2r_0[59|19]/a_60_290# WL59 SL19 VSS sky130_fd_pr__nfet_g5v0d10v5 ad=0.65 pd=3.3 as=0 ps=0 w=1 l=0.5
X5712 rr2t2r_0[60|19]/a_460_290# WL60 SL19 VSS sky130_fd_pr__nfet_g5v0d10v5 ad=0.65 pd=3.3 as=0 ps=0 w=1 l=0.5
X5713 BLP19 rr2t2r_0[60|19]/a_60_290# sky130_fd_pr_reram__reram_cell area_ox=0.0676
X5714 BLN19 rr2t2r_0[60|19]/a_460_290# sky130_fd_pr_reram__reram_cell area_ox=0.0676
X5715 rr2t2r_0[60|19]/a_60_290# WL60 SL19 VSS sky130_fd_pr__nfet_g5v0d10v5 ad=0.65 pd=3.3 as=0 ps=0 w=1 l=0.5
X5716 rr2t2r_0[61|19]/a_460_290# WL61 SL19 VSS sky130_fd_pr__nfet_g5v0d10v5 ad=0.65 pd=3.3 as=0 ps=0 w=1 l=0.5
X5717 BLP19 rr2t2r_0[61|19]/a_60_290# sky130_fd_pr_reram__reram_cell area_ox=0.0676
X5718 BLN19 rr2t2r_0[61|19]/a_460_290# sky130_fd_pr_reram__reram_cell area_ox=0.0676
X5719 rr2t2r_0[61|19]/a_60_290# WL61 SL19 VSS sky130_fd_pr__nfet_g5v0d10v5 ad=0.65 pd=3.3 as=0 ps=0 w=1 l=0.5
X5720 rr2t2r_0[62|19]/a_460_290# WL62 SL19 VSS sky130_fd_pr__nfet_g5v0d10v5 ad=0.65 pd=3.3 as=0 ps=0 w=1 l=0.5
X5721 BLP19 rr2t2r_0[62|19]/a_60_290# sky130_fd_pr_reram__reram_cell area_ox=0.0676
X5722 BLN19 rr2t2r_0[62|19]/a_460_290# sky130_fd_pr_reram__reram_cell area_ox=0.0676
X5723 rr2t2r_0[62|19]/a_60_290# WL62 SL19 VSS sky130_fd_pr__nfet_g5v0d10v5 ad=0.65 pd=3.3 as=0 ps=0 w=1 l=0.5
X5724 rr2t2r_0[63|19]/a_460_290# WL63 SL19 VSS sky130_fd_pr__nfet_g5v0d10v5 ad=0.65 pd=3.3 as=0 ps=0 w=1 l=0.5
X5725 BLP19 rr2t2r_0[63|19]/a_60_290# sky130_fd_pr_reram__reram_cell area_ox=0.0676
X5726 BLN19 rr2t2r_0[63|19]/a_460_290# sky130_fd_pr_reram__reram_cell area_ox=0.0676
X5727 rr2t2r_0[63|19]/a_60_290# WL63 SL19 VSS sky130_fd_pr__nfet_g5v0d10v5 ad=0.65 pd=3.3 as=0 ps=0 w=1 l=0.5
X5728 rr2t2r_0[64|19]/a_460_290# WL64 SL19 VSS sky130_fd_pr__nfet_g5v0d10v5 ad=0.65 pd=3.3 as=0 ps=0 w=1 l=0.5
X5729 BLP19 rr2t2r_0[64|19]/a_60_290# sky130_fd_pr_reram__reram_cell area_ox=0.0676
X5730 BLN19 rr2t2r_0[64|19]/a_460_290# sky130_fd_pr_reram__reram_cell area_ox=0.0676
X5731 rr2t2r_0[64|19]/a_60_290# WL64 SL19 VSS sky130_fd_pr__nfet_g5v0d10v5 ad=0.65 pd=3.3 as=0 ps=0 w=1 l=0.5
X5732 rr2t2r_0[65|19]/a_460_290# WL65 SL19 VSS sky130_fd_pr__nfet_g5v0d10v5 ad=0.65 pd=3.3 as=0 ps=0 w=1 l=0.5
X5733 BLP19 rr2t2r_0[65|19]/a_60_290# sky130_fd_pr_reram__reram_cell area_ox=0.0676
X5734 BLN19 rr2t2r_0[65|19]/a_460_290# sky130_fd_pr_reram__reram_cell area_ox=0.0676
X5735 rr2t2r_0[65|19]/a_60_290# WL65 SL19 VSS sky130_fd_pr__nfet_g5v0d10v5 ad=0.65 pd=3.3 as=0 ps=0 w=1 l=0.5
X5736 rr2t2r_0[66|19]/a_460_290# WL66 SL19 VSS sky130_fd_pr__nfet_g5v0d10v5 ad=0.65 pd=3.3 as=0 ps=0 w=1 l=0.5
X5737 BLP19 rr2t2r_0[66|19]/a_60_290# sky130_fd_pr_reram__reram_cell area_ox=0.0676
X5738 BLN19 rr2t2r_0[66|19]/a_460_290# sky130_fd_pr_reram__reram_cell area_ox=0.0676
X5739 rr2t2r_0[66|19]/a_60_290# WL66 SL19 VSS sky130_fd_pr__nfet_g5v0d10v5 ad=0.65 pd=3.3 as=0 ps=0 w=1 l=0.5
X5740 rr2t2r_0[67|19]/a_460_290# WL67 SL19 VSS sky130_fd_pr__nfet_g5v0d10v5 ad=0.65 pd=3.3 as=0 ps=0 w=1 l=0.5
X5741 BLP19 rr2t2r_0[67|19]/a_60_290# sky130_fd_pr_reram__reram_cell area_ox=0.0676
X5742 BLN19 rr2t2r_0[67|19]/a_460_290# sky130_fd_pr_reram__reram_cell area_ox=0.0676
X5743 rr2t2r_0[67|19]/a_60_290# WL67 SL19 VSS sky130_fd_pr__nfet_g5v0d10v5 ad=0.65 pd=3.3 as=0 ps=0 w=1 l=0.5
X5744 rr2t2r_0[68|19]/a_460_290# WL68 SL19 VSS sky130_fd_pr__nfet_g5v0d10v5 ad=0.65 pd=3.3 as=0 ps=0 w=1 l=0.5
X5745 BLP19 rr2t2r_0[68|19]/a_60_290# sky130_fd_pr_reram__reram_cell area_ox=0.0676
X5746 BLN19 rr2t2r_0[68|19]/a_460_290# sky130_fd_pr_reram__reram_cell area_ox=0.0676
X5747 rr2t2r_0[68|19]/a_60_290# WL68 SL19 VSS sky130_fd_pr__nfet_g5v0d10v5 ad=0.65 pd=3.3 as=0 ps=0 w=1 l=0.5
X5748 rr2t2r_0[69|19]/a_460_290# WL69 SL19 VSS sky130_fd_pr__nfet_g5v0d10v5 ad=0.65 pd=3.3 as=0 ps=0 w=1 l=0.5
X5749 BLP19 rr2t2r_0[69|19]/a_60_290# sky130_fd_pr_reram__reram_cell area_ox=0.0676
X5750 BLN19 rr2t2r_0[69|19]/a_460_290# sky130_fd_pr_reram__reram_cell area_ox=0.0676
X5751 rr2t2r_0[69|19]/a_60_290# WL69 SL19 VSS sky130_fd_pr__nfet_g5v0d10v5 ad=0.65 pd=3.3 as=0 ps=0 w=1 l=0.5
X5752 rr2t2r_0[70|19]/a_460_290# WL70 SL19 VSS sky130_fd_pr__nfet_g5v0d10v5 ad=0.65 pd=3.3 as=0 ps=0 w=1 l=0.5
X5753 BLP19 rr2t2r_0[70|19]/a_60_290# sky130_fd_pr_reram__reram_cell area_ox=0.0676
X5754 BLN19 rr2t2r_0[70|19]/a_460_290# sky130_fd_pr_reram__reram_cell area_ox=0.0676
X5755 rr2t2r_0[70|19]/a_60_290# WL70 SL19 VSS sky130_fd_pr__nfet_g5v0d10v5 ad=0.65 pd=3.3 as=0 ps=0 w=1 l=0.5
X5756 rr2t2r_0[71|19]/a_460_290# WL71 SL19 VSS sky130_fd_pr__nfet_g5v0d10v5 ad=0.65 pd=3.3 as=0 ps=0 w=1 l=0.5
X5757 BLP19 rr2t2r_0[71|19]/a_60_290# sky130_fd_pr_reram__reram_cell area_ox=0.0676
X5758 BLN19 rr2t2r_0[71|19]/a_460_290# sky130_fd_pr_reram__reram_cell area_ox=0.0676
X5759 rr2t2r_0[71|19]/a_60_290# WL71 SL19 VSS sky130_fd_pr__nfet_g5v0d10v5 ad=0.65 pd=3.3 as=0 ps=0 w=1 l=0.5
X5760 rr2t2r_0[0|20]/a_460_290# WL0 SL20 VSS sky130_fd_pr__nfet_g5v0d10v5 ad=0.65 pd=3.3 as=108 ps=504 w=1 l=0.5
X5761 BLP20 rr2t2r_0[0|20]/a_60_290# sky130_fd_pr_reram__reram_cell area_ox=0.0676
X5762 BLN20 rr2t2r_0[0|20]/a_460_290# sky130_fd_pr_reram__reram_cell area_ox=0.0676
X5763 rr2t2r_0[0|20]/a_60_290# WL0 SL20 VSS sky130_fd_pr__nfet_g5v0d10v5 ad=0.65 pd=3.3 as=0 ps=0 w=1 l=0.5
X5764 rr2t2r_0[1|20]/a_460_290# WL1 SL20 VSS sky130_fd_pr__nfet_g5v0d10v5 ad=0.65 pd=3.3 as=0 ps=0 w=1 l=0.5
X5765 BLP20 rr2t2r_0[1|20]/a_60_290# sky130_fd_pr_reram__reram_cell area_ox=0.0676
X5766 BLN20 rr2t2r_0[1|20]/a_460_290# sky130_fd_pr_reram__reram_cell area_ox=0.0676
X5767 rr2t2r_0[1|20]/a_60_290# WL1 SL20 VSS sky130_fd_pr__nfet_g5v0d10v5 ad=0.65 pd=3.3 as=0 ps=0 w=1 l=0.5
X5768 rr2t2r_0[2|20]/a_460_290# WL2 SL20 VSS sky130_fd_pr__nfet_g5v0d10v5 ad=0.65 pd=3.3 as=0 ps=0 w=1 l=0.5
X5769 BLP20 rr2t2r_0[2|20]/a_60_290# sky130_fd_pr_reram__reram_cell area_ox=0.0676
X5770 BLN20 rr2t2r_0[2|20]/a_460_290# sky130_fd_pr_reram__reram_cell area_ox=0.0676
X5771 rr2t2r_0[2|20]/a_60_290# WL2 SL20 VSS sky130_fd_pr__nfet_g5v0d10v5 ad=0.65 pd=3.3 as=0 ps=0 w=1 l=0.5
X5772 rr2t2r_0[3|20]/a_460_290# WL3 SL20 VSS sky130_fd_pr__nfet_g5v0d10v5 ad=0.65 pd=3.3 as=0 ps=0 w=1 l=0.5
X5773 BLP20 rr2t2r_0[3|20]/a_60_290# sky130_fd_pr_reram__reram_cell area_ox=0.0676
X5774 BLN20 rr2t2r_0[3|20]/a_460_290# sky130_fd_pr_reram__reram_cell area_ox=0.0676
X5775 rr2t2r_0[3|20]/a_60_290# WL3 SL20 VSS sky130_fd_pr__nfet_g5v0d10v5 ad=0.65 pd=3.3 as=0 ps=0 w=1 l=0.5
X5776 rr2t2r_0[4|20]/a_460_290# WL4 SL20 VSS sky130_fd_pr__nfet_g5v0d10v5 ad=0.65 pd=3.3 as=0 ps=0 w=1 l=0.5
X5777 BLP20 rr2t2r_0[4|20]/a_60_290# sky130_fd_pr_reram__reram_cell area_ox=0.0676
X5778 BLN20 rr2t2r_0[4|20]/a_460_290# sky130_fd_pr_reram__reram_cell area_ox=0.0676
X5779 rr2t2r_0[4|20]/a_60_290# WL4 SL20 VSS sky130_fd_pr__nfet_g5v0d10v5 ad=0.65 pd=3.3 as=0 ps=0 w=1 l=0.5
X5780 rr2t2r_0[5|20]/a_460_290# WL5 SL20 VSS sky130_fd_pr__nfet_g5v0d10v5 ad=0.65 pd=3.3 as=0 ps=0 w=1 l=0.5
X5781 BLP20 rr2t2r_0[5|20]/a_60_290# sky130_fd_pr_reram__reram_cell area_ox=0.0676
X5782 BLN20 rr2t2r_0[5|20]/a_460_290# sky130_fd_pr_reram__reram_cell area_ox=0.0676
X5783 rr2t2r_0[5|20]/a_60_290# WL5 SL20 VSS sky130_fd_pr__nfet_g5v0d10v5 ad=0.65 pd=3.3 as=0 ps=0 w=1 l=0.5
X5784 rr2t2r_0[6|20]/a_460_290# WL6 SL20 VSS sky130_fd_pr__nfet_g5v0d10v5 ad=0.65 pd=3.3 as=0 ps=0 w=1 l=0.5
X5785 BLP20 rr2t2r_0[6|20]/a_60_290# sky130_fd_pr_reram__reram_cell area_ox=0.0676
X5786 BLN20 rr2t2r_0[6|20]/a_460_290# sky130_fd_pr_reram__reram_cell area_ox=0.0676
X5787 rr2t2r_0[6|20]/a_60_290# WL6 SL20 VSS sky130_fd_pr__nfet_g5v0d10v5 ad=0.65 pd=3.3 as=0 ps=0 w=1 l=0.5
X5788 rr2t2r_0[7|20]/a_460_290# WL7 SL20 VSS sky130_fd_pr__nfet_g5v0d10v5 ad=0.65 pd=3.3 as=0 ps=0 w=1 l=0.5
X5789 BLP20 rr2t2r_0[7|20]/a_60_290# sky130_fd_pr_reram__reram_cell area_ox=0.0676
X5790 BLN20 rr2t2r_0[7|20]/a_460_290# sky130_fd_pr_reram__reram_cell area_ox=0.0676
X5791 rr2t2r_0[7|20]/a_60_290# WL7 SL20 VSS sky130_fd_pr__nfet_g5v0d10v5 ad=0.65 pd=3.3 as=0 ps=0 w=1 l=0.5
X5792 rr2t2r_0[8|20]/a_460_290# WL8 SL20 VSS sky130_fd_pr__nfet_g5v0d10v5 ad=0.65 pd=3.3 as=0 ps=0 w=1 l=0.5
X5793 BLP20 rr2t2r_0[8|20]/a_60_290# sky130_fd_pr_reram__reram_cell area_ox=0.0676
X5794 BLN20 rr2t2r_0[8|20]/a_460_290# sky130_fd_pr_reram__reram_cell area_ox=0.0676
X5795 rr2t2r_0[8|20]/a_60_290# WL8 SL20 VSS sky130_fd_pr__nfet_g5v0d10v5 ad=0.65 pd=3.3 as=0 ps=0 w=1 l=0.5
X5796 rr2t2r_0[9|20]/a_460_290# WL9 SL20 VSS sky130_fd_pr__nfet_g5v0d10v5 ad=0.65 pd=3.3 as=0 ps=0 w=1 l=0.5
X5797 BLP20 rr2t2r_0[9|20]/a_60_290# sky130_fd_pr_reram__reram_cell area_ox=0.0676
X5798 BLN20 rr2t2r_0[9|20]/a_460_290# sky130_fd_pr_reram__reram_cell area_ox=0.0676
X5799 rr2t2r_0[9|20]/a_60_290# WL9 SL20 VSS sky130_fd_pr__nfet_g5v0d10v5 ad=0.65 pd=3.3 as=0 ps=0 w=1 l=0.5
X5800 rr2t2r_0[10|20]/a_460_290# WL10 SL20 VSS sky130_fd_pr__nfet_g5v0d10v5 ad=0.65 pd=3.3 as=0 ps=0 w=1 l=0.5
X5801 BLP20 rr2t2r_0[10|20]/a_60_290# sky130_fd_pr_reram__reram_cell area_ox=0.0676
X5802 BLN20 rr2t2r_0[10|20]/a_460_290# sky130_fd_pr_reram__reram_cell area_ox=0.0676
X5803 rr2t2r_0[10|20]/a_60_290# WL10 SL20 VSS sky130_fd_pr__nfet_g5v0d10v5 ad=0.65 pd=3.3 as=0 ps=0 w=1 l=0.5
X5804 rr2t2r_0[11|20]/a_460_290# WL11 SL20 VSS sky130_fd_pr__nfet_g5v0d10v5 ad=0.65 pd=3.3 as=0 ps=0 w=1 l=0.5
X5805 BLP20 rr2t2r_0[11|20]/a_60_290# sky130_fd_pr_reram__reram_cell area_ox=0.0676
X5806 BLN20 rr2t2r_0[11|20]/a_460_290# sky130_fd_pr_reram__reram_cell area_ox=0.0676
X5807 rr2t2r_0[11|20]/a_60_290# WL11 SL20 VSS sky130_fd_pr__nfet_g5v0d10v5 ad=0.65 pd=3.3 as=0 ps=0 w=1 l=0.5
X5808 rr2t2r_0[12|20]/a_460_290# WL12 SL20 VSS sky130_fd_pr__nfet_g5v0d10v5 ad=0.65 pd=3.3 as=0 ps=0 w=1 l=0.5
X5809 BLP20 rr2t2r_0[12|20]/a_60_290# sky130_fd_pr_reram__reram_cell area_ox=0.0676
X5810 BLN20 rr2t2r_0[12|20]/a_460_290# sky130_fd_pr_reram__reram_cell area_ox=0.0676
X5811 rr2t2r_0[12|20]/a_60_290# WL12 SL20 VSS sky130_fd_pr__nfet_g5v0d10v5 ad=0.65 pd=3.3 as=0 ps=0 w=1 l=0.5
X5812 rr2t2r_0[13|20]/a_460_290# WL13 SL20 VSS sky130_fd_pr__nfet_g5v0d10v5 ad=0.65 pd=3.3 as=0 ps=0 w=1 l=0.5
X5813 BLP20 rr2t2r_0[13|20]/a_60_290# sky130_fd_pr_reram__reram_cell area_ox=0.0676
X5814 BLN20 rr2t2r_0[13|20]/a_460_290# sky130_fd_pr_reram__reram_cell area_ox=0.0676
X5815 rr2t2r_0[13|20]/a_60_290# WL13 SL20 VSS sky130_fd_pr__nfet_g5v0d10v5 ad=0.65 pd=3.3 as=0 ps=0 w=1 l=0.5
X5816 rr2t2r_0[14|20]/a_460_290# WL14 SL20 VSS sky130_fd_pr__nfet_g5v0d10v5 ad=0.65 pd=3.3 as=0 ps=0 w=1 l=0.5
X5817 BLP20 rr2t2r_0[14|20]/a_60_290# sky130_fd_pr_reram__reram_cell area_ox=0.0676
X5818 BLN20 rr2t2r_0[14|20]/a_460_290# sky130_fd_pr_reram__reram_cell area_ox=0.0676
X5819 rr2t2r_0[14|20]/a_60_290# WL14 SL20 VSS sky130_fd_pr__nfet_g5v0d10v5 ad=0.65 pd=3.3 as=0 ps=0 w=1 l=0.5
X5820 rr2t2r_0[15|20]/a_460_290# WL15 SL20 VSS sky130_fd_pr__nfet_g5v0d10v5 ad=0.65 pd=3.3 as=0 ps=0 w=1 l=0.5
X5821 BLP20 rr2t2r_0[15|20]/a_60_290# sky130_fd_pr_reram__reram_cell area_ox=0.0676
X5822 BLN20 rr2t2r_0[15|20]/a_460_290# sky130_fd_pr_reram__reram_cell area_ox=0.0676
X5823 rr2t2r_0[15|20]/a_60_290# WL15 SL20 VSS sky130_fd_pr__nfet_g5v0d10v5 ad=0.65 pd=3.3 as=0 ps=0 w=1 l=0.5
X5824 rr2t2r_0[16|20]/a_460_290# WL16 SL20 VSS sky130_fd_pr__nfet_g5v0d10v5 ad=0.65 pd=3.3 as=0 ps=0 w=1 l=0.5
X5825 BLP20 rr2t2r_0[16|20]/a_60_290# sky130_fd_pr_reram__reram_cell area_ox=0.0676
X5826 BLN20 rr2t2r_0[16|20]/a_460_290# sky130_fd_pr_reram__reram_cell area_ox=0.0676
X5827 rr2t2r_0[16|20]/a_60_290# WL16 SL20 VSS sky130_fd_pr__nfet_g5v0d10v5 ad=0.65 pd=3.3 as=0 ps=0 w=1 l=0.5
X5828 rr2t2r_0[17|20]/a_460_290# WL17 SL20 VSS sky130_fd_pr__nfet_g5v0d10v5 ad=0.65 pd=3.3 as=0 ps=0 w=1 l=0.5
X5829 BLP20 rr2t2r_0[17|20]/a_60_290# sky130_fd_pr_reram__reram_cell area_ox=0.0676
X5830 BLN20 rr2t2r_0[17|20]/a_460_290# sky130_fd_pr_reram__reram_cell area_ox=0.0676
X5831 rr2t2r_0[17|20]/a_60_290# WL17 SL20 VSS sky130_fd_pr__nfet_g5v0d10v5 ad=0.65 pd=3.3 as=0 ps=0 w=1 l=0.5
X5832 rr2t2r_0[18|20]/a_460_290# WL18 SL20 VSS sky130_fd_pr__nfet_g5v0d10v5 ad=0.65 pd=3.3 as=0 ps=0 w=1 l=0.5
X5833 BLP20 rr2t2r_0[18|20]/a_60_290# sky130_fd_pr_reram__reram_cell area_ox=0.0676
X5834 BLN20 rr2t2r_0[18|20]/a_460_290# sky130_fd_pr_reram__reram_cell area_ox=0.0676
X5835 rr2t2r_0[18|20]/a_60_290# WL18 SL20 VSS sky130_fd_pr__nfet_g5v0d10v5 ad=0.65 pd=3.3 as=0 ps=0 w=1 l=0.5
X5836 rr2t2r_0[19|20]/a_460_290# WL19 SL20 VSS sky130_fd_pr__nfet_g5v0d10v5 ad=0.65 pd=3.3 as=0 ps=0 w=1 l=0.5
X5837 BLP20 rr2t2r_0[19|20]/a_60_290# sky130_fd_pr_reram__reram_cell area_ox=0.0676
X5838 BLN20 rr2t2r_0[19|20]/a_460_290# sky130_fd_pr_reram__reram_cell area_ox=0.0676
X5839 rr2t2r_0[19|20]/a_60_290# WL19 SL20 VSS sky130_fd_pr__nfet_g5v0d10v5 ad=0.65 pd=3.3 as=0 ps=0 w=1 l=0.5
X5840 rr2t2r_0[20|20]/a_460_290# WL20 SL20 VSS sky130_fd_pr__nfet_g5v0d10v5 ad=0.65 pd=3.3 as=0 ps=0 w=1 l=0.5
X5841 BLP20 rr2t2r_0[20|20]/a_60_290# sky130_fd_pr_reram__reram_cell area_ox=0.0676
X5842 BLN20 rr2t2r_0[20|20]/a_460_290# sky130_fd_pr_reram__reram_cell area_ox=0.0676
X5843 rr2t2r_0[20|20]/a_60_290# WL20 SL20 VSS sky130_fd_pr__nfet_g5v0d10v5 ad=0.65 pd=3.3 as=0 ps=0 w=1 l=0.5
X5844 rr2t2r_0[21|20]/a_460_290# WL21 SL20 VSS sky130_fd_pr__nfet_g5v0d10v5 ad=0.65 pd=3.3 as=0 ps=0 w=1 l=0.5
X5845 BLP20 rr2t2r_0[21|20]/a_60_290# sky130_fd_pr_reram__reram_cell area_ox=0.0676
X5846 BLN20 rr2t2r_0[21|20]/a_460_290# sky130_fd_pr_reram__reram_cell area_ox=0.0676
X5847 rr2t2r_0[21|20]/a_60_290# WL21 SL20 VSS sky130_fd_pr__nfet_g5v0d10v5 ad=0.65 pd=3.3 as=0 ps=0 w=1 l=0.5
X5848 rr2t2r_0[22|20]/a_460_290# WL22 SL20 VSS sky130_fd_pr__nfet_g5v0d10v5 ad=0.65 pd=3.3 as=0 ps=0 w=1 l=0.5
X5849 BLP20 rr2t2r_0[22|20]/a_60_290# sky130_fd_pr_reram__reram_cell area_ox=0.0676
X5850 BLN20 rr2t2r_0[22|20]/a_460_290# sky130_fd_pr_reram__reram_cell area_ox=0.0676
X5851 rr2t2r_0[22|20]/a_60_290# WL22 SL20 VSS sky130_fd_pr__nfet_g5v0d10v5 ad=0.65 pd=3.3 as=0 ps=0 w=1 l=0.5
X5852 rr2t2r_0[23|20]/a_460_290# WL23 SL20 VSS sky130_fd_pr__nfet_g5v0d10v5 ad=0.65 pd=3.3 as=0 ps=0 w=1 l=0.5
X5853 BLP20 rr2t2r_0[23|20]/a_60_290# sky130_fd_pr_reram__reram_cell area_ox=0.0676
X5854 BLN20 rr2t2r_0[23|20]/a_460_290# sky130_fd_pr_reram__reram_cell area_ox=0.0676
X5855 rr2t2r_0[23|20]/a_60_290# WL23 SL20 VSS sky130_fd_pr__nfet_g5v0d10v5 ad=0.65 pd=3.3 as=0 ps=0 w=1 l=0.5
X5856 rr2t2r_0[24|20]/a_460_290# WL24 SL20 VSS sky130_fd_pr__nfet_g5v0d10v5 ad=0.65 pd=3.3 as=0 ps=0 w=1 l=0.5
X5857 BLP20 rr2t2r_0[24|20]/a_60_290# sky130_fd_pr_reram__reram_cell area_ox=0.0676
X5858 BLN20 rr2t2r_0[24|20]/a_460_290# sky130_fd_pr_reram__reram_cell area_ox=0.0676
X5859 rr2t2r_0[24|20]/a_60_290# WL24 SL20 VSS sky130_fd_pr__nfet_g5v0d10v5 ad=0.65 pd=3.3 as=0 ps=0 w=1 l=0.5
X5860 rr2t2r_0[25|20]/a_460_290# WL25 SL20 VSS sky130_fd_pr__nfet_g5v0d10v5 ad=0.65 pd=3.3 as=0 ps=0 w=1 l=0.5
X5861 BLP20 rr2t2r_0[25|20]/a_60_290# sky130_fd_pr_reram__reram_cell area_ox=0.0676
X5862 BLN20 rr2t2r_0[25|20]/a_460_290# sky130_fd_pr_reram__reram_cell area_ox=0.0676
X5863 rr2t2r_0[25|20]/a_60_290# WL25 SL20 VSS sky130_fd_pr__nfet_g5v0d10v5 ad=0.65 pd=3.3 as=0 ps=0 w=1 l=0.5
X5864 rr2t2r_0[26|20]/a_460_290# WL26 SL20 VSS sky130_fd_pr__nfet_g5v0d10v5 ad=0.65 pd=3.3 as=0 ps=0 w=1 l=0.5
X5865 BLP20 rr2t2r_0[26|20]/a_60_290# sky130_fd_pr_reram__reram_cell area_ox=0.0676
X5866 BLN20 rr2t2r_0[26|20]/a_460_290# sky130_fd_pr_reram__reram_cell area_ox=0.0676
X5867 rr2t2r_0[26|20]/a_60_290# WL26 SL20 VSS sky130_fd_pr__nfet_g5v0d10v5 ad=0.65 pd=3.3 as=0 ps=0 w=1 l=0.5
X5868 rr2t2r_0[27|20]/a_460_290# WL27 SL20 VSS sky130_fd_pr__nfet_g5v0d10v5 ad=0.65 pd=3.3 as=0 ps=0 w=1 l=0.5
X5869 BLP20 rr2t2r_0[27|20]/a_60_290# sky130_fd_pr_reram__reram_cell area_ox=0.0676
X5870 BLN20 rr2t2r_0[27|20]/a_460_290# sky130_fd_pr_reram__reram_cell area_ox=0.0676
X5871 rr2t2r_0[27|20]/a_60_290# WL27 SL20 VSS sky130_fd_pr__nfet_g5v0d10v5 ad=0.65 pd=3.3 as=0 ps=0 w=1 l=0.5
X5872 rr2t2r_0[28|20]/a_460_290# WL28 SL20 VSS sky130_fd_pr__nfet_g5v0d10v5 ad=0.65 pd=3.3 as=0 ps=0 w=1 l=0.5
X5873 BLP20 rr2t2r_0[28|20]/a_60_290# sky130_fd_pr_reram__reram_cell area_ox=0.0676
X5874 BLN20 rr2t2r_0[28|20]/a_460_290# sky130_fd_pr_reram__reram_cell area_ox=0.0676
X5875 rr2t2r_0[28|20]/a_60_290# WL28 SL20 VSS sky130_fd_pr__nfet_g5v0d10v5 ad=0.65 pd=3.3 as=0 ps=0 w=1 l=0.5
X5876 rr2t2r_0[29|20]/a_460_290# WL29 SL20 VSS sky130_fd_pr__nfet_g5v0d10v5 ad=0.65 pd=3.3 as=0 ps=0 w=1 l=0.5
X5877 BLP20 rr2t2r_0[29|20]/a_60_290# sky130_fd_pr_reram__reram_cell area_ox=0.0676
X5878 BLN20 rr2t2r_0[29|20]/a_460_290# sky130_fd_pr_reram__reram_cell area_ox=0.0676
X5879 rr2t2r_0[29|20]/a_60_290# WL29 SL20 VSS sky130_fd_pr__nfet_g5v0d10v5 ad=0.65 pd=3.3 as=0 ps=0 w=1 l=0.5
X5880 rr2t2r_0[30|20]/a_460_290# WL30 SL20 VSS sky130_fd_pr__nfet_g5v0d10v5 ad=0.65 pd=3.3 as=0 ps=0 w=1 l=0.5
X5881 BLP20 rr2t2r_0[30|20]/a_60_290# sky130_fd_pr_reram__reram_cell area_ox=0.0676
X5882 BLN20 rr2t2r_0[30|20]/a_460_290# sky130_fd_pr_reram__reram_cell area_ox=0.0676
X5883 rr2t2r_0[30|20]/a_60_290# WL30 SL20 VSS sky130_fd_pr__nfet_g5v0d10v5 ad=0.65 pd=3.3 as=0 ps=0 w=1 l=0.5
X5884 rr2t2r_0[31|20]/a_460_290# WL31 SL20 VSS sky130_fd_pr__nfet_g5v0d10v5 ad=0.65 pd=3.3 as=0 ps=0 w=1 l=0.5
X5885 BLP20 rr2t2r_0[31|20]/a_60_290# sky130_fd_pr_reram__reram_cell area_ox=0.0676
X5886 BLN20 rr2t2r_0[31|20]/a_460_290# sky130_fd_pr_reram__reram_cell area_ox=0.0676
X5887 rr2t2r_0[31|20]/a_60_290# WL31 SL20 VSS sky130_fd_pr__nfet_g5v0d10v5 ad=0.65 pd=3.3 as=0 ps=0 w=1 l=0.5
X5888 rr2t2r_0[32|20]/a_460_290# WL32 SL20 VSS sky130_fd_pr__nfet_g5v0d10v5 ad=0.65 pd=3.3 as=0 ps=0 w=1 l=0.5
X5889 BLP20 rr2t2r_0[32|20]/a_60_290# sky130_fd_pr_reram__reram_cell area_ox=0.0676
X5890 BLN20 rr2t2r_0[32|20]/a_460_290# sky130_fd_pr_reram__reram_cell area_ox=0.0676
X5891 rr2t2r_0[32|20]/a_60_290# WL32 SL20 VSS sky130_fd_pr__nfet_g5v0d10v5 ad=0.65 pd=3.3 as=0 ps=0 w=1 l=0.5
X5892 rr2t2r_0[33|20]/a_460_290# WL33 SL20 VSS sky130_fd_pr__nfet_g5v0d10v5 ad=0.65 pd=3.3 as=0 ps=0 w=1 l=0.5
X5893 BLP20 rr2t2r_0[33|20]/a_60_290# sky130_fd_pr_reram__reram_cell area_ox=0.0676
X5894 BLN20 rr2t2r_0[33|20]/a_460_290# sky130_fd_pr_reram__reram_cell area_ox=0.0676
X5895 rr2t2r_0[33|20]/a_60_290# WL33 SL20 VSS sky130_fd_pr__nfet_g5v0d10v5 ad=0.65 pd=3.3 as=0 ps=0 w=1 l=0.5
X5896 rr2t2r_0[34|20]/a_460_290# WL34 SL20 VSS sky130_fd_pr__nfet_g5v0d10v5 ad=0.65 pd=3.3 as=0 ps=0 w=1 l=0.5
X5897 BLP20 rr2t2r_0[34|20]/a_60_290# sky130_fd_pr_reram__reram_cell area_ox=0.0676
X5898 BLN20 rr2t2r_0[34|20]/a_460_290# sky130_fd_pr_reram__reram_cell area_ox=0.0676
X5899 rr2t2r_0[34|20]/a_60_290# WL34 SL20 VSS sky130_fd_pr__nfet_g5v0d10v5 ad=0.65 pd=3.3 as=0 ps=0 w=1 l=0.5
X5900 rr2t2r_0[35|20]/a_460_290# WL35 SL20 VSS sky130_fd_pr__nfet_g5v0d10v5 ad=0.65 pd=3.3 as=0 ps=0 w=1 l=0.5
X5901 BLP20 rr2t2r_0[35|20]/a_60_290# sky130_fd_pr_reram__reram_cell area_ox=0.0676
X5902 BLN20 rr2t2r_0[35|20]/a_460_290# sky130_fd_pr_reram__reram_cell area_ox=0.0676
X5903 rr2t2r_0[35|20]/a_60_290# WL35 SL20 VSS sky130_fd_pr__nfet_g5v0d10v5 ad=0.65 pd=3.3 as=0 ps=0 w=1 l=0.5
X5904 rr2t2r_0[36|20]/a_460_290# WL36 SL20 VSS sky130_fd_pr__nfet_g5v0d10v5 ad=0.65 pd=3.3 as=0 ps=0 w=1 l=0.5
X5905 BLP20 rr2t2r_0[36|20]/a_60_290# sky130_fd_pr_reram__reram_cell area_ox=0.0676
X5906 BLN20 rr2t2r_0[36|20]/a_460_290# sky130_fd_pr_reram__reram_cell area_ox=0.0676
X5907 rr2t2r_0[36|20]/a_60_290# WL36 SL20 VSS sky130_fd_pr__nfet_g5v0d10v5 ad=0.65 pd=3.3 as=0 ps=0 w=1 l=0.5
X5908 rr2t2r_0[37|20]/a_460_290# WL37 SL20 VSS sky130_fd_pr__nfet_g5v0d10v5 ad=0.65 pd=3.3 as=0 ps=0 w=1 l=0.5
X5909 BLP20 rr2t2r_0[37|20]/a_60_290# sky130_fd_pr_reram__reram_cell area_ox=0.0676
X5910 BLN20 rr2t2r_0[37|20]/a_460_290# sky130_fd_pr_reram__reram_cell area_ox=0.0676
X5911 rr2t2r_0[37|20]/a_60_290# WL37 SL20 VSS sky130_fd_pr__nfet_g5v0d10v5 ad=0.65 pd=3.3 as=0 ps=0 w=1 l=0.5
X5912 rr2t2r_0[38|20]/a_460_290# WL38 SL20 VSS sky130_fd_pr__nfet_g5v0d10v5 ad=0.65 pd=3.3 as=0 ps=0 w=1 l=0.5
X5913 BLP20 rr2t2r_0[38|20]/a_60_290# sky130_fd_pr_reram__reram_cell area_ox=0.0676
X5914 BLN20 rr2t2r_0[38|20]/a_460_290# sky130_fd_pr_reram__reram_cell area_ox=0.0676
X5915 rr2t2r_0[38|20]/a_60_290# WL38 SL20 VSS sky130_fd_pr__nfet_g5v0d10v5 ad=0.65 pd=3.3 as=0 ps=0 w=1 l=0.5
X5916 rr2t2r_0[39|20]/a_460_290# WL39 SL20 VSS sky130_fd_pr__nfet_g5v0d10v5 ad=0.65 pd=3.3 as=0 ps=0 w=1 l=0.5
X5917 BLP20 rr2t2r_0[39|20]/a_60_290# sky130_fd_pr_reram__reram_cell area_ox=0.0676
X5918 BLN20 rr2t2r_0[39|20]/a_460_290# sky130_fd_pr_reram__reram_cell area_ox=0.0676
X5919 rr2t2r_0[39|20]/a_60_290# WL39 SL20 VSS sky130_fd_pr__nfet_g5v0d10v5 ad=0.65 pd=3.3 as=0 ps=0 w=1 l=0.5
X5920 rr2t2r_0[40|20]/a_460_290# WL40 SL20 VSS sky130_fd_pr__nfet_g5v0d10v5 ad=0.65 pd=3.3 as=0 ps=0 w=1 l=0.5
X5921 BLP20 rr2t2r_0[40|20]/a_60_290# sky130_fd_pr_reram__reram_cell area_ox=0.0676
X5922 BLN20 rr2t2r_0[40|20]/a_460_290# sky130_fd_pr_reram__reram_cell area_ox=0.0676
X5923 rr2t2r_0[40|20]/a_60_290# WL40 SL20 VSS sky130_fd_pr__nfet_g5v0d10v5 ad=0.65 pd=3.3 as=0 ps=0 w=1 l=0.5
X5924 rr2t2r_0[41|20]/a_460_290# WL41 SL20 VSS sky130_fd_pr__nfet_g5v0d10v5 ad=0.65 pd=3.3 as=0 ps=0 w=1 l=0.5
X5925 BLP20 rr2t2r_0[41|20]/a_60_290# sky130_fd_pr_reram__reram_cell area_ox=0.0676
X5926 BLN20 rr2t2r_0[41|20]/a_460_290# sky130_fd_pr_reram__reram_cell area_ox=0.0676
X5927 rr2t2r_0[41|20]/a_60_290# WL41 SL20 VSS sky130_fd_pr__nfet_g5v0d10v5 ad=0.65 pd=3.3 as=0 ps=0 w=1 l=0.5
X5928 rr2t2r_0[42|20]/a_460_290# WL42 SL20 VSS sky130_fd_pr__nfet_g5v0d10v5 ad=0.65 pd=3.3 as=0 ps=0 w=1 l=0.5
X5929 BLP20 rr2t2r_0[42|20]/a_60_290# sky130_fd_pr_reram__reram_cell area_ox=0.0676
X5930 BLN20 rr2t2r_0[42|20]/a_460_290# sky130_fd_pr_reram__reram_cell area_ox=0.0676
X5931 rr2t2r_0[42|20]/a_60_290# WL42 SL20 VSS sky130_fd_pr__nfet_g5v0d10v5 ad=0.65 pd=3.3 as=0 ps=0 w=1 l=0.5
X5932 rr2t2r_0[43|20]/a_460_290# WL43 SL20 VSS sky130_fd_pr__nfet_g5v0d10v5 ad=0.65 pd=3.3 as=0 ps=0 w=1 l=0.5
X5933 BLP20 rr2t2r_0[43|20]/a_60_290# sky130_fd_pr_reram__reram_cell area_ox=0.0676
X5934 BLN20 rr2t2r_0[43|20]/a_460_290# sky130_fd_pr_reram__reram_cell area_ox=0.0676
X5935 rr2t2r_0[43|20]/a_60_290# WL43 SL20 VSS sky130_fd_pr__nfet_g5v0d10v5 ad=0.65 pd=3.3 as=0 ps=0 w=1 l=0.5
X5936 rr2t2r_0[44|20]/a_460_290# WL44 SL20 VSS sky130_fd_pr__nfet_g5v0d10v5 ad=0.65 pd=3.3 as=0 ps=0 w=1 l=0.5
X5937 BLP20 rr2t2r_0[44|20]/a_60_290# sky130_fd_pr_reram__reram_cell area_ox=0.0676
X5938 BLN20 rr2t2r_0[44|20]/a_460_290# sky130_fd_pr_reram__reram_cell area_ox=0.0676
X5939 rr2t2r_0[44|20]/a_60_290# WL44 SL20 VSS sky130_fd_pr__nfet_g5v0d10v5 ad=0.65 pd=3.3 as=0 ps=0 w=1 l=0.5
X5940 rr2t2r_0[45|20]/a_460_290# WL45 SL20 VSS sky130_fd_pr__nfet_g5v0d10v5 ad=0.65 pd=3.3 as=0 ps=0 w=1 l=0.5
X5941 BLP20 rr2t2r_0[45|20]/a_60_290# sky130_fd_pr_reram__reram_cell area_ox=0.0676
X5942 BLN20 rr2t2r_0[45|20]/a_460_290# sky130_fd_pr_reram__reram_cell area_ox=0.0676
X5943 rr2t2r_0[45|20]/a_60_290# WL45 SL20 VSS sky130_fd_pr__nfet_g5v0d10v5 ad=0.65 pd=3.3 as=0 ps=0 w=1 l=0.5
X5944 rr2t2r_0[46|20]/a_460_290# WL46 SL20 VSS sky130_fd_pr__nfet_g5v0d10v5 ad=0.65 pd=3.3 as=0 ps=0 w=1 l=0.5
X5945 BLP20 rr2t2r_0[46|20]/a_60_290# sky130_fd_pr_reram__reram_cell area_ox=0.0676
X5946 BLN20 rr2t2r_0[46|20]/a_460_290# sky130_fd_pr_reram__reram_cell area_ox=0.0676
X5947 rr2t2r_0[46|20]/a_60_290# WL46 SL20 VSS sky130_fd_pr__nfet_g5v0d10v5 ad=0.65 pd=3.3 as=0 ps=0 w=1 l=0.5
X5948 rr2t2r_0[47|20]/a_460_290# WL47 SL20 VSS sky130_fd_pr__nfet_g5v0d10v5 ad=0.65 pd=3.3 as=0 ps=0 w=1 l=0.5
X5949 BLP20 rr2t2r_0[47|20]/a_60_290# sky130_fd_pr_reram__reram_cell area_ox=0.0676
X5950 BLN20 rr2t2r_0[47|20]/a_460_290# sky130_fd_pr_reram__reram_cell area_ox=0.0676
X5951 rr2t2r_0[47|20]/a_60_290# WL47 SL20 VSS sky130_fd_pr__nfet_g5v0d10v5 ad=0.65 pd=3.3 as=0 ps=0 w=1 l=0.5
X5952 rr2t2r_0[48|20]/a_460_290# WL48 SL20 VSS sky130_fd_pr__nfet_g5v0d10v5 ad=0.65 pd=3.3 as=0 ps=0 w=1 l=0.5
X5953 BLP20 rr2t2r_0[48|20]/a_60_290# sky130_fd_pr_reram__reram_cell area_ox=0.0676
X5954 BLN20 rr2t2r_0[48|20]/a_460_290# sky130_fd_pr_reram__reram_cell area_ox=0.0676
X5955 rr2t2r_0[48|20]/a_60_290# WL48 SL20 VSS sky130_fd_pr__nfet_g5v0d10v5 ad=0.65 pd=3.3 as=0 ps=0 w=1 l=0.5
X5956 rr2t2r_0[49|20]/a_460_290# WL49 SL20 VSS sky130_fd_pr__nfet_g5v0d10v5 ad=0.65 pd=3.3 as=0 ps=0 w=1 l=0.5
X5957 BLP20 rr2t2r_0[49|20]/a_60_290# sky130_fd_pr_reram__reram_cell area_ox=0.0676
X5958 BLN20 rr2t2r_0[49|20]/a_460_290# sky130_fd_pr_reram__reram_cell area_ox=0.0676
X5959 rr2t2r_0[49|20]/a_60_290# WL49 SL20 VSS sky130_fd_pr__nfet_g5v0d10v5 ad=0.65 pd=3.3 as=0 ps=0 w=1 l=0.5
X5960 rr2t2r_0[50|20]/a_460_290# WL50 SL20 VSS sky130_fd_pr__nfet_g5v0d10v5 ad=0.65 pd=3.3 as=0 ps=0 w=1 l=0.5
X5961 BLP20 rr2t2r_0[50|20]/a_60_290# sky130_fd_pr_reram__reram_cell area_ox=0.0676
X5962 BLN20 rr2t2r_0[50|20]/a_460_290# sky130_fd_pr_reram__reram_cell area_ox=0.0676
X5963 rr2t2r_0[50|20]/a_60_290# WL50 SL20 VSS sky130_fd_pr__nfet_g5v0d10v5 ad=0.65 pd=3.3 as=0 ps=0 w=1 l=0.5
X5964 rr2t2r_0[51|20]/a_460_290# WL51 SL20 VSS sky130_fd_pr__nfet_g5v0d10v5 ad=0.65 pd=3.3 as=0 ps=0 w=1 l=0.5
X5965 BLP20 rr2t2r_0[51|20]/a_60_290# sky130_fd_pr_reram__reram_cell area_ox=0.0676
X5966 BLN20 rr2t2r_0[51|20]/a_460_290# sky130_fd_pr_reram__reram_cell area_ox=0.0676
X5967 rr2t2r_0[51|20]/a_60_290# WL51 SL20 VSS sky130_fd_pr__nfet_g5v0d10v5 ad=0.65 pd=3.3 as=0 ps=0 w=1 l=0.5
X5968 rr2t2r_0[52|20]/a_460_290# WL52 SL20 VSS sky130_fd_pr__nfet_g5v0d10v5 ad=0.65 pd=3.3 as=0 ps=0 w=1 l=0.5
X5969 BLP20 rr2t2r_0[52|20]/a_60_290# sky130_fd_pr_reram__reram_cell area_ox=0.0676
X5970 BLN20 rr2t2r_0[52|20]/a_460_290# sky130_fd_pr_reram__reram_cell area_ox=0.0676
X5971 rr2t2r_0[52|20]/a_60_290# WL52 SL20 VSS sky130_fd_pr__nfet_g5v0d10v5 ad=0.65 pd=3.3 as=0 ps=0 w=1 l=0.5
X5972 rr2t2r_0[53|20]/a_460_290# WL53 SL20 VSS sky130_fd_pr__nfet_g5v0d10v5 ad=0.65 pd=3.3 as=0 ps=0 w=1 l=0.5
X5973 BLP20 rr2t2r_0[53|20]/a_60_290# sky130_fd_pr_reram__reram_cell area_ox=0.0676
X5974 BLN20 rr2t2r_0[53|20]/a_460_290# sky130_fd_pr_reram__reram_cell area_ox=0.0676
X5975 rr2t2r_0[53|20]/a_60_290# WL53 SL20 VSS sky130_fd_pr__nfet_g5v0d10v5 ad=0.65 pd=3.3 as=0 ps=0 w=1 l=0.5
X5976 rr2t2r_0[54|20]/a_460_290# WL54 SL20 VSS sky130_fd_pr__nfet_g5v0d10v5 ad=0.65 pd=3.3 as=0 ps=0 w=1 l=0.5
X5977 BLP20 rr2t2r_0[54|20]/a_60_290# sky130_fd_pr_reram__reram_cell area_ox=0.0676
X5978 BLN20 rr2t2r_0[54|20]/a_460_290# sky130_fd_pr_reram__reram_cell area_ox=0.0676
X5979 rr2t2r_0[54|20]/a_60_290# WL54 SL20 VSS sky130_fd_pr__nfet_g5v0d10v5 ad=0.65 pd=3.3 as=0 ps=0 w=1 l=0.5
X5980 rr2t2r_0[55|20]/a_460_290# WL55 SL20 VSS sky130_fd_pr__nfet_g5v0d10v5 ad=0.65 pd=3.3 as=0 ps=0 w=1 l=0.5
X5981 BLP20 rr2t2r_0[55|20]/a_60_290# sky130_fd_pr_reram__reram_cell area_ox=0.0676
X5982 BLN20 rr2t2r_0[55|20]/a_460_290# sky130_fd_pr_reram__reram_cell area_ox=0.0676
X5983 rr2t2r_0[55|20]/a_60_290# WL55 SL20 VSS sky130_fd_pr__nfet_g5v0d10v5 ad=0.65 pd=3.3 as=0 ps=0 w=1 l=0.5
X5984 rr2t2r_0[56|20]/a_460_290# WL56 SL20 VSS sky130_fd_pr__nfet_g5v0d10v5 ad=0.65 pd=3.3 as=0 ps=0 w=1 l=0.5
X5985 BLP20 rr2t2r_0[56|20]/a_60_290# sky130_fd_pr_reram__reram_cell area_ox=0.0676
X5986 BLN20 rr2t2r_0[56|20]/a_460_290# sky130_fd_pr_reram__reram_cell area_ox=0.0676
X5987 rr2t2r_0[56|20]/a_60_290# WL56 SL20 VSS sky130_fd_pr__nfet_g5v0d10v5 ad=0.65 pd=3.3 as=0 ps=0 w=1 l=0.5
X5988 rr2t2r_0[57|20]/a_460_290# WL57 SL20 VSS sky130_fd_pr__nfet_g5v0d10v5 ad=0.65 pd=3.3 as=0 ps=0 w=1 l=0.5
X5989 BLP20 rr2t2r_0[57|20]/a_60_290# sky130_fd_pr_reram__reram_cell area_ox=0.0676
X5990 BLN20 rr2t2r_0[57|20]/a_460_290# sky130_fd_pr_reram__reram_cell area_ox=0.0676
X5991 rr2t2r_0[57|20]/a_60_290# WL57 SL20 VSS sky130_fd_pr__nfet_g5v0d10v5 ad=0.65 pd=3.3 as=0 ps=0 w=1 l=0.5
X5992 rr2t2r_0[58|20]/a_460_290# WL58 SL20 VSS sky130_fd_pr__nfet_g5v0d10v5 ad=0.65 pd=3.3 as=0 ps=0 w=1 l=0.5
X5993 BLP20 rr2t2r_0[58|20]/a_60_290# sky130_fd_pr_reram__reram_cell area_ox=0.0676
X5994 BLN20 rr2t2r_0[58|20]/a_460_290# sky130_fd_pr_reram__reram_cell area_ox=0.0676
X5995 rr2t2r_0[58|20]/a_60_290# WL58 SL20 VSS sky130_fd_pr__nfet_g5v0d10v5 ad=0.65 pd=3.3 as=0 ps=0 w=1 l=0.5
X5996 rr2t2r_0[59|20]/a_460_290# WL59 SL20 VSS sky130_fd_pr__nfet_g5v0d10v5 ad=0.65 pd=3.3 as=0 ps=0 w=1 l=0.5
X5997 BLP20 rr2t2r_0[59|20]/a_60_290# sky130_fd_pr_reram__reram_cell area_ox=0.0676
X5998 BLN20 rr2t2r_0[59|20]/a_460_290# sky130_fd_pr_reram__reram_cell area_ox=0.0676
X5999 rr2t2r_0[59|20]/a_60_290# WL59 SL20 VSS sky130_fd_pr__nfet_g5v0d10v5 ad=0.65 pd=3.3 as=0 ps=0 w=1 l=0.5
X6000 rr2t2r_0[60|20]/a_460_290# WL60 SL20 VSS sky130_fd_pr__nfet_g5v0d10v5 ad=0.65 pd=3.3 as=0 ps=0 w=1 l=0.5
X6001 BLP20 rr2t2r_0[60|20]/a_60_290# sky130_fd_pr_reram__reram_cell area_ox=0.0676
X6002 BLN20 rr2t2r_0[60|20]/a_460_290# sky130_fd_pr_reram__reram_cell area_ox=0.0676
X6003 rr2t2r_0[60|20]/a_60_290# WL60 SL20 VSS sky130_fd_pr__nfet_g5v0d10v5 ad=0.65 pd=3.3 as=0 ps=0 w=1 l=0.5
X6004 rr2t2r_0[61|20]/a_460_290# WL61 SL20 VSS sky130_fd_pr__nfet_g5v0d10v5 ad=0.65 pd=3.3 as=0 ps=0 w=1 l=0.5
X6005 BLP20 rr2t2r_0[61|20]/a_60_290# sky130_fd_pr_reram__reram_cell area_ox=0.0676
X6006 BLN20 rr2t2r_0[61|20]/a_460_290# sky130_fd_pr_reram__reram_cell area_ox=0.0676
X6007 rr2t2r_0[61|20]/a_60_290# WL61 SL20 VSS sky130_fd_pr__nfet_g5v0d10v5 ad=0.65 pd=3.3 as=0 ps=0 w=1 l=0.5
X6008 rr2t2r_0[62|20]/a_460_290# WL62 SL20 VSS sky130_fd_pr__nfet_g5v0d10v5 ad=0.65 pd=3.3 as=0 ps=0 w=1 l=0.5
X6009 BLP20 rr2t2r_0[62|20]/a_60_290# sky130_fd_pr_reram__reram_cell area_ox=0.0676
X6010 BLN20 rr2t2r_0[62|20]/a_460_290# sky130_fd_pr_reram__reram_cell area_ox=0.0676
X6011 rr2t2r_0[62|20]/a_60_290# WL62 SL20 VSS sky130_fd_pr__nfet_g5v0d10v5 ad=0.65 pd=3.3 as=0 ps=0 w=1 l=0.5
X6012 rr2t2r_0[63|20]/a_460_290# WL63 SL20 VSS sky130_fd_pr__nfet_g5v0d10v5 ad=0.65 pd=3.3 as=0 ps=0 w=1 l=0.5
X6013 BLP20 rr2t2r_0[63|20]/a_60_290# sky130_fd_pr_reram__reram_cell area_ox=0.0676
X6014 BLN20 rr2t2r_0[63|20]/a_460_290# sky130_fd_pr_reram__reram_cell area_ox=0.0676
X6015 rr2t2r_0[63|20]/a_60_290# WL63 SL20 VSS sky130_fd_pr__nfet_g5v0d10v5 ad=0.65 pd=3.3 as=0 ps=0 w=1 l=0.5
X6016 rr2t2r_0[64|20]/a_460_290# WL64 SL20 VSS sky130_fd_pr__nfet_g5v0d10v5 ad=0.65 pd=3.3 as=0 ps=0 w=1 l=0.5
X6017 BLP20 rr2t2r_0[64|20]/a_60_290# sky130_fd_pr_reram__reram_cell area_ox=0.0676
X6018 BLN20 rr2t2r_0[64|20]/a_460_290# sky130_fd_pr_reram__reram_cell area_ox=0.0676
X6019 rr2t2r_0[64|20]/a_60_290# WL64 SL20 VSS sky130_fd_pr__nfet_g5v0d10v5 ad=0.65 pd=3.3 as=0 ps=0 w=1 l=0.5
X6020 rr2t2r_0[65|20]/a_460_290# WL65 SL20 VSS sky130_fd_pr__nfet_g5v0d10v5 ad=0.65 pd=3.3 as=0 ps=0 w=1 l=0.5
X6021 BLP20 rr2t2r_0[65|20]/a_60_290# sky130_fd_pr_reram__reram_cell area_ox=0.0676
X6022 BLN20 rr2t2r_0[65|20]/a_460_290# sky130_fd_pr_reram__reram_cell area_ox=0.0676
X6023 rr2t2r_0[65|20]/a_60_290# WL65 SL20 VSS sky130_fd_pr__nfet_g5v0d10v5 ad=0.65 pd=3.3 as=0 ps=0 w=1 l=0.5
X6024 rr2t2r_0[66|20]/a_460_290# WL66 SL20 VSS sky130_fd_pr__nfet_g5v0d10v5 ad=0.65 pd=3.3 as=0 ps=0 w=1 l=0.5
X6025 BLP20 rr2t2r_0[66|20]/a_60_290# sky130_fd_pr_reram__reram_cell area_ox=0.0676
X6026 BLN20 rr2t2r_0[66|20]/a_460_290# sky130_fd_pr_reram__reram_cell area_ox=0.0676
X6027 rr2t2r_0[66|20]/a_60_290# WL66 SL20 VSS sky130_fd_pr__nfet_g5v0d10v5 ad=0.65 pd=3.3 as=0 ps=0 w=1 l=0.5
X6028 rr2t2r_0[67|20]/a_460_290# WL67 SL20 VSS sky130_fd_pr__nfet_g5v0d10v5 ad=0.65 pd=3.3 as=0 ps=0 w=1 l=0.5
X6029 BLP20 rr2t2r_0[67|20]/a_60_290# sky130_fd_pr_reram__reram_cell area_ox=0.0676
X6030 BLN20 rr2t2r_0[67|20]/a_460_290# sky130_fd_pr_reram__reram_cell area_ox=0.0676
X6031 rr2t2r_0[67|20]/a_60_290# WL67 SL20 VSS sky130_fd_pr__nfet_g5v0d10v5 ad=0.65 pd=3.3 as=0 ps=0 w=1 l=0.5
X6032 rr2t2r_0[68|20]/a_460_290# WL68 SL20 VSS sky130_fd_pr__nfet_g5v0d10v5 ad=0.65 pd=3.3 as=0 ps=0 w=1 l=0.5
X6033 BLP20 rr2t2r_0[68|20]/a_60_290# sky130_fd_pr_reram__reram_cell area_ox=0.0676
X6034 BLN20 rr2t2r_0[68|20]/a_460_290# sky130_fd_pr_reram__reram_cell area_ox=0.0676
X6035 rr2t2r_0[68|20]/a_60_290# WL68 SL20 VSS sky130_fd_pr__nfet_g5v0d10v5 ad=0.65 pd=3.3 as=0 ps=0 w=1 l=0.5
X6036 rr2t2r_0[69|20]/a_460_290# WL69 SL20 VSS sky130_fd_pr__nfet_g5v0d10v5 ad=0.65 pd=3.3 as=0 ps=0 w=1 l=0.5
X6037 BLP20 rr2t2r_0[69|20]/a_60_290# sky130_fd_pr_reram__reram_cell area_ox=0.0676
X6038 BLN20 rr2t2r_0[69|20]/a_460_290# sky130_fd_pr_reram__reram_cell area_ox=0.0676
X6039 rr2t2r_0[69|20]/a_60_290# WL69 SL20 VSS sky130_fd_pr__nfet_g5v0d10v5 ad=0.65 pd=3.3 as=0 ps=0 w=1 l=0.5
X6040 rr2t2r_0[70|20]/a_460_290# WL70 SL20 VSS sky130_fd_pr__nfet_g5v0d10v5 ad=0.65 pd=3.3 as=0 ps=0 w=1 l=0.5
X6041 BLP20 rr2t2r_0[70|20]/a_60_290# sky130_fd_pr_reram__reram_cell area_ox=0.0676
X6042 BLN20 rr2t2r_0[70|20]/a_460_290# sky130_fd_pr_reram__reram_cell area_ox=0.0676
X6043 rr2t2r_0[70|20]/a_60_290# WL70 SL20 VSS sky130_fd_pr__nfet_g5v0d10v5 ad=0.65 pd=3.3 as=0 ps=0 w=1 l=0.5
X6044 rr2t2r_0[71|20]/a_460_290# WL71 SL20 VSS sky130_fd_pr__nfet_g5v0d10v5 ad=0.65 pd=3.3 as=0 ps=0 w=1 l=0.5
X6045 BLP20 rr2t2r_0[71|20]/a_60_290# sky130_fd_pr_reram__reram_cell area_ox=0.0676
X6046 BLN20 rr2t2r_0[71|20]/a_460_290# sky130_fd_pr_reram__reram_cell area_ox=0.0676
X6047 rr2t2r_0[71|20]/a_60_290# WL71 SL20 VSS sky130_fd_pr__nfet_g5v0d10v5 ad=0.65 pd=3.3 as=0 ps=0 w=1 l=0.5
X6048 rr2t2r_0[0|21]/a_460_290# WL0 SL21 VSS sky130_fd_pr__nfet_g5v0d10v5 ad=0.65 pd=3.3 as=108 ps=504 w=1 l=0.5
X6049 BLP21 rr2t2r_0[0|21]/a_60_290# sky130_fd_pr_reram__reram_cell area_ox=0.0676
X6050 BLN21 rr2t2r_0[0|21]/a_460_290# sky130_fd_pr_reram__reram_cell area_ox=0.0676
X6051 rr2t2r_0[0|21]/a_60_290# WL0 SL21 VSS sky130_fd_pr__nfet_g5v0d10v5 ad=0.65 pd=3.3 as=0 ps=0 w=1 l=0.5
X6052 rr2t2r_0[1|21]/a_460_290# WL1 SL21 VSS sky130_fd_pr__nfet_g5v0d10v5 ad=0.65 pd=3.3 as=0 ps=0 w=1 l=0.5
X6053 BLP21 rr2t2r_0[1|21]/a_60_290# sky130_fd_pr_reram__reram_cell area_ox=0.0676
X6054 BLN21 rr2t2r_0[1|21]/a_460_290# sky130_fd_pr_reram__reram_cell area_ox=0.0676
X6055 rr2t2r_0[1|21]/a_60_290# WL1 SL21 VSS sky130_fd_pr__nfet_g5v0d10v5 ad=0.65 pd=3.3 as=0 ps=0 w=1 l=0.5
X6056 rr2t2r_0[2|21]/a_460_290# WL2 SL21 VSS sky130_fd_pr__nfet_g5v0d10v5 ad=0.65 pd=3.3 as=0 ps=0 w=1 l=0.5
X6057 BLP21 rr2t2r_0[2|21]/a_60_290# sky130_fd_pr_reram__reram_cell area_ox=0.0676
X6058 BLN21 rr2t2r_0[2|21]/a_460_290# sky130_fd_pr_reram__reram_cell area_ox=0.0676
X6059 rr2t2r_0[2|21]/a_60_290# WL2 SL21 VSS sky130_fd_pr__nfet_g5v0d10v5 ad=0.65 pd=3.3 as=0 ps=0 w=1 l=0.5
X6060 rr2t2r_0[3|21]/a_460_290# WL3 SL21 VSS sky130_fd_pr__nfet_g5v0d10v5 ad=0.65 pd=3.3 as=0 ps=0 w=1 l=0.5
X6061 BLP21 rr2t2r_0[3|21]/a_60_290# sky130_fd_pr_reram__reram_cell area_ox=0.0676
X6062 BLN21 rr2t2r_0[3|21]/a_460_290# sky130_fd_pr_reram__reram_cell area_ox=0.0676
X6063 rr2t2r_0[3|21]/a_60_290# WL3 SL21 VSS sky130_fd_pr__nfet_g5v0d10v5 ad=0.65 pd=3.3 as=0 ps=0 w=1 l=0.5
X6064 rr2t2r_0[4|21]/a_460_290# WL4 SL21 VSS sky130_fd_pr__nfet_g5v0d10v5 ad=0.65 pd=3.3 as=0 ps=0 w=1 l=0.5
X6065 BLP21 rr2t2r_0[4|21]/a_60_290# sky130_fd_pr_reram__reram_cell area_ox=0.0676
X6066 BLN21 rr2t2r_0[4|21]/a_460_290# sky130_fd_pr_reram__reram_cell area_ox=0.0676
X6067 rr2t2r_0[4|21]/a_60_290# WL4 SL21 VSS sky130_fd_pr__nfet_g5v0d10v5 ad=0.65 pd=3.3 as=0 ps=0 w=1 l=0.5
X6068 rr2t2r_0[5|21]/a_460_290# WL5 SL21 VSS sky130_fd_pr__nfet_g5v0d10v5 ad=0.65 pd=3.3 as=0 ps=0 w=1 l=0.5
X6069 BLP21 rr2t2r_0[5|21]/a_60_290# sky130_fd_pr_reram__reram_cell area_ox=0.0676
X6070 BLN21 rr2t2r_0[5|21]/a_460_290# sky130_fd_pr_reram__reram_cell area_ox=0.0676
X6071 rr2t2r_0[5|21]/a_60_290# WL5 SL21 VSS sky130_fd_pr__nfet_g5v0d10v5 ad=0.65 pd=3.3 as=0 ps=0 w=1 l=0.5
X6072 rr2t2r_0[6|21]/a_460_290# WL6 SL21 VSS sky130_fd_pr__nfet_g5v0d10v5 ad=0.65 pd=3.3 as=0 ps=0 w=1 l=0.5
X6073 BLP21 rr2t2r_0[6|21]/a_60_290# sky130_fd_pr_reram__reram_cell area_ox=0.0676
X6074 BLN21 rr2t2r_0[6|21]/a_460_290# sky130_fd_pr_reram__reram_cell area_ox=0.0676
X6075 rr2t2r_0[6|21]/a_60_290# WL6 SL21 VSS sky130_fd_pr__nfet_g5v0d10v5 ad=0.65 pd=3.3 as=0 ps=0 w=1 l=0.5
X6076 rr2t2r_0[7|21]/a_460_290# WL7 SL21 VSS sky130_fd_pr__nfet_g5v0d10v5 ad=0.65 pd=3.3 as=0 ps=0 w=1 l=0.5
X6077 BLP21 rr2t2r_0[7|21]/a_60_290# sky130_fd_pr_reram__reram_cell area_ox=0.0676
X6078 BLN21 rr2t2r_0[7|21]/a_460_290# sky130_fd_pr_reram__reram_cell area_ox=0.0676
X6079 rr2t2r_0[7|21]/a_60_290# WL7 SL21 VSS sky130_fd_pr__nfet_g5v0d10v5 ad=0.65 pd=3.3 as=0 ps=0 w=1 l=0.5
X6080 rr2t2r_0[8|21]/a_460_290# WL8 SL21 VSS sky130_fd_pr__nfet_g5v0d10v5 ad=0.65 pd=3.3 as=0 ps=0 w=1 l=0.5
X6081 BLP21 rr2t2r_0[8|21]/a_60_290# sky130_fd_pr_reram__reram_cell area_ox=0.0676
X6082 BLN21 rr2t2r_0[8|21]/a_460_290# sky130_fd_pr_reram__reram_cell area_ox=0.0676
X6083 rr2t2r_0[8|21]/a_60_290# WL8 SL21 VSS sky130_fd_pr__nfet_g5v0d10v5 ad=0.65 pd=3.3 as=0 ps=0 w=1 l=0.5
X6084 rr2t2r_0[9|21]/a_460_290# WL9 SL21 VSS sky130_fd_pr__nfet_g5v0d10v5 ad=0.65 pd=3.3 as=0 ps=0 w=1 l=0.5
X6085 BLP21 rr2t2r_0[9|21]/a_60_290# sky130_fd_pr_reram__reram_cell area_ox=0.0676
X6086 BLN21 rr2t2r_0[9|21]/a_460_290# sky130_fd_pr_reram__reram_cell area_ox=0.0676
X6087 rr2t2r_0[9|21]/a_60_290# WL9 SL21 VSS sky130_fd_pr__nfet_g5v0d10v5 ad=0.65 pd=3.3 as=0 ps=0 w=1 l=0.5
X6088 rr2t2r_0[10|21]/a_460_290# WL10 SL21 VSS sky130_fd_pr__nfet_g5v0d10v5 ad=0.65 pd=3.3 as=0 ps=0 w=1 l=0.5
X6089 BLP21 rr2t2r_0[10|21]/a_60_290# sky130_fd_pr_reram__reram_cell area_ox=0.0676
X6090 BLN21 rr2t2r_0[10|21]/a_460_290# sky130_fd_pr_reram__reram_cell area_ox=0.0676
X6091 rr2t2r_0[10|21]/a_60_290# WL10 SL21 VSS sky130_fd_pr__nfet_g5v0d10v5 ad=0.65 pd=3.3 as=0 ps=0 w=1 l=0.5
X6092 rr2t2r_0[11|21]/a_460_290# WL11 SL21 VSS sky130_fd_pr__nfet_g5v0d10v5 ad=0.65 pd=3.3 as=0 ps=0 w=1 l=0.5
X6093 BLP21 rr2t2r_0[11|21]/a_60_290# sky130_fd_pr_reram__reram_cell area_ox=0.0676
X6094 BLN21 rr2t2r_0[11|21]/a_460_290# sky130_fd_pr_reram__reram_cell area_ox=0.0676
X6095 rr2t2r_0[11|21]/a_60_290# WL11 SL21 VSS sky130_fd_pr__nfet_g5v0d10v5 ad=0.65 pd=3.3 as=0 ps=0 w=1 l=0.5
X6096 rr2t2r_0[12|21]/a_460_290# WL12 SL21 VSS sky130_fd_pr__nfet_g5v0d10v5 ad=0.65 pd=3.3 as=0 ps=0 w=1 l=0.5
X6097 BLP21 rr2t2r_0[12|21]/a_60_290# sky130_fd_pr_reram__reram_cell area_ox=0.0676
X6098 BLN21 rr2t2r_0[12|21]/a_460_290# sky130_fd_pr_reram__reram_cell area_ox=0.0676
X6099 rr2t2r_0[12|21]/a_60_290# WL12 SL21 VSS sky130_fd_pr__nfet_g5v0d10v5 ad=0.65 pd=3.3 as=0 ps=0 w=1 l=0.5
X6100 rr2t2r_0[13|21]/a_460_290# WL13 SL21 VSS sky130_fd_pr__nfet_g5v0d10v5 ad=0.65 pd=3.3 as=0 ps=0 w=1 l=0.5
X6101 BLP21 rr2t2r_0[13|21]/a_60_290# sky130_fd_pr_reram__reram_cell area_ox=0.0676
X6102 BLN21 rr2t2r_0[13|21]/a_460_290# sky130_fd_pr_reram__reram_cell area_ox=0.0676
X6103 rr2t2r_0[13|21]/a_60_290# WL13 SL21 VSS sky130_fd_pr__nfet_g5v0d10v5 ad=0.65 pd=3.3 as=0 ps=0 w=1 l=0.5
X6104 rr2t2r_0[14|21]/a_460_290# WL14 SL21 VSS sky130_fd_pr__nfet_g5v0d10v5 ad=0.65 pd=3.3 as=0 ps=0 w=1 l=0.5
X6105 BLP21 rr2t2r_0[14|21]/a_60_290# sky130_fd_pr_reram__reram_cell area_ox=0.0676
X6106 BLN21 rr2t2r_0[14|21]/a_460_290# sky130_fd_pr_reram__reram_cell area_ox=0.0676
X6107 rr2t2r_0[14|21]/a_60_290# WL14 SL21 VSS sky130_fd_pr__nfet_g5v0d10v5 ad=0.65 pd=3.3 as=0 ps=0 w=1 l=0.5
X6108 rr2t2r_0[15|21]/a_460_290# WL15 SL21 VSS sky130_fd_pr__nfet_g5v0d10v5 ad=0.65 pd=3.3 as=0 ps=0 w=1 l=0.5
X6109 BLP21 rr2t2r_0[15|21]/a_60_290# sky130_fd_pr_reram__reram_cell area_ox=0.0676
X6110 BLN21 rr2t2r_0[15|21]/a_460_290# sky130_fd_pr_reram__reram_cell area_ox=0.0676
X6111 rr2t2r_0[15|21]/a_60_290# WL15 SL21 VSS sky130_fd_pr__nfet_g5v0d10v5 ad=0.65 pd=3.3 as=0 ps=0 w=1 l=0.5
X6112 rr2t2r_0[16|21]/a_460_290# WL16 SL21 VSS sky130_fd_pr__nfet_g5v0d10v5 ad=0.65 pd=3.3 as=0 ps=0 w=1 l=0.5
X6113 BLP21 rr2t2r_0[16|21]/a_60_290# sky130_fd_pr_reram__reram_cell area_ox=0.0676
X6114 BLN21 rr2t2r_0[16|21]/a_460_290# sky130_fd_pr_reram__reram_cell area_ox=0.0676
X6115 rr2t2r_0[16|21]/a_60_290# WL16 SL21 VSS sky130_fd_pr__nfet_g5v0d10v5 ad=0.65 pd=3.3 as=0 ps=0 w=1 l=0.5
X6116 rr2t2r_0[17|21]/a_460_290# WL17 SL21 VSS sky130_fd_pr__nfet_g5v0d10v5 ad=0.65 pd=3.3 as=0 ps=0 w=1 l=0.5
X6117 BLP21 rr2t2r_0[17|21]/a_60_290# sky130_fd_pr_reram__reram_cell area_ox=0.0676
X6118 BLN21 rr2t2r_0[17|21]/a_460_290# sky130_fd_pr_reram__reram_cell area_ox=0.0676
X6119 rr2t2r_0[17|21]/a_60_290# WL17 SL21 VSS sky130_fd_pr__nfet_g5v0d10v5 ad=0.65 pd=3.3 as=0 ps=0 w=1 l=0.5
X6120 rr2t2r_0[18|21]/a_460_290# WL18 SL21 VSS sky130_fd_pr__nfet_g5v0d10v5 ad=0.65 pd=3.3 as=0 ps=0 w=1 l=0.5
X6121 BLP21 rr2t2r_0[18|21]/a_60_290# sky130_fd_pr_reram__reram_cell area_ox=0.0676
X6122 BLN21 rr2t2r_0[18|21]/a_460_290# sky130_fd_pr_reram__reram_cell area_ox=0.0676
X6123 rr2t2r_0[18|21]/a_60_290# WL18 SL21 VSS sky130_fd_pr__nfet_g5v0d10v5 ad=0.65 pd=3.3 as=0 ps=0 w=1 l=0.5
X6124 rr2t2r_0[19|21]/a_460_290# WL19 SL21 VSS sky130_fd_pr__nfet_g5v0d10v5 ad=0.65 pd=3.3 as=0 ps=0 w=1 l=0.5
X6125 BLP21 rr2t2r_0[19|21]/a_60_290# sky130_fd_pr_reram__reram_cell area_ox=0.0676
X6126 BLN21 rr2t2r_0[19|21]/a_460_290# sky130_fd_pr_reram__reram_cell area_ox=0.0676
X6127 rr2t2r_0[19|21]/a_60_290# WL19 SL21 VSS sky130_fd_pr__nfet_g5v0d10v5 ad=0.65 pd=3.3 as=0 ps=0 w=1 l=0.5
X6128 rr2t2r_0[20|21]/a_460_290# WL20 SL21 VSS sky130_fd_pr__nfet_g5v0d10v5 ad=0.65 pd=3.3 as=0 ps=0 w=1 l=0.5
X6129 BLP21 rr2t2r_0[20|21]/a_60_290# sky130_fd_pr_reram__reram_cell area_ox=0.0676
X6130 BLN21 rr2t2r_0[20|21]/a_460_290# sky130_fd_pr_reram__reram_cell area_ox=0.0676
X6131 rr2t2r_0[20|21]/a_60_290# WL20 SL21 VSS sky130_fd_pr__nfet_g5v0d10v5 ad=0.65 pd=3.3 as=0 ps=0 w=1 l=0.5
X6132 rr2t2r_0[21|21]/a_460_290# WL21 SL21 VSS sky130_fd_pr__nfet_g5v0d10v5 ad=0.65 pd=3.3 as=0 ps=0 w=1 l=0.5
X6133 BLP21 rr2t2r_0[21|21]/a_60_290# sky130_fd_pr_reram__reram_cell area_ox=0.0676
X6134 BLN21 rr2t2r_0[21|21]/a_460_290# sky130_fd_pr_reram__reram_cell area_ox=0.0676
X6135 rr2t2r_0[21|21]/a_60_290# WL21 SL21 VSS sky130_fd_pr__nfet_g5v0d10v5 ad=0.65 pd=3.3 as=0 ps=0 w=1 l=0.5
X6136 rr2t2r_0[22|21]/a_460_290# WL22 SL21 VSS sky130_fd_pr__nfet_g5v0d10v5 ad=0.65 pd=3.3 as=0 ps=0 w=1 l=0.5
X6137 BLP21 rr2t2r_0[22|21]/a_60_290# sky130_fd_pr_reram__reram_cell area_ox=0.0676
X6138 BLN21 rr2t2r_0[22|21]/a_460_290# sky130_fd_pr_reram__reram_cell area_ox=0.0676
X6139 rr2t2r_0[22|21]/a_60_290# WL22 SL21 VSS sky130_fd_pr__nfet_g5v0d10v5 ad=0.65 pd=3.3 as=0 ps=0 w=1 l=0.5
X6140 rr2t2r_0[23|21]/a_460_290# WL23 SL21 VSS sky130_fd_pr__nfet_g5v0d10v5 ad=0.65 pd=3.3 as=0 ps=0 w=1 l=0.5
X6141 BLP21 rr2t2r_0[23|21]/a_60_290# sky130_fd_pr_reram__reram_cell area_ox=0.0676
X6142 BLN21 rr2t2r_0[23|21]/a_460_290# sky130_fd_pr_reram__reram_cell area_ox=0.0676
X6143 rr2t2r_0[23|21]/a_60_290# WL23 SL21 VSS sky130_fd_pr__nfet_g5v0d10v5 ad=0.65 pd=3.3 as=0 ps=0 w=1 l=0.5
X6144 rr2t2r_0[24|21]/a_460_290# WL24 SL21 VSS sky130_fd_pr__nfet_g5v0d10v5 ad=0.65 pd=3.3 as=0 ps=0 w=1 l=0.5
X6145 BLP21 rr2t2r_0[24|21]/a_60_290# sky130_fd_pr_reram__reram_cell area_ox=0.0676
X6146 BLN21 rr2t2r_0[24|21]/a_460_290# sky130_fd_pr_reram__reram_cell area_ox=0.0676
X6147 rr2t2r_0[24|21]/a_60_290# WL24 SL21 VSS sky130_fd_pr__nfet_g5v0d10v5 ad=0.65 pd=3.3 as=0 ps=0 w=1 l=0.5
X6148 rr2t2r_0[25|21]/a_460_290# WL25 SL21 VSS sky130_fd_pr__nfet_g5v0d10v5 ad=0.65 pd=3.3 as=0 ps=0 w=1 l=0.5
X6149 BLP21 rr2t2r_0[25|21]/a_60_290# sky130_fd_pr_reram__reram_cell area_ox=0.0676
X6150 BLN21 rr2t2r_0[25|21]/a_460_290# sky130_fd_pr_reram__reram_cell area_ox=0.0676
X6151 rr2t2r_0[25|21]/a_60_290# WL25 SL21 VSS sky130_fd_pr__nfet_g5v0d10v5 ad=0.65 pd=3.3 as=0 ps=0 w=1 l=0.5
X6152 rr2t2r_0[26|21]/a_460_290# WL26 SL21 VSS sky130_fd_pr__nfet_g5v0d10v5 ad=0.65 pd=3.3 as=0 ps=0 w=1 l=0.5
X6153 BLP21 rr2t2r_0[26|21]/a_60_290# sky130_fd_pr_reram__reram_cell area_ox=0.0676
X6154 BLN21 rr2t2r_0[26|21]/a_460_290# sky130_fd_pr_reram__reram_cell area_ox=0.0676
X6155 rr2t2r_0[26|21]/a_60_290# WL26 SL21 VSS sky130_fd_pr__nfet_g5v0d10v5 ad=0.65 pd=3.3 as=0 ps=0 w=1 l=0.5
X6156 rr2t2r_0[27|21]/a_460_290# WL27 SL21 VSS sky130_fd_pr__nfet_g5v0d10v5 ad=0.65 pd=3.3 as=0 ps=0 w=1 l=0.5
X6157 BLP21 rr2t2r_0[27|21]/a_60_290# sky130_fd_pr_reram__reram_cell area_ox=0.0676
X6158 BLN21 rr2t2r_0[27|21]/a_460_290# sky130_fd_pr_reram__reram_cell area_ox=0.0676
X6159 rr2t2r_0[27|21]/a_60_290# WL27 SL21 VSS sky130_fd_pr__nfet_g5v0d10v5 ad=0.65 pd=3.3 as=0 ps=0 w=1 l=0.5
X6160 rr2t2r_0[28|21]/a_460_290# WL28 SL21 VSS sky130_fd_pr__nfet_g5v0d10v5 ad=0.65 pd=3.3 as=0 ps=0 w=1 l=0.5
X6161 BLP21 rr2t2r_0[28|21]/a_60_290# sky130_fd_pr_reram__reram_cell area_ox=0.0676
X6162 BLN21 rr2t2r_0[28|21]/a_460_290# sky130_fd_pr_reram__reram_cell area_ox=0.0676
X6163 rr2t2r_0[28|21]/a_60_290# WL28 SL21 VSS sky130_fd_pr__nfet_g5v0d10v5 ad=0.65 pd=3.3 as=0 ps=0 w=1 l=0.5
X6164 rr2t2r_0[29|21]/a_460_290# WL29 SL21 VSS sky130_fd_pr__nfet_g5v0d10v5 ad=0.65 pd=3.3 as=0 ps=0 w=1 l=0.5
X6165 BLP21 rr2t2r_0[29|21]/a_60_290# sky130_fd_pr_reram__reram_cell area_ox=0.0676
X6166 BLN21 rr2t2r_0[29|21]/a_460_290# sky130_fd_pr_reram__reram_cell area_ox=0.0676
X6167 rr2t2r_0[29|21]/a_60_290# WL29 SL21 VSS sky130_fd_pr__nfet_g5v0d10v5 ad=0.65 pd=3.3 as=0 ps=0 w=1 l=0.5
X6168 rr2t2r_0[30|21]/a_460_290# WL30 SL21 VSS sky130_fd_pr__nfet_g5v0d10v5 ad=0.65 pd=3.3 as=0 ps=0 w=1 l=0.5
X6169 BLP21 rr2t2r_0[30|21]/a_60_290# sky130_fd_pr_reram__reram_cell area_ox=0.0676
X6170 BLN21 rr2t2r_0[30|21]/a_460_290# sky130_fd_pr_reram__reram_cell area_ox=0.0676
X6171 rr2t2r_0[30|21]/a_60_290# WL30 SL21 VSS sky130_fd_pr__nfet_g5v0d10v5 ad=0.65 pd=3.3 as=0 ps=0 w=1 l=0.5
X6172 rr2t2r_0[31|21]/a_460_290# WL31 SL21 VSS sky130_fd_pr__nfet_g5v0d10v5 ad=0.65 pd=3.3 as=0 ps=0 w=1 l=0.5
X6173 BLP21 rr2t2r_0[31|21]/a_60_290# sky130_fd_pr_reram__reram_cell area_ox=0.0676
X6174 BLN21 rr2t2r_0[31|21]/a_460_290# sky130_fd_pr_reram__reram_cell area_ox=0.0676
X6175 rr2t2r_0[31|21]/a_60_290# WL31 SL21 VSS sky130_fd_pr__nfet_g5v0d10v5 ad=0.65 pd=3.3 as=0 ps=0 w=1 l=0.5
X6176 rr2t2r_0[32|21]/a_460_290# WL32 SL21 VSS sky130_fd_pr__nfet_g5v0d10v5 ad=0.65 pd=3.3 as=0 ps=0 w=1 l=0.5
X6177 BLP21 rr2t2r_0[32|21]/a_60_290# sky130_fd_pr_reram__reram_cell area_ox=0.0676
X6178 BLN21 rr2t2r_0[32|21]/a_460_290# sky130_fd_pr_reram__reram_cell area_ox=0.0676
X6179 rr2t2r_0[32|21]/a_60_290# WL32 SL21 VSS sky130_fd_pr__nfet_g5v0d10v5 ad=0.65 pd=3.3 as=0 ps=0 w=1 l=0.5
X6180 rr2t2r_0[33|21]/a_460_290# WL33 SL21 VSS sky130_fd_pr__nfet_g5v0d10v5 ad=0.65 pd=3.3 as=0 ps=0 w=1 l=0.5
X6181 BLP21 rr2t2r_0[33|21]/a_60_290# sky130_fd_pr_reram__reram_cell area_ox=0.0676
X6182 BLN21 rr2t2r_0[33|21]/a_460_290# sky130_fd_pr_reram__reram_cell area_ox=0.0676
X6183 rr2t2r_0[33|21]/a_60_290# WL33 SL21 VSS sky130_fd_pr__nfet_g5v0d10v5 ad=0.65 pd=3.3 as=0 ps=0 w=1 l=0.5
X6184 rr2t2r_0[34|21]/a_460_290# WL34 SL21 VSS sky130_fd_pr__nfet_g5v0d10v5 ad=0.65 pd=3.3 as=0 ps=0 w=1 l=0.5
X6185 BLP21 rr2t2r_0[34|21]/a_60_290# sky130_fd_pr_reram__reram_cell area_ox=0.0676
X6186 BLN21 rr2t2r_0[34|21]/a_460_290# sky130_fd_pr_reram__reram_cell area_ox=0.0676
X6187 rr2t2r_0[34|21]/a_60_290# WL34 SL21 VSS sky130_fd_pr__nfet_g5v0d10v5 ad=0.65 pd=3.3 as=0 ps=0 w=1 l=0.5
X6188 rr2t2r_0[35|21]/a_460_290# WL35 SL21 VSS sky130_fd_pr__nfet_g5v0d10v5 ad=0.65 pd=3.3 as=0 ps=0 w=1 l=0.5
X6189 BLP21 rr2t2r_0[35|21]/a_60_290# sky130_fd_pr_reram__reram_cell area_ox=0.0676
X6190 BLN21 rr2t2r_0[35|21]/a_460_290# sky130_fd_pr_reram__reram_cell area_ox=0.0676
X6191 rr2t2r_0[35|21]/a_60_290# WL35 SL21 VSS sky130_fd_pr__nfet_g5v0d10v5 ad=0.65 pd=3.3 as=0 ps=0 w=1 l=0.5
X6192 rr2t2r_0[36|21]/a_460_290# WL36 SL21 VSS sky130_fd_pr__nfet_g5v0d10v5 ad=0.65 pd=3.3 as=0 ps=0 w=1 l=0.5
X6193 BLP21 rr2t2r_0[36|21]/a_60_290# sky130_fd_pr_reram__reram_cell area_ox=0.0676
X6194 BLN21 rr2t2r_0[36|21]/a_460_290# sky130_fd_pr_reram__reram_cell area_ox=0.0676
X6195 rr2t2r_0[36|21]/a_60_290# WL36 SL21 VSS sky130_fd_pr__nfet_g5v0d10v5 ad=0.65 pd=3.3 as=0 ps=0 w=1 l=0.5
X6196 rr2t2r_0[37|21]/a_460_290# WL37 SL21 VSS sky130_fd_pr__nfet_g5v0d10v5 ad=0.65 pd=3.3 as=0 ps=0 w=1 l=0.5
X6197 BLP21 rr2t2r_0[37|21]/a_60_290# sky130_fd_pr_reram__reram_cell area_ox=0.0676
X6198 BLN21 rr2t2r_0[37|21]/a_460_290# sky130_fd_pr_reram__reram_cell area_ox=0.0676
X6199 rr2t2r_0[37|21]/a_60_290# WL37 SL21 VSS sky130_fd_pr__nfet_g5v0d10v5 ad=0.65 pd=3.3 as=0 ps=0 w=1 l=0.5
X6200 rr2t2r_0[38|21]/a_460_290# WL38 SL21 VSS sky130_fd_pr__nfet_g5v0d10v5 ad=0.65 pd=3.3 as=0 ps=0 w=1 l=0.5
X6201 BLP21 rr2t2r_0[38|21]/a_60_290# sky130_fd_pr_reram__reram_cell area_ox=0.0676
X6202 BLN21 rr2t2r_0[38|21]/a_460_290# sky130_fd_pr_reram__reram_cell area_ox=0.0676
X6203 rr2t2r_0[38|21]/a_60_290# WL38 SL21 VSS sky130_fd_pr__nfet_g5v0d10v5 ad=0.65 pd=3.3 as=0 ps=0 w=1 l=0.5
X6204 rr2t2r_0[39|21]/a_460_290# WL39 SL21 VSS sky130_fd_pr__nfet_g5v0d10v5 ad=0.65 pd=3.3 as=0 ps=0 w=1 l=0.5
X6205 BLP21 rr2t2r_0[39|21]/a_60_290# sky130_fd_pr_reram__reram_cell area_ox=0.0676
X6206 BLN21 rr2t2r_0[39|21]/a_460_290# sky130_fd_pr_reram__reram_cell area_ox=0.0676
X6207 rr2t2r_0[39|21]/a_60_290# WL39 SL21 VSS sky130_fd_pr__nfet_g5v0d10v5 ad=0.65 pd=3.3 as=0 ps=0 w=1 l=0.5
X6208 rr2t2r_0[40|21]/a_460_290# WL40 SL21 VSS sky130_fd_pr__nfet_g5v0d10v5 ad=0.65 pd=3.3 as=0 ps=0 w=1 l=0.5
X6209 BLP21 rr2t2r_0[40|21]/a_60_290# sky130_fd_pr_reram__reram_cell area_ox=0.0676
X6210 BLN21 rr2t2r_0[40|21]/a_460_290# sky130_fd_pr_reram__reram_cell area_ox=0.0676
X6211 rr2t2r_0[40|21]/a_60_290# WL40 SL21 VSS sky130_fd_pr__nfet_g5v0d10v5 ad=0.65 pd=3.3 as=0 ps=0 w=1 l=0.5
X6212 rr2t2r_0[41|21]/a_460_290# WL41 SL21 VSS sky130_fd_pr__nfet_g5v0d10v5 ad=0.65 pd=3.3 as=0 ps=0 w=1 l=0.5
X6213 BLP21 rr2t2r_0[41|21]/a_60_290# sky130_fd_pr_reram__reram_cell area_ox=0.0676
X6214 BLN21 rr2t2r_0[41|21]/a_460_290# sky130_fd_pr_reram__reram_cell area_ox=0.0676
X6215 rr2t2r_0[41|21]/a_60_290# WL41 SL21 VSS sky130_fd_pr__nfet_g5v0d10v5 ad=0.65 pd=3.3 as=0 ps=0 w=1 l=0.5
X6216 rr2t2r_0[42|21]/a_460_290# WL42 SL21 VSS sky130_fd_pr__nfet_g5v0d10v5 ad=0.65 pd=3.3 as=0 ps=0 w=1 l=0.5
X6217 BLP21 rr2t2r_0[42|21]/a_60_290# sky130_fd_pr_reram__reram_cell area_ox=0.0676
X6218 BLN21 rr2t2r_0[42|21]/a_460_290# sky130_fd_pr_reram__reram_cell area_ox=0.0676
X6219 rr2t2r_0[42|21]/a_60_290# WL42 SL21 VSS sky130_fd_pr__nfet_g5v0d10v5 ad=0.65 pd=3.3 as=0 ps=0 w=1 l=0.5
X6220 rr2t2r_0[43|21]/a_460_290# WL43 SL21 VSS sky130_fd_pr__nfet_g5v0d10v5 ad=0.65 pd=3.3 as=0 ps=0 w=1 l=0.5
X6221 BLP21 rr2t2r_0[43|21]/a_60_290# sky130_fd_pr_reram__reram_cell area_ox=0.0676
X6222 BLN21 rr2t2r_0[43|21]/a_460_290# sky130_fd_pr_reram__reram_cell area_ox=0.0676
X6223 rr2t2r_0[43|21]/a_60_290# WL43 SL21 VSS sky130_fd_pr__nfet_g5v0d10v5 ad=0.65 pd=3.3 as=0 ps=0 w=1 l=0.5
X6224 rr2t2r_0[44|21]/a_460_290# WL44 SL21 VSS sky130_fd_pr__nfet_g5v0d10v5 ad=0.65 pd=3.3 as=0 ps=0 w=1 l=0.5
X6225 BLP21 rr2t2r_0[44|21]/a_60_290# sky130_fd_pr_reram__reram_cell area_ox=0.0676
X6226 BLN21 rr2t2r_0[44|21]/a_460_290# sky130_fd_pr_reram__reram_cell area_ox=0.0676
X6227 rr2t2r_0[44|21]/a_60_290# WL44 SL21 VSS sky130_fd_pr__nfet_g5v0d10v5 ad=0.65 pd=3.3 as=0 ps=0 w=1 l=0.5
X6228 rr2t2r_0[45|21]/a_460_290# WL45 SL21 VSS sky130_fd_pr__nfet_g5v0d10v5 ad=0.65 pd=3.3 as=0 ps=0 w=1 l=0.5
X6229 BLP21 rr2t2r_0[45|21]/a_60_290# sky130_fd_pr_reram__reram_cell area_ox=0.0676
X6230 BLN21 rr2t2r_0[45|21]/a_460_290# sky130_fd_pr_reram__reram_cell area_ox=0.0676
X6231 rr2t2r_0[45|21]/a_60_290# WL45 SL21 VSS sky130_fd_pr__nfet_g5v0d10v5 ad=0.65 pd=3.3 as=0 ps=0 w=1 l=0.5
X6232 rr2t2r_0[46|21]/a_460_290# WL46 SL21 VSS sky130_fd_pr__nfet_g5v0d10v5 ad=0.65 pd=3.3 as=0 ps=0 w=1 l=0.5
X6233 BLP21 rr2t2r_0[46|21]/a_60_290# sky130_fd_pr_reram__reram_cell area_ox=0.0676
X6234 BLN21 rr2t2r_0[46|21]/a_460_290# sky130_fd_pr_reram__reram_cell area_ox=0.0676
X6235 rr2t2r_0[46|21]/a_60_290# WL46 SL21 VSS sky130_fd_pr__nfet_g5v0d10v5 ad=0.65 pd=3.3 as=0 ps=0 w=1 l=0.5
X6236 rr2t2r_0[47|21]/a_460_290# WL47 SL21 VSS sky130_fd_pr__nfet_g5v0d10v5 ad=0.65 pd=3.3 as=0 ps=0 w=1 l=0.5
X6237 BLP21 rr2t2r_0[47|21]/a_60_290# sky130_fd_pr_reram__reram_cell area_ox=0.0676
X6238 BLN21 rr2t2r_0[47|21]/a_460_290# sky130_fd_pr_reram__reram_cell area_ox=0.0676
X6239 rr2t2r_0[47|21]/a_60_290# WL47 SL21 VSS sky130_fd_pr__nfet_g5v0d10v5 ad=0.65 pd=3.3 as=0 ps=0 w=1 l=0.5
X6240 rr2t2r_0[48|21]/a_460_290# WL48 SL21 VSS sky130_fd_pr__nfet_g5v0d10v5 ad=0.65 pd=3.3 as=0 ps=0 w=1 l=0.5
X6241 BLP21 rr2t2r_0[48|21]/a_60_290# sky130_fd_pr_reram__reram_cell area_ox=0.0676
X6242 BLN21 rr2t2r_0[48|21]/a_460_290# sky130_fd_pr_reram__reram_cell area_ox=0.0676
X6243 rr2t2r_0[48|21]/a_60_290# WL48 SL21 VSS sky130_fd_pr__nfet_g5v0d10v5 ad=0.65 pd=3.3 as=0 ps=0 w=1 l=0.5
X6244 rr2t2r_0[49|21]/a_460_290# WL49 SL21 VSS sky130_fd_pr__nfet_g5v0d10v5 ad=0.65 pd=3.3 as=0 ps=0 w=1 l=0.5
X6245 BLP21 rr2t2r_0[49|21]/a_60_290# sky130_fd_pr_reram__reram_cell area_ox=0.0676
X6246 BLN21 rr2t2r_0[49|21]/a_460_290# sky130_fd_pr_reram__reram_cell area_ox=0.0676
X6247 rr2t2r_0[49|21]/a_60_290# WL49 SL21 VSS sky130_fd_pr__nfet_g5v0d10v5 ad=0.65 pd=3.3 as=0 ps=0 w=1 l=0.5
X6248 rr2t2r_0[50|21]/a_460_290# WL50 SL21 VSS sky130_fd_pr__nfet_g5v0d10v5 ad=0.65 pd=3.3 as=0 ps=0 w=1 l=0.5
X6249 BLP21 rr2t2r_0[50|21]/a_60_290# sky130_fd_pr_reram__reram_cell area_ox=0.0676
X6250 BLN21 rr2t2r_0[50|21]/a_460_290# sky130_fd_pr_reram__reram_cell area_ox=0.0676
X6251 rr2t2r_0[50|21]/a_60_290# WL50 SL21 VSS sky130_fd_pr__nfet_g5v0d10v5 ad=0.65 pd=3.3 as=0 ps=0 w=1 l=0.5
X6252 rr2t2r_0[51|21]/a_460_290# WL51 SL21 VSS sky130_fd_pr__nfet_g5v0d10v5 ad=0.65 pd=3.3 as=0 ps=0 w=1 l=0.5
X6253 BLP21 rr2t2r_0[51|21]/a_60_290# sky130_fd_pr_reram__reram_cell area_ox=0.0676
X6254 BLN21 rr2t2r_0[51|21]/a_460_290# sky130_fd_pr_reram__reram_cell area_ox=0.0676
X6255 rr2t2r_0[51|21]/a_60_290# WL51 SL21 VSS sky130_fd_pr__nfet_g5v0d10v5 ad=0.65 pd=3.3 as=0 ps=0 w=1 l=0.5
X6256 rr2t2r_0[52|21]/a_460_290# WL52 SL21 VSS sky130_fd_pr__nfet_g5v0d10v5 ad=0.65 pd=3.3 as=0 ps=0 w=1 l=0.5
X6257 BLP21 rr2t2r_0[52|21]/a_60_290# sky130_fd_pr_reram__reram_cell area_ox=0.0676
X6258 BLN21 rr2t2r_0[52|21]/a_460_290# sky130_fd_pr_reram__reram_cell area_ox=0.0676
X6259 rr2t2r_0[52|21]/a_60_290# WL52 SL21 VSS sky130_fd_pr__nfet_g5v0d10v5 ad=0.65 pd=3.3 as=0 ps=0 w=1 l=0.5
X6260 rr2t2r_0[53|21]/a_460_290# WL53 SL21 VSS sky130_fd_pr__nfet_g5v0d10v5 ad=0.65 pd=3.3 as=0 ps=0 w=1 l=0.5
X6261 BLP21 rr2t2r_0[53|21]/a_60_290# sky130_fd_pr_reram__reram_cell area_ox=0.0676
X6262 BLN21 rr2t2r_0[53|21]/a_460_290# sky130_fd_pr_reram__reram_cell area_ox=0.0676
X6263 rr2t2r_0[53|21]/a_60_290# WL53 SL21 VSS sky130_fd_pr__nfet_g5v0d10v5 ad=0.65 pd=3.3 as=0 ps=0 w=1 l=0.5
X6264 rr2t2r_0[54|21]/a_460_290# WL54 SL21 VSS sky130_fd_pr__nfet_g5v0d10v5 ad=0.65 pd=3.3 as=0 ps=0 w=1 l=0.5
X6265 BLP21 rr2t2r_0[54|21]/a_60_290# sky130_fd_pr_reram__reram_cell area_ox=0.0676
X6266 BLN21 rr2t2r_0[54|21]/a_460_290# sky130_fd_pr_reram__reram_cell area_ox=0.0676
X6267 rr2t2r_0[54|21]/a_60_290# WL54 SL21 VSS sky130_fd_pr__nfet_g5v0d10v5 ad=0.65 pd=3.3 as=0 ps=0 w=1 l=0.5
X6268 rr2t2r_0[55|21]/a_460_290# WL55 SL21 VSS sky130_fd_pr__nfet_g5v0d10v5 ad=0.65 pd=3.3 as=0 ps=0 w=1 l=0.5
X6269 BLP21 rr2t2r_0[55|21]/a_60_290# sky130_fd_pr_reram__reram_cell area_ox=0.0676
X6270 BLN21 rr2t2r_0[55|21]/a_460_290# sky130_fd_pr_reram__reram_cell area_ox=0.0676
X6271 rr2t2r_0[55|21]/a_60_290# WL55 SL21 VSS sky130_fd_pr__nfet_g5v0d10v5 ad=0.65 pd=3.3 as=0 ps=0 w=1 l=0.5
X6272 rr2t2r_0[56|21]/a_460_290# WL56 SL21 VSS sky130_fd_pr__nfet_g5v0d10v5 ad=0.65 pd=3.3 as=0 ps=0 w=1 l=0.5
X6273 BLP21 rr2t2r_0[56|21]/a_60_290# sky130_fd_pr_reram__reram_cell area_ox=0.0676
X6274 BLN21 rr2t2r_0[56|21]/a_460_290# sky130_fd_pr_reram__reram_cell area_ox=0.0676
X6275 rr2t2r_0[56|21]/a_60_290# WL56 SL21 VSS sky130_fd_pr__nfet_g5v0d10v5 ad=0.65 pd=3.3 as=0 ps=0 w=1 l=0.5
X6276 rr2t2r_0[57|21]/a_460_290# WL57 SL21 VSS sky130_fd_pr__nfet_g5v0d10v5 ad=0.65 pd=3.3 as=0 ps=0 w=1 l=0.5
X6277 BLP21 rr2t2r_0[57|21]/a_60_290# sky130_fd_pr_reram__reram_cell area_ox=0.0676
X6278 BLN21 rr2t2r_0[57|21]/a_460_290# sky130_fd_pr_reram__reram_cell area_ox=0.0676
X6279 rr2t2r_0[57|21]/a_60_290# WL57 SL21 VSS sky130_fd_pr__nfet_g5v0d10v5 ad=0.65 pd=3.3 as=0 ps=0 w=1 l=0.5
X6280 rr2t2r_0[58|21]/a_460_290# WL58 SL21 VSS sky130_fd_pr__nfet_g5v0d10v5 ad=0.65 pd=3.3 as=0 ps=0 w=1 l=0.5
X6281 BLP21 rr2t2r_0[58|21]/a_60_290# sky130_fd_pr_reram__reram_cell area_ox=0.0676
X6282 BLN21 rr2t2r_0[58|21]/a_460_290# sky130_fd_pr_reram__reram_cell area_ox=0.0676
X6283 rr2t2r_0[58|21]/a_60_290# WL58 SL21 VSS sky130_fd_pr__nfet_g5v0d10v5 ad=0.65 pd=3.3 as=0 ps=0 w=1 l=0.5
X6284 rr2t2r_0[59|21]/a_460_290# WL59 SL21 VSS sky130_fd_pr__nfet_g5v0d10v5 ad=0.65 pd=3.3 as=0 ps=0 w=1 l=0.5
X6285 BLP21 rr2t2r_0[59|21]/a_60_290# sky130_fd_pr_reram__reram_cell area_ox=0.0676
X6286 BLN21 rr2t2r_0[59|21]/a_460_290# sky130_fd_pr_reram__reram_cell area_ox=0.0676
X6287 rr2t2r_0[59|21]/a_60_290# WL59 SL21 VSS sky130_fd_pr__nfet_g5v0d10v5 ad=0.65 pd=3.3 as=0 ps=0 w=1 l=0.5
X6288 rr2t2r_0[60|21]/a_460_290# WL60 SL21 VSS sky130_fd_pr__nfet_g5v0d10v5 ad=0.65 pd=3.3 as=0 ps=0 w=1 l=0.5
X6289 BLP21 rr2t2r_0[60|21]/a_60_290# sky130_fd_pr_reram__reram_cell area_ox=0.0676
X6290 BLN21 rr2t2r_0[60|21]/a_460_290# sky130_fd_pr_reram__reram_cell area_ox=0.0676
X6291 rr2t2r_0[60|21]/a_60_290# WL60 SL21 VSS sky130_fd_pr__nfet_g5v0d10v5 ad=0.65 pd=3.3 as=0 ps=0 w=1 l=0.5
X6292 rr2t2r_0[61|21]/a_460_290# WL61 SL21 VSS sky130_fd_pr__nfet_g5v0d10v5 ad=0.65 pd=3.3 as=0 ps=0 w=1 l=0.5
X6293 BLP21 rr2t2r_0[61|21]/a_60_290# sky130_fd_pr_reram__reram_cell area_ox=0.0676
X6294 BLN21 rr2t2r_0[61|21]/a_460_290# sky130_fd_pr_reram__reram_cell area_ox=0.0676
X6295 rr2t2r_0[61|21]/a_60_290# WL61 SL21 VSS sky130_fd_pr__nfet_g5v0d10v5 ad=0.65 pd=3.3 as=0 ps=0 w=1 l=0.5
X6296 rr2t2r_0[62|21]/a_460_290# WL62 SL21 VSS sky130_fd_pr__nfet_g5v0d10v5 ad=0.65 pd=3.3 as=0 ps=0 w=1 l=0.5
X6297 BLP21 rr2t2r_0[62|21]/a_60_290# sky130_fd_pr_reram__reram_cell area_ox=0.0676
X6298 BLN21 rr2t2r_0[62|21]/a_460_290# sky130_fd_pr_reram__reram_cell area_ox=0.0676
X6299 rr2t2r_0[62|21]/a_60_290# WL62 SL21 VSS sky130_fd_pr__nfet_g5v0d10v5 ad=0.65 pd=3.3 as=0 ps=0 w=1 l=0.5
X6300 rr2t2r_0[63|21]/a_460_290# WL63 SL21 VSS sky130_fd_pr__nfet_g5v0d10v5 ad=0.65 pd=3.3 as=0 ps=0 w=1 l=0.5
X6301 BLP21 rr2t2r_0[63|21]/a_60_290# sky130_fd_pr_reram__reram_cell area_ox=0.0676
X6302 BLN21 rr2t2r_0[63|21]/a_460_290# sky130_fd_pr_reram__reram_cell area_ox=0.0676
X6303 rr2t2r_0[63|21]/a_60_290# WL63 SL21 VSS sky130_fd_pr__nfet_g5v0d10v5 ad=0.65 pd=3.3 as=0 ps=0 w=1 l=0.5
X6304 rr2t2r_0[64|21]/a_460_290# WL64 SL21 VSS sky130_fd_pr__nfet_g5v0d10v5 ad=0.65 pd=3.3 as=0 ps=0 w=1 l=0.5
X6305 BLP21 rr2t2r_0[64|21]/a_60_290# sky130_fd_pr_reram__reram_cell area_ox=0.0676
X6306 BLN21 rr2t2r_0[64|21]/a_460_290# sky130_fd_pr_reram__reram_cell area_ox=0.0676
X6307 rr2t2r_0[64|21]/a_60_290# WL64 SL21 VSS sky130_fd_pr__nfet_g5v0d10v5 ad=0.65 pd=3.3 as=0 ps=0 w=1 l=0.5
X6308 rr2t2r_0[65|21]/a_460_290# WL65 SL21 VSS sky130_fd_pr__nfet_g5v0d10v5 ad=0.65 pd=3.3 as=0 ps=0 w=1 l=0.5
X6309 BLP21 rr2t2r_0[65|21]/a_60_290# sky130_fd_pr_reram__reram_cell area_ox=0.0676
X6310 BLN21 rr2t2r_0[65|21]/a_460_290# sky130_fd_pr_reram__reram_cell area_ox=0.0676
X6311 rr2t2r_0[65|21]/a_60_290# WL65 SL21 VSS sky130_fd_pr__nfet_g5v0d10v5 ad=0.65 pd=3.3 as=0 ps=0 w=1 l=0.5
X6312 rr2t2r_0[66|21]/a_460_290# WL66 SL21 VSS sky130_fd_pr__nfet_g5v0d10v5 ad=0.65 pd=3.3 as=0 ps=0 w=1 l=0.5
X6313 BLP21 rr2t2r_0[66|21]/a_60_290# sky130_fd_pr_reram__reram_cell area_ox=0.0676
X6314 BLN21 rr2t2r_0[66|21]/a_460_290# sky130_fd_pr_reram__reram_cell area_ox=0.0676
X6315 rr2t2r_0[66|21]/a_60_290# WL66 SL21 VSS sky130_fd_pr__nfet_g5v0d10v5 ad=0.65 pd=3.3 as=0 ps=0 w=1 l=0.5
X6316 rr2t2r_0[67|21]/a_460_290# WL67 SL21 VSS sky130_fd_pr__nfet_g5v0d10v5 ad=0.65 pd=3.3 as=0 ps=0 w=1 l=0.5
X6317 BLP21 rr2t2r_0[67|21]/a_60_290# sky130_fd_pr_reram__reram_cell area_ox=0.0676
X6318 BLN21 rr2t2r_0[67|21]/a_460_290# sky130_fd_pr_reram__reram_cell area_ox=0.0676
X6319 rr2t2r_0[67|21]/a_60_290# WL67 SL21 VSS sky130_fd_pr__nfet_g5v0d10v5 ad=0.65 pd=3.3 as=0 ps=0 w=1 l=0.5
X6320 rr2t2r_0[68|21]/a_460_290# WL68 SL21 VSS sky130_fd_pr__nfet_g5v0d10v5 ad=0.65 pd=3.3 as=0 ps=0 w=1 l=0.5
X6321 BLP21 rr2t2r_0[68|21]/a_60_290# sky130_fd_pr_reram__reram_cell area_ox=0.0676
X6322 BLN21 rr2t2r_0[68|21]/a_460_290# sky130_fd_pr_reram__reram_cell area_ox=0.0676
X6323 rr2t2r_0[68|21]/a_60_290# WL68 SL21 VSS sky130_fd_pr__nfet_g5v0d10v5 ad=0.65 pd=3.3 as=0 ps=0 w=1 l=0.5
X6324 rr2t2r_0[69|21]/a_460_290# WL69 SL21 VSS sky130_fd_pr__nfet_g5v0d10v5 ad=0.65 pd=3.3 as=0 ps=0 w=1 l=0.5
X6325 BLP21 rr2t2r_0[69|21]/a_60_290# sky130_fd_pr_reram__reram_cell area_ox=0.0676
X6326 BLN21 rr2t2r_0[69|21]/a_460_290# sky130_fd_pr_reram__reram_cell area_ox=0.0676
X6327 rr2t2r_0[69|21]/a_60_290# WL69 SL21 VSS sky130_fd_pr__nfet_g5v0d10v5 ad=0.65 pd=3.3 as=0 ps=0 w=1 l=0.5
X6328 rr2t2r_0[70|21]/a_460_290# WL70 SL21 VSS sky130_fd_pr__nfet_g5v0d10v5 ad=0.65 pd=3.3 as=0 ps=0 w=1 l=0.5
X6329 BLP21 rr2t2r_0[70|21]/a_60_290# sky130_fd_pr_reram__reram_cell area_ox=0.0676
X6330 BLN21 rr2t2r_0[70|21]/a_460_290# sky130_fd_pr_reram__reram_cell area_ox=0.0676
X6331 rr2t2r_0[70|21]/a_60_290# WL70 SL21 VSS sky130_fd_pr__nfet_g5v0d10v5 ad=0.65 pd=3.3 as=0 ps=0 w=1 l=0.5
X6332 rr2t2r_0[71|21]/a_460_290# WL71 SL21 VSS sky130_fd_pr__nfet_g5v0d10v5 ad=0.65 pd=3.3 as=0 ps=0 w=1 l=0.5
X6333 BLP21 rr2t2r_0[71|21]/a_60_290# sky130_fd_pr_reram__reram_cell area_ox=0.0676
X6334 BLN21 rr2t2r_0[71|21]/a_460_290# sky130_fd_pr_reram__reram_cell area_ox=0.0676
X6335 rr2t2r_0[71|21]/a_60_290# WL71 SL21 VSS sky130_fd_pr__nfet_g5v0d10v5 ad=0.65 pd=3.3 as=0 ps=0 w=1 l=0.5
X6336 rr2t2r_0[0|22]/a_460_290# WL0 SL22 VSS sky130_fd_pr__nfet_g5v0d10v5 ad=0.65 pd=3.3 as=108 ps=504 w=1 l=0.5
X6337 BLP22 rr2t2r_0[0|22]/a_60_290# sky130_fd_pr_reram__reram_cell area_ox=0.0676
X6338 BLN22 rr2t2r_0[0|22]/a_460_290# sky130_fd_pr_reram__reram_cell area_ox=0.0676
X6339 rr2t2r_0[0|22]/a_60_290# WL0 SL22 VSS sky130_fd_pr__nfet_g5v0d10v5 ad=0.65 pd=3.3 as=0 ps=0 w=1 l=0.5
X6340 rr2t2r_0[1|22]/a_460_290# WL1 SL22 VSS sky130_fd_pr__nfet_g5v0d10v5 ad=0.65 pd=3.3 as=0 ps=0 w=1 l=0.5
X6341 BLP22 rr2t2r_0[1|22]/a_60_290# sky130_fd_pr_reram__reram_cell area_ox=0.0676
X6342 BLN22 rr2t2r_0[1|22]/a_460_290# sky130_fd_pr_reram__reram_cell area_ox=0.0676
X6343 rr2t2r_0[1|22]/a_60_290# WL1 SL22 VSS sky130_fd_pr__nfet_g5v0d10v5 ad=0.65 pd=3.3 as=0 ps=0 w=1 l=0.5
X6344 rr2t2r_0[2|22]/a_460_290# WL2 SL22 VSS sky130_fd_pr__nfet_g5v0d10v5 ad=0.65 pd=3.3 as=0 ps=0 w=1 l=0.5
X6345 BLP22 rr2t2r_0[2|22]/a_60_290# sky130_fd_pr_reram__reram_cell area_ox=0.0676
X6346 BLN22 rr2t2r_0[2|22]/a_460_290# sky130_fd_pr_reram__reram_cell area_ox=0.0676
X6347 rr2t2r_0[2|22]/a_60_290# WL2 SL22 VSS sky130_fd_pr__nfet_g5v0d10v5 ad=0.65 pd=3.3 as=0 ps=0 w=1 l=0.5
X6348 rr2t2r_0[3|22]/a_460_290# WL3 SL22 VSS sky130_fd_pr__nfet_g5v0d10v5 ad=0.65 pd=3.3 as=0 ps=0 w=1 l=0.5
X6349 BLP22 rr2t2r_0[3|22]/a_60_290# sky130_fd_pr_reram__reram_cell area_ox=0.0676
X6350 BLN22 rr2t2r_0[3|22]/a_460_290# sky130_fd_pr_reram__reram_cell area_ox=0.0676
X6351 rr2t2r_0[3|22]/a_60_290# WL3 SL22 VSS sky130_fd_pr__nfet_g5v0d10v5 ad=0.65 pd=3.3 as=0 ps=0 w=1 l=0.5
X6352 rr2t2r_0[4|22]/a_460_290# WL4 SL22 VSS sky130_fd_pr__nfet_g5v0d10v5 ad=0.65 pd=3.3 as=0 ps=0 w=1 l=0.5
X6353 BLP22 rr2t2r_0[4|22]/a_60_290# sky130_fd_pr_reram__reram_cell area_ox=0.0676
X6354 BLN22 rr2t2r_0[4|22]/a_460_290# sky130_fd_pr_reram__reram_cell area_ox=0.0676
X6355 rr2t2r_0[4|22]/a_60_290# WL4 SL22 VSS sky130_fd_pr__nfet_g5v0d10v5 ad=0.65 pd=3.3 as=0 ps=0 w=1 l=0.5
X6356 rr2t2r_0[5|22]/a_460_290# WL5 SL22 VSS sky130_fd_pr__nfet_g5v0d10v5 ad=0.65 pd=3.3 as=0 ps=0 w=1 l=0.5
X6357 BLP22 rr2t2r_0[5|22]/a_60_290# sky130_fd_pr_reram__reram_cell area_ox=0.0676
X6358 BLN22 rr2t2r_0[5|22]/a_460_290# sky130_fd_pr_reram__reram_cell area_ox=0.0676
X6359 rr2t2r_0[5|22]/a_60_290# WL5 SL22 VSS sky130_fd_pr__nfet_g5v0d10v5 ad=0.65 pd=3.3 as=0 ps=0 w=1 l=0.5
X6360 rr2t2r_0[6|22]/a_460_290# WL6 SL22 VSS sky130_fd_pr__nfet_g5v0d10v5 ad=0.65 pd=3.3 as=0 ps=0 w=1 l=0.5
X6361 BLP22 rr2t2r_0[6|22]/a_60_290# sky130_fd_pr_reram__reram_cell area_ox=0.0676
X6362 BLN22 rr2t2r_0[6|22]/a_460_290# sky130_fd_pr_reram__reram_cell area_ox=0.0676
X6363 rr2t2r_0[6|22]/a_60_290# WL6 SL22 VSS sky130_fd_pr__nfet_g5v0d10v5 ad=0.65 pd=3.3 as=0 ps=0 w=1 l=0.5
X6364 rr2t2r_0[7|22]/a_460_290# WL7 SL22 VSS sky130_fd_pr__nfet_g5v0d10v5 ad=0.65 pd=3.3 as=0 ps=0 w=1 l=0.5
X6365 BLP22 rr2t2r_0[7|22]/a_60_290# sky130_fd_pr_reram__reram_cell area_ox=0.0676
X6366 BLN22 rr2t2r_0[7|22]/a_460_290# sky130_fd_pr_reram__reram_cell area_ox=0.0676
X6367 rr2t2r_0[7|22]/a_60_290# WL7 SL22 VSS sky130_fd_pr__nfet_g5v0d10v5 ad=0.65 pd=3.3 as=0 ps=0 w=1 l=0.5
X6368 rr2t2r_0[8|22]/a_460_290# WL8 SL22 VSS sky130_fd_pr__nfet_g5v0d10v5 ad=0.65 pd=3.3 as=0 ps=0 w=1 l=0.5
X6369 BLP22 rr2t2r_0[8|22]/a_60_290# sky130_fd_pr_reram__reram_cell area_ox=0.0676
X6370 BLN22 rr2t2r_0[8|22]/a_460_290# sky130_fd_pr_reram__reram_cell area_ox=0.0676
X6371 rr2t2r_0[8|22]/a_60_290# WL8 SL22 VSS sky130_fd_pr__nfet_g5v0d10v5 ad=0.65 pd=3.3 as=0 ps=0 w=1 l=0.5
X6372 rr2t2r_0[9|22]/a_460_290# WL9 SL22 VSS sky130_fd_pr__nfet_g5v0d10v5 ad=0.65 pd=3.3 as=0 ps=0 w=1 l=0.5
X6373 BLP22 rr2t2r_0[9|22]/a_60_290# sky130_fd_pr_reram__reram_cell area_ox=0.0676
X6374 BLN22 rr2t2r_0[9|22]/a_460_290# sky130_fd_pr_reram__reram_cell area_ox=0.0676
X6375 rr2t2r_0[9|22]/a_60_290# WL9 SL22 VSS sky130_fd_pr__nfet_g5v0d10v5 ad=0.65 pd=3.3 as=0 ps=0 w=1 l=0.5
X6376 rr2t2r_0[10|22]/a_460_290# WL10 SL22 VSS sky130_fd_pr__nfet_g5v0d10v5 ad=0.65 pd=3.3 as=0 ps=0 w=1 l=0.5
X6377 BLP22 rr2t2r_0[10|22]/a_60_290# sky130_fd_pr_reram__reram_cell area_ox=0.0676
X6378 BLN22 rr2t2r_0[10|22]/a_460_290# sky130_fd_pr_reram__reram_cell area_ox=0.0676
X6379 rr2t2r_0[10|22]/a_60_290# WL10 SL22 VSS sky130_fd_pr__nfet_g5v0d10v5 ad=0.65 pd=3.3 as=0 ps=0 w=1 l=0.5
X6380 rr2t2r_0[11|22]/a_460_290# WL11 SL22 VSS sky130_fd_pr__nfet_g5v0d10v5 ad=0.65 pd=3.3 as=0 ps=0 w=1 l=0.5
X6381 BLP22 rr2t2r_0[11|22]/a_60_290# sky130_fd_pr_reram__reram_cell area_ox=0.0676
X6382 BLN22 rr2t2r_0[11|22]/a_460_290# sky130_fd_pr_reram__reram_cell area_ox=0.0676
X6383 rr2t2r_0[11|22]/a_60_290# WL11 SL22 VSS sky130_fd_pr__nfet_g5v0d10v5 ad=0.65 pd=3.3 as=0 ps=0 w=1 l=0.5
X6384 rr2t2r_0[12|22]/a_460_290# WL12 SL22 VSS sky130_fd_pr__nfet_g5v0d10v5 ad=0.65 pd=3.3 as=0 ps=0 w=1 l=0.5
X6385 BLP22 rr2t2r_0[12|22]/a_60_290# sky130_fd_pr_reram__reram_cell area_ox=0.0676
X6386 BLN22 rr2t2r_0[12|22]/a_460_290# sky130_fd_pr_reram__reram_cell area_ox=0.0676
X6387 rr2t2r_0[12|22]/a_60_290# WL12 SL22 VSS sky130_fd_pr__nfet_g5v0d10v5 ad=0.65 pd=3.3 as=0 ps=0 w=1 l=0.5
X6388 rr2t2r_0[13|22]/a_460_290# WL13 SL22 VSS sky130_fd_pr__nfet_g5v0d10v5 ad=0.65 pd=3.3 as=0 ps=0 w=1 l=0.5
X6389 BLP22 rr2t2r_0[13|22]/a_60_290# sky130_fd_pr_reram__reram_cell area_ox=0.0676
X6390 BLN22 rr2t2r_0[13|22]/a_460_290# sky130_fd_pr_reram__reram_cell area_ox=0.0676
X6391 rr2t2r_0[13|22]/a_60_290# WL13 SL22 VSS sky130_fd_pr__nfet_g5v0d10v5 ad=0.65 pd=3.3 as=0 ps=0 w=1 l=0.5
X6392 rr2t2r_0[14|22]/a_460_290# WL14 SL22 VSS sky130_fd_pr__nfet_g5v0d10v5 ad=0.65 pd=3.3 as=0 ps=0 w=1 l=0.5
X6393 BLP22 rr2t2r_0[14|22]/a_60_290# sky130_fd_pr_reram__reram_cell area_ox=0.0676
X6394 BLN22 rr2t2r_0[14|22]/a_460_290# sky130_fd_pr_reram__reram_cell area_ox=0.0676
X6395 rr2t2r_0[14|22]/a_60_290# WL14 SL22 VSS sky130_fd_pr__nfet_g5v0d10v5 ad=0.65 pd=3.3 as=0 ps=0 w=1 l=0.5
X6396 rr2t2r_0[15|22]/a_460_290# WL15 SL22 VSS sky130_fd_pr__nfet_g5v0d10v5 ad=0.65 pd=3.3 as=0 ps=0 w=1 l=0.5
X6397 BLP22 rr2t2r_0[15|22]/a_60_290# sky130_fd_pr_reram__reram_cell area_ox=0.0676
X6398 BLN22 rr2t2r_0[15|22]/a_460_290# sky130_fd_pr_reram__reram_cell area_ox=0.0676
X6399 rr2t2r_0[15|22]/a_60_290# WL15 SL22 VSS sky130_fd_pr__nfet_g5v0d10v5 ad=0.65 pd=3.3 as=0 ps=0 w=1 l=0.5
X6400 rr2t2r_0[16|22]/a_460_290# WL16 SL22 VSS sky130_fd_pr__nfet_g5v0d10v5 ad=0.65 pd=3.3 as=0 ps=0 w=1 l=0.5
X6401 BLP22 rr2t2r_0[16|22]/a_60_290# sky130_fd_pr_reram__reram_cell area_ox=0.0676
X6402 BLN22 rr2t2r_0[16|22]/a_460_290# sky130_fd_pr_reram__reram_cell area_ox=0.0676
X6403 rr2t2r_0[16|22]/a_60_290# WL16 SL22 VSS sky130_fd_pr__nfet_g5v0d10v5 ad=0.65 pd=3.3 as=0 ps=0 w=1 l=0.5
X6404 rr2t2r_0[17|22]/a_460_290# WL17 SL22 VSS sky130_fd_pr__nfet_g5v0d10v5 ad=0.65 pd=3.3 as=0 ps=0 w=1 l=0.5
X6405 BLP22 rr2t2r_0[17|22]/a_60_290# sky130_fd_pr_reram__reram_cell area_ox=0.0676
X6406 BLN22 rr2t2r_0[17|22]/a_460_290# sky130_fd_pr_reram__reram_cell area_ox=0.0676
X6407 rr2t2r_0[17|22]/a_60_290# WL17 SL22 VSS sky130_fd_pr__nfet_g5v0d10v5 ad=0.65 pd=3.3 as=0 ps=0 w=1 l=0.5
X6408 rr2t2r_0[18|22]/a_460_290# WL18 SL22 VSS sky130_fd_pr__nfet_g5v0d10v5 ad=0.65 pd=3.3 as=0 ps=0 w=1 l=0.5
X6409 BLP22 rr2t2r_0[18|22]/a_60_290# sky130_fd_pr_reram__reram_cell area_ox=0.0676
X6410 BLN22 rr2t2r_0[18|22]/a_460_290# sky130_fd_pr_reram__reram_cell area_ox=0.0676
X6411 rr2t2r_0[18|22]/a_60_290# WL18 SL22 VSS sky130_fd_pr__nfet_g5v0d10v5 ad=0.65 pd=3.3 as=0 ps=0 w=1 l=0.5
X6412 rr2t2r_0[19|22]/a_460_290# WL19 SL22 VSS sky130_fd_pr__nfet_g5v0d10v5 ad=0.65 pd=3.3 as=0 ps=0 w=1 l=0.5
X6413 BLP22 rr2t2r_0[19|22]/a_60_290# sky130_fd_pr_reram__reram_cell area_ox=0.0676
X6414 BLN22 rr2t2r_0[19|22]/a_460_290# sky130_fd_pr_reram__reram_cell area_ox=0.0676
X6415 rr2t2r_0[19|22]/a_60_290# WL19 SL22 VSS sky130_fd_pr__nfet_g5v0d10v5 ad=0.65 pd=3.3 as=0 ps=0 w=1 l=0.5
X6416 rr2t2r_0[20|22]/a_460_290# WL20 SL22 VSS sky130_fd_pr__nfet_g5v0d10v5 ad=0.65 pd=3.3 as=0 ps=0 w=1 l=0.5
X6417 BLP22 rr2t2r_0[20|22]/a_60_290# sky130_fd_pr_reram__reram_cell area_ox=0.0676
X6418 BLN22 rr2t2r_0[20|22]/a_460_290# sky130_fd_pr_reram__reram_cell area_ox=0.0676
X6419 rr2t2r_0[20|22]/a_60_290# WL20 SL22 VSS sky130_fd_pr__nfet_g5v0d10v5 ad=0.65 pd=3.3 as=0 ps=0 w=1 l=0.5
X6420 rr2t2r_0[21|22]/a_460_290# WL21 SL22 VSS sky130_fd_pr__nfet_g5v0d10v5 ad=0.65 pd=3.3 as=0 ps=0 w=1 l=0.5
X6421 BLP22 rr2t2r_0[21|22]/a_60_290# sky130_fd_pr_reram__reram_cell area_ox=0.0676
X6422 BLN22 rr2t2r_0[21|22]/a_460_290# sky130_fd_pr_reram__reram_cell area_ox=0.0676
X6423 rr2t2r_0[21|22]/a_60_290# WL21 SL22 VSS sky130_fd_pr__nfet_g5v0d10v5 ad=0.65 pd=3.3 as=0 ps=0 w=1 l=0.5
X6424 rr2t2r_0[22|22]/a_460_290# WL22 SL22 VSS sky130_fd_pr__nfet_g5v0d10v5 ad=0.65 pd=3.3 as=0 ps=0 w=1 l=0.5
X6425 BLP22 rr2t2r_0[22|22]/a_60_290# sky130_fd_pr_reram__reram_cell area_ox=0.0676
X6426 BLN22 rr2t2r_0[22|22]/a_460_290# sky130_fd_pr_reram__reram_cell area_ox=0.0676
X6427 rr2t2r_0[22|22]/a_60_290# WL22 SL22 VSS sky130_fd_pr__nfet_g5v0d10v5 ad=0.65 pd=3.3 as=0 ps=0 w=1 l=0.5
X6428 rr2t2r_0[23|22]/a_460_290# WL23 SL22 VSS sky130_fd_pr__nfet_g5v0d10v5 ad=0.65 pd=3.3 as=0 ps=0 w=1 l=0.5
X6429 BLP22 rr2t2r_0[23|22]/a_60_290# sky130_fd_pr_reram__reram_cell area_ox=0.0676
X6430 BLN22 rr2t2r_0[23|22]/a_460_290# sky130_fd_pr_reram__reram_cell area_ox=0.0676
X6431 rr2t2r_0[23|22]/a_60_290# WL23 SL22 VSS sky130_fd_pr__nfet_g5v0d10v5 ad=0.65 pd=3.3 as=0 ps=0 w=1 l=0.5
X6432 rr2t2r_0[24|22]/a_460_290# WL24 SL22 VSS sky130_fd_pr__nfet_g5v0d10v5 ad=0.65 pd=3.3 as=0 ps=0 w=1 l=0.5
X6433 BLP22 rr2t2r_0[24|22]/a_60_290# sky130_fd_pr_reram__reram_cell area_ox=0.0676
X6434 BLN22 rr2t2r_0[24|22]/a_460_290# sky130_fd_pr_reram__reram_cell area_ox=0.0676
X6435 rr2t2r_0[24|22]/a_60_290# WL24 SL22 VSS sky130_fd_pr__nfet_g5v0d10v5 ad=0.65 pd=3.3 as=0 ps=0 w=1 l=0.5
X6436 rr2t2r_0[25|22]/a_460_290# WL25 SL22 VSS sky130_fd_pr__nfet_g5v0d10v5 ad=0.65 pd=3.3 as=0 ps=0 w=1 l=0.5
X6437 BLP22 rr2t2r_0[25|22]/a_60_290# sky130_fd_pr_reram__reram_cell area_ox=0.0676
X6438 BLN22 rr2t2r_0[25|22]/a_460_290# sky130_fd_pr_reram__reram_cell area_ox=0.0676
X6439 rr2t2r_0[25|22]/a_60_290# WL25 SL22 VSS sky130_fd_pr__nfet_g5v0d10v5 ad=0.65 pd=3.3 as=0 ps=0 w=1 l=0.5
X6440 rr2t2r_0[26|22]/a_460_290# WL26 SL22 VSS sky130_fd_pr__nfet_g5v0d10v5 ad=0.65 pd=3.3 as=0 ps=0 w=1 l=0.5
X6441 BLP22 rr2t2r_0[26|22]/a_60_290# sky130_fd_pr_reram__reram_cell area_ox=0.0676
X6442 BLN22 rr2t2r_0[26|22]/a_460_290# sky130_fd_pr_reram__reram_cell area_ox=0.0676
X6443 rr2t2r_0[26|22]/a_60_290# WL26 SL22 VSS sky130_fd_pr__nfet_g5v0d10v5 ad=0.65 pd=3.3 as=0 ps=0 w=1 l=0.5
X6444 rr2t2r_0[27|22]/a_460_290# WL27 SL22 VSS sky130_fd_pr__nfet_g5v0d10v5 ad=0.65 pd=3.3 as=0 ps=0 w=1 l=0.5
X6445 BLP22 rr2t2r_0[27|22]/a_60_290# sky130_fd_pr_reram__reram_cell area_ox=0.0676
X6446 BLN22 rr2t2r_0[27|22]/a_460_290# sky130_fd_pr_reram__reram_cell area_ox=0.0676
X6447 rr2t2r_0[27|22]/a_60_290# WL27 SL22 VSS sky130_fd_pr__nfet_g5v0d10v5 ad=0.65 pd=3.3 as=0 ps=0 w=1 l=0.5
X6448 rr2t2r_0[28|22]/a_460_290# WL28 SL22 VSS sky130_fd_pr__nfet_g5v0d10v5 ad=0.65 pd=3.3 as=0 ps=0 w=1 l=0.5
X6449 BLP22 rr2t2r_0[28|22]/a_60_290# sky130_fd_pr_reram__reram_cell area_ox=0.0676
X6450 BLN22 rr2t2r_0[28|22]/a_460_290# sky130_fd_pr_reram__reram_cell area_ox=0.0676
X6451 rr2t2r_0[28|22]/a_60_290# WL28 SL22 VSS sky130_fd_pr__nfet_g5v0d10v5 ad=0.65 pd=3.3 as=0 ps=0 w=1 l=0.5
X6452 rr2t2r_0[29|22]/a_460_290# WL29 SL22 VSS sky130_fd_pr__nfet_g5v0d10v5 ad=0.65 pd=3.3 as=0 ps=0 w=1 l=0.5
X6453 BLP22 rr2t2r_0[29|22]/a_60_290# sky130_fd_pr_reram__reram_cell area_ox=0.0676
X6454 BLN22 rr2t2r_0[29|22]/a_460_290# sky130_fd_pr_reram__reram_cell area_ox=0.0676
X6455 rr2t2r_0[29|22]/a_60_290# WL29 SL22 VSS sky130_fd_pr__nfet_g5v0d10v5 ad=0.65 pd=3.3 as=0 ps=0 w=1 l=0.5
X6456 rr2t2r_0[30|22]/a_460_290# WL30 SL22 VSS sky130_fd_pr__nfet_g5v0d10v5 ad=0.65 pd=3.3 as=0 ps=0 w=1 l=0.5
X6457 BLP22 rr2t2r_0[30|22]/a_60_290# sky130_fd_pr_reram__reram_cell area_ox=0.0676
X6458 BLN22 rr2t2r_0[30|22]/a_460_290# sky130_fd_pr_reram__reram_cell area_ox=0.0676
X6459 rr2t2r_0[30|22]/a_60_290# WL30 SL22 VSS sky130_fd_pr__nfet_g5v0d10v5 ad=0.65 pd=3.3 as=0 ps=0 w=1 l=0.5
X6460 rr2t2r_0[31|22]/a_460_290# WL31 SL22 VSS sky130_fd_pr__nfet_g5v0d10v5 ad=0.65 pd=3.3 as=0 ps=0 w=1 l=0.5
X6461 BLP22 rr2t2r_0[31|22]/a_60_290# sky130_fd_pr_reram__reram_cell area_ox=0.0676
X6462 BLN22 rr2t2r_0[31|22]/a_460_290# sky130_fd_pr_reram__reram_cell area_ox=0.0676
X6463 rr2t2r_0[31|22]/a_60_290# WL31 SL22 VSS sky130_fd_pr__nfet_g5v0d10v5 ad=0.65 pd=3.3 as=0 ps=0 w=1 l=0.5
X6464 rr2t2r_0[32|22]/a_460_290# WL32 SL22 VSS sky130_fd_pr__nfet_g5v0d10v5 ad=0.65 pd=3.3 as=0 ps=0 w=1 l=0.5
X6465 BLP22 rr2t2r_0[32|22]/a_60_290# sky130_fd_pr_reram__reram_cell area_ox=0.0676
X6466 BLN22 rr2t2r_0[32|22]/a_460_290# sky130_fd_pr_reram__reram_cell area_ox=0.0676
X6467 rr2t2r_0[32|22]/a_60_290# WL32 SL22 VSS sky130_fd_pr__nfet_g5v0d10v5 ad=0.65 pd=3.3 as=0 ps=0 w=1 l=0.5
X6468 rr2t2r_0[33|22]/a_460_290# WL33 SL22 VSS sky130_fd_pr__nfet_g5v0d10v5 ad=0.65 pd=3.3 as=0 ps=0 w=1 l=0.5
X6469 BLP22 rr2t2r_0[33|22]/a_60_290# sky130_fd_pr_reram__reram_cell area_ox=0.0676
X6470 BLN22 rr2t2r_0[33|22]/a_460_290# sky130_fd_pr_reram__reram_cell area_ox=0.0676
X6471 rr2t2r_0[33|22]/a_60_290# WL33 SL22 VSS sky130_fd_pr__nfet_g5v0d10v5 ad=0.65 pd=3.3 as=0 ps=0 w=1 l=0.5
X6472 rr2t2r_0[34|22]/a_460_290# WL34 SL22 VSS sky130_fd_pr__nfet_g5v0d10v5 ad=0.65 pd=3.3 as=0 ps=0 w=1 l=0.5
X6473 BLP22 rr2t2r_0[34|22]/a_60_290# sky130_fd_pr_reram__reram_cell area_ox=0.0676
X6474 BLN22 rr2t2r_0[34|22]/a_460_290# sky130_fd_pr_reram__reram_cell area_ox=0.0676
X6475 rr2t2r_0[34|22]/a_60_290# WL34 SL22 VSS sky130_fd_pr__nfet_g5v0d10v5 ad=0.65 pd=3.3 as=0 ps=0 w=1 l=0.5
X6476 rr2t2r_0[35|22]/a_460_290# WL35 SL22 VSS sky130_fd_pr__nfet_g5v0d10v5 ad=0.65 pd=3.3 as=0 ps=0 w=1 l=0.5
X6477 BLP22 rr2t2r_0[35|22]/a_60_290# sky130_fd_pr_reram__reram_cell area_ox=0.0676
X6478 BLN22 rr2t2r_0[35|22]/a_460_290# sky130_fd_pr_reram__reram_cell area_ox=0.0676
X6479 rr2t2r_0[35|22]/a_60_290# WL35 SL22 VSS sky130_fd_pr__nfet_g5v0d10v5 ad=0.65 pd=3.3 as=0 ps=0 w=1 l=0.5
X6480 rr2t2r_0[36|22]/a_460_290# WL36 SL22 VSS sky130_fd_pr__nfet_g5v0d10v5 ad=0.65 pd=3.3 as=0 ps=0 w=1 l=0.5
X6481 BLP22 rr2t2r_0[36|22]/a_60_290# sky130_fd_pr_reram__reram_cell area_ox=0.0676
X6482 BLN22 rr2t2r_0[36|22]/a_460_290# sky130_fd_pr_reram__reram_cell area_ox=0.0676
X6483 rr2t2r_0[36|22]/a_60_290# WL36 SL22 VSS sky130_fd_pr__nfet_g5v0d10v5 ad=0.65 pd=3.3 as=0 ps=0 w=1 l=0.5
X6484 rr2t2r_0[37|22]/a_460_290# WL37 SL22 VSS sky130_fd_pr__nfet_g5v0d10v5 ad=0.65 pd=3.3 as=0 ps=0 w=1 l=0.5
X6485 BLP22 rr2t2r_0[37|22]/a_60_290# sky130_fd_pr_reram__reram_cell area_ox=0.0676
X6486 BLN22 rr2t2r_0[37|22]/a_460_290# sky130_fd_pr_reram__reram_cell area_ox=0.0676
X6487 rr2t2r_0[37|22]/a_60_290# WL37 SL22 VSS sky130_fd_pr__nfet_g5v0d10v5 ad=0.65 pd=3.3 as=0 ps=0 w=1 l=0.5
X6488 rr2t2r_0[38|22]/a_460_290# WL38 SL22 VSS sky130_fd_pr__nfet_g5v0d10v5 ad=0.65 pd=3.3 as=0 ps=0 w=1 l=0.5
X6489 BLP22 rr2t2r_0[38|22]/a_60_290# sky130_fd_pr_reram__reram_cell area_ox=0.0676
X6490 BLN22 rr2t2r_0[38|22]/a_460_290# sky130_fd_pr_reram__reram_cell area_ox=0.0676
X6491 rr2t2r_0[38|22]/a_60_290# WL38 SL22 VSS sky130_fd_pr__nfet_g5v0d10v5 ad=0.65 pd=3.3 as=0 ps=0 w=1 l=0.5
X6492 rr2t2r_0[39|22]/a_460_290# WL39 SL22 VSS sky130_fd_pr__nfet_g5v0d10v5 ad=0.65 pd=3.3 as=0 ps=0 w=1 l=0.5
X6493 BLP22 rr2t2r_0[39|22]/a_60_290# sky130_fd_pr_reram__reram_cell area_ox=0.0676
X6494 BLN22 rr2t2r_0[39|22]/a_460_290# sky130_fd_pr_reram__reram_cell area_ox=0.0676
X6495 rr2t2r_0[39|22]/a_60_290# WL39 SL22 VSS sky130_fd_pr__nfet_g5v0d10v5 ad=0.65 pd=3.3 as=0 ps=0 w=1 l=0.5
X6496 rr2t2r_0[40|22]/a_460_290# WL40 SL22 VSS sky130_fd_pr__nfet_g5v0d10v5 ad=0.65 pd=3.3 as=0 ps=0 w=1 l=0.5
X6497 BLP22 rr2t2r_0[40|22]/a_60_290# sky130_fd_pr_reram__reram_cell area_ox=0.0676
X6498 BLN22 rr2t2r_0[40|22]/a_460_290# sky130_fd_pr_reram__reram_cell area_ox=0.0676
X6499 rr2t2r_0[40|22]/a_60_290# WL40 SL22 VSS sky130_fd_pr__nfet_g5v0d10v5 ad=0.65 pd=3.3 as=0 ps=0 w=1 l=0.5
X6500 rr2t2r_0[41|22]/a_460_290# WL41 SL22 VSS sky130_fd_pr__nfet_g5v0d10v5 ad=0.65 pd=3.3 as=0 ps=0 w=1 l=0.5
X6501 BLP22 rr2t2r_0[41|22]/a_60_290# sky130_fd_pr_reram__reram_cell area_ox=0.0676
X6502 BLN22 rr2t2r_0[41|22]/a_460_290# sky130_fd_pr_reram__reram_cell area_ox=0.0676
X6503 rr2t2r_0[41|22]/a_60_290# WL41 SL22 VSS sky130_fd_pr__nfet_g5v0d10v5 ad=0.65 pd=3.3 as=0 ps=0 w=1 l=0.5
X6504 rr2t2r_0[42|22]/a_460_290# WL42 SL22 VSS sky130_fd_pr__nfet_g5v0d10v5 ad=0.65 pd=3.3 as=0 ps=0 w=1 l=0.5
X6505 BLP22 rr2t2r_0[42|22]/a_60_290# sky130_fd_pr_reram__reram_cell area_ox=0.0676
X6506 BLN22 rr2t2r_0[42|22]/a_460_290# sky130_fd_pr_reram__reram_cell area_ox=0.0676
X6507 rr2t2r_0[42|22]/a_60_290# WL42 SL22 VSS sky130_fd_pr__nfet_g5v0d10v5 ad=0.65 pd=3.3 as=0 ps=0 w=1 l=0.5
X6508 rr2t2r_0[43|22]/a_460_290# WL43 SL22 VSS sky130_fd_pr__nfet_g5v0d10v5 ad=0.65 pd=3.3 as=0 ps=0 w=1 l=0.5
X6509 BLP22 rr2t2r_0[43|22]/a_60_290# sky130_fd_pr_reram__reram_cell area_ox=0.0676
X6510 BLN22 rr2t2r_0[43|22]/a_460_290# sky130_fd_pr_reram__reram_cell area_ox=0.0676
X6511 rr2t2r_0[43|22]/a_60_290# WL43 SL22 VSS sky130_fd_pr__nfet_g5v0d10v5 ad=0.65 pd=3.3 as=0 ps=0 w=1 l=0.5
X6512 rr2t2r_0[44|22]/a_460_290# WL44 SL22 VSS sky130_fd_pr__nfet_g5v0d10v5 ad=0.65 pd=3.3 as=0 ps=0 w=1 l=0.5
X6513 BLP22 rr2t2r_0[44|22]/a_60_290# sky130_fd_pr_reram__reram_cell area_ox=0.0676
X6514 BLN22 rr2t2r_0[44|22]/a_460_290# sky130_fd_pr_reram__reram_cell area_ox=0.0676
X6515 rr2t2r_0[44|22]/a_60_290# WL44 SL22 VSS sky130_fd_pr__nfet_g5v0d10v5 ad=0.65 pd=3.3 as=0 ps=0 w=1 l=0.5
X6516 rr2t2r_0[45|22]/a_460_290# WL45 SL22 VSS sky130_fd_pr__nfet_g5v0d10v5 ad=0.65 pd=3.3 as=0 ps=0 w=1 l=0.5
X6517 BLP22 rr2t2r_0[45|22]/a_60_290# sky130_fd_pr_reram__reram_cell area_ox=0.0676
X6518 BLN22 rr2t2r_0[45|22]/a_460_290# sky130_fd_pr_reram__reram_cell area_ox=0.0676
X6519 rr2t2r_0[45|22]/a_60_290# WL45 SL22 VSS sky130_fd_pr__nfet_g5v0d10v5 ad=0.65 pd=3.3 as=0 ps=0 w=1 l=0.5
X6520 rr2t2r_0[46|22]/a_460_290# WL46 SL22 VSS sky130_fd_pr__nfet_g5v0d10v5 ad=0.65 pd=3.3 as=0 ps=0 w=1 l=0.5
X6521 BLP22 rr2t2r_0[46|22]/a_60_290# sky130_fd_pr_reram__reram_cell area_ox=0.0676
X6522 BLN22 rr2t2r_0[46|22]/a_460_290# sky130_fd_pr_reram__reram_cell area_ox=0.0676
X6523 rr2t2r_0[46|22]/a_60_290# WL46 SL22 VSS sky130_fd_pr__nfet_g5v0d10v5 ad=0.65 pd=3.3 as=0 ps=0 w=1 l=0.5
X6524 rr2t2r_0[47|22]/a_460_290# WL47 SL22 VSS sky130_fd_pr__nfet_g5v0d10v5 ad=0.65 pd=3.3 as=0 ps=0 w=1 l=0.5
X6525 BLP22 rr2t2r_0[47|22]/a_60_290# sky130_fd_pr_reram__reram_cell area_ox=0.0676
X6526 BLN22 rr2t2r_0[47|22]/a_460_290# sky130_fd_pr_reram__reram_cell area_ox=0.0676
X6527 rr2t2r_0[47|22]/a_60_290# WL47 SL22 VSS sky130_fd_pr__nfet_g5v0d10v5 ad=0.65 pd=3.3 as=0 ps=0 w=1 l=0.5
X6528 rr2t2r_0[48|22]/a_460_290# WL48 SL22 VSS sky130_fd_pr__nfet_g5v0d10v5 ad=0.65 pd=3.3 as=0 ps=0 w=1 l=0.5
X6529 BLP22 rr2t2r_0[48|22]/a_60_290# sky130_fd_pr_reram__reram_cell area_ox=0.0676
X6530 BLN22 rr2t2r_0[48|22]/a_460_290# sky130_fd_pr_reram__reram_cell area_ox=0.0676
X6531 rr2t2r_0[48|22]/a_60_290# WL48 SL22 VSS sky130_fd_pr__nfet_g5v0d10v5 ad=0.65 pd=3.3 as=0 ps=0 w=1 l=0.5
X6532 rr2t2r_0[49|22]/a_460_290# WL49 SL22 VSS sky130_fd_pr__nfet_g5v0d10v5 ad=0.65 pd=3.3 as=0 ps=0 w=1 l=0.5
X6533 BLP22 rr2t2r_0[49|22]/a_60_290# sky130_fd_pr_reram__reram_cell area_ox=0.0676
X6534 BLN22 rr2t2r_0[49|22]/a_460_290# sky130_fd_pr_reram__reram_cell area_ox=0.0676
X6535 rr2t2r_0[49|22]/a_60_290# WL49 SL22 VSS sky130_fd_pr__nfet_g5v0d10v5 ad=0.65 pd=3.3 as=0 ps=0 w=1 l=0.5
X6536 rr2t2r_0[50|22]/a_460_290# WL50 SL22 VSS sky130_fd_pr__nfet_g5v0d10v5 ad=0.65 pd=3.3 as=0 ps=0 w=1 l=0.5
X6537 BLP22 rr2t2r_0[50|22]/a_60_290# sky130_fd_pr_reram__reram_cell area_ox=0.0676
X6538 BLN22 rr2t2r_0[50|22]/a_460_290# sky130_fd_pr_reram__reram_cell area_ox=0.0676
X6539 rr2t2r_0[50|22]/a_60_290# WL50 SL22 VSS sky130_fd_pr__nfet_g5v0d10v5 ad=0.65 pd=3.3 as=0 ps=0 w=1 l=0.5
X6540 rr2t2r_0[51|22]/a_460_290# WL51 SL22 VSS sky130_fd_pr__nfet_g5v0d10v5 ad=0.65 pd=3.3 as=0 ps=0 w=1 l=0.5
X6541 BLP22 rr2t2r_0[51|22]/a_60_290# sky130_fd_pr_reram__reram_cell area_ox=0.0676
X6542 BLN22 rr2t2r_0[51|22]/a_460_290# sky130_fd_pr_reram__reram_cell area_ox=0.0676
X6543 rr2t2r_0[51|22]/a_60_290# WL51 SL22 VSS sky130_fd_pr__nfet_g5v0d10v5 ad=0.65 pd=3.3 as=0 ps=0 w=1 l=0.5
X6544 rr2t2r_0[52|22]/a_460_290# WL52 SL22 VSS sky130_fd_pr__nfet_g5v0d10v5 ad=0.65 pd=3.3 as=0 ps=0 w=1 l=0.5
X6545 BLP22 rr2t2r_0[52|22]/a_60_290# sky130_fd_pr_reram__reram_cell area_ox=0.0676
X6546 BLN22 rr2t2r_0[52|22]/a_460_290# sky130_fd_pr_reram__reram_cell area_ox=0.0676
X6547 rr2t2r_0[52|22]/a_60_290# WL52 SL22 VSS sky130_fd_pr__nfet_g5v0d10v5 ad=0.65 pd=3.3 as=0 ps=0 w=1 l=0.5
X6548 rr2t2r_0[53|22]/a_460_290# WL53 SL22 VSS sky130_fd_pr__nfet_g5v0d10v5 ad=0.65 pd=3.3 as=0 ps=0 w=1 l=0.5
X6549 BLP22 rr2t2r_0[53|22]/a_60_290# sky130_fd_pr_reram__reram_cell area_ox=0.0676
X6550 BLN22 rr2t2r_0[53|22]/a_460_290# sky130_fd_pr_reram__reram_cell area_ox=0.0676
X6551 rr2t2r_0[53|22]/a_60_290# WL53 SL22 VSS sky130_fd_pr__nfet_g5v0d10v5 ad=0.65 pd=3.3 as=0 ps=0 w=1 l=0.5
X6552 rr2t2r_0[54|22]/a_460_290# WL54 SL22 VSS sky130_fd_pr__nfet_g5v0d10v5 ad=0.65 pd=3.3 as=0 ps=0 w=1 l=0.5
X6553 BLP22 rr2t2r_0[54|22]/a_60_290# sky130_fd_pr_reram__reram_cell area_ox=0.0676
X6554 BLN22 rr2t2r_0[54|22]/a_460_290# sky130_fd_pr_reram__reram_cell area_ox=0.0676
X6555 rr2t2r_0[54|22]/a_60_290# WL54 SL22 VSS sky130_fd_pr__nfet_g5v0d10v5 ad=0.65 pd=3.3 as=0 ps=0 w=1 l=0.5
X6556 rr2t2r_0[55|22]/a_460_290# WL55 SL22 VSS sky130_fd_pr__nfet_g5v0d10v5 ad=0.65 pd=3.3 as=0 ps=0 w=1 l=0.5
X6557 BLP22 rr2t2r_0[55|22]/a_60_290# sky130_fd_pr_reram__reram_cell area_ox=0.0676
X6558 BLN22 rr2t2r_0[55|22]/a_460_290# sky130_fd_pr_reram__reram_cell area_ox=0.0676
X6559 rr2t2r_0[55|22]/a_60_290# WL55 SL22 VSS sky130_fd_pr__nfet_g5v0d10v5 ad=0.65 pd=3.3 as=0 ps=0 w=1 l=0.5
X6560 rr2t2r_0[56|22]/a_460_290# WL56 SL22 VSS sky130_fd_pr__nfet_g5v0d10v5 ad=0.65 pd=3.3 as=0 ps=0 w=1 l=0.5
X6561 BLP22 rr2t2r_0[56|22]/a_60_290# sky130_fd_pr_reram__reram_cell area_ox=0.0676
X6562 BLN22 rr2t2r_0[56|22]/a_460_290# sky130_fd_pr_reram__reram_cell area_ox=0.0676
X6563 rr2t2r_0[56|22]/a_60_290# WL56 SL22 VSS sky130_fd_pr__nfet_g5v0d10v5 ad=0.65 pd=3.3 as=0 ps=0 w=1 l=0.5
X6564 rr2t2r_0[57|22]/a_460_290# WL57 SL22 VSS sky130_fd_pr__nfet_g5v0d10v5 ad=0.65 pd=3.3 as=0 ps=0 w=1 l=0.5
X6565 BLP22 rr2t2r_0[57|22]/a_60_290# sky130_fd_pr_reram__reram_cell area_ox=0.0676
X6566 BLN22 rr2t2r_0[57|22]/a_460_290# sky130_fd_pr_reram__reram_cell area_ox=0.0676
X6567 rr2t2r_0[57|22]/a_60_290# WL57 SL22 VSS sky130_fd_pr__nfet_g5v0d10v5 ad=0.65 pd=3.3 as=0 ps=0 w=1 l=0.5
X6568 rr2t2r_0[58|22]/a_460_290# WL58 SL22 VSS sky130_fd_pr__nfet_g5v0d10v5 ad=0.65 pd=3.3 as=0 ps=0 w=1 l=0.5
X6569 BLP22 rr2t2r_0[58|22]/a_60_290# sky130_fd_pr_reram__reram_cell area_ox=0.0676
X6570 BLN22 rr2t2r_0[58|22]/a_460_290# sky130_fd_pr_reram__reram_cell area_ox=0.0676
X6571 rr2t2r_0[58|22]/a_60_290# WL58 SL22 VSS sky130_fd_pr__nfet_g5v0d10v5 ad=0.65 pd=3.3 as=0 ps=0 w=1 l=0.5
X6572 rr2t2r_0[59|22]/a_460_290# WL59 SL22 VSS sky130_fd_pr__nfet_g5v0d10v5 ad=0.65 pd=3.3 as=0 ps=0 w=1 l=0.5
X6573 BLP22 rr2t2r_0[59|22]/a_60_290# sky130_fd_pr_reram__reram_cell area_ox=0.0676
X6574 BLN22 rr2t2r_0[59|22]/a_460_290# sky130_fd_pr_reram__reram_cell area_ox=0.0676
X6575 rr2t2r_0[59|22]/a_60_290# WL59 SL22 VSS sky130_fd_pr__nfet_g5v0d10v5 ad=0.65 pd=3.3 as=0 ps=0 w=1 l=0.5
X6576 rr2t2r_0[60|22]/a_460_290# WL60 SL22 VSS sky130_fd_pr__nfet_g5v0d10v5 ad=0.65 pd=3.3 as=0 ps=0 w=1 l=0.5
X6577 BLP22 rr2t2r_0[60|22]/a_60_290# sky130_fd_pr_reram__reram_cell area_ox=0.0676
X6578 BLN22 rr2t2r_0[60|22]/a_460_290# sky130_fd_pr_reram__reram_cell area_ox=0.0676
X6579 rr2t2r_0[60|22]/a_60_290# WL60 SL22 VSS sky130_fd_pr__nfet_g5v0d10v5 ad=0.65 pd=3.3 as=0 ps=0 w=1 l=0.5
X6580 rr2t2r_0[61|22]/a_460_290# WL61 SL22 VSS sky130_fd_pr__nfet_g5v0d10v5 ad=0.65 pd=3.3 as=0 ps=0 w=1 l=0.5
X6581 BLP22 rr2t2r_0[61|22]/a_60_290# sky130_fd_pr_reram__reram_cell area_ox=0.0676
X6582 BLN22 rr2t2r_0[61|22]/a_460_290# sky130_fd_pr_reram__reram_cell area_ox=0.0676
X6583 rr2t2r_0[61|22]/a_60_290# WL61 SL22 VSS sky130_fd_pr__nfet_g5v0d10v5 ad=0.65 pd=3.3 as=0 ps=0 w=1 l=0.5
X6584 rr2t2r_0[62|22]/a_460_290# WL62 SL22 VSS sky130_fd_pr__nfet_g5v0d10v5 ad=0.65 pd=3.3 as=0 ps=0 w=1 l=0.5
X6585 BLP22 rr2t2r_0[62|22]/a_60_290# sky130_fd_pr_reram__reram_cell area_ox=0.0676
X6586 BLN22 rr2t2r_0[62|22]/a_460_290# sky130_fd_pr_reram__reram_cell area_ox=0.0676
X6587 rr2t2r_0[62|22]/a_60_290# WL62 SL22 VSS sky130_fd_pr__nfet_g5v0d10v5 ad=0.65 pd=3.3 as=0 ps=0 w=1 l=0.5
X6588 rr2t2r_0[63|22]/a_460_290# WL63 SL22 VSS sky130_fd_pr__nfet_g5v0d10v5 ad=0.65 pd=3.3 as=0 ps=0 w=1 l=0.5
X6589 BLP22 rr2t2r_0[63|22]/a_60_290# sky130_fd_pr_reram__reram_cell area_ox=0.0676
X6590 BLN22 rr2t2r_0[63|22]/a_460_290# sky130_fd_pr_reram__reram_cell area_ox=0.0676
X6591 rr2t2r_0[63|22]/a_60_290# WL63 SL22 VSS sky130_fd_pr__nfet_g5v0d10v5 ad=0.65 pd=3.3 as=0 ps=0 w=1 l=0.5
X6592 rr2t2r_0[64|22]/a_460_290# WL64 SL22 VSS sky130_fd_pr__nfet_g5v0d10v5 ad=0.65 pd=3.3 as=0 ps=0 w=1 l=0.5
X6593 BLP22 rr2t2r_0[64|22]/a_60_290# sky130_fd_pr_reram__reram_cell area_ox=0.0676
X6594 BLN22 rr2t2r_0[64|22]/a_460_290# sky130_fd_pr_reram__reram_cell area_ox=0.0676
X6595 rr2t2r_0[64|22]/a_60_290# WL64 SL22 VSS sky130_fd_pr__nfet_g5v0d10v5 ad=0.65 pd=3.3 as=0 ps=0 w=1 l=0.5
X6596 rr2t2r_0[65|22]/a_460_290# WL65 SL22 VSS sky130_fd_pr__nfet_g5v0d10v5 ad=0.65 pd=3.3 as=0 ps=0 w=1 l=0.5
X6597 BLP22 rr2t2r_0[65|22]/a_60_290# sky130_fd_pr_reram__reram_cell area_ox=0.0676
X6598 BLN22 rr2t2r_0[65|22]/a_460_290# sky130_fd_pr_reram__reram_cell area_ox=0.0676
X6599 rr2t2r_0[65|22]/a_60_290# WL65 SL22 VSS sky130_fd_pr__nfet_g5v0d10v5 ad=0.65 pd=3.3 as=0 ps=0 w=1 l=0.5
X6600 rr2t2r_0[66|22]/a_460_290# WL66 SL22 VSS sky130_fd_pr__nfet_g5v0d10v5 ad=0.65 pd=3.3 as=0 ps=0 w=1 l=0.5
X6601 BLP22 rr2t2r_0[66|22]/a_60_290# sky130_fd_pr_reram__reram_cell area_ox=0.0676
X6602 BLN22 rr2t2r_0[66|22]/a_460_290# sky130_fd_pr_reram__reram_cell area_ox=0.0676
X6603 rr2t2r_0[66|22]/a_60_290# WL66 SL22 VSS sky130_fd_pr__nfet_g5v0d10v5 ad=0.65 pd=3.3 as=0 ps=0 w=1 l=0.5
X6604 rr2t2r_0[67|22]/a_460_290# WL67 SL22 VSS sky130_fd_pr__nfet_g5v0d10v5 ad=0.65 pd=3.3 as=0 ps=0 w=1 l=0.5
X6605 BLP22 rr2t2r_0[67|22]/a_60_290# sky130_fd_pr_reram__reram_cell area_ox=0.0676
X6606 BLN22 rr2t2r_0[67|22]/a_460_290# sky130_fd_pr_reram__reram_cell area_ox=0.0676
X6607 rr2t2r_0[67|22]/a_60_290# WL67 SL22 VSS sky130_fd_pr__nfet_g5v0d10v5 ad=0.65 pd=3.3 as=0 ps=0 w=1 l=0.5
X6608 rr2t2r_0[68|22]/a_460_290# WL68 SL22 VSS sky130_fd_pr__nfet_g5v0d10v5 ad=0.65 pd=3.3 as=0 ps=0 w=1 l=0.5
X6609 BLP22 rr2t2r_0[68|22]/a_60_290# sky130_fd_pr_reram__reram_cell area_ox=0.0676
X6610 BLN22 rr2t2r_0[68|22]/a_460_290# sky130_fd_pr_reram__reram_cell area_ox=0.0676
X6611 rr2t2r_0[68|22]/a_60_290# WL68 SL22 VSS sky130_fd_pr__nfet_g5v0d10v5 ad=0.65 pd=3.3 as=0 ps=0 w=1 l=0.5
X6612 rr2t2r_0[69|22]/a_460_290# WL69 SL22 VSS sky130_fd_pr__nfet_g5v0d10v5 ad=0.65 pd=3.3 as=0 ps=0 w=1 l=0.5
X6613 BLP22 rr2t2r_0[69|22]/a_60_290# sky130_fd_pr_reram__reram_cell area_ox=0.0676
X6614 BLN22 rr2t2r_0[69|22]/a_460_290# sky130_fd_pr_reram__reram_cell area_ox=0.0676
X6615 rr2t2r_0[69|22]/a_60_290# WL69 SL22 VSS sky130_fd_pr__nfet_g5v0d10v5 ad=0.65 pd=3.3 as=0 ps=0 w=1 l=0.5
X6616 rr2t2r_0[70|22]/a_460_290# WL70 SL22 VSS sky130_fd_pr__nfet_g5v0d10v5 ad=0.65 pd=3.3 as=0 ps=0 w=1 l=0.5
X6617 BLP22 rr2t2r_0[70|22]/a_60_290# sky130_fd_pr_reram__reram_cell area_ox=0.0676
X6618 BLN22 rr2t2r_0[70|22]/a_460_290# sky130_fd_pr_reram__reram_cell area_ox=0.0676
X6619 rr2t2r_0[70|22]/a_60_290# WL70 SL22 VSS sky130_fd_pr__nfet_g5v0d10v5 ad=0.65 pd=3.3 as=0 ps=0 w=1 l=0.5
X6620 rr2t2r_0[71|22]/a_460_290# WL71 SL22 VSS sky130_fd_pr__nfet_g5v0d10v5 ad=0.65 pd=3.3 as=0 ps=0 w=1 l=0.5
X6621 BLP22 rr2t2r_0[71|22]/a_60_290# sky130_fd_pr_reram__reram_cell area_ox=0.0676
X6622 BLN22 rr2t2r_0[71|22]/a_460_290# sky130_fd_pr_reram__reram_cell area_ox=0.0676
X6623 rr2t2r_0[71|22]/a_60_290# WL71 SL22 VSS sky130_fd_pr__nfet_g5v0d10v5 ad=0.65 pd=3.3 as=0 ps=0 w=1 l=0.5
X6624 rr2t2r_0[0|23]/a_460_290# WL0 SL23 VSS sky130_fd_pr__nfet_g5v0d10v5 ad=0.65 pd=3.3 as=108 ps=504 w=1 l=0.5
X6625 BLP23 rr2t2r_0[0|23]/a_60_290# sky130_fd_pr_reram__reram_cell area_ox=0.0676
X6626 BLN23 rr2t2r_0[0|23]/a_460_290# sky130_fd_pr_reram__reram_cell area_ox=0.0676
X6627 rr2t2r_0[0|23]/a_60_290# WL0 SL23 VSS sky130_fd_pr__nfet_g5v0d10v5 ad=0.65 pd=3.3 as=0 ps=0 w=1 l=0.5
X6628 rr2t2r_0[1|23]/a_460_290# WL1 SL23 VSS sky130_fd_pr__nfet_g5v0d10v5 ad=0.65 pd=3.3 as=0 ps=0 w=1 l=0.5
X6629 BLP23 rr2t2r_0[1|23]/a_60_290# sky130_fd_pr_reram__reram_cell area_ox=0.0676
X6630 BLN23 rr2t2r_0[1|23]/a_460_290# sky130_fd_pr_reram__reram_cell area_ox=0.0676
X6631 rr2t2r_0[1|23]/a_60_290# WL1 SL23 VSS sky130_fd_pr__nfet_g5v0d10v5 ad=0.65 pd=3.3 as=0 ps=0 w=1 l=0.5
X6632 rr2t2r_0[2|23]/a_460_290# WL2 SL23 VSS sky130_fd_pr__nfet_g5v0d10v5 ad=0.65 pd=3.3 as=0 ps=0 w=1 l=0.5
X6633 BLP23 rr2t2r_0[2|23]/a_60_290# sky130_fd_pr_reram__reram_cell area_ox=0.0676
X6634 BLN23 rr2t2r_0[2|23]/a_460_290# sky130_fd_pr_reram__reram_cell area_ox=0.0676
X6635 rr2t2r_0[2|23]/a_60_290# WL2 SL23 VSS sky130_fd_pr__nfet_g5v0d10v5 ad=0.65 pd=3.3 as=0 ps=0 w=1 l=0.5
X6636 rr2t2r_0[3|23]/a_460_290# WL3 SL23 VSS sky130_fd_pr__nfet_g5v0d10v5 ad=0.65 pd=3.3 as=0 ps=0 w=1 l=0.5
X6637 BLP23 rr2t2r_0[3|23]/a_60_290# sky130_fd_pr_reram__reram_cell area_ox=0.0676
X6638 BLN23 rr2t2r_0[3|23]/a_460_290# sky130_fd_pr_reram__reram_cell area_ox=0.0676
X6639 rr2t2r_0[3|23]/a_60_290# WL3 SL23 VSS sky130_fd_pr__nfet_g5v0d10v5 ad=0.65 pd=3.3 as=0 ps=0 w=1 l=0.5
X6640 rr2t2r_0[4|23]/a_460_290# WL4 SL23 VSS sky130_fd_pr__nfet_g5v0d10v5 ad=0.65 pd=3.3 as=0 ps=0 w=1 l=0.5
X6641 BLP23 rr2t2r_0[4|23]/a_60_290# sky130_fd_pr_reram__reram_cell area_ox=0.0676
X6642 BLN23 rr2t2r_0[4|23]/a_460_290# sky130_fd_pr_reram__reram_cell area_ox=0.0676
X6643 rr2t2r_0[4|23]/a_60_290# WL4 SL23 VSS sky130_fd_pr__nfet_g5v0d10v5 ad=0.65 pd=3.3 as=0 ps=0 w=1 l=0.5
X6644 rr2t2r_0[5|23]/a_460_290# WL5 SL23 VSS sky130_fd_pr__nfet_g5v0d10v5 ad=0.65 pd=3.3 as=0 ps=0 w=1 l=0.5
X6645 BLP23 rr2t2r_0[5|23]/a_60_290# sky130_fd_pr_reram__reram_cell area_ox=0.0676
X6646 BLN23 rr2t2r_0[5|23]/a_460_290# sky130_fd_pr_reram__reram_cell area_ox=0.0676
X6647 rr2t2r_0[5|23]/a_60_290# WL5 SL23 VSS sky130_fd_pr__nfet_g5v0d10v5 ad=0.65 pd=3.3 as=0 ps=0 w=1 l=0.5
X6648 rr2t2r_0[6|23]/a_460_290# WL6 SL23 VSS sky130_fd_pr__nfet_g5v0d10v5 ad=0.65 pd=3.3 as=0 ps=0 w=1 l=0.5
X6649 BLP23 rr2t2r_0[6|23]/a_60_290# sky130_fd_pr_reram__reram_cell area_ox=0.0676
X6650 BLN23 rr2t2r_0[6|23]/a_460_290# sky130_fd_pr_reram__reram_cell area_ox=0.0676
X6651 rr2t2r_0[6|23]/a_60_290# WL6 SL23 VSS sky130_fd_pr__nfet_g5v0d10v5 ad=0.65 pd=3.3 as=0 ps=0 w=1 l=0.5
X6652 rr2t2r_0[7|23]/a_460_290# WL7 SL23 VSS sky130_fd_pr__nfet_g5v0d10v5 ad=0.65 pd=3.3 as=0 ps=0 w=1 l=0.5
X6653 BLP23 rr2t2r_0[7|23]/a_60_290# sky130_fd_pr_reram__reram_cell area_ox=0.0676
X6654 BLN23 rr2t2r_0[7|23]/a_460_290# sky130_fd_pr_reram__reram_cell area_ox=0.0676
X6655 rr2t2r_0[7|23]/a_60_290# WL7 SL23 VSS sky130_fd_pr__nfet_g5v0d10v5 ad=0.65 pd=3.3 as=0 ps=0 w=1 l=0.5
X6656 rr2t2r_0[8|23]/a_460_290# WL8 SL23 VSS sky130_fd_pr__nfet_g5v0d10v5 ad=0.65 pd=3.3 as=0 ps=0 w=1 l=0.5
X6657 BLP23 rr2t2r_0[8|23]/a_60_290# sky130_fd_pr_reram__reram_cell area_ox=0.0676
X6658 BLN23 rr2t2r_0[8|23]/a_460_290# sky130_fd_pr_reram__reram_cell area_ox=0.0676
X6659 rr2t2r_0[8|23]/a_60_290# WL8 SL23 VSS sky130_fd_pr__nfet_g5v0d10v5 ad=0.65 pd=3.3 as=0 ps=0 w=1 l=0.5
X6660 rr2t2r_0[9|23]/a_460_290# WL9 SL23 VSS sky130_fd_pr__nfet_g5v0d10v5 ad=0.65 pd=3.3 as=0 ps=0 w=1 l=0.5
X6661 BLP23 rr2t2r_0[9|23]/a_60_290# sky130_fd_pr_reram__reram_cell area_ox=0.0676
X6662 BLN23 rr2t2r_0[9|23]/a_460_290# sky130_fd_pr_reram__reram_cell area_ox=0.0676
X6663 rr2t2r_0[9|23]/a_60_290# WL9 SL23 VSS sky130_fd_pr__nfet_g5v0d10v5 ad=0.65 pd=3.3 as=0 ps=0 w=1 l=0.5
X6664 rr2t2r_0[10|23]/a_460_290# WL10 SL23 VSS sky130_fd_pr__nfet_g5v0d10v5 ad=0.65 pd=3.3 as=0 ps=0 w=1 l=0.5
X6665 BLP23 rr2t2r_0[10|23]/a_60_290# sky130_fd_pr_reram__reram_cell area_ox=0.0676
X6666 BLN23 rr2t2r_0[10|23]/a_460_290# sky130_fd_pr_reram__reram_cell area_ox=0.0676
X6667 rr2t2r_0[10|23]/a_60_290# WL10 SL23 VSS sky130_fd_pr__nfet_g5v0d10v5 ad=0.65 pd=3.3 as=0 ps=0 w=1 l=0.5
X6668 rr2t2r_0[11|23]/a_460_290# WL11 SL23 VSS sky130_fd_pr__nfet_g5v0d10v5 ad=0.65 pd=3.3 as=0 ps=0 w=1 l=0.5
X6669 BLP23 rr2t2r_0[11|23]/a_60_290# sky130_fd_pr_reram__reram_cell area_ox=0.0676
X6670 BLN23 rr2t2r_0[11|23]/a_460_290# sky130_fd_pr_reram__reram_cell area_ox=0.0676
X6671 rr2t2r_0[11|23]/a_60_290# WL11 SL23 VSS sky130_fd_pr__nfet_g5v0d10v5 ad=0.65 pd=3.3 as=0 ps=0 w=1 l=0.5
X6672 rr2t2r_0[12|23]/a_460_290# WL12 SL23 VSS sky130_fd_pr__nfet_g5v0d10v5 ad=0.65 pd=3.3 as=0 ps=0 w=1 l=0.5
X6673 BLP23 rr2t2r_0[12|23]/a_60_290# sky130_fd_pr_reram__reram_cell area_ox=0.0676
X6674 BLN23 rr2t2r_0[12|23]/a_460_290# sky130_fd_pr_reram__reram_cell area_ox=0.0676
X6675 rr2t2r_0[12|23]/a_60_290# WL12 SL23 VSS sky130_fd_pr__nfet_g5v0d10v5 ad=0.65 pd=3.3 as=0 ps=0 w=1 l=0.5
X6676 rr2t2r_0[13|23]/a_460_290# WL13 SL23 VSS sky130_fd_pr__nfet_g5v0d10v5 ad=0.65 pd=3.3 as=0 ps=0 w=1 l=0.5
X6677 BLP23 rr2t2r_0[13|23]/a_60_290# sky130_fd_pr_reram__reram_cell area_ox=0.0676
X6678 BLN23 rr2t2r_0[13|23]/a_460_290# sky130_fd_pr_reram__reram_cell area_ox=0.0676
X6679 rr2t2r_0[13|23]/a_60_290# WL13 SL23 VSS sky130_fd_pr__nfet_g5v0d10v5 ad=0.65 pd=3.3 as=0 ps=0 w=1 l=0.5
X6680 rr2t2r_0[14|23]/a_460_290# WL14 SL23 VSS sky130_fd_pr__nfet_g5v0d10v5 ad=0.65 pd=3.3 as=0 ps=0 w=1 l=0.5
X6681 BLP23 rr2t2r_0[14|23]/a_60_290# sky130_fd_pr_reram__reram_cell area_ox=0.0676
X6682 BLN23 rr2t2r_0[14|23]/a_460_290# sky130_fd_pr_reram__reram_cell area_ox=0.0676
X6683 rr2t2r_0[14|23]/a_60_290# WL14 SL23 VSS sky130_fd_pr__nfet_g5v0d10v5 ad=0.65 pd=3.3 as=0 ps=0 w=1 l=0.5
X6684 rr2t2r_0[15|23]/a_460_290# WL15 SL23 VSS sky130_fd_pr__nfet_g5v0d10v5 ad=0.65 pd=3.3 as=0 ps=0 w=1 l=0.5
X6685 BLP23 rr2t2r_0[15|23]/a_60_290# sky130_fd_pr_reram__reram_cell area_ox=0.0676
X6686 BLN23 rr2t2r_0[15|23]/a_460_290# sky130_fd_pr_reram__reram_cell area_ox=0.0676
X6687 rr2t2r_0[15|23]/a_60_290# WL15 SL23 VSS sky130_fd_pr__nfet_g5v0d10v5 ad=0.65 pd=3.3 as=0 ps=0 w=1 l=0.5
X6688 rr2t2r_0[16|23]/a_460_290# WL16 SL23 VSS sky130_fd_pr__nfet_g5v0d10v5 ad=0.65 pd=3.3 as=0 ps=0 w=1 l=0.5
X6689 BLP23 rr2t2r_0[16|23]/a_60_290# sky130_fd_pr_reram__reram_cell area_ox=0.0676
X6690 BLN23 rr2t2r_0[16|23]/a_460_290# sky130_fd_pr_reram__reram_cell area_ox=0.0676
X6691 rr2t2r_0[16|23]/a_60_290# WL16 SL23 VSS sky130_fd_pr__nfet_g5v0d10v5 ad=0.65 pd=3.3 as=0 ps=0 w=1 l=0.5
X6692 rr2t2r_0[17|23]/a_460_290# WL17 SL23 VSS sky130_fd_pr__nfet_g5v0d10v5 ad=0.65 pd=3.3 as=0 ps=0 w=1 l=0.5
X6693 BLP23 rr2t2r_0[17|23]/a_60_290# sky130_fd_pr_reram__reram_cell area_ox=0.0676
X6694 BLN23 rr2t2r_0[17|23]/a_460_290# sky130_fd_pr_reram__reram_cell area_ox=0.0676
X6695 rr2t2r_0[17|23]/a_60_290# WL17 SL23 VSS sky130_fd_pr__nfet_g5v0d10v5 ad=0.65 pd=3.3 as=0 ps=0 w=1 l=0.5
X6696 rr2t2r_0[18|23]/a_460_290# WL18 SL23 VSS sky130_fd_pr__nfet_g5v0d10v5 ad=0.65 pd=3.3 as=0 ps=0 w=1 l=0.5
X6697 BLP23 rr2t2r_0[18|23]/a_60_290# sky130_fd_pr_reram__reram_cell area_ox=0.0676
X6698 BLN23 rr2t2r_0[18|23]/a_460_290# sky130_fd_pr_reram__reram_cell area_ox=0.0676
X6699 rr2t2r_0[18|23]/a_60_290# WL18 SL23 VSS sky130_fd_pr__nfet_g5v0d10v5 ad=0.65 pd=3.3 as=0 ps=0 w=1 l=0.5
X6700 rr2t2r_0[19|23]/a_460_290# WL19 SL23 VSS sky130_fd_pr__nfet_g5v0d10v5 ad=0.65 pd=3.3 as=0 ps=0 w=1 l=0.5
X6701 BLP23 rr2t2r_0[19|23]/a_60_290# sky130_fd_pr_reram__reram_cell area_ox=0.0676
X6702 BLN23 rr2t2r_0[19|23]/a_460_290# sky130_fd_pr_reram__reram_cell area_ox=0.0676
X6703 rr2t2r_0[19|23]/a_60_290# WL19 SL23 VSS sky130_fd_pr__nfet_g5v0d10v5 ad=0.65 pd=3.3 as=0 ps=0 w=1 l=0.5
X6704 rr2t2r_0[20|23]/a_460_290# WL20 SL23 VSS sky130_fd_pr__nfet_g5v0d10v5 ad=0.65 pd=3.3 as=0 ps=0 w=1 l=0.5
X6705 BLP23 rr2t2r_0[20|23]/a_60_290# sky130_fd_pr_reram__reram_cell area_ox=0.0676
X6706 BLN23 rr2t2r_0[20|23]/a_460_290# sky130_fd_pr_reram__reram_cell area_ox=0.0676
X6707 rr2t2r_0[20|23]/a_60_290# WL20 SL23 VSS sky130_fd_pr__nfet_g5v0d10v5 ad=0.65 pd=3.3 as=0 ps=0 w=1 l=0.5
X6708 rr2t2r_0[21|23]/a_460_290# WL21 SL23 VSS sky130_fd_pr__nfet_g5v0d10v5 ad=0.65 pd=3.3 as=0 ps=0 w=1 l=0.5
X6709 BLP23 rr2t2r_0[21|23]/a_60_290# sky130_fd_pr_reram__reram_cell area_ox=0.0676
X6710 BLN23 rr2t2r_0[21|23]/a_460_290# sky130_fd_pr_reram__reram_cell area_ox=0.0676
X6711 rr2t2r_0[21|23]/a_60_290# WL21 SL23 VSS sky130_fd_pr__nfet_g5v0d10v5 ad=0.65 pd=3.3 as=0 ps=0 w=1 l=0.5
X6712 rr2t2r_0[22|23]/a_460_290# WL22 SL23 VSS sky130_fd_pr__nfet_g5v0d10v5 ad=0.65 pd=3.3 as=0 ps=0 w=1 l=0.5
X6713 BLP23 rr2t2r_0[22|23]/a_60_290# sky130_fd_pr_reram__reram_cell area_ox=0.0676
X6714 BLN23 rr2t2r_0[22|23]/a_460_290# sky130_fd_pr_reram__reram_cell area_ox=0.0676
X6715 rr2t2r_0[22|23]/a_60_290# WL22 SL23 VSS sky130_fd_pr__nfet_g5v0d10v5 ad=0.65 pd=3.3 as=0 ps=0 w=1 l=0.5
X6716 rr2t2r_0[23|23]/a_460_290# WL23 SL23 VSS sky130_fd_pr__nfet_g5v0d10v5 ad=0.65 pd=3.3 as=0 ps=0 w=1 l=0.5
X6717 BLP23 rr2t2r_0[23|23]/a_60_290# sky130_fd_pr_reram__reram_cell area_ox=0.0676
X6718 BLN23 rr2t2r_0[23|23]/a_460_290# sky130_fd_pr_reram__reram_cell area_ox=0.0676
X6719 rr2t2r_0[23|23]/a_60_290# WL23 SL23 VSS sky130_fd_pr__nfet_g5v0d10v5 ad=0.65 pd=3.3 as=0 ps=0 w=1 l=0.5
X6720 rr2t2r_0[24|23]/a_460_290# WL24 SL23 VSS sky130_fd_pr__nfet_g5v0d10v5 ad=0.65 pd=3.3 as=0 ps=0 w=1 l=0.5
X6721 BLP23 rr2t2r_0[24|23]/a_60_290# sky130_fd_pr_reram__reram_cell area_ox=0.0676
X6722 BLN23 rr2t2r_0[24|23]/a_460_290# sky130_fd_pr_reram__reram_cell area_ox=0.0676
X6723 rr2t2r_0[24|23]/a_60_290# WL24 SL23 VSS sky130_fd_pr__nfet_g5v0d10v5 ad=0.65 pd=3.3 as=0 ps=0 w=1 l=0.5
X6724 rr2t2r_0[25|23]/a_460_290# WL25 SL23 VSS sky130_fd_pr__nfet_g5v0d10v5 ad=0.65 pd=3.3 as=0 ps=0 w=1 l=0.5
X6725 BLP23 rr2t2r_0[25|23]/a_60_290# sky130_fd_pr_reram__reram_cell area_ox=0.0676
X6726 BLN23 rr2t2r_0[25|23]/a_460_290# sky130_fd_pr_reram__reram_cell area_ox=0.0676
X6727 rr2t2r_0[25|23]/a_60_290# WL25 SL23 VSS sky130_fd_pr__nfet_g5v0d10v5 ad=0.65 pd=3.3 as=0 ps=0 w=1 l=0.5
X6728 rr2t2r_0[26|23]/a_460_290# WL26 SL23 VSS sky130_fd_pr__nfet_g5v0d10v5 ad=0.65 pd=3.3 as=0 ps=0 w=1 l=0.5
X6729 BLP23 rr2t2r_0[26|23]/a_60_290# sky130_fd_pr_reram__reram_cell area_ox=0.0676
X6730 BLN23 rr2t2r_0[26|23]/a_460_290# sky130_fd_pr_reram__reram_cell area_ox=0.0676
X6731 rr2t2r_0[26|23]/a_60_290# WL26 SL23 VSS sky130_fd_pr__nfet_g5v0d10v5 ad=0.65 pd=3.3 as=0 ps=0 w=1 l=0.5
X6732 rr2t2r_0[27|23]/a_460_290# WL27 SL23 VSS sky130_fd_pr__nfet_g5v0d10v5 ad=0.65 pd=3.3 as=0 ps=0 w=1 l=0.5
X6733 BLP23 rr2t2r_0[27|23]/a_60_290# sky130_fd_pr_reram__reram_cell area_ox=0.0676
X6734 BLN23 rr2t2r_0[27|23]/a_460_290# sky130_fd_pr_reram__reram_cell area_ox=0.0676
X6735 rr2t2r_0[27|23]/a_60_290# WL27 SL23 VSS sky130_fd_pr__nfet_g5v0d10v5 ad=0.65 pd=3.3 as=0 ps=0 w=1 l=0.5
X6736 rr2t2r_0[28|23]/a_460_290# WL28 SL23 VSS sky130_fd_pr__nfet_g5v0d10v5 ad=0.65 pd=3.3 as=0 ps=0 w=1 l=0.5
X6737 BLP23 rr2t2r_0[28|23]/a_60_290# sky130_fd_pr_reram__reram_cell area_ox=0.0676
X6738 BLN23 rr2t2r_0[28|23]/a_460_290# sky130_fd_pr_reram__reram_cell area_ox=0.0676
X6739 rr2t2r_0[28|23]/a_60_290# WL28 SL23 VSS sky130_fd_pr__nfet_g5v0d10v5 ad=0.65 pd=3.3 as=0 ps=0 w=1 l=0.5
X6740 rr2t2r_0[29|23]/a_460_290# WL29 SL23 VSS sky130_fd_pr__nfet_g5v0d10v5 ad=0.65 pd=3.3 as=0 ps=0 w=1 l=0.5
X6741 BLP23 rr2t2r_0[29|23]/a_60_290# sky130_fd_pr_reram__reram_cell area_ox=0.0676
X6742 BLN23 rr2t2r_0[29|23]/a_460_290# sky130_fd_pr_reram__reram_cell area_ox=0.0676
X6743 rr2t2r_0[29|23]/a_60_290# WL29 SL23 VSS sky130_fd_pr__nfet_g5v0d10v5 ad=0.65 pd=3.3 as=0 ps=0 w=1 l=0.5
X6744 rr2t2r_0[30|23]/a_460_290# WL30 SL23 VSS sky130_fd_pr__nfet_g5v0d10v5 ad=0.65 pd=3.3 as=0 ps=0 w=1 l=0.5
X6745 BLP23 rr2t2r_0[30|23]/a_60_290# sky130_fd_pr_reram__reram_cell area_ox=0.0676
X6746 BLN23 rr2t2r_0[30|23]/a_460_290# sky130_fd_pr_reram__reram_cell area_ox=0.0676
X6747 rr2t2r_0[30|23]/a_60_290# WL30 SL23 VSS sky130_fd_pr__nfet_g5v0d10v5 ad=0.65 pd=3.3 as=0 ps=0 w=1 l=0.5
X6748 rr2t2r_0[31|23]/a_460_290# WL31 SL23 VSS sky130_fd_pr__nfet_g5v0d10v5 ad=0.65 pd=3.3 as=0 ps=0 w=1 l=0.5
X6749 BLP23 rr2t2r_0[31|23]/a_60_290# sky130_fd_pr_reram__reram_cell area_ox=0.0676
X6750 BLN23 rr2t2r_0[31|23]/a_460_290# sky130_fd_pr_reram__reram_cell area_ox=0.0676
X6751 rr2t2r_0[31|23]/a_60_290# WL31 SL23 VSS sky130_fd_pr__nfet_g5v0d10v5 ad=0.65 pd=3.3 as=0 ps=0 w=1 l=0.5
X6752 rr2t2r_0[32|23]/a_460_290# WL32 SL23 VSS sky130_fd_pr__nfet_g5v0d10v5 ad=0.65 pd=3.3 as=0 ps=0 w=1 l=0.5
X6753 BLP23 rr2t2r_0[32|23]/a_60_290# sky130_fd_pr_reram__reram_cell area_ox=0.0676
X6754 BLN23 rr2t2r_0[32|23]/a_460_290# sky130_fd_pr_reram__reram_cell area_ox=0.0676
X6755 rr2t2r_0[32|23]/a_60_290# WL32 SL23 VSS sky130_fd_pr__nfet_g5v0d10v5 ad=0.65 pd=3.3 as=0 ps=0 w=1 l=0.5
X6756 rr2t2r_0[33|23]/a_460_290# WL33 SL23 VSS sky130_fd_pr__nfet_g5v0d10v5 ad=0.65 pd=3.3 as=0 ps=0 w=1 l=0.5
X6757 BLP23 rr2t2r_0[33|23]/a_60_290# sky130_fd_pr_reram__reram_cell area_ox=0.0676
X6758 BLN23 rr2t2r_0[33|23]/a_460_290# sky130_fd_pr_reram__reram_cell area_ox=0.0676
X6759 rr2t2r_0[33|23]/a_60_290# WL33 SL23 VSS sky130_fd_pr__nfet_g5v0d10v5 ad=0.65 pd=3.3 as=0 ps=0 w=1 l=0.5
X6760 rr2t2r_0[34|23]/a_460_290# WL34 SL23 VSS sky130_fd_pr__nfet_g5v0d10v5 ad=0.65 pd=3.3 as=0 ps=0 w=1 l=0.5
X6761 BLP23 rr2t2r_0[34|23]/a_60_290# sky130_fd_pr_reram__reram_cell area_ox=0.0676
X6762 BLN23 rr2t2r_0[34|23]/a_460_290# sky130_fd_pr_reram__reram_cell area_ox=0.0676
X6763 rr2t2r_0[34|23]/a_60_290# WL34 SL23 VSS sky130_fd_pr__nfet_g5v0d10v5 ad=0.65 pd=3.3 as=0 ps=0 w=1 l=0.5
X6764 rr2t2r_0[35|23]/a_460_290# WL35 SL23 VSS sky130_fd_pr__nfet_g5v0d10v5 ad=0.65 pd=3.3 as=0 ps=0 w=1 l=0.5
X6765 BLP23 rr2t2r_0[35|23]/a_60_290# sky130_fd_pr_reram__reram_cell area_ox=0.0676
X6766 BLN23 rr2t2r_0[35|23]/a_460_290# sky130_fd_pr_reram__reram_cell area_ox=0.0676
X6767 rr2t2r_0[35|23]/a_60_290# WL35 SL23 VSS sky130_fd_pr__nfet_g5v0d10v5 ad=0.65 pd=3.3 as=0 ps=0 w=1 l=0.5
X6768 rr2t2r_0[36|23]/a_460_290# WL36 SL23 VSS sky130_fd_pr__nfet_g5v0d10v5 ad=0.65 pd=3.3 as=0 ps=0 w=1 l=0.5
X6769 BLP23 rr2t2r_0[36|23]/a_60_290# sky130_fd_pr_reram__reram_cell area_ox=0.0676
X6770 BLN23 rr2t2r_0[36|23]/a_460_290# sky130_fd_pr_reram__reram_cell area_ox=0.0676
X6771 rr2t2r_0[36|23]/a_60_290# WL36 SL23 VSS sky130_fd_pr__nfet_g5v0d10v5 ad=0.65 pd=3.3 as=0 ps=0 w=1 l=0.5
X6772 rr2t2r_0[37|23]/a_460_290# WL37 SL23 VSS sky130_fd_pr__nfet_g5v0d10v5 ad=0.65 pd=3.3 as=0 ps=0 w=1 l=0.5
X6773 BLP23 rr2t2r_0[37|23]/a_60_290# sky130_fd_pr_reram__reram_cell area_ox=0.0676
X6774 BLN23 rr2t2r_0[37|23]/a_460_290# sky130_fd_pr_reram__reram_cell area_ox=0.0676
X6775 rr2t2r_0[37|23]/a_60_290# WL37 SL23 VSS sky130_fd_pr__nfet_g5v0d10v5 ad=0.65 pd=3.3 as=0 ps=0 w=1 l=0.5
X6776 rr2t2r_0[38|23]/a_460_290# WL38 SL23 VSS sky130_fd_pr__nfet_g5v0d10v5 ad=0.65 pd=3.3 as=0 ps=0 w=1 l=0.5
X6777 BLP23 rr2t2r_0[38|23]/a_60_290# sky130_fd_pr_reram__reram_cell area_ox=0.0676
X6778 BLN23 rr2t2r_0[38|23]/a_460_290# sky130_fd_pr_reram__reram_cell area_ox=0.0676
X6779 rr2t2r_0[38|23]/a_60_290# WL38 SL23 VSS sky130_fd_pr__nfet_g5v0d10v5 ad=0.65 pd=3.3 as=0 ps=0 w=1 l=0.5
X6780 rr2t2r_0[39|23]/a_460_290# WL39 SL23 VSS sky130_fd_pr__nfet_g5v0d10v5 ad=0.65 pd=3.3 as=0 ps=0 w=1 l=0.5
X6781 BLP23 rr2t2r_0[39|23]/a_60_290# sky130_fd_pr_reram__reram_cell area_ox=0.0676
X6782 BLN23 rr2t2r_0[39|23]/a_460_290# sky130_fd_pr_reram__reram_cell area_ox=0.0676
X6783 rr2t2r_0[39|23]/a_60_290# WL39 SL23 VSS sky130_fd_pr__nfet_g5v0d10v5 ad=0.65 pd=3.3 as=0 ps=0 w=1 l=0.5
X6784 rr2t2r_0[40|23]/a_460_290# WL40 SL23 VSS sky130_fd_pr__nfet_g5v0d10v5 ad=0.65 pd=3.3 as=0 ps=0 w=1 l=0.5
X6785 BLP23 rr2t2r_0[40|23]/a_60_290# sky130_fd_pr_reram__reram_cell area_ox=0.0676
X6786 BLN23 rr2t2r_0[40|23]/a_460_290# sky130_fd_pr_reram__reram_cell area_ox=0.0676
X6787 rr2t2r_0[40|23]/a_60_290# WL40 SL23 VSS sky130_fd_pr__nfet_g5v0d10v5 ad=0.65 pd=3.3 as=0 ps=0 w=1 l=0.5
X6788 rr2t2r_0[41|23]/a_460_290# WL41 SL23 VSS sky130_fd_pr__nfet_g5v0d10v5 ad=0.65 pd=3.3 as=0 ps=0 w=1 l=0.5
X6789 BLP23 rr2t2r_0[41|23]/a_60_290# sky130_fd_pr_reram__reram_cell area_ox=0.0676
X6790 BLN23 rr2t2r_0[41|23]/a_460_290# sky130_fd_pr_reram__reram_cell area_ox=0.0676
X6791 rr2t2r_0[41|23]/a_60_290# WL41 SL23 VSS sky130_fd_pr__nfet_g5v0d10v5 ad=0.65 pd=3.3 as=0 ps=0 w=1 l=0.5
X6792 rr2t2r_0[42|23]/a_460_290# WL42 SL23 VSS sky130_fd_pr__nfet_g5v0d10v5 ad=0.65 pd=3.3 as=0 ps=0 w=1 l=0.5
X6793 BLP23 rr2t2r_0[42|23]/a_60_290# sky130_fd_pr_reram__reram_cell area_ox=0.0676
X6794 BLN23 rr2t2r_0[42|23]/a_460_290# sky130_fd_pr_reram__reram_cell area_ox=0.0676
X6795 rr2t2r_0[42|23]/a_60_290# WL42 SL23 VSS sky130_fd_pr__nfet_g5v0d10v5 ad=0.65 pd=3.3 as=0 ps=0 w=1 l=0.5
X6796 rr2t2r_0[43|23]/a_460_290# WL43 SL23 VSS sky130_fd_pr__nfet_g5v0d10v5 ad=0.65 pd=3.3 as=0 ps=0 w=1 l=0.5
X6797 BLP23 rr2t2r_0[43|23]/a_60_290# sky130_fd_pr_reram__reram_cell area_ox=0.0676
X6798 BLN23 rr2t2r_0[43|23]/a_460_290# sky130_fd_pr_reram__reram_cell area_ox=0.0676
X6799 rr2t2r_0[43|23]/a_60_290# WL43 SL23 VSS sky130_fd_pr__nfet_g5v0d10v5 ad=0.65 pd=3.3 as=0 ps=0 w=1 l=0.5
X6800 rr2t2r_0[44|23]/a_460_290# WL44 SL23 VSS sky130_fd_pr__nfet_g5v0d10v5 ad=0.65 pd=3.3 as=0 ps=0 w=1 l=0.5
X6801 BLP23 rr2t2r_0[44|23]/a_60_290# sky130_fd_pr_reram__reram_cell area_ox=0.0676
X6802 BLN23 rr2t2r_0[44|23]/a_460_290# sky130_fd_pr_reram__reram_cell area_ox=0.0676
X6803 rr2t2r_0[44|23]/a_60_290# WL44 SL23 VSS sky130_fd_pr__nfet_g5v0d10v5 ad=0.65 pd=3.3 as=0 ps=0 w=1 l=0.5
X6804 rr2t2r_0[45|23]/a_460_290# WL45 SL23 VSS sky130_fd_pr__nfet_g5v0d10v5 ad=0.65 pd=3.3 as=0 ps=0 w=1 l=0.5
X6805 BLP23 rr2t2r_0[45|23]/a_60_290# sky130_fd_pr_reram__reram_cell area_ox=0.0676
X6806 BLN23 rr2t2r_0[45|23]/a_460_290# sky130_fd_pr_reram__reram_cell area_ox=0.0676
X6807 rr2t2r_0[45|23]/a_60_290# WL45 SL23 VSS sky130_fd_pr__nfet_g5v0d10v5 ad=0.65 pd=3.3 as=0 ps=0 w=1 l=0.5
X6808 rr2t2r_0[46|23]/a_460_290# WL46 SL23 VSS sky130_fd_pr__nfet_g5v0d10v5 ad=0.65 pd=3.3 as=0 ps=0 w=1 l=0.5
X6809 BLP23 rr2t2r_0[46|23]/a_60_290# sky130_fd_pr_reram__reram_cell area_ox=0.0676
X6810 BLN23 rr2t2r_0[46|23]/a_460_290# sky130_fd_pr_reram__reram_cell area_ox=0.0676
X6811 rr2t2r_0[46|23]/a_60_290# WL46 SL23 VSS sky130_fd_pr__nfet_g5v0d10v5 ad=0.65 pd=3.3 as=0 ps=0 w=1 l=0.5
X6812 rr2t2r_0[47|23]/a_460_290# WL47 SL23 VSS sky130_fd_pr__nfet_g5v0d10v5 ad=0.65 pd=3.3 as=0 ps=0 w=1 l=0.5
X6813 BLP23 rr2t2r_0[47|23]/a_60_290# sky130_fd_pr_reram__reram_cell area_ox=0.0676
X6814 BLN23 rr2t2r_0[47|23]/a_460_290# sky130_fd_pr_reram__reram_cell area_ox=0.0676
X6815 rr2t2r_0[47|23]/a_60_290# WL47 SL23 VSS sky130_fd_pr__nfet_g5v0d10v5 ad=0.65 pd=3.3 as=0 ps=0 w=1 l=0.5
X6816 rr2t2r_0[48|23]/a_460_290# WL48 SL23 VSS sky130_fd_pr__nfet_g5v0d10v5 ad=0.65 pd=3.3 as=0 ps=0 w=1 l=0.5
X6817 BLP23 rr2t2r_0[48|23]/a_60_290# sky130_fd_pr_reram__reram_cell area_ox=0.0676
X6818 BLN23 rr2t2r_0[48|23]/a_460_290# sky130_fd_pr_reram__reram_cell area_ox=0.0676
X6819 rr2t2r_0[48|23]/a_60_290# WL48 SL23 VSS sky130_fd_pr__nfet_g5v0d10v5 ad=0.65 pd=3.3 as=0 ps=0 w=1 l=0.5
X6820 rr2t2r_0[49|23]/a_460_290# WL49 SL23 VSS sky130_fd_pr__nfet_g5v0d10v5 ad=0.65 pd=3.3 as=0 ps=0 w=1 l=0.5
X6821 BLP23 rr2t2r_0[49|23]/a_60_290# sky130_fd_pr_reram__reram_cell area_ox=0.0676
X6822 BLN23 rr2t2r_0[49|23]/a_460_290# sky130_fd_pr_reram__reram_cell area_ox=0.0676
X6823 rr2t2r_0[49|23]/a_60_290# WL49 SL23 VSS sky130_fd_pr__nfet_g5v0d10v5 ad=0.65 pd=3.3 as=0 ps=0 w=1 l=0.5
X6824 rr2t2r_0[50|23]/a_460_290# WL50 SL23 VSS sky130_fd_pr__nfet_g5v0d10v5 ad=0.65 pd=3.3 as=0 ps=0 w=1 l=0.5
X6825 BLP23 rr2t2r_0[50|23]/a_60_290# sky130_fd_pr_reram__reram_cell area_ox=0.0676
X6826 BLN23 rr2t2r_0[50|23]/a_460_290# sky130_fd_pr_reram__reram_cell area_ox=0.0676
X6827 rr2t2r_0[50|23]/a_60_290# WL50 SL23 VSS sky130_fd_pr__nfet_g5v0d10v5 ad=0.65 pd=3.3 as=0 ps=0 w=1 l=0.5
X6828 rr2t2r_0[51|23]/a_460_290# WL51 SL23 VSS sky130_fd_pr__nfet_g5v0d10v5 ad=0.65 pd=3.3 as=0 ps=0 w=1 l=0.5
X6829 BLP23 rr2t2r_0[51|23]/a_60_290# sky130_fd_pr_reram__reram_cell area_ox=0.0676
X6830 BLN23 rr2t2r_0[51|23]/a_460_290# sky130_fd_pr_reram__reram_cell area_ox=0.0676
X6831 rr2t2r_0[51|23]/a_60_290# WL51 SL23 VSS sky130_fd_pr__nfet_g5v0d10v5 ad=0.65 pd=3.3 as=0 ps=0 w=1 l=0.5
X6832 rr2t2r_0[52|23]/a_460_290# WL52 SL23 VSS sky130_fd_pr__nfet_g5v0d10v5 ad=0.65 pd=3.3 as=0 ps=0 w=1 l=0.5
X6833 BLP23 rr2t2r_0[52|23]/a_60_290# sky130_fd_pr_reram__reram_cell area_ox=0.0676
X6834 BLN23 rr2t2r_0[52|23]/a_460_290# sky130_fd_pr_reram__reram_cell area_ox=0.0676
X6835 rr2t2r_0[52|23]/a_60_290# WL52 SL23 VSS sky130_fd_pr__nfet_g5v0d10v5 ad=0.65 pd=3.3 as=0 ps=0 w=1 l=0.5
X6836 rr2t2r_0[53|23]/a_460_290# WL53 SL23 VSS sky130_fd_pr__nfet_g5v0d10v5 ad=0.65 pd=3.3 as=0 ps=0 w=1 l=0.5
X6837 BLP23 rr2t2r_0[53|23]/a_60_290# sky130_fd_pr_reram__reram_cell area_ox=0.0676
X6838 BLN23 rr2t2r_0[53|23]/a_460_290# sky130_fd_pr_reram__reram_cell area_ox=0.0676
X6839 rr2t2r_0[53|23]/a_60_290# WL53 SL23 VSS sky130_fd_pr__nfet_g5v0d10v5 ad=0.65 pd=3.3 as=0 ps=0 w=1 l=0.5
X6840 rr2t2r_0[54|23]/a_460_290# WL54 SL23 VSS sky130_fd_pr__nfet_g5v0d10v5 ad=0.65 pd=3.3 as=0 ps=0 w=1 l=0.5
X6841 BLP23 rr2t2r_0[54|23]/a_60_290# sky130_fd_pr_reram__reram_cell area_ox=0.0676
X6842 BLN23 rr2t2r_0[54|23]/a_460_290# sky130_fd_pr_reram__reram_cell area_ox=0.0676
X6843 rr2t2r_0[54|23]/a_60_290# WL54 SL23 VSS sky130_fd_pr__nfet_g5v0d10v5 ad=0.65 pd=3.3 as=0 ps=0 w=1 l=0.5
X6844 rr2t2r_0[55|23]/a_460_290# WL55 SL23 VSS sky130_fd_pr__nfet_g5v0d10v5 ad=0.65 pd=3.3 as=0 ps=0 w=1 l=0.5
X6845 BLP23 rr2t2r_0[55|23]/a_60_290# sky130_fd_pr_reram__reram_cell area_ox=0.0676
X6846 BLN23 rr2t2r_0[55|23]/a_460_290# sky130_fd_pr_reram__reram_cell area_ox=0.0676
X6847 rr2t2r_0[55|23]/a_60_290# WL55 SL23 VSS sky130_fd_pr__nfet_g5v0d10v5 ad=0.65 pd=3.3 as=0 ps=0 w=1 l=0.5
X6848 rr2t2r_0[56|23]/a_460_290# WL56 SL23 VSS sky130_fd_pr__nfet_g5v0d10v5 ad=0.65 pd=3.3 as=0 ps=0 w=1 l=0.5
X6849 BLP23 rr2t2r_0[56|23]/a_60_290# sky130_fd_pr_reram__reram_cell area_ox=0.0676
X6850 BLN23 rr2t2r_0[56|23]/a_460_290# sky130_fd_pr_reram__reram_cell area_ox=0.0676
X6851 rr2t2r_0[56|23]/a_60_290# WL56 SL23 VSS sky130_fd_pr__nfet_g5v0d10v5 ad=0.65 pd=3.3 as=0 ps=0 w=1 l=0.5
X6852 rr2t2r_0[57|23]/a_460_290# WL57 SL23 VSS sky130_fd_pr__nfet_g5v0d10v5 ad=0.65 pd=3.3 as=0 ps=0 w=1 l=0.5
X6853 BLP23 rr2t2r_0[57|23]/a_60_290# sky130_fd_pr_reram__reram_cell area_ox=0.0676
X6854 BLN23 rr2t2r_0[57|23]/a_460_290# sky130_fd_pr_reram__reram_cell area_ox=0.0676
X6855 rr2t2r_0[57|23]/a_60_290# WL57 SL23 VSS sky130_fd_pr__nfet_g5v0d10v5 ad=0.65 pd=3.3 as=0 ps=0 w=1 l=0.5
X6856 rr2t2r_0[58|23]/a_460_290# WL58 SL23 VSS sky130_fd_pr__nfet_g5v0d10v5 ad=0.65 pd=3.3 as=0 ps=0 w=1 l=0.5
X6857 BLP23 rr2t2r_0[58|23]/a_60_290# sky130_fd_pr_reram__reram_cell area_ox=0.0676
X6858 BLN23 rr2t2r_0[58|23]/a_460_290# sky130_fd_pr_reram__reram_cell area_ox=0.0676
X6859 rr2t2r_0[58|23]/a_60_290# WL58 SL23 VSS sky130_fd_pr__nfet_g5v0d10v5 ad=0.65 pd=3.3 as=0 ps=0 w=1 l=0.5
X6860 rr2t2r_0[59|23]/a_460_290# WL59 SL23 VSS sky130_fd_pr__nfet_g5v0d10v5 ad=0.65 pd=3.3 as=0 ps=0 w=1 l=0.5
X6861 BLP23 rr2t2r_0[59|23]/a_60_290# sky130_fd_pr_reram__reram_cell area_ox=0.0676
X6862 BLN23 rr2t2r_0[59|23]/a_460_290# sky130_fd_pr_reram__reram_cell area_ox=0.0676
X6863 rr2t2r_0[59|23]/a_60_290# WL59 SL23 VSS sky130_fd_pr__nfet_g5v0d10v5 ad=0.65 pd=3.3 as=0 ps=0 w=1 l=0.5
X6864 rr2t2r_0[60|23]/a_460_290# WL60 SL23 VSS sky130_fd_pr__nfet_g5v0d10v5 ad=0.65 pd=3.3 as=0 ps=0 w=1 l=0.5
X6865 BLP23 rr2t2r_0[60|23]/a_60_290# sky130_fd_pr_reram__reram_cell area_ox=0.0676
X6866 BLN23 rr2t2r_0[60|23]/a_460_290# sky130_fd_pr_reram__reram_cell area_ox=0.0676
X6867 rr2t2r_0[60|23]/a_60_290# WL60 SL23 VSS sky130_fd_pr__nfet_g5v0d10v5 ad=0.65 pd=3.3 as=0 ps=0 w=1 l=0.5
X6868 rr2t2r_0[61|23]/a_460_290# WL61 SL23 VSS sky130_fd_pr__nfet_g5v0d10v5 ad=0.65 pd=3.3 as=0 ps=0 w=1 l=0.5
X6869 BLP23 rr2t2r_0[61|23]/a_60_290# sky130_fd_pr_reram__reram_cell area_ox=0.0676
X6870 BLN23 rr2t2r_0[61|23]/a_460_290# sky130_fd_pr_reram__reram_cell area_ox=0.0676
X6871 rr2t2r_0[61|23]/a_60_290# WL61 SL23 VSS sky130_fd_pr__nfet_g5v0d10v5 ad=0.65 pd=3.3 as=0 ps=0 w=1 l=0.5
X6872 rr2t2r_0[62|23]/a_460_290# WL62 SL23 VSS sky130_fd_pr__nfet_g5v0d10v5 ad=0.65 pd=3.3 as=0 ps=0 w=1 l=0.5
X6873 BLP23 rr2t2r_0[62|23]/a_60_290# sky130_fd_pr_reram__reram_cell area_ox=0.0676
X6874 BLN23 rr2t2r_0[62|23]/a_460_290# sky130_fd_pr_reram__reram_cell area_ox=0.0676
X6875 rr2t2r_0[62|23]/a_60_290# WL62 SL23 VSS sky130_fd_pr__nfet_g5v0d10v5 ad=0.65 pd=3.3 as=0 ps=0 w=1 l=0.5
X6876 rr2t2r_0[63|23]/a_460_290# WL63 SL23 VSS sky130_fd_pr__nfet_g5v0d10v5 ad=0.65 pd=3.3 as=0 ps=0 w=1 l=0.5
X6877 BLP23 rr2t2r_0[63|23]/a_60_290# sky130_fd_pr_reram__reram_cell area_ox=0.0676
X6878 BLN23 rr2t2r_0[63|23]/a_460_290# sky130_fd_pr_reram__reram_cell area_ox=0.0676
X6879 rr2t2r_0[63|23]/a_60_290# WL63 SL23 VSS sky130_fd_pr__nfet_g5v0d10v5 ad=0.65 pd=3.3 as=0 ps=0 w=1 l=0.5
X6880 rr2t2r_0[64|23]/a_460_290# WL64 SL23 VSS sky130_fd_pr__nfet_g5v0d10v5 ad=0.65 pd=3.3 as=0 ps=0 w=1 l=0.5
X6881 BLP23 rr2t2r_0[64|23]/a_60_290# sky130_fd_pr_reram__reram_cell area_ox=0.0676
X6882 BLN23 rr2t2r_0[64|23]/a_460_290# sky130_fd_pr_reram__reram_cell area_ox=0.0676
X6883 rr2t2r_0[64|23]/a_60_290# WL64 SL23 VSS sky130_fd_pr__nfet_g5v0d10v5 ad=0.65 pd=3.3 as=0 ps=0 w=1 l=0.5
X6884 rr2t2r_0[65|23]/a_460_290# WL65 SL23 VSS sky130_fd_pr__nfet_g5v0d10v5 ad=0.65 pd=3.3 as=0 ps=0 w=1 l=0.5
X6885 BLP23 rr2t2r_0[65|23]/a_60_290# sky130_fd_pr_reram__reram_cell area_ox=0.0676
X6886 BLN23 rr2t2r_0[65|23]/a_460_290# sky130_fd_pr_reram__reram_cell area_ox=0.0676
X6887 rr2t2r_0[65|23]/a_60_290# WL65 SL23 VSS sky130_fd_pr__nfet_g5v0d10v5 ad=0.65 pd=3.3 as=0 ps=0 w=1 l=0.5
X6888 rr2t2r_0[66|23]/a_460_290# WL66 SL23 VSS sky130_fd_pr__nfet_g5v0d10v5 ad=0.65 pd=3.3 as=0 ps=0 w=1 l=0.5
X6889 BLP23 rr2t2r_0[66|23]/a_60_290# sky130_fd_pr_reram__reram_cell area_ox=0.0676
X6890 BLN23 rr2t2r_0[66|23]/a_460_290# sky130_fd_pr_reram__reram_cell area_ox=0.0676
X6891 rr2t2r_0[66|23]/a_60_290# WL66 SL23 VSS sky130_fd_pr__nfet_g5v0d10v5 ad=0.65 pd=3.3 as=0 ps=0 w=1 l=0.5
X6892 rr2t2r_0[67|23]/a_460_290# WL67 SL23 VSS sky130_fd_pr__nfet_g5v0d10v5 ad=0.65 pd=3.3 as=0 ps=0 w=1 l=0.5
X6893 BLP23 rr2t2r_0[67|23]/a_60_290# sky130_fd_pr_reram__reram_cell area_ox=0.0676
X6894 BLN23 rr2t2r_0[67|23]/a_460_290# sky130_fd_pr_reram__reram_cell area_ox=0.0676
X6895 rr2t2r_0[67|23]/a_60_290# WL67 SL23 VSS sky130_fd_pr__nfet_g5v0d10v5 ad=0.65 pd=3.3 as=0 ps=0 w=1 l=0.5
X6896 rr2t2r_0[68|23]/a_460_290# WL68 SL23 VSS sky130_fd_pr__nfet_g5v0d10v5 ad=0.65 pd=3.3 as=0 ps=0 w=1 l=0.5
X6897 BLP23 rr2t2r_0[68|23]/a_60_290# sky130_fd_pr_reram__reram_cell area_ox=0.0676
X6898 BLN23 rr2t2r_0[68|23]/a_460_290# sky130_fd_pr_reram__reram_cell area_ox=0.0676
X6899 rr2t2r_0[68|23]/a_60_290# WL68 SL23 VSS sky130_fd_pr__nfet_g5v0d10v5 ad=0.65 pd=3.3 as=0 ps=0 w=1 l=0.5
X6900 rr2t2r_0[69|23]/a_460_290# WL69 SL23 VSS sky130_fd_pr__nfet_g5v0d10v5 ad=0.65 pd=3.3 as=0 ps=0 w=1 l=0.5
X6901 BLP23 rr2t2r_0[69|23]/a_60_290# sky130_fd_pr_reram__reram_cell area_ox=0.0676
X6902 BLN23 rr2t2r_0[69|23]/a_460_290# sky130_fd_pr_reram__reram_cell area_ox=0.0676
X6903 rr2t2r_0[69|23]/a_60_290# WL69 SL23 VSS sky130_fd_pr__nfet_g5v0d10v5 ad=0.65 pd=3.3 as=0 ps=0 w=1 l=0.5
X6904 rr2t2r_0[70|23]/a_460_290# WL70 SL23 VSS sky130_fd_pr__nfet_g5v0d10v5 ad=0.65 pd=3.3 as=0 ps=0 w=1 l=0.5
X6905 BLP23 rr2t2r_0[70|23]/a_60_290# sky130_fd_pr_reram__reram_cell area_ox=0.0676
X6906 BLN23 rr2t2r_0[70|23]/a_460_290# sky130_fd_pr_reram__reram_cell area_ox=0.0676
X6907 rr2t2r_0[70|23]/a_60_290# WL70 SL23 VSS sky130_fd_pr__nfet_g5v0d10v5 ad=0.65 pd=3.3 as=0 ps=0 w=1 l=0.5
X6908 rr2t2r_0[71|23]/a_460_290# WL71 SL23 VSS sky130_fd_pr__nfet_g5v0d10v5 ad=0.65 pd=3.3 as=0 ps=0 w=1 l=0.5
X6909 BLP23 rr2t2r_0[71|23]/a_60_290# sky130_fd_pr_reram__reram_cell area_ox=0.0676
X6910 BLN23 rr2t2r_0[71|23]/a_460_290# sky130_fd_pr_reram__reram_cell area_ox=0.0676
X6911 rr2t2r_0[71|23]/a_60_290# WL71 SL23 VSS sky130_fd_pr__nfet_g5v0d10v5 ad=0.65 pd=3.3 as=0 ps=0 w=1 l=0.5
.ends
