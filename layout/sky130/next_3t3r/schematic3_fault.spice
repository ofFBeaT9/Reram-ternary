.subckt tcim_sky130_array3 WL0 WL1 WL2 WL3 WL4 WL5 WL6 WL7 WL8 WL9 WL10 WL11 WL12 WL13 WL14 WL15 WL16 WL17 WL18 WL19 WL20 WL21 WL22 WL23 WL24 WL25 WL26 WL27 WL28 WL29 WL30 WL31 WL32 WL33 WL34 WL35 WL36 WL37 WL38 WL39 WL40 WL41 WL42 WL43 WL44 WL45 WL46 WL47 WL48 WL49 WL50 WL51 WL52 WL53 WL54 WL55 WL56 WL57 WL58 WL59 WL60 WL61 WL62 WL63 WL64 WL65 WL66 WL67 WL68 WL69 WL70 WL71 BLP0 BLP1 BLP2 BLP3 BLP4 BLP5 BLP6 BLP7 BLP8 BLP9 BLP10 BLP11 BLP12 BLP13 BLP14 BLP15 BLP16 BLP17 BLP18 BLP19 BLP20 BLP21 BLP22 BLP23 BLZ0 BLZ1 BLZ2 BLZ3 BLZ4 BLZ5 BLZ6 BLZ7 BLZ8 BLZ9 BLZ10 BLZ11 BLZ12 BLZ13 BLZ14 BLZ15 BLZ16 BLZ17 BLZ18 BLZ19 BLZ20 BLZ21 BLZ22 BLZ23 BLN0 BLN1 BLN2 BLN3 BLN4 BLN5 BLN6 BLN7 BLN8 BLN9 BLN10 BLN11 BLN12 BLN13 BLN14 BLN15 BLN16 BLN17 BLN18 BLN19 BLN20 BLN21 BLN22 BLN23 SL0 SL1 SL2 SL3 SL4 SL5 SL6 SL7 SL8 SL9 SL10 SL11 SL12 SL13 SL14 SL15 SL16 SL17 SL18 SL19 SL20 SL21 SL22 SL23 VSS
XMp_0_0 dp_0_0 WL0 SL0 VSS sky130_fd_pr__nfet_g5v0d10v5 w=1 l=0.5
XRp_0_0 BLP0 dp_0_0 sky130_fd_pr_reram__reram_cell area_ox=0.0676
XMz_0_0 dz_0_0 WL0 SL0 VSS sky130_fd_pr__nfet_g5v0d10v5 w=1 l=0.5
XRz_0_0 BLZ0 dz_0_0 sky130_fd_pr_reram__reram_cell area_ox=0.0676
XMn_0_0 dn_0_0 WL0 SL0 VSS sky130_fd_pr__nfet_g5v0d10v5 w=1 l=0.5
XRn_0_0 BLN0 dn_0_0 sky130_fd_pr_reram__reram_cell area_ox=0.0676
XMp_0_1 dp_0_1 WL0 SL1 VSS sky130_fd_pr__nfet_g5v0d10v5 w=1 l=0.5
XRp_0_1 BLP1 dp_0_1 sky130_fd_pr_reram__reram_cell area_ox=0.0676
XMz_0_1 dz_0_1 WL0 SL1 VSS sky130_fd_pr__nfet_g5v0d10v5 w=1 l=0.5
XRz_0_1 BLZ1 dz_0_1 sky130_fd_pr_reram__reram_cell area_ox=0.0676
XMn_0_1 dn_0_1 WL0 SL1 VSS sky130_fd_pr__nfet_g5v0d10v5 w=1 l=0.5
XRn_0_1 BLN1 dn_0_1 sky130_fd_pr_reram__reram_cell area_ox=0.0676
XMp_0_2 dp_0_2 WL0 SL2 VSS sky130_fd_pr__nfet_g5v0d10v5 w=1 l=0.5
XRp_0_2 BLP2 dp_0_2 sky130_fd_pr_reram__reram_cell area_ox=0.0676
XMz_0_2 dz_0_2 WL0 SL2 VSS sky130_fd_pr__nfet_g5v0d10v5 w=1 l=0.5
XRz_0_2 BLZ2 dz_0_2 sky130_fd_pr_reram__reram_cell area_ox=0.0676
XMn_0_2 dn_0_2 WL0 SL2 VSS sky130_fd_pr__nfet_g5v0d10v5 w=1 l=0.5
XRn_0_2 BLN2 dn_0_2 sky130_fd_pr_reram__reram_cell area_ox=0.0676
XMp_0_3 dp_0_3 WL0 SL3 VSS sky130_fd_pr__nfet_g5v0d10v5 w=1 l=0.5
XRp_0_3 BLP3 dp_0_3 sky130_fd_pr_reram__reram_cell area_ox=0.0676
XMz_0_3 dz_0_3 WL0 SL3 VSS sky130_fd_pr__nfet_g5v0d10v5 w=1 l=0.5
XRz_0_3 BLZ3 dz_0_3 sky130_fd_pr_reram__reram_cell area_ox=0.0676
XMn_0_3 dn_0_3 WL0 SL3 VSS sky130_fd_pr__nfet_g5v0d10v5 w=1 l=0.5
XRn_0_3 BLN3 dn_0_3 sky130_fd_pr_reram__reram_cell area_ox=0.0676
XMp_0_4 dp_0_4 WL0 SL4 VSS sky130_fd_pr__nfet_g5v0d10v5 w=1 l=0.5
XRp_0_4 BLP4 dp_0_4 sky130_fd_pr_reram__reram_cell area_ox=0.0676
XMz_0_4 dz_0_4 WL0 SL4 VSS sky130_fd_pr__nfet_g5v0d10v5 w=1 l=0.5
XRz_0_4 BLZ4 dz_0_4 sky130_fd_pr_reram__reram_cell area_ox=0.0676
XMn_0_4 dn_0_4 WL0 SL4 VSS sky130_fd_pr__nfet_g5v0d10v5 w=1 l=0.5
XRn_0_4 BLN4 dn_0_4 sky130_fd_pr_reram__reram_cell area_ox=0.0676
XMp_0_5 dp_0_5 WL0 SL5 VSS sky130_fd_pr__nfet_g5v0d10v5 w=1 l=0.5
XRp_0_5 BLP5 dp_0_5 sky130_fd_pr_reram__reram_cell area_ox=0.0676
XMz_0_5 dz_0_5 WL0 SL5 VSS sky130_fd_pr__nfet_g5v0d10v5 w=1 l=0.5
XRz_0_5 BLZ5 dz_0_5 sky130_fd_pr_reram__reram_cell area_ox=0.0676
XMn_0_5 dn_0_5 WL0 SL5 VSS sky130_fd_pr__nfet_g5v0d10v5 w=1 l=0.5
XRn_0_5 BLN5 dn_0_5 sky130_fd_pr_reram__reram_cell area_ox=0.0676
XMp_0_6 dp_0_6 WL0 SL6 VSS sky130_fd_pr__nfet_g5v0d10v5 w=1 l=0.5
XRp_0_6 BLP6 dp_0_6 sky130_fd_pr_reram__reram_cell area_ox=0.0676
XMz_0_6 dz_0_6 WL0 SL6 VSS sky130_fd_pr__nfet_g5v0d10v5 w=1 l=0.5
XRz_0_6 BLZ6 dz_0_6 sky130_fd_pr_reram__reram_cell area_ox=0.0676
XMn_0_6 dn_0_6 WL0 SL6 VSS sky130_fd_pr__nfet_g5v0d10v5 w=1 l=0.5
XRn_0_6 BLN6 dn_0_6 sky130_fd_pr_reram__reram_cell area_ox=0.0676
XMp_0_7 dp_0_7 WL0 SL7 VSS sky130_fd_pr__nfet_g5v0d10v5 w=1 l=0.5
XRp_0_7 BLP7 dp_0_7 sky130_fd_pr_reram__reram_cell area_ox=0.0676
XMz_0_7 dz_0_7 WL0 SL7 VSS sky130_fd_pr__nfet_g5v0d10v5 w=1 l=0.5
XRz_0_7 BLZ7 dz_0_7 sky130_fd_pr_reram__reram_cell area_ox=0.0676
XMn_0_7 dn_0_7 WL0 SL7 VSS sky130_fd_pr__nfet_g5v0d10v5 w=1 l=0.5
XRn_0_7 BLN7 dn_0_7 sky130_fd_pr_reram__reram_cell area_ox=0.0676
XMp_0_8 dp_0_8 WL0 SL8 VSS sky130_fd_pr__nfet_g5v0d10v5 w=1 l=0.5
XRp_0_8 BLP8 dp_0_8 sky130_fd_pr_reram__reram_cell area_ox=0.0676
XMz_0_8 dz_0_8 WL0 SL8 VSS sky130_fd_pr__nfet_g5v0d10v5 w=1 l=0.5
XRz_0_8 BLZ8 dz_0_8 sky130_fd_pr_reram__reram_cell area_ox=0.0676
XMn_0_8 dn_0_8 WL0 SL8 VSS sky130_fd_pr__nfet_g5v0d10v5 w=1 l=0.5
XRn_0_8 BLN8 dn_0_8 sky130_fd_pr_reram__reram_cell area_ox=0.0676
XMp_0_9 dp_0_9 WL0 SL9 VSS sky130_fd_pr__nfet_g5v0d10v5 w=1 l=0.5
XRp_0_9 BLP9 dp_0_9 sky130_fd_pr_reram__reram_cell area_ox=0.0676
XMz_0_9 dz_0_9 WL0 SL9 VSS sky130_fd_pr__nfet_g5v0d10v5 w=1 l=0.5
XRz_0_9 BLZ9 dz_0_9 sky130_fd_pr_reram__reram_cell area_ox=0.0676
XMn_0_9 dn_0_9 WL0 SL9 VSS sky130_fd_pr__nfet_g5v0d10v5 w=1 l=0.5
XRn_0_9 BLN9 dn_0_9 sky130_fd_pr_reram__reram_cell area_ox=0.0676
XMp_0_10 dp_0_10 WL0 SL10 VSS sky130_fd_pr__nfet_g5v0d10v5 w=1 l=0.5
XRp_0_10 BLP10 dp_0_10 sky130_fd_pr_reram__reram_cell area_ox=0.0676
XMz_0_10 dz_0_10 WL0 SL10 VSS sky130_fd_pr__nfet_g5v0d10v5 w=1 l=0.5
XRz_0_10 BLZ10 dz_0_10 sky130_fd_pr_reram__reram_cell area_ox=0.0676
XMn_0_10 dn_0_10 WL0 SL10 VSS sky130_fd_pr__nfet_g5v0d10v5 w=1 l=0.5
XRn_0_10 BLN10 dn_0_10 sky130_fd_pr_reram__reram_cell area_ox=0.0676
XMp_0_11 dp_0_11 WL0 SL11 VSS sky130_fd_pr__nfet_g5v0d10v5 w=1 l=0.5
XRp_0_11 BLP11 dp_0_11 sky130_fd_pr_reram__reram_cell area_ox=0.0676
XMz_0_11 dz_0_11 WL0 SL11 VSS sky130_fd_pr__nfet_g5v0d10v5 w=1 l=0.5
XRz_0_11 BLZ11 dz_0_11 sky130_fd_pr_reram__reram_cell area_ox=0.0676
XMn_0_11 dn_0_11 WL0 SL11 VSS sky130_fd_pr__nfet_g5v0d10v5 w=1 l=0.5
XRn_0_11 BLN11 dn_0_11 sky130_fd_pr_reram__reram_cell area_ox=0.0676
XMp_0_12 dp_0_12 WL0 SL12 VSS sky130_fd_pr__nfet_g5v0d10v5 w=1 l=0.5
XRp_0_12 BLP12 dp_0_12 sky130_fd_pr_reram__reram_cell area_ox=0.0676
XMz_0_12 dz_0_12 WL0 SL12 VSS sky130_fd_pr__nfet_g5v0d10v5 w=1 l=0.5
XRz_0_12 BLZ12 dz_0_12 sky130_fd_pr_reram__reram_cell area_ox=0.0676
XMn_0_12 dn_0_12 WL0 SL12 VSS sky130_fd_pr__nfet_g5v0d10v5 w=1 l=0.5
XRn_0_12 BLN12 dn_0_12 sky130_fd_pr_reram__reram_cell area_ox=0.0676
XMp_0_13 dp_0_13 WL0 SL13 VSS sky130_fd_pr__nfet_g5v0d10v5 w=1 l=0.5
XRp_0_13 BLP13 dp_0_13 sky130_fd_pr_reram__reram_cell area_ox=0.0676
XMz_0_13 dz_0_13 WL0 SL13 VSS sky130_fd_pr__nfet_g5v0d10v5 w=1 l=0.5
XRz_0_13 BLZ13 dz_0_13 sky130_fd_pr_reram__reram_cell area_ox=0.0676
XMn_0_13 dn_0_13 WL0 SL13 VSS sky130_fd_pr__nfet_g5v0d10v5 w=1 l=0.5
XRn_0_13 BLN13 dn_0_13 sky130_fd_pr_reram__reram_cell area_ox=0.0676
XMp_0_14 dp_0_14 WL0 SL14 VSS sky130_fd_pr__nfet_g5v0d10v5 w=1 l=0.5
XRp_0_14 BLP14 dp_0_14 sky130_fd_pr_reram__reram_cell area_ox=0.0676
XMz_0_14 dz_0_14 WL0 SL14 VSS sky130_fd_pr__nfet_g5v0d10v5 w=1 l=0.5
XRz_0_14 BLZ14 dz_0_14 sky130_fd_pr_reram__reram_cell area_ox=0.0676
XMn_0_14 dn_0_14 WL0 SL14 VSS sky130_fd_pr__nfet_g5v0d10v5 w=1 l=0.5
XRn_0_14 BLN14 dn_0_14 sky130_fd_pr_reram__reram_cell area_ox=0.0676
XMp_0_15 dp_0_15 WL0 SL15 VSS sky130_fd_pr__nfet_g5v0d10v5 w=1 l=0.5
XRp_0_15 BLP15 dp_0_15 sky130_fd_pr_reram__reram_cell area_ox=0.0676
XMz_0_15 dz_0_15 WL0 SL15 VSS sky130_fd_pr__nfet_g5v0d10v5 w=1 l=0.5
XRz_0_15 BLZ15 dz_0_15 sky130_fd_pr_reram__reram_cell area_ox=0.0676
XMn_0_15 dn_0_15 WL0 SL15 VSS sky130_fd_pr__nfet_g5v0d10v5 w=1 l=0.5
XRn_0_15 BLN15 dn_0_15 sky130_fd_pr_reram__reram_cell area_ox=0.0676
XMp_0_16 dp_0_16 WL0 SL16 VSS sky130_fd_pr__nfet_g5v0d10v5 w=1 l=0.5
XRp_0_16 BLP16 dp_0_16 sky130_fd_pr_reram__reram_cell area_ox=0.0676
XMz_0_16 dz_0_16 WL0 SL16 VSS sky130_fd_pr__nfet_g5v0d10v5 w=1 l=0.5
XRz_0_16 BLZ16 dz_0_16 sky130_fd_pr_reram__reram_cell area_ox=0.0676
XMn_0_16 dn_0_16 WL0 SL16 VSS sky130_fd_pr__nfet_g5v0d10v5 w=1 l=0.5
XRn_0_16 BLN16 dn_0_16 sky130_fd_pr_reram__reram_cell area_ox=0.0676
XMp_0_17 dp_0_17 WL0 SL17 VSS sky130_fd_pr__nfet_g5v0d10v5 w=1 l=0.5
XRp_0_17 BLP17 dp_0_17 sky130_fd_pr_reram__reram_cell area_ox=0.0676
XMz_0_17 dz_0_17 WL0 SL17 VSS sky130_fd_pr__nfet_g5v0d10v5 w=1 l=0.5
XRz_0_17 BLZ17 dz_0_17 sky130_fd_pr_reram__reram_cell area_ox=0.0676
XMn_0_17 dn_0_17 WL0 SL17 VSS sky130_fd_pr__nfet_g5v0d10v5 w=1 l=0.5
XRn_0_17 BLN17 dn_0_17 sky130_fd_pr_reram__reram_cell area_ox=0.0676
XMp_0_18 dp_0_18 WL0 SL18 VSS sky130_fd_pr__nfet_g5v0d10v5 w=1 l=0.5
XRp_0_18 BLP18 dp_0_18 sky130_fd_pr_reram__reram_cell area_ox=0.0676
XMz_0_18 dz_0_18 WL0 SL18 VSS sky130_fd_pr__nfet_g5v0d10v5 w=1 l=0.5
XRz_0_18 BLZ18 dz_0_18 sky130_fd_pr_reram__reram_cell area_ox=0.0676
XMn_0_18 dn_0_18 WL0 SL18 VSS sky130_fd_pr__nfet_g5v0d10v5 w=1 l=0.5
XRn_0_18 BLN18 dn_0_18 sky130_fd_pr_reram__reram_cell area_ox=0.0676
XMp_0_19 dp_0_19 WL0 SL19 VSS sky130_fd_pr__nfet_g5v0d10v5 w=1 l=0.5
XRp_0_19 BLP19 dp_0_19 sky130_fd_pr_reram__reram_cell area_ox=0.0676
XMz_0_19 dz_0_19 WL0 SL19 VSS sky130_fd_pr__nfet_g5v0d10v5 w=1 l=0.5
XRz_0_19 BLZ19 dz_0_19 sky130_fd_pr_reram__reram_cell area_ox=0.0676
XMn_0_19 dn_0_19 WL0 SL19 VSS sky130_fd_pr__nfet_g5v0d10v5 w=1 l=0.5
XRn_0_19 BLN19 dn_0_19 sky130_fd_pr_reram__reram_cell area_ox=0.0676
XMp_0_20 dp_0_20 WL0 SL20 VSS sky130_fd_pr__nfet_g5v0d10v5 w=1 l=0.5
XRp_0_20 BLP20 dp_0_20 sky130_fd_pr_reram__reram_cell area_ox=0.0676
XMz_0_20 dz_0_20 WL0 SL20 VSS sky130_fd_pr__nfet_g5v0d10v5 w=1 l=0.5
XRz_0_20 BLZ20 dz_0_20 sky130_fd_pr_reram__reram_cell area_ox=0.0676
XMn_0_20 dn_0_20 WL0 SL20 VSS sky130_fd_pr__nfet_g5v0d10v5 w=1 l=0.5
XRn_0_20 BLN20 dn_0_20 sky130_fd_pr_reram__reram_cell area_ox=0.0676
XMp_0_21 dp_0_21 WL0 SL21 VSS sky130_fd_pr__nfet_g5v0d10v5 w=1 l=0.5
XRp_0_21 BLP21 dp_0_21 sky130_fd_pr_reram__reram_cell area_ox=0.0676
XMz_0_21 dz_0_21 WL0 SL21 VSS sky130_fd_pr__nfet_g5v0d10v5 w=1 l=0.5
XRz_0_21 BLZ21 dz_0_21 sky130_fd_pr_reram__reram_cell area_ox=0.0676
XMn_0_21 dn_0_21 WL0 SL21 VSS sky130_fd_pr__nfet_g5v0d10v5 w=1 l=0.5
XRn_0_21 BLN21 dn_0_21 sky130_fd_pr_reram__reram_cell area_ox=0.0676
XMp_0_22 dp_0_22 WL0 SL22 VSS sky130_fd_pr__nfet_g5v0d10v5 w=1 l=0.5
XRp_0_22 BLP22 dp_0_22 sky130_fd_pr_reram__reram_cell area_ox=0.0676
XMz_0_22 dz_0_22 WL0 SL22 VSS sky130_fd_pr__nfet_g5v0d10v5 w=1 l=0.5
XRz_0_22 BLZ22 dz_0_22 sky130_fd_pr_reram__reram_cell area_ox=0.0676
XMn_0_22 dn_0_22 WL0 SL22 VSS sky130_fd_pr__nfet_g5v0d10v5 w=1 l=0.5
XRn_0_22 BLN22 dn_0_22 sky130_fd_pr_reram__reram_cell area_ox=0.0676
XMp_0_23 dp_0_23 WL0 SL23 VSS sky130_fd_pr__nfet_g5v0d10v5 w=1 l=0.5
XRp_0_23 BLP23 dp_0_23 sky130_fd_pr_reram__reram_cell area_ox=0.0676
XMz_0_23 dz_0_23 WL0 SL23 VSS sky130_fd_pr__nfet_g5v0d10v5 w=1 l=0.5
XRz_0_23 BLZ23 dz_0_23 sky130_fd_pr_reram__reram_cell area_ox=0.0676
XMn_0_23 dn_0_23 WL0 SL23 VSS sky130_fd_pr__nfet_g5v0d10v5 w=1 l=0.5
XRn_0_23 BLN23 dn_0_23 sky130_fd_pr_reram__reram_cell area_ox=0.0676
XMp_1_0 dp_1_0 WL1 SL0 VSS sky130_fd_pr__nfet_g5v0d10v5 w=1 l=0.5
XRp_1_0 BLP0 dp_1_0 sky130_fd_pr_reram__reram_cell area_ox=0.0676
XMz_1_0 dz_1_0 WL1 SL0 VSS sky130_fd_pr__nfet_g5v0d10v5 w=1 l=0.5
XRz_1_0 BLZ0 dz_1_0 sky130_fd_pr_reram__reram_cell area_ox=0.0676
XMn_1_0 dn_1_0 WL1 SL0 VSS sky130_fd_pr__nfet_g5v0d10v5 w=1 l=0.5
XRn_1_0 BLN0 dn_1_0 sky130_fd_pr_reram__reram_cell area_ox=0.0676
XMp_1_1 dp_1_1 WL1 SL1 VSS sky130_fd_pr__nfet_g5v0d10v5 w=1 l=0.5
XRp_1_1 BLP1 dp_1_1 sky130_fd_pr_reram__reram_cell area_ox=0.0676
XMz_1_1 dz_1_1 WL1 SL1 VSS sky130_fd_pr__nfet_g5v0d10v5 w=1 l=0.5
XRz_1_1 BLZ1 dz_1_1 sky130_fd_pr_reram__reram_cell area_ox=0.0676
XMn_1_1 dn_1_1 WL1 SL1 VSS sky130_fd_pr__nfet_g5v0d10v5 w=1 l=0.5
XRn_1_1 BLN1 dn_1_1 sky130_fd_pr_reram__reram_cell area_ox=0.0676
XMp_1_2 dp_1_2 WL1 SL2 VSS sky130_fd_pr__nfet_g5v0d10v5 w=1 l=0.5
XRp_1_2 BLP2 dp_1_2 sky130_fd_pr_reram__reram_cell area_ox=0.0676
XMz_1_2 dz_1_2 WL1 SL2 VSS sky130_fd_pr__nfet_g5v0d10v5 w=1 l=0.5
XRz_1_2 BLZ2 dz_1_2 sky130_fd_pr_reram__reram_cell area_ox=0.0676
XMn_1_2 dn_1_2 WL1 SL2 VSS sky130_fd_pr__nfet_g5v0d10v5 w=1 l=0.5
XRn_1_2 BLN2 dn_1_2 sky130_fd_pr_reram__reram_cell area_ox=0.0676
XMp_1_3 dp_1_3 WL1 SL3 VSS sky130_fd_pr__nfet_g5v0d10v5 w=1 l=0.5
XRp_1_3 BLP3 dp_1_3 sky130_fd_pr_reram__reram_cell area_ox=0.0676
XMz_1_3 dz_1_3 WL1 SL3 VSS sky130_fd_pr__nfet_g5v0d10v5 w=1 l=0.5
XRz_1_3 BLZ3 dz_1_3 sky130_fd_pr_reram__reram_cell area_ox=0.0676
XMn_1_3 dn_1_3 WL1 SL3 VSS sky130_fd_pr__nfet_g5v0d10v5 w=1 l=0.5
XRn_1_3 BLN3 dn_1_3 sky130_fd_pr_reram__reram_cell area_ox=0.0676
XMp_1_4 dp_1_4 WL1 SL4 VSS sky130_fd_pr__nfet_g5v0d10v5 w=1 l=0.5
XRp_1_4 BLP4 dp_1_4 sky130_fd_pr_reram__reram_cell area_ox=0.0676
XMz_1_4 dz_1_4 WL1 SL4 VSS sky130_fd_pr__nfet_g5v0d10v5 w=1 l=0.5
XRz_1_4 BLZ4 dz_1_4 sky130_fd_pr_reram__reram_cell area_ox=0.0676
XMn_1_4 dn_1_4 WL1 SL4 VSS sky130_fd_pr__nfet_g5v0d10v5 w=1 l=0.5
XRn_1_4 BLN4 dn_1_4 sky130_fd_pr_reram__reram_cell area_ox=0.0676
XMp_1_5 dp_1_5 WL1 SL5 VSS sky130_fd_pr__nfet_g5v0d10v5 w=1 l=0.5
XRp_1_5 BLP5 dp_1_5 sky130_fd_pr_reram__reram_cell area_ox=0.0676
XMz_1_5 dz_1_5 WL1 SL5 VSS sky130_fd_pr__nfet_g5v0d10v5 w=1 l=0.5
XRz_1_5 BLZ5 dz_1_5 sky130_fd_pr_reram__reram_cell area_ox=0.0676
XMn_1_5 dn_1_5 WL1 SL5 VSS sky130_fd_pr__nfet_g5v0d10v5 w=1 l=0.5
XRn_1_5 BLN5 dn_1_5 sky130_fd_pr_reram__reram_cell area_ox=0.0676
XMp_1_6 dp_1_6 WL1 SL6 VSS sky130_fd_pr__nfet_g5v0d10v5 w=1 l=0.5
XRp_1_6 BLP6 dp_1_6 sky130_fd_pr_reram__reram_cell area_ox=0.0676
XMz_1_6 dz_1_6 WL1 SL6 VSS sky130_fd_pr__nfet_g5v0d10v5 w=1 l=0.5
XRz_1_6 BLZ6 dz_1_6 sky130_fd_pr_reram__reram_cell area_ox=0.0676
XMn_1_6 dn_1_6 WL1 SL6 VSS sky130_fd_pr__nfet_g5v0d10v5 w=1 l=0.5
XRn_1_6 BLN6 dn_1_6 sky130_fd_pr_reram__reram_cell area_ox=0.0676
XMp_1_7 dp_1_7 WL1 SL7 VSS sky130_fd_pr__nfet_g5v0d10v5 w=1 l=0.5
XRp_1_7 BLP7 dp_1_7 sky130_fd_pr_reram__reram_cell area_ox=0.0676
XMz_1_7 dz_1_7 WL1 SL7 VSS sky130_fd_pr__nfet_g5v0d10v5 w=1 l=0.5
XRz_1_7 BLZ7 dz_1_7 sky130_fd_pr_reram__reram_cell area_ox=0.0676
XMn_1_7 dn_1_7 WL1 SL7 VSS sky130_fd_pr__nfet_g5v0d10v5 w=1 l=0.5
XRn_1_7 BLN7 dn_1_7 sky130_fd_pr_reram__reram_cell area_ox=0.0676
XMp_1_8 dp_1_8 WL1 SL8 VSS sky130_fd_pr__nfet_g5v0d10v5 w=1 l=0.5
XRp_1_8 BLP8 dp_1_8 sky130_fd_pr_reram__reram_cell area_ox=0.0676
XMz_1_8 dz_1_8 WL1 SL8 VSS sky130_fd_pr__nfet_g5v0d10v5 w=1 l=0.5
XRz_1_8 BLZ8 dz_1_8 sky130_fd_pr_reram__reram_cell area_ox=0.0676
XMn_1_8 dn_1_8 WL1 SL8 VSS sky130_fd_pr__nfet_g5v0d10v5 w=1 l=0.5
XRn_1_8 BLN8 dn_1_8 sky130_fd_pr_reram__reram_cell area_ox=0.0676
XMp_1_9 dp_1_9 WL1 SL9 VSS sky130_fd_pr__nfet_g5v0d10v5 w=1 l=0.5
XRp_1_9 BLP9 dp_1_9 sky130_fd_pr_reram__reram_cell area_ox=0.0676
XMz_1_9 dz_1_9 WL1 SL9 VSS sky130_fd_pr__nfet_g5v0d10v5 w=1 l=0.5
XRz_1_9 BLZ9 dz_1_9 sky130_fd_pr_reram__reram_cell area_ox=0.0676
XMn_1_9 dn_1_9 WL1 SL9 VSS sky130_fd_pr__nfet_g5v0d10v5 w=1 l=0.5
XRn_1_9 BLN9 dn_1_9 sky130_fd_pr_reram__reram_cell area_ox=0.0676
XMp_1_10 dp_1_10 WL1 SL10 VSS sky130_fd_pr__nfet_g5v0d10v5 w=1 l=0.5
XRp_1_10 BLP10 dp_1_10 sky130_fd_pr_reram__reram_cell area_ox=0.0676
XMz_1_10 dz_1_10 WL1 SL10 VSS sky130_fd_pr__nfet_g5v0d10v5 w=1 l=0.5
XRz_1_10 BLZ10 dz_1_10 sky130_fd_pr_reram__reram_cell area_ox=0.0676
XMn_1_10 dn_1_10 WL1 SL10 VSS sky130_fd_pr__nfet_g5v0d10v5 w=1 l=0.5
XRn_1_10 BLN10 dn_1_10 sky130_fd_pr_reram__reram_cell area_ox=0.0676
XMp_1_11 dp_1_11 WL1 SL11 VSS sky130_fd_pr__nfet_g5v0d10v5 w=1 l=0.5
XRp_1_11 BLP11 dp_1_11 sky130_fd_pr_reram__reram_cell area_ox=0.0676
XMz_1_11 dz_1_11 WL1 SL11 VSS sky130_fd_pr__nfet_g5v0d10v5 w=1 l=0.5
XRz_1_11 BLZ11 dz_1_11 sky130_fd_pr_reram__reram_cell area_ox=0.0676
XMn_1_11 dn_1_11 WL1 SL11 VSS sky130_fd_pr__nfet_g5v0d10v5 w=1 l=0.5
XRn_1_11 BLN11 dn_1_11 sky130_fd_pr_reram__reram_cell area_ox=0.0676
XMp_1_12 dp_1_12 WL1 SL12 VSS sky130_fd_pr__nfet_g5v0d10v5 w=1 l=0.5
XRp_1_12 BLP12 dp_1_12 sky130_fd_pr_reram__reram_cell area_ox=0.0676
XMz_1_12 dz_1_12 WL1 SL12 VSS sky130_fd_pr__nfet_g5v0d10v5 w=1 l=0.5
XRz_1_12 BLZ12 dz_1_12 sky130_fd_pr_reram__reram_cell area_ox=0.0676
XMn_1_12 dn_1_12 WL1 SL12 VSS sky130_fd_pr__nfet_g5v0d10v5 w=1 l=0.5
XRn_1_12 BLN12 dn_1_12 sky130_fd_pr_reram__reram_cell area_ox=0.0676
XMp_1_13 dp_1_13 WL1 SL13 VSS sky130_fd_pr__nfet_g5v0d10v5 w=1 l=0.5
XRp_1_13 BLP13 dp_1_13 sky130_fd_pr_reram__reram_cell area_ox=0.0676
XMz_1_13 dz_1_13 WL1 SL13 VSS sky130_fd_pr__nfet_g5v0d10v5 w=1 l=0.5
XRz_1_13 BLZ13 dz_1_13 sky130_fd_pr_reram__reram_cell area_ox=0.0676
XMn_1_13 dn_1_13 WL1 SL13 VSS sky130_fd_pr__nfet_g5v0d10v5 w=1 l=0.5
XRn_1_13 BLN13 dn_1_13 sky130_fd_pr_reram__reram_cell area_ox=0.0676
XMp_1_14 dp_1_14 WL1 SL14 VSS sky130_fd_pr__nfet_g5v0d10v5 w=1 l=0.5
XRp_1_14 BLP14 dp_1_14 sky130_fd_pr_reram__reram_cell area_ox=0.0676
XMz_1_14 dz_1_14 WL1 SL14 VSS sky130_fd_pr__nfet_g5v0d10v5 w=1 l=0.5
XRz_1_14 BLZ14 dz_1_14 sky130_fd_pr_reram__reram_cell area_ox=0.0676
XMn_1_14 dn_1_14 WL1 SL14 VSS sky130_fd_pr__nfet_g5v0d10v5 w=1 l=0.5
XRn_1_14 BLN14 dn_1_14 sky130_fd_pr_reram__reram_cell area_ox=0.0676
XMp_1_15 dp_1_15 WL1 SL15 VSS sky130_fd_pr__nfet_g5v0d10v5 w=1 l=0.5
XRp_1_15 BLP15 dp_1_15 sky130_fd_pr_reram__reram_cell area_ox=0.0676
XMz_1_15 dz_1_15 WL1 SL15 VSS sky130_fd_pr__nfet_g5v0d10v5 w=1 l=0.5
XRz_1_15 BLZ15 dz_1_15 sky130_fd_pr_reram__reram_cell area_ox=0.0676
XMn_1_15 dn_1_15 WL1 SL15 VSS sky130_fd_pr__nfet_g5v0d10v5 w=1 l=0.5
XRn_1_15 BLN15 dn_1_15 sky130_fd_pr_reram__reram_cell area_ox=0.0676
XMp_1_16 dp_1_16 WL1 SL16 VSS sky130_fd_pr__nfet_g5v0d10v5 w=1 l=0.5
XRp_1_16 BLP16 dp_1_16 sky130_fd_pr_reram__reram_cell area_ox=0.0676
XMz_1_16 dz_1_16 WL1 SL16 VSS sky130_fd_pr__nfet_g5v0d10v5 w=1 l=0.5
XRz_1_16 BLZ16 dz_1_16 sky130_fd_pr_reram__reram_cell area_ox=0.0676
XMn_1_16 dn_1_16 WL1 SL16 VSS sky130_fd_pr__nfet_g5v0d10v5 w=1 l=0.5
XRn_1_16 BLN16 dn_1_16 sky130_fd_pr_reram__reram_cell area_ox=0.0676
XMp_1_17 dp_1_17 WL1 SL17 VSS sky130_fd_pr__nfet_g5v0d10v5 w=1 l=0.5
XRp_1_17 BLP17 dp_1_17 sky130_fd_pr_reram__reram_cell area_ox=0.0676
XMz_1_17 dz_1_17 WL1 SL17 VSS sky130_fd_pr__nfet_g5v0d10v5 w=1 l=0.5
XRz_1_17 BLZ17 dz_1_17 sky130_fd_pr_reram__reram_cell area_ox=0.0676
XMn_1_17 dn_1_17 WL1 SL17 VSS sky130_fd_pr__nfet_g5v0d10v5 w=1 l=0.5
XRn_1_17 BLN17 dn_1_17 sky130_fd_pr_reram__reram_cell area_ox=0.0676
XMp_1_18 dp_1_18 WL1 SL18 VSS sky130_fd_pr__nfet_g5v0d10v5 w=1 l=0.5
XRp_1_18 BLP18 dp_1_18 sky130_fd_pr_reram__reram_cell area_ox=0.0676
XMz_1_18 dz_1_18 WL1 SL18 VSS sky130_fd_pr__nfet_g5v0d10v5 w=1 l=0.5
XRz_1_18 BLZ18 dz_1_18 sky130_fd_pr_reram__reram_cell area_ox=0.0676
XMn_1_18 dn_1_18 WL1 SL18 VSS sky130_fd_pr__nfet_g5v0d10v5 w=1 l=0.5
XRn_1_18 BLN18 dn_1_18 sky130_fd_pr_reram__reram_cell area_ox=0.0676
XMp_1_19 dp_1_19 WL1 SL19 VSS sky130_fd_pr__nfet_g5v0d10v5 w=1 l=0.5
XRp_1_19 BLP19 dp_1_19 sky130_fd_pr_reram__reram_cell area_ox=0.0676
XMz_1_19 dz_1_19 WL1 SL19 VSS sky130_fd_pr__nfet_g5v0d10v5 w=1 l=0.5
XRz_1_19 BLZ19 dz_1_19 sky130_fd_pr_reram__reram_cell area_ox=0.0676
XMn_1_19 dn_1_19 WL1 SL19 VSS sky130_fd_pr__nfet_g5v0d10v5 w=1 l=0.5
XRn_1_19 BLN19 dn_1_19 sky130_fd_pr_reram__reram_cell area_ox=0.0676
XMp_1_20 dp_1_20 WL1 SL20 VSS sky130_fd_pr__nfet_g5v0d10v5 w=1 l=0.5
XRp_1_20 BLP20 dp_1_20 sky130_fd_pr_reram__reram_cell area_ox=0.0676
XMz_1_20 dz_1_20 WL1 SL20 VSS sky130_fd_pr__nfet_g5v0d10v5 w=1 l=0.5
XRz_1_20 BLZ20 dz_1_20 sky130_fd_pr_reram__reram_cell area_ox=0.0676
XMn_1_20 dn_1_20 WL1 SL20 VSS sky130_fd_pr__nfet_g5v0d10v5 w=1 l=0.5
XRn_1_20 BLN20 dn_1_20 sky130_fd_pr_reram__reram_cell area_ox=0.0676
XMp_1_21 dp_1_21 WL1 SL21 VSS sky130_fd_pr__nfet_g5v0d10v5 w=1 l=0.5
XRp_1_21 BLP21 dp_1_21 sky130_fd_pr_reram__reram_cell area_ox=0.0676
XMz_1_21 dz_1_21 WL1 SL21 VSS sky130_fd_pr__nfet_g5v0d10v5 w=1 l=0.5
XRz_1_21 BLZ21 dz_1_21 sky130_fd_pr_reram__reram_cell area_ox=0.0676
XMn_1_21 dn_1_21 WL1 SL21 VSS sky130_fd_pr__nfet_g5v0d10v5 w=1 l=0.5
XRn_1_21 BLN21 dn_1_21 sky130_fd_pr_reram__reram_cell area_ox=0.0676
XMp_1_22 dp_1_22 WL1 SL22 VSS sky130_fd_pr__nfet_g5v0d10v5 w=1 l=0.5
XRp_1_22 BLP22 dp_1_22 sky130_fd_pr_reram__reram_cell area_ox=0.0676
XMz_1_22 dz_1_22 WL1 SL22 VSS sky130_fd_pr__nfet_g5v0d10v5 w=1 l=0.5
XRz_1_22 BLZ22 dz_1_22 sky130_fd_pr_reram__reram_cell area_ox=0.0676
XMn_1_22 dn_1_22 WL1 SL22 VSS sky130_fd_pr__nfet_g5v0d10v5 w=1 l=0.5
XRn_1_22 BLN22 dn_1_22 sky130_fd_pr_reram__reram_cell area_ox=0.0676
XMp_1_23 dp_1_23 WL1 SL23 VSS sky130_fd_pr__nfet_g5v0d10v5 w=1 l=0.5
XRp_1_23 BLP23 dp_1_23 sky130_fd_pr_reram__reram_cell area_ox=0.0676
XMz_1_23 dz_1_23 WL1 SL23 VSS sky130_fd_pr__nfet_g5v0d10v5 w=1 l=0.5
XRz_1_23 BLZ23 dz_1_23 sky130_fd_pr_reram__reram_cell area_ox=0.0676
XMn_1_23 dn_1_23 WL1 SL23 VSS sky130_fd_pr__nfet_g5v0d10v5 w=1 l=0.5
XRn_1_23 BLN23 dn_1_23 sky130_fd_pr_reram__reram_cell area_ox=0.0676
XMp_2_0 dp_2_0 WL2 SL0 VSS sky130_fd_pr__nfet_g5v0d10v5 w=1 l=0.5
XRp_2_0 BLP0 dp_2_0 sky130_fd_pr_reram__reram_cell area_ox=0.0676
XMz_2_0 dz_2_0 WL2 SL0 VSS sky130_fd_pr__nfet_g5v0d10v5 w=1 l=0.5
XRz_2_0 BLZ0 dz_2_0 sky130_fd_pr_reram__reram_cell area_ox=0.0676
XMn_2_0 dn_2_0 WL2 SL0 VSS sky130_fd_pr__nfet_g5v0d10v5 w=1 l=0.5
XRn_2_0 BLN0 dn_2_0 sky130_fd_pr_reram__reram_cell area_ox=0.0676
XMp_2_1 dp_2_1 WL2 SL1 VSS sky130_fd_pr__nfet_g5v0d10v5 w=1 l=0.5
XRp_2_1 BLP1 dp_2_1 sky130_fd_pr_reram__reram_cell area_ox=0.0676
XMz_2_1 dz_2_1 WL2 SL1 VSS sky130_fd_pr__nfet_g5v0d10v5 w=1 l=0.5
XRz_2_1 BLZ1 dz_2_1 sky130_fd_pr_reram__reram_cell area_ox=0.0676
XMn_2_1 dn_2_1 WL2 SL1 VSS sky130_fd_pr__nfet_g5v0d10v5 w=1 l=0.5
XRn_2_1 BLN1 dn_2_1 sky130_fd_pr_reram__reram_cell area_ox=0.0676
XMp_2_2 dp_2_2 WL2 SL2 VSS sky130_fd_pr__nfet_g5v0d10v5 w=1 l=0.5
XRp_2_2 BLP2 dp_2_2 sky130_fd_pr_reram__reram_cell area_ox=0.0676
XMz_2_2 dz_2_2 WL2 SL2 VSS sky130_fd_pr__nfet_g5v0d10v5 w=1 l=0.5
XRz_2_2 BLZ2 dz_2_2 sky130_fd_pr_reram__reram_cell area_ox=0.0676
XMn_2_2 dn_2_2 WL2 SL2 VSS sky130_fd_pr__nfet_g5v0d10v5 w=1 l=0.5
XRn_2_2 BLN2 dn_2_2 sky130_fd_pr_reram__reram_cell area_ox=0.0676
XMp_2_3 dp_2_3 WL2 SL3 VSS sky130_fd_pr__nfet_g5v0d10v5 w=1 l=0.5
XRp_2_3 BLP3 dp_2_3 sky130_fd_pr_reram__reram_cell area_ox=0.0676
XMz_2_3 dz_2_3 WL2 SL3 VSS sky130_fd_pr__nfet_g5v0d10v5 w=1 l=0.5
XRz_2_3 BLZ3 dz_2_3 sky130_fd_pr_reram__reram_cell area_ox=0.0676
XMn_2_3 dn_2_3 WL2 SL3 VSS sky130_fd_pr__nfet_g5v0d10v5 w=1 l=0.5
XRn_2_3 BLN3 dn_2_3 sky130_fd_pr_reram__reram_cell area_ox=0.0676
XMp_2_4 dp_2_4 WL2 SL4 VSS sky130_fd_pr__nfet_g5v0d10v5 w=1 l=0.5
XRp_2_4 BLP4 dp_2_4 sky130_fd_pr_reram__reram_cell area_ox=0.0676
XMz_2_4 dz_2_4 WL2 SL4 VSS sky130_fd_pr__nfet_g5v0d10v5 w=1 l=0.5
XRz_2_4 BLZ4 dz_2_4 sky130_fd_pr_reram__reram_cell area_ox=0.0676
XMn_2_4 dn_2_4 WL2 SL4 VSS sky130_fd_pr__nfet_g5v0d10v5 w=1 l=0.5
XRn_2_4 BLN4 dn_2_4 sky130_fd_pr_reram__reram_cell area_ox=0.0676
XMp_2_5 dp_2_5 WL2 SL5 VSS sky130_fd_pr__nfet_g5v0d10v5 w=1 l=0.5
XRp_2_5 BLP5 dp_2_5 sky130_fd_pr_reram__reram_cell area_ox=0.0676
XMz_2_5 dz_2_5 WL2 SL5 VSS sky130_fd_pr__nfet_g5v0d10v5 w=1 l=0.5
XRz_2_5 BLZ5 dz_2_5 sky130_fd_pr_reram__reram_cell area_ox=0.0676
XMn_2_5 dn_2_5 WL2 SL5 VSS sky130_fd_pr__nfet_g5v0d10v5 w=1 l=0.5
XRn_2_5 BLN5 dn_2_5 sky130_fd_pr_reram__reram_cell area_ox=0.0676
XMp_2_6 dp_2_6 WL2 SL6 VSS sky130_fd_pr__nfet_g5v0d10v5 w=1 l=0.5
XRp_2_6 BLP6 dp_2_6 sky130_fd_pr_reram__reram_cell area_ox=0.0676
XMz_2_6 dz_2_6 WL2 SL6 VSS sky130_fd_pr__nfet_g5v0d10v5 w=1 l=0.5
XRz_2_6 BLZ6 dz_2_6 sky130_fd_pr_reram__reram_cell area_ox=0.0676
XMn_2_6 dn_2_6 WL2 SL6 VSS sky130_fd_pr__nfet_g5v0d10v5 w=1 l=0.5
XRn_2_6 BLN6 dn_2_6 sky130_fd_pr_reram__reram_cell area_ox=0.0676
XMp_2_7 dp_2_7 WL2 SL7 VSS sky130_fd_pr__nfet_g5v0d10v5 w=1 l=0.5
XRp_2_7 BLP7 dp_2_7 sky130_fd_pr_reram__reram_cell area_ox=0.0676
XMz_2_7 dz_2_7 WL2 SL7 VSS sky130_fd_pr__nfet_g5v0d10v5 w=1 l=0.5
XRz_2_7 BLZ7 dz_2_7 sky130_fd_pr_reram__reram_cell area_ox=0.0676
XMn_2_7 dn_2_7 WL2 SL7 VSS sky130_fd_pr__nfet_g5v0d10v5 w=1 l=0.5
XRn_2_7 BLN7 dn_2_7 sky130_fd_pr_reram__reram_cell area_ox=0.0676
XMp_2_8 dp_2_8 WL2 SL8 VSS sky130_fd_pr__nfet_g5v0d10v5 w=1 l=0.5
XRp_2_8 BLP8 dp_2_8 sky130_fd_pr_reram__reram_cell area_ox=0.0676
XMz_2_8 dz_2_8 WL2 SL8 VSS sky130_fd_pr__nfet_g5v0d10v5 w=1 l=0.5
XRz_2_8 BLZ8 dz_2_8 sky130_fd_pr_reram__reram_cell area_ox=0.0676
XMn_2_8 dn_2_8 WL2 SL8 VSS sky130_fd_pr__nfet_g5v0d10v5 w=1 l=0.5
XRn_2_8 BLN8 dn_2_8 sky130_fd_pr_reram__reram_cell area_ox=0.0676
XMp_2_9 dp_2_9 WL2 SL9 VSS sky130_fd_pr__nfet_g5v0d10v5 w=1 l=0.5
XRp_2_9 BLP9 dp_2_9 sky130_fd_pr_reram__reram_cell area_ox=0.0676
XMz_2_9 dz_2_9 WL2 SL9 VSS sky130_fd_pr__nfet_g5v0d10v5 w=1 l=0.5
XRz_2_9 BLZ9 dz_2_9 sky130_fd_pr_reram__reram_cell area_ox=0.0676
XMn_2_9 dn_2_9 WL2 SL9 VSS sky130_fd_pr__nfet_g5v0d10v5 w=1 l=0.5
XRn_2_9 BLN9 dn_2_9 sky130_fd_pr_reram__reram_cell area_ox=0.0676
XMp_2_10 dp_2_10 WL2 SL10 VSS sky130_fd_pr__nfet_g5v0d10v5 w=1 l=0.5
XRp_2_10 BLP10 dp_2_10 sky130_fd_pr_reram__reram_cell area_ox=0.0676
XMz_2_10 dz_2_10 WL2 SL10 VSS sky130_fd_pr__nfet_g5v0d10v5 w=1 l=0.5
XRz_2_10 BLZ10 dz_2_10 sky130_fd_pr_reram__reram_cell area_ox=0.0676
XMn_2_10 dn_2_10 WL2 SL10 VSS sky130_fd_pr__nfet_g5v0d10v5 w=1 l=0.5
XRn_2_10 BLN10 dn_2_10 sky130_fd_pr_reram__reram_cell area_ox=0.0676
XMp_2_11 dp_2_11 WL2 SL11 VSS sky130_fd_pr__nfet_g5v0d10v5 w=1 l=0.5
XRp_2_11 BLP11 dp_2_11 sky130_fd_pr_reram__reram_cell area_ox=0.0676
XMz_2_11 dz_2_11 WL2 SL11 VSS sky130_fd_pr__nfet_g5v0d10v5 w=1 l=0.5
XRz_2_11 BLZ11 dz_2_11 sky130_fd_pr_reram__reram_cell area_ox=0.0676
XMn_2_11 dn_2_11 WL2 SL11 VSS sky130_fd_pr__nfet_g5v0d10v5 w=1 l=0.5
XRn_2_11 BLN11 dn_2_11 sky130_fd_pr_reram__reram_cell area_ox=0.0676
XMp_2_12 dp_2_12 WL2 SL12 VSS sky130_fd_pr__nfet_g5v0d10v5 w=1 l=0.5
XRp_2_12 BLP12 dp_2_12 sky130_fd_pr_reram__reram_cell area_ox=0.0676
XMz_2_12 dz_2_12 WL2 SL12 VSS sky130_fd_pr__nfet_g5v0d10v5 w=1 l=0.5
XRz_2_12 BLZ12 dz_2_12 sky130_fd_pr_reram__reram_cell area_ox=0.0676
XMn_2_12 dn_2_12 WL2 SL12 VSS sky130_fd_pr__nfet_g5v0d10v5 w=1 l=0.5
XRn_2_12 BLN12 dn_2_12 sky130_fd_pr_reram__reram_cell area_ox=0.0676
XMp_2_13 dp_2_13 WL2 SL13 VSS sky130_fd_pr__nfet_g5v0d10v5 w=1 l=0.5
XRp_2_13 BLP13 dp_2_13 sky130_fd_pr_reram__reram_cell area_ox=0.0676
XMz_2_13 dz_2_13 WL2 SL13 VSS sky130_fd_pr__nfet_g5v0d10v5 w=1 l=0.5
XRz_2_13 BLZ13 dz_2_13 sky130_fd_pr_reram__reram_cell area_ox=0.0676
XMn_2_13 dn_2_13 WL2 SL13 VSS sky130_fd_pr__nfet_g5v0d10v5 w=1 l=0.5
XRn_2_13 BLN13 dn_2_13 sky130_fd_pr_reram__reram_cell area_ox=0.0676
XMp_2_14 dp_2_14 WL2 SL14 VSS sky130_fd_pr__nfet_g5v0d10v5 w=1 l=0.5
XRp_2_14 BLP14 dp_2_14 sky130_fd_pr_reram__reram_cell area_ox=0.0676
XMz_2_14 dz_2_14 WL2 SL14 VSS sky130_fd_pr__nfet_g5v0d10v5 w=1 l=0.5
XRz_2_14 BLZ14 dz_2_14 sky130_fd_pr_reram__reram_cell area_ox=0.0676
XMn_2_14 dn_2_14 WL2 SL14 VSS sky130_fd_pr__nfet_g5v0d10v5 w=1 l=0.5
XRn_2_14 BLN14 dn_2_14 sky130_fd_pr_reram__reram_cell area_ox=0.0676
XMp_2_15 dp_2_15 WL2 SL15 VSS sky130_fd_pr__nfet_g5v0d10v5 w=1 l=0.5
XRp_2_15 BLP15 dp_2_15 sky130_fd_pr_reram__reram_cell area_ox=0.0676
XMz_2_15 dz_2_15 WL2 SL15 VSS sky130_fd_pr__nfet_g5v0d10v5 w=1 l=0.5
XRz_2_15 BLZ15 dz_2_15 sky130_fd_pr_reram__reram_cell area_ox=0.0676
XMn_2_15 dn_2_15 WL2 SL15 VSS sky130_fd_pr__nfet_g5v0d10v5 w=1 l=0.5
XRn_2_15 BLN15 dn_2_15 sky130_fd_pr_reram__reram_cell area_ox=0.0676
XMp_2_16 dp_2_16 WL2 SL16 VSS sky130_fd_pr__nfet_g5v0d10v5 w=1 l=0.5
XRp_2_16 BLP16 dp_2_16 sky130_fd_pr_reram__reram_cell area_ox=0.0676
XMz_2_16 dz_2_16 WL2 SL16 VSS sky130_fd_pr__nfet_g5v0d10v5 w=1 l=0.5
XRz_2_16 BLZ16 dz_2_16 sky130_fd_pr_reram__reram_cell area_ox=0.0676
XMn_2_16 dn_2_16 WL2 SL16 VSS sky130_fd_pr__nfet_g5v0d10v5 w=1 l=0.5
XRn_2_16 BLN16 dn_2_16 sky130_fd_pr_reram__reram_cell area_ox=0.0676
XMp_2_17 dp_2_17 WL2 SL17 VSS sky130_fd_pr__nfet_g5v0d10v5 w=1 l=0.5
XRp_2_17 BLP17 dp_2_17 sky130_fd_pr_reram__reram_cell area_ox=0.0676
XMz_2_17 dz_2_17 WL2 SL17 VSS sky130_fd_pr__nfet_g5v0d10v5 w=1 l=0.5
XRz_2_17 BLZ17 dz_2_17 sky130_fd_pr_reram__reram_cell area_ox=0.0676
XMn_2_17 dn_2_17 WL2 SL17 VSS sky130_fd_pr__nfet_g5v0d10v5 w=1 l=0.5
XRn_2_17 BLN17 dn_2_17 sky130_fd_pr_reram__reram_cell area_ox=0.0676
XMp_2_18 dp_2_18 WL2 SL18 VSS sky130_fd_pr__nfet_g5v0d10v5 w=1 l=0.5
XRp_2_18 BLP18 dp_2_18 sky130_fd_pr_reram__reram_cell area_ox=0.0676
XMz_2_18 dz_2_18 WL2 SL18 VSS sky130_fd_pr__nfet_g5v0d10v5 w=1 l=0.5
XRz_2_18 BLZ18 dz_2_18 sky130_fd_pr_reram__reram_cell area_ox=0.0676
XMn_2_18 dn_2_18 WL2 SL18 VSS sky130_fd_pr__nfet_g5v0d10v5 w=1 l=0.5
XRn_2_18 BLN18 dn_2_18 sky130_fd_pr_reram__reram_cell area_ox=0.0676
XMp_2_19 dp_2_19 WL2 SL19 VSS sky130_fd_pr__nfet_g5v0d10v5 w=1 l=0.5
XRp_2_19 BLP19 dp_2_19 sky130_fd_pr_reram__reram_cell area_ox=0.0676
XMz_2_19 dz_2_19 WL2 SL19 VSS sky130_fd_pr__nfet_g5v0d10v5 w=1 l=0.5
XRz_2_19 BLZ19 dz_2_19 sky130_fd_pr_reram__reram_cell area_ox=0.0676
XMn_2_19 dn_2_19 WL2 SL19 VSS sky130_fd_pr__nfet_g5v0d10v5 w=1 l=0.5
XRn_2_19 BLN19 dn_2_19 sky130_fd_pr_reram__reram_cell area_ox=0.0676
XMp_2_20 dp_2_20 WL2 SL20 VSS sky130_fd_pr__nfet_g5v0d10v5 w=1 l=0.5
XRp_2_20 BLP20 dp_2_20 sky130_fd_pr_reram__reram_cell area_ox=0.0676
XMz_2_20 dz_2_20 WL2 SL20 VSS sky130_fd_pr__nfet_g5v0d10v5 w=1 l=0.5
XRz_2_20 BLZ20 dz_2_20 sky130_fd_pr_reram__reram_cell area_ox=0.0676
XMn_2_20 dn_2_20 WL2 SL20 VSS sky130_fd_pr__nfet_g5v0d10v5 w=1 l=0.5
XRn_2_20 BLN20 dn_2_20 sky130_fd_pr_reram__reram_cell area_ox=0.0676
XMp_2_21 dp_2_21 WL2 SL21 VSS sky130_fd_pr__nfet_g5v0d10v5 w=1 l=0.5
XRp_2_21 BLP21 dp_2_21 sky130_fd_pr_reram__reram_cell area_ox=0.0676
XMz_2_21 dz_2_21 WL2 SL21 VSS sky130_fd_pr__nfet_g5v0d10v5 w=1 l=0.5
XRz_2_21 BLZ21 dz_2_21 sky130_fd_pr_reram__reram_cell area_ox=0.0676
XMn_2_21 dn_2_21 WL2 SL21 VSS sky130_fd_pr__nfet_g5v0d10v5 w=1 l=0.5
XRn_2_21 BLN21 dn_2_21 sky130_fd_pr_reram__reram_cell area_ox=0.0676
XMp_2_22 dp_2_22 WL2 SL22 VSS sky130_fd_pr__nfet_g5v0d10v5 w=1 l=0.5
XRp_2_22 BLP22 dp_2_22 sky130_fd_pr_reram__reram_cell area_ox=0.0676
XMz_2_22 dz_2_22 WL2 SL22 VSS sky130_fd_pr__nfet_g5v0d10v5 w=1 l=0.5
XRz_2_22 BLZ22 dz_2_22 sky130_fd_pr_reram__reram_cell area_ox=0.0676
XMn_2_22 dn_2_22 WL2 SL22 VSS sky130_fd_pr__nfet_g5v0d10v5 w=1 l=0.5
XRn_2_22 BLN22 dn_2_22 sky130_fd_pr_reram__reram_cell area_ox=0.0676
XMp_2_23 dp_2_23 WL2 SL23 VSS sky130_fd_pr__nfet_g5v0d10v5 w=1 l=0.5
XRp_2_23 BLP23 dp_2_23 sky130_fd_pr_reram__reram_cell area_ox=0.0676
XMz_2_23 dz_2_23 WL2 SL23 VSS sky130_fd_pr__nfet_g5v0d10v5 w=1 l=0.5
XRz_2_23 BLZ23 dz_2_23 sky130_fd_pr_reram__reram_cell area_ox=0.0676
XMn_2_23 dn_2_23 WL2 SL23 VSS sky130_fd_pr__nfet_g5v0d10v5 w=1 l=0.5
XRn_2_23 BLN23 dn_2_23 sky130_fd_pr_reram__reram_cell area_ox=0.0676
XMp_3_0 dp_3_0 WL3 SL0 VSS sky130_fd_pr__nfet_g5v0d10v5 w=1 l=0.5
XRp_3_0 BLP0 dp_3_0 sky130_fd_pr_reram__reram_cell area_ox=0.0676
XMz_3_0 dz_3_0 WL3 SL0 VSS sky130_fd_pr__nfet_g5v0d10v5 w=1 l=0.5
XRz_3_0 BLZ0 dz_3_0 sky130_fd_pr_reram__reram_cell area_ox=0.0676
XMn_3_0 dn_3_0 WL3 SL0 VSS sky130_fd_pr__nfet_g5v0d10v5 w=1 l=0.5
XRn_3_0 BLN0 dn_3_0 sky130_fd_pr_reram__reram_cell area_ox=0.0676
XMp_3_1 dp_3_1 WL3 SL1 VSS sky130_fd_pr__nfet_g5v0d10v5 w=1 l=0.5
XRp_3_1 BLP1 dp_3_1 sky130_fd_pr_reram__reram_cell area_ox=0.0676
XMz_3_1 dz_3_1 WL3 SL1 VSS sky130_fd_pr__nfet_g5v0d10v5 w=1 l=0.5
XRz_3_1 BLZ1 dz_3_1 sky130_fd_pr_reram__reram_cell area_ox=0.0676
XMn_3_1 dn_3_1 WL3 SL1 VSS sky130_fd_pr__nfet_g5v0d10v5 w=1 l=0.5
XRn_3_1 BLN1 dn_3_1 sky130_fd_pr_reram__reram_cell area_ox=0.0676
XMp_3_2 dp_3_2 WL3 SL2 VSS sky130_fd_pr__nfet_g5v0d10v5 w=1 l=0.5
XRp_3_2 BLP2 dp_3_2 sky130_fd_pr_reram__reram_cell area_ox=0.0676
XMz_3_2 dz_3_2 WL3 SL2 VSS sky130_fd_pr__nfet_g5v0d10v5 w=1 l=0.5
XRz_3_2 BLZ2 dz_3_2 sky130_fd_pr_reram__reram_cell area_ox=0.0676
XMn_3_2 dn_3_2 WL3 SL2 VSS sky130_fd_pr__nfet_g5v0d10v5 w=1 l=0.5
XRn_3_2 BLN2 dn_3_2 sky130_fd_pr_reram__reram_cell area_ox=0.0676
XMp_3_3 dp_3_3 WL3 SL3 VSS sky130_fd_pr__nfet_g5v0d10v5 w=1 l=0.5
XRp_3_3 BLP3 dp_3_3 sky130_fd_pr_reram__reram_cell area_ox=0.0676
XMz_3_3 dz_3_3 WL3 SL3 VSS sky130_fd_pr__nfet_g5v0d10v5 w=1 l=0.5
XRz_3_3 BLZ3 dz_3_3 sky130_fd_pr_reram__reram_cell area_ox=0.0676
XMn_3_3 dn_3_3 WL3 SL3 VSS sky130_fd_pr__nfet_g5v0d10v5 w=1 l=0.5
XRn_3_3 BLN3 dn_3_3 sky130_fd_pr_reram__reram_cell area_ox=0.0676
XMp_3_4 dp_3_4 WL3 SL4 VSS sky130_fd_pr__nfet_g5v0d10v5 w=1 l=0.5
XRp_3_4 BLP4 dp_3_4 sky130_fd_pr_reram__reram_cell area_ox=0.0676
XMz_3_4 dz_3_4 WL3 SL4 VSS sky130_fd_pr__nfet_g5v0d10v5 w=1 l=0.5
XRz_3_4 BLZ4 dz_3_4 sky130_fd_pr_reram__reram_cell area_ox=0.0676
XMn_3_4 dn_3_4 WL3 SL4 VSS sky130_fd_pr__nfet_g5v0d10v5 w=1 l=0.5
XRn_3_4 BLN4 dn_3_4 sky130_fd_pr_reram__reram_cell area_ox=0.0676
XMp_3_5 dp_3_5 WL3 SL5 VSS sky130_fd_pr__nfet_g5v0d10v5 w=1 l=0.5
XRp_3_5 BLP5 dp_3_5 sky130_fd_pr_reram__reram_cell area_ox=0.0676
XMz_3_5 dz_3_5 WL3 SL5 VSS sky130_fd_pr__nfet_g5v0d10v5 w=1 l=0.5
XRz_3_5 BLZ5 dz_3_5 sky130_fd_pr_reram__reram_cell area_ox=0.0676
XMn_3_5 dn_3_5 WL3 SL5 VSS sky130_fd_pr__nfet_g5v0d10v5 w=1 l=0.5
XRn_3_5 BLN5 dn_3_5 sky130_fd_pr_reram__reram_cell area_ox=0.0676
XMp_3_6 dp_3_6 WL3 SL6 VSS sky130_fd_pr__nfet_g5v0d10v5 w=1 l=0.5
XRp_3_6 BLP6 dp_3_6 sky130_fd_pr_reram__reram_cell area_ox=0.0676
XMz_3_6 dz_3_6 WL3 SL6 VSS sky130_fd_pr__nfet_g5v0d10v5 w=1 l=0.5
XRz_3_6 BLZ6 dz_3_6 sky130_fd_pr_reram__reram_cell area_ox=0.0676
XMn_3_6 dn_3_6 WL3 SL6 VSS sky130_fd_pr__nfet_g5v0d10v5 w=1 l=0.5
XRn_3_6 BLN6 dn_3_6 sky130_fd_pr_reram__reram_cell area_ox=0.0676
XMp_3_7 dp_3_7 WL3 SL7 VSS sky130_fd_pr__nfet_g5v0d10v5 w=1 l=0.5
XRp_3_7 BLP7 dp_3_7 sky130_fd_pr_reram__reram_cell area_ox=0.0676
XMz_3_7 dz_3_7 WL3 SL7 VSS sky130_fd_pr__nfet_g5v0d10v5 w=1 l=0.5
XRz_3_7 BLZ7 dz_3_7 sky130_fd_pr_reram__reram_cell area_ox=0.0676
XMn_3_7 dn_3_7 WL3 SL7 VSS sky130_fd_pr__nfet_g5v0d10v5 w=1 l=0.5
XRn_3_7 BLN7 dn_3_7 sky130_fd_pr_reram__reram_cell area_ox=0.0676
XMp_3_8 dp_3_8 WL3 SL8 VSS sky130_fd_pr__nfet_g5v0d10v5 w=1 l=0.5
XRp_3_8 BLP8 dp_3_8 sky130_fd_pr_reram__reram_cell area_ox=0.0676
XMz_3_8 dz_3_8 WL3 SL8 VSS sky130_fd_pr__nfet_g5v0d10v5 w=1 l=0.5
XRz_3_8 BLZ8 dz_3_8 sky130_fd_pr_reram__reram_cell area_ox=0.0676
XMn_3_8 dn_3_8 WL3 SL8 VSS sky130_fd_pr__nfet_g5v0d10v5 w=1 l=0.5
XRn_3_8 BLN8 dn_3_8 sky130_fd_pr_reram__reram_cell area_ox=0.0676
XMp_3_9 dp_3_9 WL3 SL9 VSS sky130_fd_pr__nfet_g5v0d10v5 w=1 l=0.5
XRp_3_9 BLP9 dp_3_9 sky130_fd_pr_reram__reram_cell area_ox=0.0676
XMz_3_9 dz_3_9 WL3 SL9 VSS sky130_fd_pr__nfet_g5v0d10v5 w=1 l=0.5
XRz_3_9 BLZ9 dz_3_9 sky130_fd_pr_reram__reram_cell area_ox=0.0676
XMn_3_9 dn_3_9 WL3 SL9 VSS sky130_fd_pr__nfet_g5v0d10v5 w=1 l=0.5
XRn_3_9 BLN9 dn_3_9 sky130_fd_pr_reram__reram_cell area_ox=0.0676
XMp_3_10 dp_3_10 WL3 SL10 VSS sky130_fd_pr__nfet_g5v0d10v5 w=1 l=0.5
XRp_3_10 BLP10 dp_3_10 sky130_fd_pr_reram__reram_cell area_ox=0.0676
XMz_3_10 dz_3_10 WL3 SL10 VSS sky130_fd_pr__nfet_g5v0d10v5 w=1 l=0.5
XRz_3_10 BLZ10 dz_3_10 sky130_fd_pr_reram__reram_cell area_ox=0.0676
XMn_3_10 dn_3_10 WL3 SL10 VSS sky130_fd_pr__nfet_g5v0d10v5 w=1 l=0.5
XRn_3_10 BLN10 dn_3_10 sky130_fd_pr_reram__reram_cell area_ox=0.0676
XMp_3_11 dp_3_11 WL3 SL11 VSS sky130_fd_pr__nfet_g5v0d10v5 w=1 l=0.5
XRp_3_11 BLP11 dp_3_11 sky130_fd_pr_reram__reram_cell area_ox=0.0676
XMz_3_11 dz_3_11 WL3 SL11 VSS sky130_fd_pr__nfet_g5v0d10v5 w=1 l=0.5
XRz_3_11 BLZ11 dz_3_11 sky130_fd_pr_reram__reram_cell area_ox=0.0676
XMn_3_11 dn_3_11 WL3 SL11 VSS sky130_fd_pr__nfet_g5v0d10v5 w=1 l=0.5
XRn_3_11 BLN11 dn_3_11 sky130_fd_pr_reram__reram_cell area_ox=0.0676
XMp_3_12 dp_3_12 WL3 SL12 VSS sky130_fd_pr__nfet_g5v0d10v5 w=1 l=0.5
XRp_3_12 BLP12 dp_3_12 sky130_fd_pr_reram__reram_cell area_ox=0.0676
XMz_3_12 dz_3_12 WL3 SL12 VSS sky130_fd_pr__nfet_g5v0d10v5 w=1 l=0.5
XRz_3_12 BLZ12 dz_3_12 sky130_fd_pr_reram__reram_cell area_ox=0.0676
XMn_3_12 dn_3_12 WL3 SL12 VSS sky130_fd_pr__nfet_g5v0d10v5 w=1 l=0.5
XRn_3_12 BLN12 dn_3_12 sky130_fd_pr_reram__reram_cell area_ox=0.0676
XMp_3_13 dp_3_13 WL3 SL13 VSS sky130_fd_pr__nfet_g5v0d10v5 w=1 l=0.5
XRp_3_13 BLP13 dp_3_13 sky130_fd_pr_reram__reram_cell area_ox=0.0676
XMz_3_13 dz_3_13 WL3 SL13 VSS sky130_fd_pr__nfet_g5v0d10v5 w=1 l=0.5
XRz_3_13 BLZ13 dz_3_13 sky130_fd_pr_reram__reram_cell area_ox=0.0676
XMn_3_13 dn_3_13 WL3 SL13 VSS sky130_fd_pr__nfet_g5v0d10v5 w=1 l=0.5
XRn_3_13 BLN13 dn_3_13 sky130_fd_pr_reram__reram_cell area_ox=0.0676
XMp_3_14 dp_3_14 WL3 SL14 VSS sky130_fd_pr__nfet_g5v0d10v5 w=1 l=0.5
XRp_3_14 BLP14 dp_3_14 sky130_fd_pr_reram__reram_cell area_ox=0.0676
XMz_3_14 dz_3_14 WL3 SL14 VSS sky130_fd_pr__nfet_g5v0d10v5 w=1 l=0.5
XRz_3_14 BLZ14 dz_3_14 sky130_fd_pr_reram__reram_cell area_ox=0.0676
XMn_3_14 dn_3_14 WL3 SL14 VSS sky130_fd_pr__nfet_g5v0d10v5 w=1 l=0.5
XRn_3_14 BLN14 dn_3_14 sky130_fd_pr_reram__reram_cell area_ox=0.0676
XMp_3_15 dp_3_15 WL3 SL15 VSS sky130_fd_pr__nfet_g5v0d10v5 w=1 l=0.5
XRp_3_15 BLP15 dp_3_15 sky130_fd_pr_reram__reram_cell area_ox=0.0676
XMz_3_15 dz_3_15 WL3 SL15 VSS sky130_fd_pr__nfet_g5v0d10v5 w=1 l=0.5
XRz_3_15 BLZ15 dz_3_15 sky130_fd_pr_reram__reram_cell area_ox=0.0676
XMn_3_15 dn_3_15 WL3 SL15 VSS sky130_fd_pr__nfet_g5v0d10v5 w=1 l=0.5
XRn_3_15 BLN15 dn_3_15 sky130_fd_pr_reram__reram_cell area_ox=0.0676
XMp_3_16 dp_3_16 WL3 SL16 VSS sky130_fd_pr__nfet_g5v0d10v5 w=1 l=0.5
XRp_3_16 BLP16 dp_3_16 sky130_fd_pr_reram__reram_cell area_ox=0.0676
XMz_3_16 dz_3_16 WL3 SL16 VSS sky130_fd_pr__nfet_g5v0d10v5 w=1 l=0.5
XRz_3_16 BLZ16 dz_3_16 sky130_fd_pr_reram__reram_cell area_ox=0.0676
XMn_3_16 dn_3_16 WL3 SL16 VSS sky130_fd_pr__nfet_g5v0d10v5 w=1 l=0.5
XRn_3_16 BLN16 dn_3_16 sky130_fd_pr_reram__reram_cell area_ox=0.0676
XMp_3_17 dp_3_17 WL3 SL17 VSS sky130_fd_pr__nfet_g5v0d10v5 w=1 l=0.5
XRp_3_17 BLP17 dp_3_17 sky130_fd_pr_reram__reram_cell area_ox=0.0676
XMz_3_17 dz_3_17 WL3 SL17 VSS sky130_fd_pr__nfet_g5v0d10v5 w=1 l=0.5
XRz_3_17 BLZ17 dz_3_17 sky130_fd_pr_reram__reram_cell area_ox=0.0676
XMn_3_17 dn_3_17 WL3 SL17 VSS sky130_fd_pr__nfet_g5v0d10v5 w=1 l=0.5
XRn_3_17 BLN17 dn_3_17 sky130_fd_pr_reram__reram_cell area_ox=0.0676
XMp_3_18 dp_3_18 WL3 SL18 VSS sky130_fd_pr__nfet_g5v0d10v5 w=1 l=0.5
XRp_3_18 BLP18 dp_3_18 sky130_fd_pr_reram__reram_cell area_ox=0.0676
XMz_3_18 dz_3_18 WL3 SL18 VSS sky130_fd_pr__nfet_g5v0d10v5 w=1 l=0.5
XRz_3_18 BLZ18 dz_3_18 sky130_fd_pr_reram__reram_cell area_ox=0.0676
XMn_3_18 dn_3_18 WL3 SL18 VSS sky130_fd_pr__nfet_g5v0d10v5 w=1 l=0.5
XRn_3_18 BLN18 dn_3_18 sky130_fd_pr_reram__reram_cell area_ox=0.0676
XMp_3_19 dp_3_19 WL3 SL19 VSS sky130_fd_pr__nfet_g5v0d10v5 w=1 l=0.5
XRp_3_19 BLP19 dp_3_19 sky130_fd_pr_reram__reram_cell area_ox=0.0676
XMz_3_19 dz_3_19 WL3 SL19 VSS sky130_fd_pr__nfet_g5v0d10v5 w=1 l=0.5
XRz_3_19 BLZ19 dz_3_19 sky130_fd_pr_reram__reram_cell area_ox=0.0676
XMn_3_19 dn_3_19 WL3 SL19 VSS sky130_fd_pr__nfet_g5v0d10v5 w=1 l=0.5
XRn_3_19 BLN19 dn_3_19 sky130_fd_pr_reram__reram_cell area_ox=0.0676
XMp_3_20 dp_3_20 WL3 SL20 VSS sky130_fd_pr__nfet_g5v0d10v5 w=1 l=0.5
XRp_3_20 BLP20 dp_3_20 sky130_fd_pr_reram__reram_cell area_ox=0.0676
XMz_3_20 dz_3_20 WL3 SL20 VSS sky130_fd_pr__nfet_g5v0d10v5 w=1 l=0.5
XRz_3_20 BLZ20 dz_3_20 sky130_fd_pr_reram__reram_cell area_ox=0.0676
XMn_3_20 dn_3_20 WL3 SL20 VSS sky130_fd_pr__nfet_g5v0d10v5 w=1 l=0.5
XRn_3_20 BLN20 dn_3_20 sky130_fd_pr_reram__reram_cell area_ox=0.0676
XMp_3_21 dp_3_21 WL3 SL21 VSS sky130_fd_pr__nfet_g5v0d10v5 w=1 l=0.5
XRp_3_21 BLP21 dp_3_21 sky130_fd_pr_reram__reram_cell area_ox=0.0676
XMz_3_21 dz_3_21 WL3 SL21 VSS sky130_fd_pr__nfet_g5v0d10v5 w=1 l=0.5
XRz_3_21 BLZ21 dz_3_21 sky130_fd_pr_reram__reram_cell area_ox=0.0676
XMn_3_21 dn_3_21 WL3 SL21 VSS sky130_fd_pr__nfet_g5v0d10v5 w=1 l=0.5
XRn_3_21 BLN21 dn_3_21 sky130_fd_pr_reram__reram_cell area_ox=0.0676
XMp_3_22 dp_3_22 WL3 SL22 VSS sky130_fd_pr__nfet_g5v0d10v5 w=1 l=0.5
XRp_3_22 BLP22 dp_3_22 sky130_fd_pr_reram__reram_cell area_ox=0.0676
XMz_3_22 dz_3_22 WL3 SL22 VSS sky130_fd_pr__nfet_g5v0d10v5 w=1 l=0.5
XRz_3_22 BLZ22 dz_3_22 sky130_fd_pr_reram__reram_cell area_ox=0.0676
XMn_3_22 dn_3_22 WL3 SL22 VSS sky130_fd_pr__nfet_g5v0d10v5 w=1 l=0.5
XRn_3_22 BLN22 dn_3_22 sky130_fd_pr_reram__reram_cell area_ox=0.0676
XMp_3_23 dp_3_23 WL3 SL23 VSS sky130_fd_pr__nfet_g5v0d10v5 w=1 l=0.5
XRp_3_23 BLP23 dp_3_23 sky130_fd_pr_reram__reram_cell area_ox=0.0676
XMz_3_23 dz_3_23 WL3 SL23 VSS sky130_fd_pr__nfet_g5v0d10v5 w=1 l=0.5
XRz_3_23 BLZ23 dz_3_23 sky130_fd_pr_reram__reram_cell area_ox=0.0676
XMn_3_23 dn_3_23 WL3 SL23 VSS sky130_fd_pr__nfet_g5v0d10v5 w=1 l=0.5
XRn_3_23 BLN23 dn_3_23 sky130_fd_pr_reram__reram_cell area_ox=0.0676
XMp_4_0 dp_4_0 WL4 SL0 VSS sky130_fd_pr__nfet_g5v0d10v5 w=1 l=0.5
XRp_4_0 BLP0 dp_4_0 sky130_fd_pr_reram__reram_cell area_ox=0.0676
XMz_4_0 dz_4_0 WL4 SL0 VSS sky130_fd_pr__nfet_g5v0d10v5 w=1 l=0.5
XRz_4_0 BLZ0 dz_4_0 sky130_fd_pr_reram__reram_cell area_ox=0.0676
XMn_4_0 dn_4_0 WL4 SL0 VSS sky130_fd_pr__nfet_g5v0d10v5 w=1 l=0.5
XRn_4_0 BLN0 dn_4_0 sky130_fd_pr_reram__reram_cell area_ox=0.0676
XMp_4_1 dp_4_1 WL4 SL1 VSS sky130_fd_pr__nfet_g5v0d10v5 w=1 l=0.5
XRp_4_1 BLP1 dp_4_1 sky130_fd_pr_reram__reram_cell area_ox=0.0676
XMz_4_1 dz_4_1 WL4 SL1 VSS sky130_fd_pr__nfet_g5v0d10v5 w=1 l=0.5
XRz_4_1 BLZ1 dz_4_1 sky130_fd_pr_reram__reram_cell area_ox=0.0676
XMn_4_1 dn_4_1 WL4 SL1 VSS sky130_fd_pr__nfet_g5v0d10v5 w=1 l=0.5
XRn_4_1 BLN1 dn_4_1 sky130_fd_pr_reram__reram_cell area_ox=0.0676
XMp_4_2 dp_4_2 WL4 SL2 VSS sky130_fd_pr__nfet_g5v0d10v5 w=1 l=0.5
XRp_4_2 BLP2 dp_4_2 sky130_fd_pr_reram__reram_cell area_ox=0.0676
XMz_4_2 dz_4_2 WL4 SL2 VSS sky130_fd_pr__nfet_g5v0d10v5 w=1 l=0.5
XRz_4_2 BLZ2 dz_4_2 sky130_fd_pr_reram__reram_cell area_ox=0.0676
XMn_4_2 dn_4_2 WL4 SL2 VSS sky130_fd_pr__nfet_g5v0d10v5 w=1 l=0.5
XRn_4_2 BLN2 dn_4_2 sky130_fd_pr_reram__reram_cell area_ox=0.0676
XMp_4_3 dp_4_3 WL4 SL3 VSS sky130_fd_pr__nfet_g5v0d10v5 w=1 l=0.5
XRp_4_3 BLP3 dp_4_3 sky130_fd_pr_reram__reram_cell area_ox=0.0676
XMz_4_3 dz_4_3 WL4 SL3 VSS sky130_fd_pr__nfet_g5v0d10v5 w=1 l=0.5
XRz_4_3 BLZ3 dz_4_3 sky130_fd_pr_reram__reram_cell area_ox=0.0676
XMn_4_3 dn_4_3 WL4 SL3 VSS sky130_fd_pr__nfet_g5v0d10v5 w=1 l=0.5
XRn_4_3 BLN3 dn_4_3 sky130_fd_pr_reram__reram_cell area_ox=0.0676
XMp_4_4 dp_4_4 WL4 SL4 VSS sky130_fd_pr__nfet_g5v0d10v5 w=1 l=0.5
XRp_4_4 BLP4 dp_4_4 sky130_fd_pr_reram__reram_cell area_ox=0.0676
XMz_4_4 dz_4_4 WL4 SL4 VSS sky130_fd_pr__nfet_g5v0d10v5 w=1 l=0.5
XRz_4_4 BLZ4 dz_4_4 sky130_fd_pr_reram__reram_cell area_ox=0.0676
XMn_4_4 dn_4_4 WL4 SL4 VSS sky130_fd_pr__nfet_g5v0d10v5 w=1 l=0.5
XRn_4_4 BLN4 dn_4_4 sky130_fd_pr_reram__reram_cell area_ox=0.0676
XMp_4_5 dp_4_5 WL4 SL5 VSS sky130_fd_pr__nfet_g5v0d10v5 w=1 l=0.5
XRp_4_5 BLP5 dp_4_5 sky130_fd_pr_reram__reram_cell area_ox=0.0676
XMz_4_5 dz_4_5 WL4 SL5 VSS sky130_fd_pr__nfet_g5v0d10v5 w=1 l=0.5
XRz_4_5 BLZ5 dz_4_5 sky130_fd_pr_reram__reram_cell area_ox=0.0676
XMn_4_5 dn_4_5 WL4 SL5 VSS sky130_fd_pr__nfet_g5v0d10v5 w=1 l=0.5
XRn_4_5 BLN5 dn_4_5 sky130_fd_pr_reram__reram_cell area_ox=0.0676
XMp_4_6 dp_4_6 WL4 SL6 VSS sky130_fd_pr__nfet_g5v0d10v5 w=1 l=0.5
XRp_4_6 BLP6 dp_4_6 sky130_fd_pr_reram__reram_cell area_ox=0.0676
XMz_4_6 dz_4_6 WL4 SL6 VSS sky130_fd_pr__nfet_g5v0d10v5 w=1 l=0.5
XRz_4_6 BLZ6 dz_4_6 sky130_fd_pr_reram__reram_cell area_ox=0.0676
XMn_4_6 dn_4_6 WL4 SL6 VSS sky130_fd_pr__nfet_g5v0d10v5 w=1 l=0.5
XRn_4_6 BLN6 dn_4_6 sky130_fd_pr_reram__reram_cell area_ox=0.0676
XMp_4_7 dp_4_7 WL4 SL7 VSS sky130_fd_pr__nfet_g5v0d10v5 w=1 l=0.5
XRp_4_7 BLP7 dp_4_7 sky130_fd_pr_reram__reram_cell area_ox=0.0676
XMz_4_7 dz_4_7 WL4 SL7 VSS sky130_fd_pr__nfet_g5v0d10v5 w=1 l=0.5
XRz_4_7 BLZ7 dz_4_7 sky130_fd_pr_reram__reram_cell area_ox=0.0676
XMn_4_7 dn_4_7 WL4 SL7 VSS sky130_fd_pr__nfet_g5v0d10v5 w=1 l=0.5
XRn_4_7 BLN7 dn_4_7 sky130_fd_pr_reram__reram_cell area_ox=0.0676
XMp_4_8 dp_4_8 WL4 SL8 VSS sky130_fd_pr__nfet_g5v0d10v5 w=1 l=0.5
XRp_4_8 BLP8 dp_4_8 sky130_fd_pr_reram__reram_cell area_ox=0.0676
XMz_4_8 dz_4_8 WL4 SL8 VSS sky130_fd_pr__nfet_g5v0d10v5 w=1 l=0.5
XRz_4_8 BLZ8 dz_4_8 sky130_fd_pr_reram__reram_cell area_ox=0.0676
XMn_4_8 dn_4_8 WL4 SL8 VSS sky130_fd_pr__nfet_g5v0d10v5 w=1 l=0.5
XRn_4_8 BLN8 dn_4_8 sky130_fd_pr_reram__reram_cell area_ox=0.0676
XMp_4_9 dp_4_9 WL4 SL9 VSS sky130_fd_pr__nfet_g5v0d10v5 w=1 l=0.5
XRp_4_9 BLP9 dp_4_9 sky130_fd_pr_reram__reram_cell area_ox=0.0676
XMz_4_9 dz_4_9 WL4 SL9 VSS sky130_fd_pr__nfet_g5v0d10v5 w=1 l=0.5
XRz_4_9 BLZ9 dz_4_9 sky130_fd_pr_reram__reram_cell area_ox=0.0676
XMn_4_9 dn_4_9 WL4 SL9 VSS sky130_fd_pr__nfet_g5v0d10v5 w=1 l=0.5
XRn_4_9 BLN9 dn_4_9 sky130_fd_pr_reram__reram_cell area_ox=0.0676
XMp_4_10 dp_4_10 WL4 SL10 VSS sky130_fd_pr__nfet_g5v0d10v5 w=1 l=0.5
XRp_4_10 BLP10 dp_4_10 sky130_fd_pr_reram__reram_cell area_ox=0.0676
XMz_4_10 dz_4_10 WL4 SL10 VSS sky130_fd_pr__nfet_g5v0d10v5 w=1 l=0.5
XRz_4_10 BLZ10 dz_4_10 sky130_fd_pr_reram__reram_cell area_ox=0.0676
XMn_4_10 dn_4_10 WL4 SL10 VSS sky130_fd_pr__nfet_g5v0d10v5 w=1 l=0.5
XRn_4_10 BLN10 dn_4_10 sky130_fd_pr_reram__reram_cell area_ox=0.0676
XMp_4_11 dp_4_11 WL4 SL11 VSS sky130_fd_pr__nfet_g5v0d10v5 w=1 l=0.5
XRp_4_11 BLP11 dp_4_11 sky130_fd_pr_reram__reram_cell area_ox=0.0676
XMz_4_11 dz_4_11 WL4 SL11 VSS sky130_fd_pr__nfet_g5v0d10v5 w=1 l=0.5
XRz_4_11 BLZ11 dz_4_11 sky130_fd_pr_reram__reram_cell area_ox=0.0676
XMn_4_11 dn_4_11 WL4 SL11 VSS sky130_fd_pr__nfet_g5v0d10v5 w=1 l=0.5
XRn_4_11 BLN11 dn_4_11 sky130_fd_pr_reram__reram_cell area_ox=0.0676
XMp_4_12 dp_4_12 WL4 SL12 VSS sky130_fd_pr__nfet_g5v0d10v5 w=1 l=0.5
XRp_4_12 BLP12 dp_4_12 sky130_fd_pr_reram__reram_cell area_ox=0.0676
XMz_4_12 dz_4_12 WL4 SL12 VSS sky130_fd_pr__nfet_g5v0d10v5 w=1 l=0.5
XRz_4_12 BLZ12 dz_4_12 sky130_fd_pr_reram__reram_cell area_ox=0.0676
XMn_4_12 dn_4_12 WL4 SL12 VSS sky130_fd_pr__nfet_g5v0d10v5 w=1 l=0.5
XRn_4_12 BLN12 dn_4_12 sky130_fd_pr_reram__reram_cell area_ox=0.0676
XMp_4_13 dp_4_13 WL4 SL13 VSS sky130_fd_pr__nfet_g5v0d10v5 w=1 l=0.5
XRp_4_13 BLP13 dp_4_13 sky130_fd_pr_reram__reram_cell area_ox=0.0676
XMz_4_13 dz_4_13 WL4 SL13 VSS sky130_fd_pr__nfet_g5v0d10v5 w=1 l=0.5
XRz_4_13 BLZ13 dz_4_13 sky130_fd_pr_reram__reram_cell area_ox=0.0676
XMn_4_13 dn_4_13 WL4 SL13 VSS sky130_fd_pr__nfet_g5v0d10v5 w=1 l=0.5
XRn_4_13 BLN13 dn_4_13 sky130_fd_pr_reram__reram_cell area_ox=0.0676
XMp_4_14 dp_4_14 WL4 SL14 VSS sky130_fd_pr__nfet_g5v0d10v5 w=1 l=0.5
XRp_4_14 BLP14 dp_4_14 sky130_fd_pr_reram__reram_cell area_ox=0.0676
XMz_4_14 dz_4_14 WL4 SL14 VSS sky130_fd_pr__nfet_g5v0d10v5 w=1 l=0.5
XRz_4_14 BLZ14 dz_4_14 sky130_fd_pr_reram__reram_cell area_ox=0.0676
XMn_4_14 dn_4_14 WL4 SL14 VSS sky130_fd_pr__nfet_g5v0d10v5 w=1 l=0.5
XRn_4_14 BLN14 dn_4_14 sky130_fd_pr_reram__reram_cell area_ox=0.0676
XMp_4_15 dp_4_15 WL4 SL15 VSS sky130_fd_pr__nfet_g5v0d10v5 w=1 l=0.5
XRp_4_15 BLP15 dp_4_15 sky130_fd_pr_reram__reram_cell area_ox=0.0676
XMz_4_15 dz_4_15 WL4 SL15 VSS sky130_fd_pr__nfet_g5v0d10v5 w=1 l=0.5
XRz_4_15 BLZ15 dz_4_15 sky130_fd_pr_reram__reram_cell area_ox=0.0676
XMn_4_15 dn_4_15 WL4 SL15 VSS sky130_fd_pr__nfet_g5v0d10v5 w=1 l=0.5
XRn_4_15 BLN15 dn_4_15 sky130_fd_pr_reram__reram_cell area_ox=0.0676
XMp_4_16 dp_4_16 WL4 SL16 VSS sky130_fd_pr__nfet_g5v0d10v5 w=1 l=0.5
XRp_4_16 BLP16 dp_4_16 sky130_fd_pr_reram__reram_cell area_ox=0.0676
XMz_4_16 dz_4_16 WL4 SL16 VSS sky130_fd_pr__nfet_g5v0d10v5 w=1 l=0.5
XRz_4_16 BLZ16 dz_4_16 sky130_fd_pr_reram__reram_cell area_ox=0.0676
XMn_4_16 dn_4_16 WL4 SL16 VSS sky130_fd_pr__nfet_g5v0d10v5 w=1 l=0.5
XRn_4_16 BLN16 dn_4_16 sky130_fd_pr_reram__reram_cell area_ox=0.0676
XMp_4_17 dp_4_17 WL4 SL17 VSS sky130_fd_pr__nfet_g5v0d10v5 w=1 l=0.5
XRp_4_17 BLP17 dp_4_17 sky130_fd_pr_reram__reram_cell area_ox=0.0676
XMz_4_17 dz_4_17 WL4 SL17 VSS sky130_fd_pr__nfet_g5v0d10v5 w=1 l=0.5
XRz_4_17 BLZ17 dz_4_17 sky130_fd_pr_reram__reram_cell area_ox=0.0676
XMn_4_17 dn_4_17 WL4 SL17 VSS sky130_fd_pr__nfet_g5v0d10v5 w=1 l=0.5
XRn_4_17 BLN17 dn_4_17 sky130_fd_pr_reram__reram_cell area_ox=0.0676
XMp_4_18 dp_4_18 WL4 SL18 VSS sky130_fd_pr__nfet_g5v0d10v5 w=1 l=0.5
XRp_4_18 BLP18 dp_4_18 sky130_fd_pr_reram__reram_cell area_ox=0.0676
XMz_4_18 dz_4_18 WL4 SL18 VSS sky130_fd_pr__nfet_g5v0d10v5 w=1 l=0.5
XRz_4_18 BLZ18 dz_4_18 sky130_fd_pr_reram__reram_cell area_ox=0.0676
XMn_4_18 dn_4_18 WL4 SL18 VSS sky130_fd_pr__nfet_g5v0d10v5 w=1 l=0.5
XRn_4_18 BLN18 dn_4_18 sky130_fd_pr_reram__reram_cell area_ox=0.0676
XMp_4_19 dp_4_19 WL4 SL19 VSS sky130_fd_pr__nfet_g5v0d10v5 w=1 l=0.5
XRp_4_19 BLP19 dp_4_19 sky130_fd_pr_reram__reram_cell area_ox=0.0676
XMz_4_19 dz_4_19 WL4 SL19 VSS sky130_fd_pr__nfet_g5v0d10v5 w=1 l=0.5
XRz_4_19 BLZ19 dz_4_19 sky130_fd_pr_reram__reram_cell area_ox=0.0676
XMn_4_19 dn_4_19 WL4 SL19 VSS sky130_fd_pr__nfet_g5v0d10v5 w=1 l=0.5
XRn_4_19 BLN19 dn_4_19 sky130_fd_pr_reram__reram_cell area_ox=0.0676
XMp_4_20 dp_4_20 WL4 SL20 VSS sky130_fd_pr__nfet_g5v0d10v5 w=1 l=0.5
XRp_4_20 BLP20 dp_4_20 sky130_fd_pr_reram__reram_cell area_ox=0.0676
XMz_4_20 dz_4_20 WL4 SL20 VSS sky130_fd_pr__nfet_g5v0d10v5 w=1 l=0.5
XRz_4_20 BLZ20 dz_4_20 sky130_fd_pr_reram__reram_cell area_ox=0.0676
XMn_4_20 dn_4_20 WL4 SL20 VSS sky130_fd_pr__nfet_g5v0d10v5 w=1 l=0.5
XRn_4_20 BLN20 dn_4_20 sky130_fd_pr_reram__reram_cell area_ox=0.0676
XMp_4_21 dp_4_21 WL4 SL21 VSS sky130_fd_pr__nfet_g5v0d10v5 w=1 l=0.5
XRp_4_21 BLP21 dp_4_21 sky130_fd_pr_reram__reram_cell area_ox=0.0676
XMz_4_21 dz_4_21 WL4 SL21 VSS sky130_fd_pr__nfet_g5v0d10v5 w=1 l=0.5
XRz_4_21 BLZ21 dz_4_21 sky130_fd_pr_reram__reram_cell area_ox=0.0676
XMn_4_21 dn_4_21 WL4 SL21 VSS sky130_fd_pr__nfet_g5v0d10v5 w=1 l=0.5
XRn_4_21 BLN21 dn_4_21 sky130_fd_pr_reram__reram_cell area_ox=0.0676
XMp_4_22 dp_4_22 WL4 SL22 VSS sky130_fd_pr__nfet_g5v0d10v5 w=1 l=0.5
XRp_4_22 BLP22 dp_4_22 sky130_fd_pr_reram__reram_cell area_ox=0.0676
XMz_4_22 dz_4_22 WL4 SL22 VSS sky130_fd_pr__nfet_g5v0d10v5 w=1 l=0.5
XRz_4_22 BLZ22 dz_4_22 sky130_fd_pr_reram__reram_cell area_ox=0.0676
XMn_4_22 dn_4_22 WL4 SL22 VSS sky130_fd_pr__nfet_g5v0d10v5 w=1 l=0.5
XRn_4_22 BLN22 dn_4_22 sky130_fd_pr_reram__reram_cell area_ox=0.0676
XMp_4_23 dp_4_23 WL4 SL23 VSS sky130_fd_pr__nfet_g5v0d10v5 w=1 l=0.5
XRp_4_23 BLP23 dp_4_23 sky130_fd_pr_reram__reram_cell area_ox=0.0676
XMz_4_23 dz_4_23 WL4 SL23 VSS sky130_fd_pr__nfet_g5v0d10v5 w=1 l=0.5
XRz_4_23 BLZ23 dz_4_23 sky130_fd_pr_reram__reram_cell area_ox=0.0676
XMn_4_23 dn_4_23 WL4 SL23 VSS sky130_fd_pr__nfet_g5v0d10v5 w=1 l=0.5
XRn_4_23 BLN23 dn_4_23 sky130_fd_pr_reram__reram_cell area_ox=0.0676
XMp_5_0 dp_5_0 WL5 SL0 VSS sky130_fd_pr__nfet_g5v0d10v5 w=1 l=0.5
XRp_5_0 BLP0 dp_5_0 sky130_fd_pr_reram__reram_cell area_ox=0.0676
XMz_5_0 dz_5_0 WL5 SL0 VSS sky130_fd_pr__nfet_g5v0d10v5 w=1 l=0.5
XRz_5_0 BLZ0 dz_5_0 sky130_fd_pr_reram__reram_cell area_ox=0.0676
XMn_5_0 dn_5_0 WL5 SL0 VSS sky130_fd_pr__nfet_g5v0d10v5 w=1 l=0.5
XRn_5_0 BLN0 dn_5_0 sky130_fd_pr_reram__reram_cell area_ox=0.0676
XMp_5_1 dp_5_1 WL5 SL1 VSS sky130_fd_pr__nfet_g5v0d10v5 w=1 l=0.5
XRp_5_1 BLP1 dp_5_1 sky130_fd_pr_reram__reram_cell area_ox=0.0676
XMz_5_1 dz_5_1 WL5 SL1 VSS sky130_fd_pr__nfet_g5v0d10v5 w=1 l=0.5
XRz_5_1 BLZ1 dz_5_1 sky130_fd_pr_reram__reram_cell area_ox=0.0676
XMn_5_1 dn_5_1 WL5 SL1 VSS sky130_fd_pr__nfet_g5v0d10v5 w=1 l=0.5
XRn_5_1 BLN1 dn_5_1 sky130_fd_pr_reram__reram_cell area_ox=0.0676
XMp_5_2 dp_5_2 WL5 SL2 VSS sky130_fd_pr__nfet_g5v0d10v5 w=1 l=0.5
XRp_5_2 BLP2 dp_5_2 sky130_fd_pr_reram__reram_cell area_ox=0.0676
XMz_5_2 dz_5_2 WL5 SL2 VSS sky130_fd_pr__nfet_g5v0d10v5 w=1 l=0.5
XRz_5_2 BLZ2 dz_5_2 sky130_fd_pr_reram__reram_cell area_ox=0.0676
XMn_5_2 dn_5_2 WL5 SL2 VSS sky130_fd_pr__nfet_g5v0d10v5 w=1 l=0.5
XRn_5_2 BLN2 dn_5_2 sky130_fd_pr_reram__reram_cell area_ox=0.0676
XMp_5_3 dp_5_3 WL5 SL3 VSS sky130_fd_pr__nfet_g5v0d10v5 w=1 l=0.5
XRp_5_3 BLP3 dp_5_3 sky130_fd_pr_reram__reram_cell area_ox=0.0676
XMz_5_3 dz_5_3 WL5 SL3 VSS sky130_fd_pr__nfet_g5v0d10v5 w=1 l=0.5
XRz_5_3 BLZ3 dz_5_3 sky130_fd_pr_reram__reram_cell area_ox=0.0676
XMn_5_3 dn_5_3 WL5 SL3 VSS sky130_fd_pr__nfet_g5v0d10v5 w=1 l=0.5
XRn_5_3 BLN3 dn_5_3 sky130_fd_pr_reram__reram_cell area_ox=0.0676
XMp_5_4 dp_5_4 WL5 SL4 VSS sky130_fd_pr__nfet_g5v0d10v5 w=1 l=0.5
XRp_5_4 BLP4 dp_5_4 sky130_fd_pr_reram__reram_cell area_ox=0.0676
XMz_5_4 dz_5_4 WL5 SL4 VSS sky130_fd_pr__nfet_g5v0d10v5 w=1 l=0.5
XRz_5_4 BLZ4 dz_5_4 sky130_fd_pr_reram__reram_cell area_ox=0.0676
XMn_5_4 dn_5_4 WL5 SL4 VSS sky130_fd_pr__nfet_g5v0d10v5 w=1 l=0.5
XRn_5_4 BLN4 dn_5_4 sky130_fd_pr_reram__reram_cell area_ox=0.0676
XMp_5_5 dp_5_5 WL5 SL5 VSS sky130_fd_pr__nfet_g5v0d10v5 w=1 l=0.5
XRp_5_5 BLP5 dp_5_5 sky130_fd_pr_reram__reram_cell area_ox=0.0676
XMz_5_5 dz_5_5 WL5 SL5 VSS sky130_fd_pr__nfet_g5v0d10v5 w=1 l=0.5
XRz_5_5 BLZ5 dz_5_5 sky130_fd_pr_reram__reram_cell area_ox=0.0676
XMn_5_5 dn_5_5 WL5 SL5 VSS sky130_fd_pr__nfet_g5v0d10v5 w=1 l=0.5
XRn_5_5 BLN5 dn_5_5 sky130_fd_pr_reram__reram_cell area_ox=0.0676
XMp_5_6 dp_5_6 WL5 SL6 VSS sky130_fd_pr__nfet_g5v0d10v5 w=1 l=0.5
XRp_5_6 BLP6 dp_5_6 sky130_fd_pr_reram__reram_cell area_ox=0.0676
XMz_5_6 dz_5_6 WL5 SL6 VSS sky130_fd_pr__nfet_g5v0d10v5 w=1 l=0.5
XRz_5_6 BLZ6 dz_5_6 sky130_fd_pr_reram__reram_cell area_ox=0.0676
XMn_5_6 dn_5_6 WL5 SL6 VSS sky130_fd_pr__nfet_g5v0d10v5 w=1 l=0.5
XRn_5_6 BLN6 dn_5_6 sky130_fd_pr_reram__reram_cell area_ox=0.0676
XMp_5_7 dp_5_7 WL5 SL7 VSS sky130_fd_pr__nfet_g5v0d10v5 w=1 l=0.5
XRp_5_7 BLP7 dp_5_7 sky130_fd_pr_reram__reram_cell area_ox=0.0676
XMz_5_7 dz_5_7 WL5 SL7 VSS sky130_fd_pr__nfet_g5v0d10v5 w=1 l=0.5
XRz_5_7 BLZ7 dz_5_7 sky130_fd_pr_reram__reram_cell area_ox=0.0676
XMn_5_7 dn_5_7 WL5 SL7 VSS sky130_fd_pr__nfet_g5v0d10v5 w=1 l=0.5
XRn_5_7 BLN7 dn_5_7 sky130_fd_pr_reram__reram_cell area_ox=0.0676
XMp_5_8 dp_5_8 WL5 SL8 VSS sky130_fd_pr__nfet_g5v0d10v5 w=1 l=0.5
XRp_5_8 BLP8 dp_5_8 sky130_fd_pr_reram__reram_cell area_ox=0.0676
XMz_5_8 dz_5_8 WL5 SL8 VSS sky130_fd_pr__nfet_g5v0d10v5 w=1 l=0.5
XRz_5_8 BLZ8 dz_5_8 sky130_fd_pr_reram__reram_cell area_ox=0.0676
XMn_5_8 dn_5_8 WL5 SL8 VSS sky130_fd_pr__nfet_g5v0d10v5 w=1 l=0.5
XRn_5_8 BLN8 dn_5_8 sky130_fd_pr_reram__reram_cell area_ox=0.0676
XMp_5_9 dp_5_9 WL5 SL9 VSS sky130_fd_pr__nfet_g5v0d10v5 w=1 l=0.5
XRp_5_9 BLP9 dp_5_9 sky130_fd_pr_reram__reram_cell area_ox=0.0676
XMz_5_9 dz_5_9 WL5 SL9 VSS sky130_fd_pr__nfet_g5v0d10v5 w=1 l=0.5
XRz_5_9 BLZ9 dz_5_9 sky130_fd_pr_reram__reram_cell area_ox=0.0676
XMn_5_9 dn_5_9 WL5 SL9 VSS sky130_fd_pr__nfet_g5v0d10v5 w=1 l=0.5
XRn_5_9 BLN9 dn_5_9 sky130_fd_pr_reram__reram_cell area_ox=0.0676
XMp_5_10 dp_5_10 WL5 SL10 VSS sky130_fd_pr__nfet_g5v0d10v5 w=1 l=0.5
XRp_5_10 BLP10 dp_5_10 sky130_fd_pr_reram__reram_cell area_ox=0.0676
XMz_5_10 dz_5_10 WL5 SL10 VSS sky130_fd_pr__nfet_g5v0d10v5 w=1 l=0.5
XRz_5_10 BLZ10 dz_5_10 sky130_fd_pr_reram__reram_cell area_ox=0.0676
XMn_5_10 dn_5_10 WL5 SL10 VSS sky130_fd_pr__nfet_g5v0d10v5 w=1 l=0.5
XRn_5_10 BLN10 dn_5_10 sky130_fd_pr_reram__reram_cell area_ox=0.0676
XMp_5_11 dp_5_11 WL5 SL11 VSS sky130_fd_pr__nfet_g5v0d10v5 w=1 l=0.5
XRp_5_11 BLP11 dp_5_11 sky130_fd_pr_reram__reram_cell area_ox=0.0676
XMz_5_11 dz_5_11 WL5 SL11 VSS sky130_fd_pr__nfet_g5v0d10v5 w=1 l=0.5
XRz_5_11 BLZ11 dz_5_11 sky130_fd_pr_reram__reram_cell area_ox=0.0676
XMn_5_11 dn_5_11 WL5 SL11 VSS sky130_fd_pr__nfet_g5v0d10v5 w=1 l=0.5
XRn_5_11 BLN11 dn_5_11 sky130_fd_pr_reram__reram_cell area_ox=0.0676
XMp_5_12 dp_5_12 WL5 SL12 VSS sky130_fd_pr__nfet_g5v0d10v5 w=1 l=0.5
XRp_5_12 BLP12 dp_5_12 sky130_fd_pr_reram__reram_cell area_ox=0.0676
XMz_5_12 dz_5_12 WL5 SL12 VSS sky130_fd_pr__nfet_g5v0d10v5 w=1 l=0.5
XRz_5_12 BLZ12 dz_5_12 sky130_fd_pr_reram__reram_cell area_ox=0.0676
XMn_5_12 dn_5_12 WL5 SL12 VSS sky130_fd_pr__nfet_g5v0d10v5 w=1 l=0.5
XRn_5_12 BLN12 dn_5_12 sky130_fd_pr_reram__reram_cell area_ox=0.0676
XMp_5_13 dp_5_13 WL5 SL13 VSS sky130_fd_pr__nfet_g5v0d10v5 w=1 l=0.5
XRp_5_13 BLP13 dp_5_13 sky130_fd_pr_reram__reram_cell area_ox=0.0676
XMz_5_13 dz_5_13 WL5 SL13 VSS sky130_fd_pr__nfet_g5v0d10v5 w=1 l=0.5
XRz_5_13 BLZ13 dz_5_13 sky130_fd_pr_reram__reram_cell area_ox=0.0676
XMn_5_13 dn_5_13 WL5 SL13 VSS sky130_fd_pr__nfet_g5v0d10v5 w=1 l=0.5
XRn_5_13 BLN13 dn_5_13 sky130_fd_pr_reram__reram_cell area_ox=0.0676
XMp_5_14 dp_5_14 WL5 SL14 VSS sky130_fd_pr__nfet_g5v0d10v5 w=1 l=0.5
XRp_5_14 BLP14 dp_5_14 sky130_fd_pr_reram__reram_cell area_ox=0.0676
XMz_5_14 dz_5_14 WL5 SL14 VSS sky130_fd_pr__nfet_g5v0d10v5 w=1 l=0.5
XRz_5_14 BLZ14 dz_5_14 sky130_fd_pr_reram__reram_cell area_ox=0.0676
XMn_5_14 dn_5_14 WL5 SL14 VSS sky130_fd_pr__nfet_g5v0d10v5 w=1 l=0.5
XRn_5_14 BLN14 dn_5_14 sky130_fd_pr_reram__reram_cell area_ox=0.0676
XMp_5_15 dp_5_15 WL5 SL15 VSS sky130_fd_pr__nfet_g5v0d10v5 w=1 l=0.5
XRp_5_15 BLP15 dp_5_15 sky130_fd_pr_reram__reram_cell area_ox=0.0676
XMz_5_15 dz_5_15 WL5 SL15 VSS sky130_fd_pr__nfet_g5v0d10v5 w=1 l=0.5
XRz_5_15 BLZ15 dz_5_15 sky130_fd_pr_reram__reram_cell area_ox=0.0676
XMn_5_15 dn_5_15 WL5 SL15 VSS sky130_fd_pr__nfet_g5v0d10v5 w=1 l=0.5
XRn_5_15 BLN15 dn_5_15 sky130_fd_pr_reram__reram_cell area_ox=0.0676
XMp_5_16 dp_5_16 WL5 SL16 VSS sky130_fd_pr__nfet_g5v0d10v5 w=1 l=0.5
XRp_5_16 BLP16 dp_5_16 sky130_fd_pr_reram__reram_cell area_ox=0.0676
XMz_5_16 dz_5_16 WL5 SL16 VSS sky130_fd_pr__nfet_g5v0d10v5 w=1 l=0.5
XRz_5_16 BLZ16 dz_5_16 sky130_fd_pr_reram__reram_cell area_ox=0.0676
XMn_5_16 dn_5_16 WL5 SL16 VSS sky130_fd_pr__nfet_g5v0d10v5 w=1 l=0.5
XRn_5_16 BLN16 dn_5_16 sky130_fd_pr_reram__reram_cell area_ox=0.0676
XMp_5_17 dp_5_17 WL5 SL17 VSS sky130_fd_pr__nfet_g5v0d10v5 w=1 l=0.5
XRp_5_17 BLP17 dp_5_17 sky130_fd_pr_reram__reram_cell area_ox=0.0676
XMz_5_17 dz_5_17 WL5 SL17 VSS sky130_fd_pr__nfet_g5v0d10v5 w=1 l=0.5
XRz_5_17 BLZ17 dz_5_17 sky130_fd_pr_reram__reram_cell area_ox=0.0676
XMn_5_17 dn_5_17 WL5 SL17 VSS sky130_fd_pr__nfet_g5v0d10v5 w=1 l=0.5
XRn_5_17 BLN17 dn_5_17 sky130_fd_pr_reram__reram_cell area_ox=0.0676
XMp_5_18 dp_5_18 WL5 SL18 VSS sky130_fd_pr__nfet_g5v0d10v5 w=1 l=0.5
XRp_5_18 BLP18 dp_5_18 sky130_fd_pr_reram__reram_cell area_ox=0.0676
XMz_5_18 dz_5_18 WL5 SL18 VSS sky130_fd_pr__nfet_g5v0d10v5 w=1 l=0.5
XRz_5_18 BLZ18 dz_5_18 sky130_fd_pr_reram__reram_cell area_ox=0.0676
XMn_5_18 dn_5_18 WL5 SL18 VSS sky130_fd_pr__nfet_g5v0d10v5 w=1 l=0.5
XRn_5_18 BLN18 dn_5_18 sky130_fd_pr_reram__reram_cell area_ox=0.0676
XMp_5_19 dp_5_19 WL5 SL19 VSS sky130_fd_pr__nfet_g5v0d10v5 w=1 l=0.5
XRp_5_19 BLP19 dp_5_19 sky130_fd_pr_reram__reram_cell area_ox=0.0676
XMz_5_19 dz_5_19 WL5 SL19 VSS sky130_fd_pr__nfet_g5v0d10v5 w=1 l=0.5
XRz_5_19 BLZ19 dz_5_19 sky130_fd_pr_reram__reram_cell area_ox=0.0676
XMn_5_19 dn_5_19 WL5 SL19 VSS sky130_fd_pr__nfet_g5v0d10v5 w=1 l=0.5
XRn_5_19 BLN19 dn_5_19 sky130_fd_pr_reram__reram_cell area_ox=0.0676
XMp_5_20 dp_5_20 WL5 SL20 VSS sky130_fd_pr__nfet_g5v0d10v5 w=1 l=0.5
XRp_5_20 BLP20 dp_5_20 sky130_fd_pr_reram__reram_cell area_ox=0.0676
XMz_5_20 dz_5_20 WL5 SL20 VSS sky130_fd_pr__nfet_g5v0d10v5 w=1 l=0.5
XRz_5_20 BLZ20 dz_5_20 sky130_fd_pr_reram__reram_cell area_ox=0.0676
XMn_5_20 dn_5_20 WL5 SL20 VSS sky130_fd_pr__nfet_g5v0d10v5 w=1 l=0.5
XRn_5_20 BLN20 dn_5_20 sky130_fd_pr_reram__reram_cell area_ox=0.0676
XMp_5_21 dp_5_21 WL5 SL21 VSS sky130_fd_pr__nfet_g5v0d10v5 w=1 l=0.5
XRp_5_21 BLP21 dp_5_21 sky130_fd_pr_reram__reram_cell area_ox=0.0676
XMz_5_21 dz_5_21 WL5 SL21 VSS sky130_fd_pr__nfet_g5v0d10v5 w=1 l=0.5
XRz_5_21 BLZ21 dz_5_21 sky130_fd_pr_reram__reram_cell area_ox=0.0676
XMn_5_21 dn_5_21 WL5 SL21 VSS sky130_fd_pr__nfet_g5v0d10v5 w=1 l=0.5
XRn_5_21 BLN21 dn_5_21 sky130_fd_pr_reram__reram_cell area_ox=0.0676
XMp_5_22 dp_5_22 WL5 SL22 VSS sky130_fd_pr__nfet_g5v0d10v5 w=1 l=0.5
XRp_5_22 BLP22 dp_5_22 sky130_fd_pr_reram__reram_cell area_ox=0.0676
XMz_5_22 dz_5_22 WL5 SL22 VSS sky130_fd_pr__nfet_g5v0d10v5 w=1 l=0.5
XRz_5_22 BLZ22 dz_5_22 sky130_fd_pr_reram__reram_cell area_ox=0.0676
XMn_5_22 dn_5_22 WL5 SL22 VSS sky130_fd_pr__nfet_g5v0d10v5 w=1 l=0.5
XRn_5_22 BLN22 dn_5_22 sky130_fd_pr_reram__reram_cell area_ox=0.0676
XMp_5_23 dp_5_23 WL5 SL23 VSS sky130_fd_pr__nfet_g5v0d10v5 w=1 l=0.5
XRp_5_23 BLP23 dp_5_23 sky130_fd_pr_reram__reram_cell area_ox=0.0676
XMz_5_23 dz_5_23 WL5 SL23 VSS sky130_fd_pr__nfet_g5v0d10v5 w=1 l=0.5
XRz_5_23 BLZ23 dz_5_23 sky130_fd_pr_reram__reram_cell area_ox=0.0676
XMn_5_23 dn_5_23 WL5 SL23 VSS sky130_fd_pr__nfet_g5v0d10v5 w=1 l=0.5
XRn_5_23 BLN23 dn_5_23 sky130_fd_pr_reram__reram_cell area_ox=0.0676
XMp_6_0 dp_6_0 WL6 SL0 VSS sky130_fd_pr__nfet_g5v0d10v5 w=1 l=0.5
XRp_6_0 BLP0 dp_6_0 sky130_fd_pr_reram__reram_cell area_ox=0.0676
XMz_6_0 dz_6_0 WL6 SL0 VSS sky130_fd_pr__nfet_g5v0d10v5 w=1 l=0.5
XRz_6_0 BLZ0 dz_6_0 sky130_fd_pr_reram__reram_cell area_ox=0.0676
XMn_6_0 dn_6_0 WL6 SL0 VSS sky130_fd_pr__nfet_g5v0d10v5 w=1 l=0.5
XRn_6_0 BLN0 dn_6_0 sky130_fd_pr_reram__reram_cell area_ox=0.0676
XMp_6_1 dp_6_1 WL6 SL1 VSS sky130_fd_pr__nfet_g5v0d10v5 w=1 l=0.5
XRp_6_1 BLP1 dp_6_1 sky130_fd_pr_reram__reram_cell area_ox=0.0676
XMz_6_1 dz_6_1 WL6 SL1 VSS sky130_fd_pr__nfet_g5v0d10v5 w=1 l=0.5
XRz_6_1 BLZ1 dz_6_1 sky130_fd_pr_reram__reram_cell area_ox=0.0676
XMn_6_1 dn_6_1 WL6 SL1 VSS sky130_fd_pr__nfet_g5v0d10v5 w=1 l=0.5
XRn_6_1 BLN1 dn_6_1 sky130_fd_pr_reram__reram_cell area_ox=0.0676
XMp_6_2 dp_6_2 WL6 SL2 VSS sky130_fd_pr__nfet_g5v0d10v5 w=1 l=0.5
XRp_6_2 BLP2 dp_6_2 sky130_fd_pr_reram__reram_cell area_ox=0.0676
XMz_6_2 dz_6_2 WL6 SL2 VSS sky130_fd_pr__nfet_g5v0d10v5 w=1 l=0.5
XRz_6_2 BLZ2 dz_6_2 sky130_fd_pr_reram__reram_cell area_ox=0.0676
XMn_6_2 dn_6_2 WL6 SL2 VSS sky130_fd_pr__nfet_g5v0d10v5 w=1 l=0.5
XRn_6_2 BLN2 dn_6_2 sky130_fd_pr_reram__reram_cell area_ox=0.0676
XMp_6_3 dp_6_3 WL6 SL3 VSS sky130_fd_pr__nfet_g5v0d10v5 w=1 l=0.5
XRp_6_3 BLP3 dp_6_3 sky130_fd_pr_reram__reram_cell area_ox=0.0676
XMz_6_3 dz_6_3 WL6 SL3 VSS sky130_fd_pr__nfet_g5v0d10v5 w=1 l=0.5
XRz_6_3 BLZ3 dz_6_3 sky130_fd_pr_reram__reram_cell area_ox=0.0676
XMn_6_3 dn_6_3 WL6 SL3 VSS sky130_fd_pr__nfet_g5v0d10v5 w=1 l=0.5
XRn_6_3 BLN3 dn_6_3 sky130_fd_pr_reram__reram_cell area_ox=0.0676
XMp_6_4 dp_6_4 WL6 SL4 VSS sky130_fd_pr__nfet_g5v0d10v5 w=1 l=0.5
XRp_6_4 BLP4 dp_6_4 sky130_fd_pr_reram__reram_cell area_ox=0.0676
XMz_6_4 dz_6_4 WL6 SL4 VSS sky130_fd_pr__nfet_g5v0d10v5 w=1 l=0.5
XRz_6_4 BLZ4 dz_6_4 sky130_fd_pr_reram__reram_cell area_ox=0.0676
XMn_6_4 dn_6_4 WL6 SL4 VSS sky130_fd_pr__nfet_g5v0d10v5 w=1 l=0.5
XRn_6_4 BLN4 dn_6_4 sky130_fd_pr_reram__reram_cell area_ox=0.0676
XMp_6_5 dp_6_5 WL6 SL5 VSS sky130_fd_pr__nfet_g5v0d10v5 w=1 l=0.5
XRp_6_5 BLP5 dp_6_5 sky130_fd_pr_reram__reram_cell area_ox=0.0676
XMz_6_5 dz_6_5 WL6 SL5 VSS sky130_fd_pr__nfet_g5v0d10v5 w=1 l=0.5
XRz_6_5 BLZ5 dz_6_5 sky130_fd_pr_reram__reram_cell area_ox=0.0676
XMn_6_5 dn_6_5 WL6 SL5 VSS sky130_fd_pr__nfet_g5v0d10v5 w=1 l=0.5
XRn_6_5 BLN5 dn_6_5 sky130_fd_pr_reram__reram_cell area_ox=0.0676
XMp_6_6 dp_6_6 WL6 SL6 VSS sky130_fd_pr__nfet_g5v0d10v5 w=1 l=0.5
XRp_6_6 BLP6 dp_6_6 sky130_fd_pr_reram__reram_cell area_ox=0.0676
XMz_6_6 dz_6_6 WL6 SL6 VSS sky130_fd_pr__nfet_g5v0d10v5 w=1 l=0.5
XRz_6_6 BLZ6 dz_6_6 sky130_fd_pr_reram__reram_cell area_ox=0.0676
XMn_6_6 dn_6_6 WL6 SL6 VSS sky130_fd_pr__nfet_g5v0d10v5 w=1 l=0.5
XRn_6_6 BLN6 dn_6_6 sky130_fd_pr_reram__reram_cell area_ox=0.0676
XMp_6_7 dp_6_7 WL6 SL7 VSS sky130_fd_pr__nfet_g5v0d10v5 w=1 l=0.5
XRp_6_7 BLP7 dp_6_7 sky130_fd_pr_reram__reram_cell area_ox=0.0676
XMz_6_7 dz_6_7 WL6 SL7 VSS sky130_fd_pr__nfet_g5v0d10v5 w=1 l=0.5
XRz_6_7 BLZ7 dz_6_7 sky130_fd_pr_reram__reram_cell area_ox=0.0676
XMn_6_7 dn_6_7 WL6 SL7 VSS sky130_fd_pr__nfet_g5v0d10v5 w=1 l=0.5
XRn_6_7 BLN7 dn_6_7 sky130_fd_pr_reram__reram_cell area_ox=0.0676
XMp_6_8 dp_6_8 WL6 SL8 VSS sky130_fd_pr__nfet_g5v0d10v5 w=1 l=0.5
XRp_6_8 BLP8 dp_6_8 sky130_fd_pr_reram__reram_cell area_ox=0.0676
XMz_6_8 dz_6_8 WL6 SL8 VSS sky130_fd_pr__nfet_g5v0d10v5 w=1 l=0.5
XRz_6_8 BLZ8 dz_6_8 sky130_fd_pr_reram__reram_cell area_ox=0.0676
XMn_6_8 dn_6_8 WL6 SL8 VSS sky130_fd_pr__nfet_g5v0d10v5 w=1 l=0.5
XRn_6_8 BLN8 dn_6_8 sky130_fd_pr_reram__reram_cell area_ox=0.0676
XMp_6_9 dp_6_9 WL6 SL9 VSS sky130_fd_pr__nfet_g5v0d10v5 w=1 l=0.5
XRp_6_9 BLP9 dp_6_9 sky130_fd_pr_reram__reram_cell area_ox=0.0676
XMz_6_9 dz_6_9 WL6 SL9 VSS sky130_fd_pr__nfet_g5v0d10v5 w=1 l=0.5
XRz_6_9 BLZ9 dz_6_9 sky130_fd_pr_reram__reram_cell area_ox=0.0676
XMn_6_9 dn_6_9 WL6 SL9 VSS sky130_fd_pr__nfet_g5v0d10v5 w=1 l=0.5
XRn_6_9 BLN9 dn_6_9 sky130_fd_pr_reram__reram_cell area_ox=0.0676
XMp_6_10 dp_6_10 WL6 SL10 VSS sky130_fd_pr__nfet_g5v0d10v5 w=1 l=0.5
XRp_6_10 BLP10 dp_6_10 sky130_fd_pr_reram__reram_cell area_ox=0.0676
XMz_6_10 dz_6_10 WL6 SL10 VSS sky130_fd_pr__nfet_g5v0d10v5 w=1 l=0.5
XRz_6_10 BLZ10 dz_6_10 sky130_fd_pr_reram__reram_cell area_ox=0.0676
XMn_6_10 dn_6_10 WL6 SL10 VSS sky130_fd_pr__nfet_g5v0d10v5 w=1 l=0.5
XRn_6_10 BLN10 dn_6_10 sky130_fd_pr_reram__reram_cell area_ox=0.0676
XMp_6_11 dp_6_11 WL6 SL11 VSS sky130_fd_pr__nfet_g5v0d10v5 w=1 l=0.5
XRp_6_11 BLP11 dp_6_11 sky130_fd_pr_reram__reram_cell area_ox=0.0676
XMz_6_11 dz_6_11 WL6 SL11 VSS sky130_fd_pr__nfet_g5v0d10v5 w=1 l=0.5
XRz_6_11 BLZ11 dz_6_11 sky130_fd_pr_reram__reram_cell area_ox=0.0676
XMn_6_11 dn_6_11 WL6 SL11 VSS sky130_fd_pr__nfet_g5v0d10v5 w=1 l=0.5
XRn_6_11 BLN11 dn_6_11 sky130_fd_pr_reram__reram_cell area_ox=0.0676
XMp_6_12 dp_6_12 WL6 SL12 VSS sky130_fd_pr__nfet_g5v0d10v5 w=1 l=0.5
XRp_6_12 BLP12 dp_6_12 sky130_fd_pr_reram__reram_cell area_ox=0.0676
XMz_6_12 dz_6_12 WL6 SL12 VSS sky130_fd_pr__nfet_g5v0d10v5 w=1 l=0.5
XRz_6_12 BLZ12 dz_6_12 sky130_fd_pr_reram__reram_cell area_ox=0.0676
XMn_6_12 dn_6_12 WL6 SL12 VSS sky130_fd_pr__nfet_g5v0d10v5 w=1 l=0.5
XRn_6_12 BLN12 dn_6_12 sky130_fd_pr_reram__reram_cell area_ox=0.0676
XMp_6_13 dp_6_13 WL6 SL13 VSS sky130_fd_pr__nfet_g5v0d10v5 w=1 l=0.5
XRp_6_13 BLP13 dp_6_13 sky130_fd_pr_reram__reram_cell area_ox=0.0676
XMz_6_13 dz_6_13 WL6 SL13 VSS sky130_fd_pr__nfet_g5v0d10v5 w=1 l=0.5
XRz_6_13 BLZ13 dz_6_13 sky130_fd_pr_reram__reram_cell area_ox=0.0676
XMn_6_13 dn_6_13 WL6 SL13 VSS sky130_fd_pr__nfet_g5v0d10v5 w=1 l=0.5
XRn_6_13 BLN13 dn_6_13 sky130_fd_pr_reram__reram_cell area_ox=0.0676
XMp_6_14 dp_6_14 WL6 SL14 VSS sky130_fd_pr__nfet_g5v0d10v5 w=1 l=0.5
XRp_6_14 BLP14 dp_6_14 sky130_fd_pr_reram__reram_cell area_ox=0.0676
XMz_6_14 dz_6_14 WL6 SL14 VSS sky130_fd_pr__nfet_g5v0d10v5 w=1 l=0.5
XRz_6_14 BLZ14 dz_6_14 sky130_fd_pr_reram__reram_cell area_ox=0.0676
XMn_6_14 dn_6_14 WL6 SL14 VSS sky130_fd_pr__nfet_g5v0d10v5 w=1 l=0.5
XRn_6_14 BLN14 dn_6_14 sky130_fd_pr_reram__reram_cell area_ox=0.0676
XMp_6_15 dp_6_15 WL6 SL15 VSS sky130_fd_pr__nfet_g5v0d10v5 w=1 l=0.5
XRp_6_15 BLP15 dp_6_15 sky130_fd_pr_reram__reram_cell area_ox=0.0676
XMz_6_15 dz_6_15 WL6 SL15 VSS sky130_fd_pr__nfet_g5v0d10v5 w=1 l=0.5
XRz_6_15 BLZ15 dz_6_15 sky130_fd_pr_reram__reram_cell area_ox=0.0676
XMn_6_15 dn_6_15 WL6 SL15 VSS sky130_fd_pr__nfet_g5v0d10v5 w=1 l=0.5
XRn_6_15 BLN15 dn_6_15 sky130_fd_pr_reram__reram_cell area_ox=0.0676
XMp_6_16 dp_6_16 WL6 SL16 VSS sky130_fd_pr__nfet_g5v0d10v5 w=1 l=0.5
XRp_6_16 BLP16 dp_6_16 sky130_fd_pr_reram__reram_cell area_ox=0.0676
XMz_6_16 dz_6_16 WL6 SL16 VSS sky130_fd_pr__nfet_g5v0d10v5 w=1 l=0.5
XRz_6_16 BLZ16 dz_6_16 sky130_fd_pr_reram__reram_cell area_ox=0.0676
XMn_6_16 dn_6_16 WL6 SL16 VSS sky130_fd_pr__nfet_g5v0d10v5 w=1 l=0.5
XRn_6_16 BLN16 dn_6_16 sky130_fd_pr_reram__reram_cell area_ox=0.0676
XMp_6_17 dp_6_17 WL6 SL17 VSS sky130_fd_pr__nfet_g5v0d10v5 w=1 l=0.5
XRp_6_17 BLP17 dp_6_17 sky130_fd_pr_reram__reram_cell area_ox=0.0676
XMz_6_17 dz_6_17 WL6 SL17 VSS sky130_fd_pr__nfet_g5v0d10v5 w=1 l=0.5
XRz_6_17 BLZ17 dz_6_17 sky130_fd_pr_reram__reram_cell area_ox=0.0676
XMn_6_17 dn_6_17 WL6 SL17 VSS sky130_fd_pr__nfet_g5v0d10v5 w=1 l=0.5
XRn_6_17 BLN17 dn_6_17 sky130_fd_pr_reram__reram_cell area_ox=0.0676
XMp_6_18 dp_6_18 WL6 SL18 VSS sky130_fd_pr__nfet_g5v0d10v5 w=1 l=0.5
XRp_6_18 BLP18 dp_6_18 sky130_fd_pr_reram__reram_cell area_ox=0.0676
XMz_6_18 dz_6_18 WL6 SL18 VSS sky130_fd_pr__nfet_g5v0d10v5 w=1 l=0.5
XRz_6_18 BLZ18 dz_6_18 sky130_fd_pr_reram__reram_cell area_ox=0.0676
XMn_6_18 dn_6_18 WL6 SL18 VSS sky130_fd_pr__nfet_g5v0d10v5 w=1 l=0.5
XRn_6_18 BLN18 dn_6_18 sky130_fd_pr_reram__reram_cell area_ox=0.0676
XMp_6_19 dp_6_19 WL6 SL19 VSS sky130_fd_pr__nfet_g5v0d10v5 w=1 l=0.5
XRp_6_19 BLP19 dp_6_19 sky130_fd_pr_reram__reram_cell area_ox=0.0676
XMz_6_19 dz_6_19 WL6 SL19 VSS sky130_fd_pr__nfet_g5v0d10v5 w=1 l=0.5
XRz_6_19 BLZ19 dz_6_19 sky130_fd_pr_reram__reram_cell area_ox=0.0676
XMn_6_19 dn_6_19 WL6 SL19 VSS sky130_fd_pr__nfet_g5v0d10v5 w=1 l=0.5
XRn_6_19 BLN19 dn_6_19 sky130_fd_pr_reram__reram_cell area_ox=0.0676
XMp_6_20 dp_6_20 WL6 SL20 VSS sky130_fd_pr__nfet_g5v0d10v5 w=1 l=0.5
XRp_6_20 BLP20 dp_6_20 sky130_fd_pr_reram__reram_cell area_ox=0.0676
XMz_6_20 dz_6_20 WL6 SL20 VSS sky130_fd_pr__nfet_g5v0d10v5 w=1 l=0.5
XRz_6_20 BLZ20 dz_6_20 sky130_fd_pr_reram__reram_cell area_ox=0.0676
XMn_6_20 dn_6_20 WL6 SL20 VSS sky130_fd_pr__nfet_g5v0d10v5 w=1 l=0.5
XRn_6_20 BLN20 dn_6_20 sky130_fd_pr_reram__reram_cell area_ox=0.0676
XMp_6_21 dp_6_21 WL6 SL21 VSS sky130_fd_pr__nfet_g5v0d10v5 w=1 l=0.5
XRp_6_21 BLP21 dp_6_21 sky130_fd_pr_reram__reram_cell area_ox=0.0676
XMz_6_21 dz_6_21 WL6 SL21 VSS sky130_fd_pr__nfet_g5v0d10v5 w=1 l=0.5
XRz_6_21 BLZ21 dz_6_21 sky130_fd_pr_reram__reram_cell area_ox=0.0676
XMn_6_21 dn_6_21 WL6 SL21 VSS sky130_fd_pr__nfet_g5v0d10v5 w=1 l=0.5
XRn_6_21 BLN21 dn_6_21 sky130_fd_pr_reram__reram_cell area_ox=0.0676
XMp_6_22 dp_6_22 WL6 SL22 VSS sky130_fd_pr__nfet_g5v0d10v5 w=1 l=0.5
XRp_6_22 BLP22 dp_6_22 sky130_fd_pr_reram__reram_cell area_ox=0.0676
XMz_6_22 dz_6_22 WL6 SL22 VSS sky130_fd_pr__nfet_g5v0d10v5 w=1 l=0.5
XRz_6_22 BLZ22 dz_6_22 sky130_fd_pr_reram__reram_cell area_ox=0.0676
XMn_6_22 dn_6_22 WL6 SL22 VSS sky130_fd_pr__nfet_g5v0d10v5 w=1 l=0.5
XRn_6_22 BLN22 dn_6_22 sky130_fd_pr_reram__reram_cell area_ox=0.0676
XMp_6_23 dp_6_23 WL6 SL23 VSS sky130_fd_pr__nfet_g5v0d10v5 w=1 l=0.5
XRp_6_23 BLP23 dp_6_23 sky130_fd_pr_reram__reram_cell area_ox=0.0676
XMz_6_23 dz_6_23 WL6 SL23 VSS sky130_fd_pr__nfet_g5v0d10v5 w=1 l=0.5
XRz_6_23 BLZ23 dz_6_23 sky130_fd_pr_reram__reram_cell area_ox=0.0676
XMn_6_23 dn_6_23 WL6 SL23 VSS sky130_fd_pr__nfet_g5v0d10v5 w=1 l=0.5
XRn_6_23 BLN23 dn_6_23 sky130_fd_pr_reram__reram_cell area_ox=0.0676
XMp_7_0 dp_7_0 WL7 SL0 VSS sky130_fd_pr__nfet_g5v0d10v5 w=1 l=0.5
XRp_7_0 BLP0 dp_7_0 sky130_fd_pr_reram__reram_cell area_ox=0.0676
XMz_7_0 dz_7_0 WL7 SL0 VSS sky130_fd_pr__nfet_g5v0d10v5 w=1 l=0.5
XRz_7_0 BLZ0 dz_7_0 sky130_fd_pr_reram__reram_cell area_ox=0.0676
XMn_7_0 dn_7_0 WL7 SL0 VSS sky130_fd_pr__nfet_g5v0d10v5 w=1 l=0.5
XRn_7_0 BLN0 dn_7_0 sky130_fd_pr_reram__reram_cell area_ox=0.0676
XMp_7_1 dp_7_1 WL7 SL1 VSS sky130_fd_pr__nfet_g5v0d10v5 w=1 l=0.5
XRp_7_1 BLP1 dp_7_1 sky130_fd_pr_reram__reram_cell area_ox=0.0676
XMz_7_1 dz_7_1 WL7 SL1 VSS sky130_fd_pr__nfet_g5v0d10v5 w=1 l=0.5
XRz_7_1 BLZ1 dz_7_1 sky130_fd_pr_reram__reram_cell area_ox=0.0676
XMn_7_1 dn_7_1 WL7 SL1 VSS sky130_fd_pr__nfet_g5v0d10v5 w=1 l=0.5
XRn_7_1 BLN1 dn_7_1 sky130_fd_pr_reram__reram_cell area_ox=0.0676
XMp_7_2 dp_7_2 WL7 SL2 VSS sky130_fd_pr__nfet_g5v0d10v5 w=1 l=0.5
XRp_7_2 BLP2 dp_7_2 sky130_fd_pr_reram__reram_cell area_ox=0.0676
XMz_7_2 dz_7_2 WL7 SL2 VSS sky130_fd_pr__nfet_g5v0d10v5 w=1 l=0.5
XRz_7_2 BLZ2 dz_7_2 sky130_fd_pr_reram__reram_cell area_ox=0.0676
XMn_7_2 dn_7_2 WL7 SL2 VSS sky130_fd_pr__nfet_g5v0d10v5 w=1 l=0.5
XRn_7_2 BLN2 dn_7_2 sky130_fd_pr_reram__reram_cell area_ox=0.0676
XMp_7_3 dp_7_3 WL7 SL3 VSS sky130_fd_pr__nfet_g5v0d10v5 w=1 l=0.5
XRp_7_3 BLP3 dp_7_3 sky130_fd_pr_reram__reram_cell area_ox=0.0676
XMz_7_3 dz_7_3 WL7 SL3 VSS sky130_fd_pr__nfet_g5v0d10v5 w=1 l=0.5
XRz_7_3 BLZ3 dz_7_3 sky130_fd_pr_reram__reram_cell area_ox=0.0676
XMn_7_3 dn_7_3 WL7 SL3 VSS sky130_fd_pr__nfet_g5v0d10v5 w=1 l=0.5
XRn_7_3 BLN3 dn_7_3 sky130_fd_pr_reram__reram_cell area_ox=0.0676
XMp_7_4 dp_7_4 WL7 SL4 VSS sky130_fd_pr__nfet_g5v0d10v5 w=1 l=0.5
XRp_7_4 BLP4 dp_7_4 sky130_fd_pr_reram__reram_cell area_ox=0.0676
XMz_7_4 dz_7_4 WL7 SL4 VSS sky130_fd_pr__nfet_g5v0d10v5 w=1 l=0.5
XRz_7_4 BLZ4 dz_7_4 sky130_fd_pr_reram__reram_cell area_ox=0.0676
XMn_7_4 dn_7_4 WL7 SL4 VSS sky130_fd_pr__nfet_g5v0d10v5 w=1 l=0.5
XRn_7_4 BLN4 dn_7_4 sky130_fd_pr_reram__reram_cell area_ox=0.0676
XMp_7_5 dp_7_5 WL7 SL5 VSS sky130_fd_pr__nfet_g5v0d10v5 w=1 l=0.5
XRp_7_5 BLP5 dp_7_5 sky130_fd_pr_reram__reram_cell area_ox=0.0676
XMz_7_5 dz_7_5 WL7 SL5 VSS sky130_fd_pr__nfet_g5v0d10v5 w=1 l=0.5
XRz_7_5 BLZ5 dz_7_5 sky130_fd_pr_reram__reram_cell area_ox=0.0676
XMn_7_5 dn_7_5 WL7 SL5 VSS sky130_fd_pr__nfet_g5v0d10v5 w=1 l=0.5
XRn_7_5 BLN5 dn_7_5 sky130_fd_pr_reram__reram_cell area_ox=0.0676
XMp_7_6 dp_7_6 WL7 SL6 VSS sky130_fd_pr__nfet_g5v0d10v5 w=1 l=0.5
XRp_7_6 BLP6 dp_7_6 sky130_fd_pr_reram__reram_cell area_ox=0.0676
XMz_7_6 dz_7_6 WL7 SL6 VSS sky130_fd_pr__nfet_g5v0d10v5 w=1 l=0.5
XRz_7_6 BLZ6 dz_7_6 sky130_fd_pr_reram__reram_cell area_ox=0.0676
XMn_7_6 dn_7_6 WL7 SL6 VSS sky130_fd_pr__nfet_g5v0d10v5 w=1 l=0.5
XRn_7_6 BLN6 dn_7_6 sky130_fd_pr_reram__reram_cell area_ox=0.0676
XMp_7_7 dp_7_7 WL7 SL7 VSS sky130_fd_pr__nfet_g5v0d10v5 w=1 l=0.5
XRp_7_7 BLP7 dp_7_7 sky130_fd_pr_reram__reram_cell area_ox=0.0676
XMz_7_7 dz_7_7 WL7 SL7 VSS sky130_fd_pr__nfet_g5v0d10v5 w=1 l=0.5
XRz_7_7 BLZ7 dz_7_7 sky130_fd_pr_reram__reram_cell area_ox=0.0676
XMn_7_7 dn_7_7 WL7 SL7 VSS sky130_fd_pr__nfet_g5v0d10v5 w=1 l=0.5
XRn_7_7 BLN7 dn_7_7 sky130_fd_pr_reram__reram_cell area_ox=0.0676
XMp_7_8 dp_7_8 WL7 SL8 VSS sky130_fd_pr__nfet_g5v0d10v5 w=1 l=0.5
XRp_7_8 BLP8 dp_7_8 sky130_fd_pr_reram__reram_cell area_ox=0.0676
XMz_7_8 dz_7_8 WL7 SL8 VSS sky130_fd_pr__nfet_g5v0d10v5 w=1 l=0.5
XRz_7_8 BLZ8 dz_7_8 sky130_fd_pr_reram__reram_cell area_ox=0.0676
XMn_7_8 dn_7_8 WL7 SL8 VSS sky130_fd_pr__nfet_g5v0d10v5 w=1 l=0.5
XRn_7_8 BLN8 dn_7_8 sky130_fd_pr_reram__reram_cell area_ox=0.0676
XMp_7_9 dp_7_9 WL7 SL9 VSS sky130_fd_pr__nfet_g5v0d10v5 w=1 l=0.5
XRp_7_9 BLP9 dp_7_9 sky130_fd_pr_reram__reram_cell area_ox=0.0676
XMz_7_9 dz_7_9 WL7 SL9 VSS sky130_fd_pr__nfet_g5v0d10v5 w=1 l=0.5
XRz_7_9 BLZ9 dz_7_9 sky130_fd_pr_reram__reram_cell area_ox=0.0676
XMn_7_9 dn_7_9 WL7 SL9 VSS sky130_fd_pr__nfet_g5v0d10v5 w=1 l=0.5
XRn_7_9 BLN9 dn_7_9 sky130_fd_pr_reram__reram_cell area_ox=0.0676
XMp_7_10 dp_7_10 WL7 SL10 VSS sky130_fd_pr__nfet_g5v0d10v5 w=1 l=0.5
XRp_7_10 BLP10 dp_7_10 sky130_fd_pr_reram__reram_cell area_ox=0.0676
XMz_7_10 dz_7_10 WL7 SL10 VSS sky130_fd_pr__nfet_g5v0d10v5 w=1 l=0.5
XRz_7_10 BLZ10 dz_7_10 sky130_fd_pr_reram__reram_cell area_ox=0.0676
XMn_7_10 dn_7_10 WL7 SL10 VSS sky130_fd_pr__nfet_g5v0d10v5 w=1 l=0.5
XRn_7_10 BLN10 dn_7_10 sky130_fd_pr_reram__reram_cell area_ox=0.0676
XMp_7_11 dp_7_11 WL7 SL11 VSS sky130_fd_pr__nfet_g5v0d10v5 w=1 l=0.5
XRp_7_11 BLP11 dp_7_11 sky130_fd_pr_reram__reram_cell area_ox=0.0676
XMz_7_11 dz_7_11 WL7 SL11 VSS sky130_fd_pr__nfet_g5v0d10v5 w=1 l=0.5
XRz_7_11 BLZ11 dz_7_11 sky130_fd_pr_reram__reram_cell area_ox=0.0676
XMn_7_11 dn_7_11 WL7 SL11 VSS sky130_fd_pr__nfet_g5v0d10v5 w=1 l=0.5
XRn_7_11 BLN11 dn_7_11 sky130_fd_pr_reram__reram_cell area_ox=0.0676
XMp_7_12 dp_7_12 WL7 SL12 VSS sky130_fd_pr__nfet_g5v0d10v5 w=1 l=0.5
XRp_7_12 BLP12 dp_7_12 sky130_fd_pr_reram__reram_cell area_ox=0.0676
XMz_7_12 dz_7_12 WL7 SL12 VSS sky130_fd_pr__nfet_g5v0d10v5 w=1 l=0.5
XRz_7_12 BLZ12 dz_7_12 sky130_fd_pr_reram__reram_cell area_ox=0.0676
XMn_7_12 dn_7_12 WL7 SL12 VSS sky130_fd_pr__nfet_g5v0d10v5 w=1 l=0.5
XRn_7_12 BLN12 dn_7_12 sky130_fd_pr_reram__reram_cell area_ox=0.0676
XMp_7_13 dp_7_13 WL7 SL13 VSS sky130_fd_pr__nfet_g5v0d10v5 w=1 l=0.5
XRp_7_13 BLP13 dp_7_13 sky130_fd_pr_reram__reram_cell area_ox=0.0676
XMz_7_13 dz_7_13 WL7 SL13 VSS sky130_fd_pr__nfet_g5v0d10v5 w=1 l=0.5
XRz_7_13 BLZ13 dz_7_13 sky130_fd_pr_reram__reram_cell area_ox=0.0676
XMn_7_13 dn_7_13 WL7 SL13 VSS sky130_fd_pr__nfet_g5v0d10v5 w=1 l=0.5
XRn_7_13 BLN13 dn_7_13 sky130_fd_pr_reram__reram_cell area_ox=0.0676
XMp_7_14 dp_7_14 WL7 SL14 VSS sky130_fd_pr__nfet_g5v0d10v5 w=1 l=0.5
XRp_7_14 BLP14 dp_7_14 sky130_fd_pr_reram__reram_cell area_ox=0.0676
XMz_7_14 dz_7_14 WL7 SL14 VSS sky130_fd_pr__nfet_g5v0d10v5 w=1 l=0.5
XRz_7_14 BLZ14 dz_7_14 sky130_fd_pr_reram__reram_cell area_ox=0.0676
XMn_7_14 dn_7_14 WL7 SL14 VSS sky130_fd_pr__nfet_g5v0d10v5 w=1 l=0.5
XRn_7_14 BLN14 dn_7_14 sky130_fd_pr_reram__reram_cell area_ox=0.0676
XMp_7_15 dp_7_15 WL7 SL15 VSS sky130_fd_pr__nfet_g5v0d10v5 w=1 l=0.5
XRp_7_15 BLP15 dp_7_15 sky130_fd_pr_reram__reram_cell area_ox=0.0676
XMz_7_15 dz_7_15 WL7 SL15 VSS sky130_fd_pr__nfet_g5v0d10v5 w=1 l=0.5
XRz_7_15 BLZ15 dz_7_15 sky130_fd_pr_reram__reram_cell area_ox=0.0676
XMn_7_15 dn_7_15 WL7 SL15 VSS sky130_fd_pr__nfet_g5v0d10v5 w=1 l=0.5
XRn_7_15 BLN15 dn_7_15 sky130_fd_pr_reram__reram_cell area_ox=0.0676
XMp_7_16 dp_7_16 WL7 SL16 VSS sky130_fd_pr__nfet_g5v0d10v5 w=1 l=0.5
XRp_7_16 BLP16 dp_7_16 sky130_fd_pr_reram__reram_cell area_ox=0.0676
XMz_7_16 dz_7_16 WL7 SL16 VSS sky130_fd_pr__nfet_g5v0d10v5 w=1 l=0.5
XRz_7_16 BLZ16 dz_7_16 sky130_fd_pr_reram__reram_cell area_ox=0.0676
XMn_7_16 dn_7_16 WL7 SL16 VSS sky130_fd_pr__nfet_g5v0d10v5 w=1 l=0.5
XRn_7_16 BLN16 dn_7_16 sky130_fd_pr_reram__reram_cell area_ox=0.0676
XMp_7_17 dp_7_17 WL7 SL17 VSS sky130_fd_pr__nfet_g5v0d10v5 w=1 l=0.5
XRp_7_17 BLP17 dp_7_17 sky130_fd_pr_reram__reram_cell area_ox=0.0676
XMz_7_17 dz_7_17 WL7 SL17 VSS sky130_fd_pr__nfet_g5v0d10v5 w=1 l=0.5
XRz_7_17 BLZ17 dz_7_17 sky130_fd_pr_reram__reram_cell area_ox=0.0676
XMn_7_17 dn_7_17 WL7 SL17 VSS sky130_fd_pr__nfet_g5v0d10v5 w=1 l=0.5
XRn_7_17 BLN17 dn_7_17 sky130_fd_pr_reram__reram_cell area_ox=0.0676
XMp_7_18 dp_7_18 WL7 SL18 VSS sky130_fd_pr__nfet_g5v0d10v5 w=1 l=0.5
XRp_7_18 BLP18 dp_7_18 sky130_fd_pr_reram__reram_cell area_ox=0.0676
XMz_7_18 dz_7_18 WL7 SL18 VSS sky130_fd_pr__nfet_g5v0d10v5 w=1 l=0.5
XRz_7_18 BLZ18 dz_7_18 sky130_fd_pr_reram__reram_cell area_ox=0.0676
XMn_7_18 dn_7_18 WL7 SL18 VSS sky130_fd_pr__nfet_g5v0d10v5 w=1 l=0.5
XRn_7_18 BLN18 dn_7_18 sky130_fd_pr_reram__reram_cell area_ox=0.0676
XMp_7_19 dp_7_19 WL7 SL19 VSS sky130_fd_pr__nfet_g5v0d10v5 w=1 l=0.5
XRp_7_19 BLP19 dp_7_19 sky130_fd_pr_reram__reram_cell area_ox=0.0676
XMz_7_19 dz_7_19 WL7 SL19 VSS sky130_fd_pr__nfet_g5v0d10v5 w=1 l=0.5
XRz_7_19 BLZ19 dz_7_19 sky130_fd_pr_reram__reram_cell area_ox=0.0676
XMn_7_19 dn_7_19 WL7 SL19 VSS sky130_fd_pr__nfet_g5v0d10v5 w=1 l=0.5
XRn_7_19 BLN19 dn_7_19 sky130_fd_pr_reram__reram_cell area_ox=0.0676
XMp_7_20 dp_7_20 WL7 SL20 VSS sky130_fd_pr__nfet_g5v0d10v5 w=1 l=0.5
XRp_7_20 BLP20 dp_7_20 sky130_fd_pr_reram__reram_cell area_ox=0.0676
XMz_7_20 dz_7_20 WL7 SL20 VSS sky130_fd_pr__nfet_g5v0d10v5 w=1 l=0.5
XRz_7_20 BLZ20 dz_7_20 sky130_fd_pr_reram__reram_cell area_ox=0.0676
XMn_7_20 dn_7_20 WL7 SL20 VSS sky130_fd_pr__nfet_g5v0d10v5 w=1 l=0.5
XRn_7_20 BLN20 dn_7_20 sky130_fd_pr_reram__reram_cell area_ox=0.0676
XMp_7_21 dp_7_21 WL7 SL21 VSS sky130_fd_pr__nfet_g5v0d10v5 w=1 l=0.5
XRp_7_21 BLP21 dp_7_21 sky130_fd_pr_reram__reram_cell area_ox=0.0676
XMz_7_21 dz_7_21 WL7 SL21 VSS sky130_fd_pr__nfet_g5v0d10v5 w=1 l=0.5
XRz_7_21 BLZ21 dz_7_21 sky130_fd_pr_reram__reram_cell area_ox=0.0676
XMn_7_21 dn_7_21 WL7 SL21 VSS sky130_fd_pr__nfet_g5v0d10v5 w=1 l=0.5
XRn_7_21 BLN21 dn_7_21 sky130_fd_pr_reram__reram_cell area_ox=0.0676
XMp_7_22 dp_7_22 WL7 SL22 VSS sky130_fd_pr__nfet_g5v0d10v5 w=1 l=0.5
XRp_7_22 BLP22 dp_7_22 sky130_fd_pr_reram__reram_cell area_ox=0.0676
XMz_7_22 dz_7_22 WL7 SL22 VSS sky130_fd_pr__nfet_g5v0d10v5 w=1 l=0.5
XRz_7_22 BLZ22 dz_7_22 sky130_fd_pr_reram__reram_cell area_ox=0.0676
XMn_7_22 dn_7_22 WL7 SL22 VSS sky130_fd_pr__nfet_g5v0d10v5 w=1 l=0.5
XRn_7_22 BLN22 dn_7_22 sky130_fd_pr_reram__reram_cell area_ox=0.0676
XMp_7_23 dp_7_23 WL7 SL23 VSS sky130_fd_pr__nfet_g5v0d10v5 w=1 l=0.5
XRp_7_23 BLP23 dp_7_23 sky130_fd_pr_reram__reram_cell area_ox=0.0676
XMz_7_23 dz_7_23 WL7 SL23 VSS sky130_fd_pr__nfet_g5v0d10v5 w=1 l=0.5
XRz_7_23 BLZ23 dz_7_23 sky130_fd_pr_reram__reram_cell area_ox=0.0676
XMn_7_23 dn_7_23 WL7 SL23 VSS sky130_fd_pr__nfet_g5v0d10v5 w=1 l=0.5
XRn_7_23 BLN23 dn_7_23 sky130_fd_pr_reram__reram_cell area_ox=0.0676
XMp_8_0 dp_8_0 WL8 SL0 VSS sky130_fd_pr__nfet_g5v0d10v5 w=1 l=0.5
XRp_8_0 BLP0 dp_8_0 sky130_fd_pr_reram__reram_cell area_ox=0.0676
XMz_8_0 dz_8_0 WL8 SL0 VSS sky130_fd_pr__nfet_g5v0d10v5 w=1 l=0.5
XRz_8_0 BLZ0 dz_8_0 sky130_fd_pr_reram__reram_cell area_ox=0.0676
XMn_8_0 dn_8_0 WL8 SL0 VSS sky130_fd_pr__nfet_g5v0d10v5 w=1 l=0.5
XRn_8_0 BLN0 dn_8_0 sky130_fd_pr_reram__reram_cell area_ox=0.0676
XMp_8_1 dp_8_1 WL8 SL1 VSS sky130_fd_pr__nfet_g5v0d10v5 w=1 l=0.5
XRp_8_1 BLP1 dp_8_1 sky130_fd_pr_reram__reram_cell area_ox=0.0676
XMz_8_1 dz_8_1 WL8 SL1 VSS sky130_fd_pr__nfet_g5v0d10v5 w=1 l=0.5
XRz_8_1 BLZ1 dz_8_1 sky130_fd_pr_reram__reram_cell area_ox=0.0676
XMn_8_1 dn_8_1 WL8 SL1 VSS sky130_fd_pr__nfet_g5v0d10v5 w=1 l=0.5
XRn_8_1 BLN1 dn_8_1 sky130_fd_pr_reram__reram_cell area_ox=0.0676
XMp_8_2 dp_8_2 WL8 SL2 VSS sky130_fd_pr__nfet_g5v0d10v5 w=1 l=0.5
XRp_8_2 BLP2 dp_8_2 sky130_fd_pr_reram__reram_cell area_ox=0.0676
XMz_8_2 dz_8_2 WL8 SL2 VSS sky130_fd_pr__nfet_g5v0d10v5 w=1 l=0.5
XRz_8_2 BLZ2 dz_8_2 sky130_fd_pr_reram__reram_cell area_ox=0.0676
XMn_8_2 dn_8_2 WL8 SL2 VSS sky130_fd_pr__nfet_g5v0d10v5 w=1 l=0.5
XRn_8_2 BLN2 dn_8_2 sky130_fd_pr_reram__reram_cell area_ox=0.0676
XMp_8_3 dp_8_3 WL8 SL3 VSS sky130_fd_pr__nfet_g5v0d10v5 w=1 l=0.5
XRp_8_3 BLP3 dp_8_3 sky130_fd_pr_reram__reram_cell area_ox=0.0676
XMz_8_3 dz_8_3 WL8 SL3 VSS sky130_fd_pr__nfet_g5v0d10v5 w=1 l=0.5
XRz_8_3 BLZ3 dz_8_3 sky130_fd_pr_reram__reram_cell area_ox=0.0676
XMn_8_3 dn_8_3 WL8 SL3 VSS sky130_fd_pr__nfet_g5v0d10v5 w=1 l=0.5
XRn_8_3 BLN3 dn_8_3 sky130_fd_pr_reram__reram_cell area_ox=0.0676
XMp_8_4 dp_8_4 WL8 SL4 VSS sky130_fd_pr__nfet_g5v0d10v5 w=1 l=0.5
XRp_8_4 BLP4 dp_8_4 sky130_fd_pr_reram__reram_cell area_ox=0.0676
XMz_8_4 dz_8_4 WL8 SL4 VSS sky130_fd_pr__nfet_g5v0d10v5 w=1 l=0.5
XRz_8_4 BLZ4 dz_8_4 sky130_fd_pr_reram__reram_cell area_ox=0.0676
XMn_8_4 dn_8_4 WL8 SL4 VSS sky130_fd_pr__nfet_g5v0d10v5 w=1 l=0.5
XRn_8_4 BLN4 dn_8_4 sky130_fd_pr_reram__reram_cell area_ox=0.0676
XMp_8_5 dp_8_5 WL8 SL5 VSS sky130_fd_pr__nfet_g5v0d10v5 w=1 l=0.5
XRp_8_5 BLP5 dp_8_5 sky130_fd_pr_reram__reram_cell area_ox=0.0676
XMz_8_5 dz_8_5 WL8 SL5 VSS sky130_fd_pr__nfet_g5v0d10v5 w=1 l=0.5
XRz_8_5 BLZ5 dz_8_5 sky130_fd_pr_reram__reram_cell area_ox=0.0676
XMn_8_5 dn_8_5 WL8 SL5 VSS sky130_fd_pr__nfet_g5v0d10v5 w=1 l=0.5
XRn_8_5 BLN5 dn_8_5 sky130_fd_pr_reram__reram_cell area_ox=0.0676
XMp_8_6 dp_8_6 WL8 SL6 VSS sky130_fd_pr__nfet_g5v0d10v5 w=1 l=0.5
XRp_8_6 BLP6 dp_8_6 sky130_fd_pr_reram__reram_cell area_ox=0.0676
XMz_8_6 dz_8_6 WL8 SL6 VSS sky130_fd_pr__nfet_g5v0d10v5 w=1 l=0.5
XRz_8_6 BLZ6 dz_8_6 sky130_fd_pr_reram__reram_cell area_ox=0.0676
XMn_8_6 dn_8_6 WL8 SL6 VSS sky130_fd_pr__nfet_g5v0d10v5 w=1 l=0.5
XRn_8_6 BLN6 dn_8_6 sky130_fd_pr_reram__reram_cell area_ox=0.0676
XMp_8_7 dp_8_7 WL8 SL7 VSS sky130_fd_pr__nfet_g5v0d10v5 w=1 l=0.5
XRp_8_7 BLP7 dp_8_7 sky130_fd_pr_reram__reram_cell area_ox=0.0676
XMz_8_7 dz_8_7 WL8 SL7 VSS sky130_fd_pr__nfet_g5v0d10v5 w=1 l=0.5
XRz_8_7 BLZ7 dz_8_7 sky130_fd_pr_reram__reram_cell area_ox=0.0676
XMn_8_7 dn_8_7 WL8 SL7 VSS sky130_fd_pr__nfet_g5v0d10v5 w=1 l=0.5
XRn_8_7 BLN7 dn_8_7 sky130_fd_pr_reram__reram_cell area_ox=0.0676
XMp_8_8 dp_8_8 WL8 SL8 VSS sky130_fd_pr__nfet_g5v0d10v5 w=1 l=0.5
XRp_8_8 BLP8 dp_8_8 sky130_fd_pr_reram__reram_cell area_ox=0.0676
XMz_8_8 dz_8_8 WL8 SL8 VSS sky130_fd_pr__nfet_g5v0d10v5 w=1 l=0.5
XRz_8_8 BLZ8 dz_8_8 sky130_fd_pr_reram__reram_cell area_ox=0.0676
XMn_8_8 dn_8_8 WL8 SL8 VSS sky130_fd_pr__nfet_g5v0d10v5 w=1 l=0.5
XRn_8_8 BLN8 dn_8_8 sky130_fd_pr_reram__reram_cell area_ox=0.0676
XMp_8_9 dp_8_9 WL8 SL9 VSS sky130_fd_pr__nfet_g5v0d10v5 w=1 l=0.5
XRp_8_9 BLP9 dp_8_9 sky130_fd_pr_reram__reram_cell area_ox=0.0676
XMz_8_9 dz_8_9 WL8 SL9 VSS sky130_fd_pr__nfet_g5v0d10v5 w=1 l=0.5
XRz_8_9 BLZ9 dz_8_9 sky130_fd_pr_reram__reram_cell area_ox=0.0676
XMn_8_9 dn_8_9 WL8 SL9 VSS sky130_fd_pr__nfet_g5v0d10v5 w=1 l=0.5
XRn_8_9 BLN9 dn_8_9 sky130_fd_pr_reram__reram_cell area_ox=0.0676
XMp_8_10 dp_8_10 WL8 SL10 VSS sky130_fd_pr__nfet_g5v0d10v5 w=1 l=0.5
XRp_8_10 BLP10 dp_8_10 sky130_fd_pr_reram__reram_cell area_ox=0.0676
XMz_8_10 dz_8_10 WL8 SL10 VSS sky130_fd_pr__nfet_g5v0d10v5 w=1 l=0.5
XRz_8_10 BLZ10 dz_8_10 sky130_fd_pr_reram__reram_cell area_ox=0.0676
XMn_8_10 dn_8_10 WL8 SL10 VSS sky130_fd_pr__nfet_g5v0d10v5 w=1 l=0.5
XRn_8_10 BLN10 dn_8_10 sky130_fd_pr_reram__reram_cell area_ox=0.0676
XMp_8_11 dp_8_11 WL8 SL11 VSS sky130_fd_pr__nfet_g5v0d10v5 w=1 l=0.5
XRp_8_11 BLP11 dp_8_11 sky130_fd_pr_reram__reram_cell area_ox=0.0676
XMz_8_11 dz_8_11 WL8 SL11 VSS sky130_fd_pr__nfet_g5v0d10v5 w=1 l=0.5
XRz_8_11 BLZ11 dz_8_11 sky130_fd_pr_reram__reram_cell area_ox=0.0676
XMn_8_11 dn_8_11 WL8 SL11 VSS sky130_fd_pr__nfet_g5v0d10v5 w=1 l=0.5
XRn_8_11 BLN11 dn_8_11 sky130_fd_pr_reram__reram_cell area_ox=0.0676
XMp_8_12 dp_8_12 WL8 SL12 VSS sky130_fd_pr__nfet_g5v0d10v5 w=1 l=0.5
XRp_8_12 BLP12 dp_8_12 sky130_fd_pr_reram__reram_cell area_ox=0.0676
XMz_8_12 dz_8_12 WL8 SL12 VSS sky130_fd_pr__nfet_g5v0d10v5 w=1 l=0.5
XRz_8_12 BLZ12 dz_8_12 sky130_fd_pr_reram__reram_cell area_ox=0.0676
XMn_8_12 dn_8_12 WL8 SL12 VSS sky130_fd_pr__nfet_g5v0d10v5 w=1 l=0.5
XRn_8_12 BLN12 dn_8_12 sky130_fd_pr_reram__reram_cell area_ox=0.0676
XMp_8_13 dp_8_13 WL8 SL13 VSS sky130_fd_pr__nfet_g5v0d10v5 w=1 l=0.5
XRp_8_13 BLP13 dp_8_13 sky130_fd_pr_reram__reram_cell area_ox=0.0676
XMz_8_13 dz_8_13 WL8 SL13 VSS sky130_fd_pr__nfet_g5v0d10v5 w=1 l=0.5
XRz_8_13 BLZ13 dz_8_13 sky130_fd_pr_reram__reram_cell area_ox=0.0676
XMn_8_13 dn_8_13 WL8 SL13 VSS sky130_fd_pr__nfet_g5v0d10v5 w=1 l=0.5
XRn_8_13 BLN13 dn_8_13 sky130_fd_pr_reram__reram_cell area_ox=0.0676
XMp_8_14 dp_8_14 WL8 SL14 VSS sky130_fd_pr__nfet_g5v0d10v5 w=1 l=0.5
XRp_8_14 BLP14 dp_8_14 sky130_fd_pr_reram__reram_cell area_ox=0.0676
XMz_8_14 dz_8_14 WL8 SL14 VSS sky130_fd_pr__nfet_g5v0d10v5 w=1 l=0.5
XRz_8_14 BLZ14 dz_8_14 sky130_fd_pr_reram__reram_cell area_ox=0.0676
XMn_8_14 dn_8_14 WL8 SL14 VSS sky130_fd_pr__nfet_g5v0d10v5 w=1 l=0.5
XRn_8_14 BLN14 dn_8_14 sky130_fd_pr_reram__reram_cell area_ox=0.0676
XMp_8_15 dp_8_15 WL8 SL15 VSS sky130_fd_pr__nfet_g5v0d10v5 w=1 l=0.5
XRp_8_15 BLP15 dp_8_15 sky130_fd_pr_reram__reram_cell area_ox=0.0676
XMz_8_15 dz_8_15 WL8 SL15 VSS sky130_fd_pr__nfet_g5v0d10v5 w=1 l=0.5
XRz_8_15 BLZ15 dz_8_15 sky130_fd_pr_reram__reram_cell area_ox=0.0676
XMn_8_15 dn_8_15 WL8 SL15 VSS sky130_fd_pr__nfet_g5v0d10v5 w=1 l=0.5
XRn_8_15 BLN15 dn_8_15 sky130_fd_pr_reram__reram_cell area_ox=0.0676
XMp_8_16 dp_8_16 WL8 SL16 VSS sky130_fd_pr__nfet_g5v0d10v5 w=1 l=0.5
XRp_8_16 BLP16 dp_8_16 sky130_fd_pr_reram__reram_cell area_ox=0.0676
XMz_8_16 dz_8_16 WL8 SL16 VSS sky130_fd_pr__nfet_g5v0d10v5 w=1 l=0.5
XRz_8_16 BLZ16 dz_8_16 sky130_fd_pr_reram__reram_cell area_ox=0.0676
XMn_8_16 dn_8_16 WL8 SL16 VSS sky130_fd_pr__nfet_g5v0d10v5 w=1 l=0.5
XRn_8_16 BLN16 dn_8_16 sky130_fd_pr_reram__reram_cell area_ox=0.0676
XMp_8_17 dp_8_17 WL8 SL17 VSS sky130_fd_pr__nfet_g5v0d10v5 w=1 l=0.5
XRp_8_17 BLP17 dp_8_17 sky130_fd_pr_reram__reram_cell area_ox=0.0676
XMz_8_17 dz_8_17 WL8 SL17 VSS sky130_fd_pr__nfet_g5v0d10v5 w=1 l=0.5
XRz_8_17 BLZ17 dz_8_17 sky130_fd_pr_reram__reram_cell area_ox=0.0676
XMn_8_17 dn_8_17 WL8 SL17 VSS sky130_fd_pr__nfet_g5v0d10v5 w=1 l=0.5
XRn_8_17 BLN17 dn_8_17 sky130_fd_pr_reram__reram_cell area_ox=0.0676
XMp_8_18 dp_8_18 WL8 SL18 VSS sky130_fd_pr__nfet_g5v0d10v5 w=1 l=0.5
XRp_8_18 BLP18 dp_8_18 sky130_fd_pr_reram__reram_cell area_ox=0.0676
XMz_8_18 dz_8_18 WL8 SL18 VSS sky130_fd_pr__nfet_g5v0d10v5 w=1 l=0.5
XRz_8_18 BLZ18 dz_8_18 sky130_fd_pr_reram__reram_cell area_ox=0.0676
XMn_8_18 dn_8_18 WL8 SL18 VSS sky130_fd_pr__nfet_g5v0d10v5 w=1 l=0.5
XRn_8_18 BLN18 dn_8_18 sky130_fd_pr_reram__reram_cell area_ox=0.0676
XMp_8_19 dp_8_19 WL8 SL19 VSS sky130_fd_pr__nfet_g5v0d10v5 w=1 l=0.5
XRp_8_19 BLP19 dp_8_19 sky130_fd_pr_reram__reram_cell area_ox=0.0676
XMz_8_19 dz_8_19 WL8 SL19 VSS sky130_fd_pr__nfet_g5v0d10v5 w=1 l=0.5
XRz_8_19 BLZ19 dz_8_19 sky130_fd_pr_reram__reram_cell area_ox=0.0676
XMn_8_19 dn_8_19 WL8 SL19 VSS sky130_fd_pr__nfet_g5v0d10v5 w=1 l=0.5
XRn_8_19 BLN19 dn_8_19 sky130_fd_pr_reram__reram_cell area_ox=0.0676
XMp_8_20 dp_8_20 WL8 SL20 VSS sky130_fd_pr__nfet_g5v0d10v5 w=1 l=0.5
XRp_8_20 BLP20 dp_8_20 sky130_fd_pr_reram__reram_cell area_ox=0.0676
XMz_8_20 dz_8_20 WL8 SL20 VSS sky130_fd_pr__nfet_g5v0d10v5 w=1 l=0.5
XRz_8_20 BLZ20 dz_8_20 sky130_fd_pr_reram__reram_cell area_ox=0.0676
XMn_8_20 dn_8_20 WL8 SL20 VSS sky130_fd_pr__nfet_g5v0d10v5 w=1 l=0.5
XRn_8_20 BLN20 dn_8_20 sky130_fd_pr_reram__reram_cell area_ox=0.0676
XMp_8_21 dp_8_21 WL8 SL21 VSS sky130_fd_pr__nfet_g5v0d10v5 w=1 l=0.5
XRp_8_21 BLP21 dp_8_21 sky130_fd_pr_reram__reram_cell area_ox=0.0676
XMz_8_21 dz_8_21 WL8 SL21 VSS sky130_fd_pr__nfet_g5v0d10v5 w=1 l=0.5
XRz_8_21 BLZ21 dz_8_21 sky130_fd_pr_reram__reram_cell area_ox=0.0676
XMn_8_21 dn_8_21 WL8 SL21 VSS sky130_fd_pr__nfet_g5v0d10v5 w=1 l=0.5
XRn_8_21 BLN21 dn_8_21 sky130_fd_pr_reram__reram_cell area_ox=0.0676
XMp_8_22 dp_8_22 WL8 SL22 VSS sky130_fd_pr__nfet_g5v0d10v5 w=1 l=0.5
XRp_8_22 BLP22 dp_8_22 sky130_fd_pr_reram__reram_cell area_ox=0.0676
XMz_8_22 dz_8_22 WL8 SL22 VSS sky130_fd_pr__nfet_g5v0d10v5 w=1 l=0.5
XRz_8_22 BLZ22 dz_8_22 sky130_fd_pr_reram__reram_cell area_ox=0.0676
XMn_8_22 dn_8_22 WL8 SL22 VSS sky130_fd_pr__nfet_g5v0d10v5 w=1 l=0.5
XRn_8_22 BLN22 dn_8_22 sky130_fd_pr_reram__reram_cell area_ox=0.0676
XMp_8_23 dp_8_23 WL8 SL23 VSS sky130_fd_pr__nfet_g5v0d10v5 w=1 l=0.5
XRp_8_23 BLP23 dp_8_23 sky130_fd_pr_reram__reram_cell area_ox=0.0676
XMz_8_23 dz_8_23 WL8 SL23 VSS sky130_fd_pr__nfet_g5v0d10v5 w=1 l=0.5
XRz_8_23 BLZ23 dz_8_23 sky130_fd_pr_reram__reram_cell area_ox=0.0676
XMn_8_23 dn_8_23 WL8 SL23 VSS sky130_fd_pr__nfet_g5v0d10v5 w=1 l=0.5
XRn_8_23 BLN23 dn_8_23 sky130_fd_pr_reram__reram_cell area_ox=0.0676
XMp_9_0 dp_9_0 WL9 SL0 VSS sky130_fd_pr__nfet_g5v0d10v5 w=1 l=0.5
XRp_9_0 BLP0 dp_9_0 sky130_fd_pr_reram__reram_cell area_ox=0.0676
XMz_9_0 dz_9_0 WL9 SL0 VSS sky130_fd_pr__nfet_g5v0d10v5 w=1 l=0.5
XRz_9_0 BLZ0 dz_9_0 sky130_fd_pr_reram__reram_cell area_ox=0.0676
XMn_9_0 dn_9_0 WL9 SL0 VSS sky130_fd_pr__nfet_g5v0d10v5 w=1 l=0.5
XRn_9_0 BLN0 dn_9_0 sky130_fd_pr_reram__reram_cell area_ox=0.0676
XMp_9_1 dp_9_1 WL9 SL1 VSS sky130_fd_pr__nfet_g5v0d10v5 w=1 l=0.5
XRp_9_1 BLP1 dp_9_1 sky130_fd_pr_reram__reram_cell area_ox=0.0676
XMz_9_1 dz_9_1 WL9 SL1 VSS sky130_fd_pr__nfet_g5v0d10v5 w=1 l=0.5
XRz_9_1 BLZ1 dz_9_1 sky130_fd_pr_reram__reram_cell area_ox=0.0676
XMn_9_1 dn_9_1 WL9 SL1 VSS sky130_fd_pr__nfet_g5v0d10v5 w=1 l=0.5
XRn_9_1 BLN1 dn_9_1 sky130_fd_pr_reram__reram_cell area_ox=0.0676
XMp_9_2 dp_9_2 WL9 SL2 VSS sky130_fd_pr__nfet_g5v0d10v5 w=1 l=0.5
XRp_9_2 BLP2 dp_9_2 sky130_fd_pr_reram__reram_cell area_ox=0.0676
XMz_9_2 dz_9_2 WL9 SL2 VSS sky130_fd_pr__nfet_g5v0d10v5 w=1 l=0.5
XRz_9_2 BLZ2 dz_9_2 sky130_fd_pr_reram__reram_cell area_ox=0.0676
XMn_9_2 dn_9_2 WL9 SL2 VSS sky130_fd_pr__nfet_g5v0d10v5 w=1 l=0.5
XRn_9_2 BLN2 dn_9_2 sky130_fd_pr_reram__reram_cell area_ox=0.0676
XMp_9_3 dp_9_3 WL9 SL3 VSS sky130_fd_pr__nfet_g5v0d10v5 w=1 l=0.5
XRp_9_3 BLP3 dp_9_3 sky130_fd_pr_reram__reram_cell area_ox=0.0676
XMz_9_3 dz_9_3 WL9 SL3 VSS sky130_fd_pr__nfet_g5v0d10v5 w=1 l=0.5
XRz_9_3 BLZ3 dz_9_3 sky130_fd_pr_reram__reram_cell area_ox=0.0676
XMn_9_3 dn_9_3 WL9 SL3 VSS sky130_fd_pr__nfet_g5v0d10v5 w=1 l=0.5
XRn_9_3 BLN3 dn_9_3 sky130_fd_pr_reram__reram_cell area_ox=0.0676
XMp_9_4 dp_9_4 WL9 SL4 VSS sky130_fd_pr__nfet_g5v0d10v5 w=1 l=0.5
XRp_9_4 BLP4 dp_9_4 sky130_fd_pr_reram__reram_cell area_ox=0.0676
XMz_9_4 dz_9_4 WL9 SL4 VSS sky130_fd_pr__nfet_g5v0d10v5 w=1 l=0.5
XRz_9_4 BLZ4 dz_9_4 sky130_fd_pr_reram__reram_cell area_ox=0.0676
XMn_9_4 dn_9_4 WL9 SL4 VSS sky130_fd_pr__nfet_g5v0d10v5 w=1 l=0.5
XRn_9_4 BLN4 dn_9_4 sky130_fd_pr_reram__reram_cell area_ox=0.0676
XMp_9_5 dp_9_5 WL9 SL5 VSS sky130_fd_pr__nfet_g5v0d10v5 w=1 l=0.5
XRp_9_5 BLP5 dp_9_5 sky130_fd_pr_reram__reram_cell area_ox=0.0676
XMz_9_5 dz_9_5 WL9 SL5 VSS sky130_fd_pr__nfet_g5v0d10v5 w=1 l=0.5
XRz_9_5 BLZ5 dz_9_5 sky130_fd_pr_reram__reram_cell area_ox=0.0676
XMn_9_5 dn_9_5 WL9 SL5 VSS sky130_fd_pr__nfet_g5v0d10v5 w=1 l=0.5
XRn_9_5 BLN5 dn_9_5 sky130_fd_pr_reram__reram_cell area_ox=0.0676
XMp_9_6 dp_9_6 WL9 SL6 VSS sky130_fd_pr__nfet_g5v0d10v5 w=1 l=0.5
XRp_9_6 BLP6 dp_9_6 sky130_fd_pr_reram__reram_cell area_ox=0.0676
XMz_9_6 dz_9_6 WL9 SL6 VSS sky130_fd_pr__nfet_g5v0d10v5 w=1 l=0.5
XRz_9_6 BLZ6 dz_9_6 sky130_fd_pr_reram__reram_cell area_ox=0.0676
XMn_9_6 dn_9_6 WL9 SL6 VSS sky130_fd_pr__nfet_g5v0d10v5 w=1 l=0.5
XRn_9_6 BLN6 dn_9_6 sky130_fd_pr_reram__reram_cell area_ox=0.0676
XMp_9_7 dp_9_7 WL9 SL7 VSS sky130_fd_pr__nfet_g5v0d10v5 w=1 l=0.5
XRp_9_7 BLP7 dp_9_7 sky130_fd_pr_reram__reram_cell area_ox=0.0676
XMz_9_7 dz_9_7 WL9 SL7 VSS sky130_fd_pr__nfet_g5v0d10v5 w=1 l=0.5
XRz_9_7 BLZ7 dz_9_7 sky130_fd_pr_reram__reram_cell area_ox=0.0676
XMn_9_7 dn_9_7 WL9 SL7 VSS sky130_fd_pr__nfet_g5v0d10v5 w=1 l=0.5
XRn_9_7 BLN7 dn_9_7 sky130_fd_pr_reram__reram_cell area_ox=0.0676
XMp_9_8 dp_9_8 WL9 SL8 VSS sky130_fd_pr__nfet_g5v0d10v5 w=1 l=0.5
XRp_9_8 BLP8 dp_9_8 sky130_fd_pr_reram__reram_cell area_ox=0.0676
XMz_9_8 dz_9_8 WL9 SL8 VSS sky130_fd_pr__nfet_g5v0d10v5 w=1 l=0.5
XRz_9_8 BLZ8 dz_9_8 sky130_fd_pr_reram__reram_cell area_ox=0.0676
XMn_9_8 dn_9_8 WL9 SL8 VSS sky130_fd_pr__nfet_g5v0d10v5 w=1 l=0.5
XRn_9_8 BLN8 dn_9_8 sky130_fd_pr_reram__reram_cell area_ox=0.0676
XMp_9_9 dp_9_9 WL9 SL9 VSS sky130_fd_pr__nfet_g5v0d10v5 w=1 l=0.5
XRp_9_9 BLP9 dp_9_9 sky130_fd_pr_reram__reram_cell area_ox=0.0676
XMz_9_9 dz_9_9 WL9 SL9 VSS sky130_fd_pr__nfet_g5v0d10v5 w=1 l=0.5
XRz_9_9 BLZ9 dz_9_9 sky130_fd_pr_reram__reram_cell area_ox=0.0676
XMn_9_9 dn_9_9 WL9 SL9 VSS sky130_fd_pr__nfet_g5v0d10v5 w=1 l=0.5
XRn_9_9 BLN9 dn_9_9 sky130_fd_pr_reram__reram_cell area_ox=0.0676
XMp_9_10 dp_9_10 WL9 SL10 VSS sky130_fd_pr__nfet_g5v0d10v5 w=1 l=0.5
XRp_9_10 BLP10 dp_9_10 sky130_fd_pr_reram__reram_cell area_ox=0.0676
XMz_9_10 dz_9_10 WL9 SL10 VSS sky130_fd_pr__nfet_g5v0d10v5 w=1 l=0.5
XRz_9_10 BLZ10 dz_9_10 sky130_fd_pr_reram__reram_cell area_ox=0.0676
XMn_9_10 dn_9_10 WL9 SL10 VSS sky130_fd_pr__nfet_g5v0d10v5 w=1 l=0.5
XRn_9_10 BLN10 dn_9_10 sky130_fd_pr_reram__reram_cell area_ox=0.0676
XMp_9_11 dp_9_11 WL9 SL11 VSS sky130_fd_pr__nfet_g5v0d10v5 w=1 l=0.5
XRp_9_11 BLP11 dp_9_11 sky130_fd_pr_reram__reram_cell area_ox=0.0676
XMz_9_11 dz_9_11 WL9 SL11 VSS sky130_fd_pr__nfet_g5v0d10v5 w=1 l=0.5
XRz_9_11 BLZ11 dz_9_11 sky130_fd_pr_reram__reram_cell area_ox=0.0676
XMn_9_11 dn_9_11 WL9 SL11 VSS sky130_fd_pr__nfet_g5v0d10v5 w=1 l=0.5
XRn_9_11 BLN11 dn_9_11 sky130_fd_pr_reram__reram_cell area_ox=0.0676
XMp_9_12 dp_9_12 WL9 SL12 VSS sky130_fd_pr__nfet_g5v0d10v5 w=1 l=0.5
XRp_9_12 BLP12 dp_9_12 sky130_fd_pr_reram__reram_cell area_ox=0.0676
XMz_9_12 dz_9_12 WL9 SL12 VSS sky130_fd_pr__nfet_g5v0d10v5 w=1 l=0.5
XRz_9_12 BLZ12 dz_9_12 sky130_fd_pr_reram__reram_cell area_ox=0.0676
XMn_9_12 dn_9_12 WL9 SL12 VSS sky130_fd_pr__nfet_g5v0d10v5 w=1 l=0.5
XRn_9_12 BLN12 dn_9_12 sky130_fd_pr_reram__reram_cell area_ox=0.0676
XMp_9_13 dp_9_13 WL9 SL13 VSS sky130_fd_pr__nfet_g5v0d10v5 w=1 l=0.5
XRp_9_13 BLP13 dp_9_13 sky130_fd_pr_reram__reram_cell area_ox=0.0676
XMz_9_13 dz_9_13 WL9 SL13 VSS sky130_fd_pr__nfet_g5v0d10v5 w=1 l=0.5
XRz_9_13 BLZ13 dz_9_13 sky130_fd_pr_reram__reram_cell area_ox=0.0676
XMn_9_13 dn_9_13 WL9 SL13 VSS sky130_fd_pr__nfet_g5v0d10v5 w=1 l=0.5
XRn_9_13 BLN13 dn_9_13 sky130_fd_pr_reram__reram_cell area_ox=0.0676
XMp_9_14 dp_9_14 WL9 SL14 VSS sky130_fd_pr__nfet_g5v0d10v5 w=1 l=0.5
XRp_9_14 BLP14 dp_9_14 sky130_fd_pr_reram__reram_cell area_ox=0.0676
XMz_9_14 dz_9_14 WL9 SL14 VSS sky130_fd_pr__nfet_g5v0d10v5 w=1 l=0.5
XRz_9_14 BLZ14 dz_9_14 sky130_fd_pr_reram__reram_cell area_ox=0.0676
XMn_9_14 dn_9_14 WL9 SL14 VSS sky130_fd_pr__nfet_g5v0d10v5 w=1 l=0.5
XRn_9_14 BLN14 dn_9_14 sky130_fd_pr_reram__reram_cell area_ox=0.0676
XMp_9_15 dp_9_15 WL9 SL15 VSS sky130_fd_pr__nfet_g5v0d10v5 w=1 l=0.5
XRp_9_15 BLP15 dp_9_15 sky130_fd_pr_reram__reram_cell area_ox=0.0676
XMz_9_15 dz_9_15 WL9 SL15 VSS sky130_fd_pr__nfet_g5v0d10v5 w=1 l=0.5
XRz_9_15 BLZ15 dz_9_15 sky130_fd_pr_reram__reram_cell area_ox=0.0676
XMn_9_15 dn_9_15 WL9 SL15 VSS sky130_fd_pr__nfet_g5v0d10v5 w=1 l=0.5
XRn_9_15 BLN15 dn_9_15 sky130_fd_pr_reram__reram_cell area_ox=0.0676
XMp_9_16 dp_9_16 WL9 SL16 VSS sky130_fd_pr__nfet_g5v0d10v5 w=1 l=0.5
XRp_9_16 BLP16 dp_9_16 sky130_fd_pr_reram__reram_cell area_ox=0.0676
XMz_9_16 dz_9_16 WL9 SL16 VSS sky130_fd_pr__nfet_g5v0d10v5 w=1 l=0.5
XRz_9_16 BLZ16 dz_9_16 sky130_fd_pr_reram__reram_cell area_ox=0.0676
XMn_9_16 dn_9_16 WL9 SL16 VSS sky130_fd_pr__nfet_g5v0d10v5 w=1 l=0.5
XRn_9_16 BLN16 dn_9_16 sky130_fd_pr_reram__reram_cell area_ox=0.0676
XMp_9_17 dp_9_17 WL9 SL17 VSS sky130_fd_pr__nfet_g5v0d10v5 w=1 l=0.5
XRp_9_17 BLP17 dp_9_17 sky130_fd_pr_reram__reram_cell area_ox=0.0676
XMz_9_17 dz_9_17 WL9 SL17 VSS sky130_fd_pr__nfet_g5v0d10v5 w=1 l=0.5
XRz_9_17 BLZ17 dz_9_17 sky130_fd_pr_reram__reram_cell area_ox=0.0676
XMn_9_17 dn_9_17 WL9 SL17 VSS sky130_fd_pr__nfet_g5v0d10v5 w=1 l=0.5
XRn_9_17 BLN17 dn_9_17 sky130_fd_pr_reram__reram_cell area_ox=0.0676
XMp_9_18 dp_9_18 WL9 SL18 VSS sky130_fd_pr__nfet_g5v0d10v5 w=1 l=0.5
XRp_9_18 BLP18 dp_9_18 sky130_fd_pr_reram__reram_cell area_ox=0.0676
XMz_9_18 dz_9_18 WL9 SL18 VSS sky130_fd_pr__nfet_g5v0d10v5 w=1 l=0.5
XRz_9_18 BLZ18 dz_9_18 sky130_fd_pr_reram__reram_cell area_ox=0.0676
XMn_9_18 dn_9_18 WL9 SL18 VSS sky130_fd_pr__nfet_g5v0d10v5 w=1 l=0.5
XRn_9_18 BLN18 dn_9_18 sky130_fd_pr_reram__reram_cell area_ox=0.0676
XMp_9_19 dp_9_19 WL9 SL19 VSS sky130_fd_pr__nfet_g5v0d10v5 w=1 l=0.5
XRp_9_19 BLP19 dp_9_19 sky130_fd_pr_reram__reram_cell area_ox=0.0676
XMz_9_19 dz_9_19 WL9 SL19 VSS sky130_fd_pr__nfet_g5v0d10v5 w=1 l=0.5
XRz_9_19 BLZ19 dz_9_19 sky130_fd_pr_reram__reram_cell area_ox=0.0676
XMn_9_19 dn_9_19 WL9 SL19 VSS sky130_fd_pr__nfet_g5v0d10v5 w=1 l=0.5
XRn_9_19 BLN19 dn_9_19 sky130_fd_pr_reram__reram_cell area_ox=0.0676
XMp_9_20 dp_9_20 WL9 SL20 VSS sky130_fd_pr__nfet_g5v0d10v5 w=1 l=0.5
XRp_9_20 BLP20 dp_9_20 sky130_fd_pr_reram__reram_cell area_ox=0.0676
XMz_9_20 dz_9_20 WL9 SL20 VSS sky130_fd_pr__nfet_g5v0d10v5 w=1 l=0.5
XRz_9_20 BLZ20 dz_9_20 sky130_fd_pr_reram__reram_cell area_ox=0.0676
XMn_9_20 dn_9_20 WL9 SL20 VSS sky130_fd_pr__nfet_g5v0d10v5 w=1 l=0.5
XRn_9_20 BLN20 dn_9_20 sky130_fd_pr_reram__reram_cell area_ox=0.0676
XMp_9_21 dp_9_21 WL9 SL21 VSS sky130_fd_pr__nfet_g5v0d10v5 w=1 l=0.5
XRp_9_21 BLP21 dp_9_21 sky130_fd_pr_reram__reram_cell area_ox=0.0676
XMz_9_21 dz_9_21 WL9 SL21 VSS sky130_fd_pr__nfet_g5v0d10v5 w=1 l=0.5
XRz_9_21 BLZ21 dz_9_21 sky130_fd_pr_reram__reram_cell area_ox=0.0676
XMn_9_21 dn_9_21 WL9 SL21 VSS sky130_fd_pr__nfet_g5v0d10v5 w=1 l=0.5
XRn_9_21 BLN21 dn_9_21 sky130_fd_pr_reram__reram_cell area_ox=0.0676
XMp_9_22 dp_9_22 WL9 SL22 VSS sky130_fd_pr__nfet_g5v0d10v5 w=1 l=0.5
XRp_9_22 BLP22 dp_9_22 sky130_fd_pr_reram__reram_cell area_ox=0.0676
XMz_9_22 dz_9_22 WL9 SL22 VSS sky130_fd_pr__nfet_g5v0d10v5 w=1 l=0.5
XRz_9_22 BLZ22 dz_9_22 sky130_fd_pr_reram__reram_cell area_ox=0.0676
XMn_9_22 dn_9_22 WL9 SL22 VSS sky130_fd_pr__nfet_g5v0d10v5 w=1 l=0.5
XRn_9_22 BLN22 dn_9_22 sky130_fd_pr_reram__reram_cell area_ox=0.0676
XMp_9_23 dp_9_23 WL9 SL23 VSS sky130_fd_pr__nfet_g5v0d10v5 w=1 l=0.5
XRp_9_23 BLP23 dp_9_23 sky130_fd_pr_reram__reram_cell area_ox=0.0676
XMz_9_23 dz_9_23 WL9 SL23 VSS sky130_fd_pr__nfet_g5v0d10v5 w=1 l=0.5
XRz_9_23 BLZ23 dz_9_23 sky130_fd_pr_reram__reram_cell area_ox=0.0676
XMn_9_23 dn_9_23 WL9 SL23 VSS sky130_fd_pr__nfet_g5v0d10v5 w=1 l=0.5
XRn_9_23 BLN23 dn_9_23 sky130_fd_pr_reram__reram_cell area_ox=0.0676
XMp_10_0 dp_10_0 WL10 SL0 VSS sky130_fd_pr__nfet_g5v0d10v5 w=1 l=0.5
XRp_10_0 BLP0 dp_10_0 sky130_fd_pr_reram__reram_cell area_ox=0.0676
XMz_10_0 dz_10_0 WL10 SL0 VSS sky130_fd_pr__nfet_g5v0d10v5 w=1 l=0.5
XRz_10_0 BLZ0 dz_10_0 sky130_fd_pr_reram__reram_cell area_ox=0.0676
XMn_10_0 dn_10_0 WL10 SL0 VSS sky130_fd_pr__nfet_g5v0d10v5 w=1 l=0.5
XRn_10_0 BLN0 dn_10_0 sky130_fd_pr_reram__reram_cell area_ox=0.0676
XMp_10_1 dp_10_1 WL10 SL1 VSS sky130_fd_pr__nfet_g5v0d10v5 w=1 l=0.5
XRp_10_1 BLP1 dp_10_1 sky130_fd_pr_reram__reram_cell area_ox=0.0676
XMz_10_1 dz_10_1 WL10 SL1 VSS sky130_fd_pr__nfet_g5v0d10v5 w=1 l=0.5
XRz_10_1 BLZ1 dz_10_1 sky130_fd_pr_reram__reram_cell area_ox=0.0676
XMn_10_1 dn_10_1 WL10 SL1 VSS sky130_fd_pr__nfet_g5v0d10v5 w=1 l=0.5
XRn_10_1 BLN1 dn_10_1 sky130_fd_pr_reram__reram_cell area_ox=0.0676
XMp_10_2 dp_10_2 WL10 SL2 VSS sky130_fd_pr__nfet_g5v0d10v5 w=1 l=0.5
XRp_10_2 BLP2 dp_10_2 sky130_fd_pr_reram__reram_cell area_ox=0.0676
XMz_10_2 dz_10_2 WL10 SL2 VSS sky130_fd_pr__nfet_g5v0d10v5 w=1 l=0.5
XRz_10_2 BLZ2 dz_10_2 sky130_fd_pr_reram__reram_cell area_ox=0.0676
XMn_10_2 dn_10_2 WL10 SL2 VSS sky130_fd_pr__nfet_g5v0d10v5 w=1 l=0.5
XRn_10_2 BLN2 dn_10_2 sky130_fd_pr_reram__reram_cell area_ox=0.0676
XMp_10_3 dp_10_3 WL10 SL3 VSS sky130_fd_pr__nfet_g5v0d10v5 w=1 l=0.5
XRp_10_3 BLP3 dp_10_3 sky130_fd_pr_reram__reram_cell area_ox=0.0676
XMz_10_3 dz_10_3 WL10 SL3 VSS sky130_fd_pr__nfet_g5v0d10v5 w=1 l=0.5
XRz_10_3 BLZ3 dz_10_3 sky130_fd_pr_reram__reram_cell area_ox=0.0676
XMn_10_3 dn_10_3 WL10 SL3 VSS sky130_fd_pr__nfet_g5v0d10v5 w=1 l=0.5
XRn_10_3 BLN3 dn_10_3 sky130_fd_pr_reram__reram_cell area_ox=0.0676
XMp_10_4 dp_10_4 WL10 SL4 VSS sky130_fd_pr__nfet_g5v0d10v5 w=1 l=0.5
XRp_10_4 BLP4 dp_10_4 sky130_fd_pr_reram__reram_cell area_ox=0.0676
XMz_10_4 dz_10_4 WL10 SL4 VSS sky130_fd_pr__nfet_g5v0d10v5 w=1 l=0.5
XRz_10_4 BLZ4 dz_10_4 sky130_fd_pr_reram__reram_cell area_ox=0.0676
XMn_10_4 dn_10_4 WL10 SL4 VSS sky130_fd_pr__nfet_g5v0d10v5 w=1 l=0.5
XRn_10_4 BLN4 dn_10_4 sky130_fd_pr_reram__reram_cell area_ox=0.0676
XMp_10_5 dp_10_5 WL10 SL5 VSS sky130_fd_pr__nfet_g5v0d10v5 w=1 l=0.5
XRp_10_5 BLP5 dp_10_5 sky130_fd_pr_reram__reram_cell area_ox=0.0676
XMz_10_5 dz_10_5 WL10 SL5 VSS sky130_fd_pr__nfet_g5v0d10v5 w=1 l=0.5
XRz_10_5 BLZ5 dz_10_5 sky130_fd_pr_reram__reram_cell area_ox=0.0676
XMn_10_5 dn_10_5 WL10 SL5 VSS sky130_fd_pr__nfet_g5v0d10v5 w=1 l=0.5
XRn_10_5 BLN5 dn_10_5 sky130_fd_pr_reram__reram_cell area_ox=0.0676
XMp_10_6 dp_10_6 WL10 SL6 VSS sky130_fd_pr__nfet_g5v0d10v5 w=1 l=0.5
XRp_10_6 BLP6 dp_10_6 sky130_fd_pr_reram__reram_cell area_ox=0.0676
XMz_10_6 dz_10_6 WL10 SL6 VSS sky130_fd_pr__nfet_g5v0d10v5 w=1 l=0.5
XRz_10_6 BLZ6 dz_10_6 sky130_fd_pr_reram__reram_cell area_ox=0.0676
XMn_10_6 dn_10_6 WL10 SL6 VSS sky130_fd_pr__nfet_g5v0d10v5 w=1 l=0.5
XRn_10_6 BLN6 dn_10_6 sky130_fd_pr_reram__reram_cell area_ox=0.0676
XMp_10_7 dp_10_7 WL10 SL7 VSS sky130_fd_pr__nfet_g5v0d10v5 w=1 l=0.5
XRp_10_7 BLP7 dp_10_7 sky130_fd_pr_reram__reram_cell area_ox=0.0676
XMz_10_7 dz_10_7 WL10 SL7 VSS sky130_fd_pr__nfet_g5v0d10v5 w=1 l=0.5
XRz_10_7 BLZ7 dz_10_7 sky130_fd_pr_reram__reram_cell area_ox=0.0676
XMn_10_7 dn_10_7 WL10 SL7 VSS sky130_fd_pr__nfet_g5v0d10v5 w=1 l=0.5
XRn_10_7 BLN7 dn_10_7 sky130_fd_pr_reram__reram_cell area_ox=0.0676
XMp_10_8 dp_10_8 WL10 SL8 VSS sky130_fd_pr__nfet_g5v0d10v5 w=1 l=0.5
XRp_10_8 BLP8 dp_10_8 sky130_fd_pr_reram__reram_cell area_ox=0.0676
XMz_10_8 dz_10_8 WL10 SL8 VSS sky130_fd_pr__nfet_g5v0d10v5 w=1 l=0.5
XRz_10_8 BLZ8 dz_10_8 sky130_fd_pr_reram__reram_cell area_ox=0.0676
XMn_10_8 dn_10_8 WL10 SL8 VSS sky130_fd_pr__nfet_g5v0d10v5 w=1 l=0.5
XRn_10_8 BLN8 dn_10_8 sky130_fd_pr_reram__reram_cell area_ox=0.0676
XMp_10_9 dp_10_9 WL10 SL9 VSS sky130_fd_pr__nfet_g5v0d10v5 w=1 l=0.5
XRp_10_9 BLP9 dp_10_9 sky130_fd_pr_reram__reram_cell area_ox=0.0676
XMz_10_9 dz_10_9 WL10 SL9 VSS sky130_fd_pr__nfet_g5v0d10v5 w=1 l=0.5
XRz_10_9 BLZ9 dz_10_9 sky130_fd_pr_reram__reram_cell area_ox=0.0676
XMn_10_9 dn_10_9 WL10 SL9 VSS sky130_fd_pr__nfet_g5v0d10v5 w=1 l=0.5
XRn_10_9 BLN9 dn_10_9 sky130_fd_pr_reram__reram_cell area_ox=0.0676
XMp_10_10 dp_10_10 WL10 SL10 VSS sky130_fd_pr__nfet_g5v0d10v5 w=1 l=0.5
XRp_10_10 BLP10 dp_10_10 sky130_fd_pr_reram__reram_cell area_ox=0.0676
XMz_10_10 dz_10_10 WL10 SL10 VSS sky130_fd_pr__nfet_g5v0d10v5 w=1 l=0.5
XRz_10_10 BLZ10 dz_10_10 sky130_fd_pr_reram__reram_cell area_ox=0.0676
XMn_10_10 dn_10_10 WL10 SL10 VSS sky130_fd_pr__nfet_g5v0d10v5 w=1 l=0.5
XRn_10_10 BLN10 dn_10_10 sky130_fd_pr_reram__reram_cell area_ox=0.0676
XMp_10_11 dp_10_11 WL10 SL11 VSS sky130_fd_pr__nfet_g5v0d10v5 w=1 l=0.5
XRp_10_11 BLP11 dp_10_11 sky130_fd_pr_reram__reram_cell area_ox=0.0676
XMz_10_11 dz_10_11 WL10 SL11 VSS sky130_fd_pr__nfet_g5v0d10v5 w=1 l=0.5
XRz_10_11 BLZ11 dz_10_11 sky130_fd_pr_reram__reram_cell area_ox=0.0676
XMn_10_11 dn_10_11 WL10 SL11 VSS sky130_fd_pr__nfet_g5v0d10v5 w=1 l=0.5
XRn_10_11 BLN11 dn_10_11 sky130_fd_pr_reram__reram_cell area_ox=0.0676
XMp_10_12 dp_10_12 WL10 SL12 VSS sky130_fd_pr__nfet_g5v0d10v5 w=1 l=0.5
XRp_10_12 BLP12 dp_10_12 sky130_fd_pr_reram__reram_cell area_ox=0.0676
XMz_10_12 dz_10_12 WL10 SL12 VSS sky130_fd_pr__nfet_g5v0d10v5 w=1 l=0.5
XRz_10_12 BLZ12 dz_10_12 sky130_fd_pr_reram__reram_cell area_ox=0.0676
XMn_10_12 dn_10_12 WL10 SL12 VSS sky130_fd_pr__nfet_g5v0d10v5 w=1 l=0.5
XRn_10_12 BLN12 dn_10_12 sky130_fd_pr_reram__reram_cell area_ox=0.0676
XMp_10_13 dp_10_13 WL10 SL13 VSS sky130_fd_pr__nfet_g5v0d10v5 w=1 l=0.5
XRp_10_13 BLP13 dp_10_13 sky130_fd_pr_reram__reram_cell area_ox=0.0676
XMz_10_13 dz_10_13 WL10 SL13 VSS sky130_fd_pr__nfet_g5v0d10v5 w=1 l=0.5
XRz_10_13 BLZ13 dz_10_13 sky130_fd_pr_reram__reram_cell area_ox=0.0676
XMn_10_13 dn_10_13 WL10 SL13 VSS sky130_fd_pr__nfet_g5v0d10v5 w=1 l=0.5
XRn_10_13 BLN13 dn_10_13 sky130_fd_pr_reram__reram_cell area_ox=0.0676
XMp_10_14 dp_10_14 WL10 SL14 VSS sky130_fd_pr__nfet_g5v0d10v5 w=1 l=0.5
XRp_10_14 BLP14 dp_10_14 sky130_fd_pr_reram__reram_cell area_ox=0.0676
XMz_10_14 dz_10_14 WL10 SL14 VSS sky130_fd_pr__nfet_g5v0d10v5 w=1 l=0.5
XRz_10_14 BLZ14 dz_10_14 sky130_fd_pr_reram__reram_cell area_ox=0.0676
XMn_10_14 dn_10_14 WL10 SL14 VSS sky130_fd_pr__nfet_g5v0d10v5 w=1 l=0.5
XRn_10_14 BLN14 dn_10_14 sky130_fd_pr_reram__reram_cell area_ox=0.0676
XMp_10_15 dp_10_15 WL10 SL15 VSS sky130_fd_pr__nfet_g5v0d10v5 w=1 l=0.5
XRp_10_15 BLP15 dp_10_15 sky130_fd_pr_reram__reram_cell area_ox=0.0676
XMz_10_15 dz_10_15 WL10 SL15 VSS sky130_fd_pr__nfet_g5v0d10v5 w=1 l=0.5
XRz_10_15 BLZ15 dz_10_15 sky130_fd_pr_reram__reram_cell area_ox=0.0676
XMn_10_15 dn_10_15 WL10 SL15 VSS sky130_fd_pr__nfet_g5v0d10v5 w=1 l=0.5
XRn_10_15 BLN15 dn_10_15 sky130_fd_pr_reram__reram_cell area_ox=0.0676
XMp_10_16 dp_10_16 WL10 SL16 VSS sky130_fd_pr__nfet_g5v0d10v5 w=1 l=0.5
XRp_10_16 BLP16 dp_10_16 sky130_fd_pr_reram__reram_cell area_ox=0.0676
XMz_10_16 dz_10_16 WL10 SL16 VSS sky130_fd_pr__nfet_g5v0d10v5 w=1 l=0.5
XRz_10_16 BLZ16 dz_10_16 sky130_fd_pr_reram__reram_cell area_ox=0.0676
XMn_10_16 dn_10_16 WL10 SL16 VSS sky130_fd_pr__nfet_g5v0d10v5 w=1 l=0.5
XRn_10_16 BLN16 dn_10_16 sky130_fd_pr_reram__reram_cell area_ox=0.0676
XMp_10_17 dp_10_17 WL10 SL17 VSS sky130_fd_pr__nfet_g5v0d10v5 w=1 l=0.5
XRp_10_17 BLP17 dp_10_17 sky130_fd_pr_reram__reram_cell area_ox=0.0676
XMz_10_17 dz_10_17 WL10 SL17 VSS sky130_fd_pr__nfet_g5v0d10v5 w=1 l=0.5
XRz_10_17 BLZ17 dz_10_17 sky130_fd_pr_reram__reram_cell area_ox=0.0676
XMn_10_17 dn_10_17 WL10 SL17 VSS sky130_fd_pr__nfet_g5v0d10v5 w=1 l=0.5
XRn_10_17 BLN17 dn_10_17 sky130_fd_pr_reram__reram_cell area_ox=0.0676
XMp_10_18 dp_10_18 WL10 SL18 VSS sky130_fd_pr__nfet_g5v0d10v5 w=1 l=0.5
XRp_10_18 BLP18 dp_10_18 sky130_fd_pr_reram__reram_cell area_ox=0.0676
XMz_10_18 dz_10_18 WL10 SL18 VSS sky130_fd_pr__nfet_g5v0d10v5 w=1 l=0.5
XRz_10_18 BLZ18 dz_10_18 sky130_fd_pr_reram__reram_cell area_ox=0.0676
XMn_10_18 dn_10_18 WL10 SL18 VSS sky130_fd_pr__nfet_g5v0d10v5 w=1 l=0.5
XRn_10_18 BLN18 dn_10_18 sky130_fd_pr_reram__reram_cell area_ox=0.0676
XMp_10_19 dp_10_19 WL10 SL19 VSS sky130_fd_pr__nfet_g5v0d10v5 w=1 l=0.5
XRp_10_19 BLP19 dp_10_19 sky130_fd_pr_reram__reram_cell area_ox=0.0676
XMz_10_19 dz_10_19 WL10 SL19 VSS sky130_fd_pr__nfet_g5v0d10v5 w=1 l=0.5
XRz_10_19 BLZ19 dz_10_19 sky130_fd_pr_reram__reram_cell area_ox=0.0676
XMn_10_19 dn_10_19 WL10 SL19 VSS sky130_fd_pr__nfet_g5v0d10v5 w=1 l=0.5
XRn_10_19 BLN19 dn_10_19 sky130_fd_pr_reram__reram_cell area_ox=0.0676
XMp_10_20 dp_10_20 WL10 SL20 VSS sky130_fd_pr__nfet_g5v0d10v5 w=1 l=0.5
XRp_10_20 BLP20 dp_10_20 sky130_fd_pr_reram__reram_cell area_ox=0.0676
XMz_10_20 dz_10_20 WL10 SL20 VSS sky130_fd_pr__nfet_g5v0d10v5 w=1 l=0.5
XRz_10_20 BLZ20 dz_10_20 sky130_fd_pr_reram__reram_cell area_ox=0.0676
XMn_10_20 dn_10_20 WL10 SL20 VSS sky130_fd_pr__nfet_g5v0d10v5 w=1 l=0.5
XRn_10_20 BLN20 dn_10_20 sky130_fd_pr_reram__reram_cell area_ox=0.0676
XMp_10_21 dp_10_21 WL10 SL21 VSS sky130_fd_pr__nfet_g5v0d10v5 w=1 l=0.5
XRp_10_21 BLP21 dp_10_21 sky130_fd_pr_reram__reram_cell area_ox=0.0676
XMz_10_21 dz_10_21 WL10 SL21 VSS sky130_fd_pr__nfet_g5v0d10v5 w=1 l=0.5
XRz_10_21 BLZ21 dz_10_21 sky130_fd_pr_reram__reram_cell area_ox=0.0676
XMn_10_21 dn_10_21 WL10 SL21 VSS sky130_fd_pr__nfet_g5v0d10v5 w=1 l=0.5
XRn_10_21 BLN21 dn_10_21 sky130_fd_pr_reram__reram_cell area_ox=0.0676
XMp_10_22 dp_10_22 WL10 SL22 VSS sky130_fd_pr__nfet_g5v0d10v5 w=1 l=0.5
XRp_10_22 BLP22 dp_10_22 sky130_fd_pr_reram__reram_cell area_ox=0.0676
XMz_10_22 dz_10_22 WL10 SL22 VSS sky130_fd_pr__nfet_g5v0d10v5 w=1 l=0.5
XRz_10_22 BLZ22 dz_10_22 sky130_fd_pr_reram__reram_cell area_ox=0.0676
XMn_10_22 dn_10_22 WL10 SL22 VSS sky130_fd_pr__nfet_g5v0d10v5 w=1 l=0.5
XRn_10_22 BLN22 dn_10_22 sky130_fd_pr_reram__reram_cell area_ox=0.0676
XMp_10_23 dp_10_23 WL10 SL23 VSS sky130_fd_pr__nfet_g5v0d10v5 w=1 l=0.5
XRp_10_23 BLP23 dp_10_23 sky130_fd_pr_reram__reram_cell area_ox=0.0676
XMz_10_23 dz_10_23 WL10 SL23 VSS sky130_fd_pr__nfet_g5v0d10v5 w=1 l=0.5
XRz_10_23 BLZ23 dz_10_23 sky130_fd_pr_reram__reram_cell area_ox=0.0676
XMn_10_23 dn_10_23 WL10 SL23 VSS sky130_fd_pr__nfet_g5v0d10v5 w=1 l=0.5
XRn_10_23 BLN23 dn_10_23 sky130_fd_pr_reram__reram_cell area_ox=0.0676
XMp_11_0 dp_11_0 WL11 SL0 VSS sky130_fd_pr__nfet_g5v0d10v5 w=1 l=0.5
XRp_11_0 BLP0 dp_11_0 sky130_fd_pr_reram__reram_cell area_ox=0.0676
XMz_11_0 dz_11_0 WL11 SL0 VSS sky130_fd_pr__nfet_g5v0d10v5 w=1 l=0.5
XRz_11_0 BLZ0 dz_11_0 sky130_fd_pr_reram__reram_cell area_ox=0.0676
XMn_11_0 dn_11_0 WL11 SL0 VSS sky130_fd_pr__nfet_g5v0d10v5 w=1 l=0.5
XRn_11_0 BLN0 dn_11_0 sky130_fd_pr_reram__reram_cell area_ox=0.0676
XMp_11_1 dp_11_1 WL11 SL1 VSS sky130_fd_pr__nfet_g5v0d10v5 w=1 l=0.5
XRp_11_1 BLP1 dp_11_1 sky130_fd_pr_reram__reram_cell area_ox=0.0676
XMz_11_1 dz_11_1 WL11 SL1 VSS sky130_fd_pr__nfet_g5v0d10v5 w=1 l=0.5
XRz_11_1 BLZ1 dz_11_1 sky130_fd_pr_reram__reram_cell area_ox=0.0676
XMn_11_1 dn_11_1 WL11 SL1 VSS sky130_fd_pr__nfet_g5v0d10v5 w=1 l=0.5
XRn_11_1 BLN1 dn_11_1 sky130_fd_pr_reram__reram_cell area_ox=0.0676
XMp_11_2 dp_11_2 WL11 SL2 VSS sky130_fd_pr__nfet_g5v0d10v5 w=1 l=0.5
XRp_11_2 BLP2 dp_11_2 sky130_fd_pr_reram__reram_cell area_ox=0.0676
XMz_11_2 dz_11_2 WL11 SL2 VSS sky130_fd_pr__nfet_g5v0d10v5 w=1 l=0.5
XRz_11_2 BLZ2 dz_11_2 sky130_fd_pr_reram__reram_cell area_ox=0.0676
XMn_11_2 dn_11_2 WL11 SL2 VSS sky130_fd_pr__nfet_g5v0d10v5 w=1 l=0.5
XRn_11_2 BLN2 dn_11_2 sky130_fd_pr_reram__reram_cell area_ox=0.0676
XMp_11_3 dp_11_3 WL11 SL3 VSS sky130_fd_pr__nfet_g5v0d10v5 w=1 l=0.5
XRp_11_3 BLP3 dp_11_3 sky130_fd_pr_reram__reram_cell area_ox=0.0676
XMz_11_3 dz_11_3 WL11 SL3 VSS sky130_fd_pr__nfet_g5v0d10v5 w=1 l=0.5
XRz_11_3 BLZ3 dz_11_3 sky130_fd_pr_reram__reram_cell area_ox=0.0676
XMn_11_3 dn_11_3 WL11 SL3 VSS sky130_fd_pr__nfet_g5v0d10v5 w=1 l=0.5
XRn_11_3 BLN3 dn_11_3 sky130_fd_pr_reram__reram_cell area_ox=0.0676
XMp_11_4 dp_11_4 WL11 SL4 VSS sky130_fd_pr__nfet_g5v0d10v5 w=1 l=0.5
XRp_11_4 BLP4 dp_11_4 sky130_fd_pr_reram__reram_cell area_ox=0.0676
XMz_11_4 dz_11_4 WL11 SL4 VSS sky130_fd_pr__nfet_g5v0d10v5 w=1 l=0.5
XRz_11_4 BLZ4 dz_11_4 sky130_fd_pr_reram__reram_cell area_ox=0.0676
XMn_11_4 dn_11_4 WL11 SL4 VSS sky130_fd_pr__nfet_g5v0d10v5 w=1 l=0.5
XRn_11_4 BLN4 dn_11_4 sky130_fd_pr_reram__reram_cell area_ox=0.0676
XMp_11_5 dp_11_5 WL11 SL5 VSS sky130_fd_pr__nfet_g5v0d10v5 w=1 l=0.5
XRp_11_5 BLP5 dp_11_5 sky130_fd_pr_reram__reram_cell area_ox=0.0676
XMz_11_5 dz_11_5 WL11 SL5 VSS sky130_fd_pr__nfet_g5v0d10v5 w=1 l=0.5
XRz_11_5 BLZ5 dz_11_5 sky130_fd_pr_reram__reram_cell area_ox=0.0676
XMn_11_5 dn_11_5 WL11 SL5 VSS sky130_fd_pr__nfet_g5v0d10v5 w=1 l=0.5
XRn_11_5 BLN5 dn_11_5 sky130_fd_pr_reram__reram_cell area_ox=0.0676
XMp_11_6 dp_11_6 WL11 SL6 VSS sky130_fd_pr__nfet_g5v0d10v5 w=1 l=0.5
XRp_11_6 BLP6 dp_11_6 sky130_fd_pr_reram__reram_cell area_ox=0.0676
XMz_11_6 dz_11_6 WL11 SL6 VSS sky130_fd_pr__nfet_g5v0d10v5 w=1 l=0.5
XRz_11_6 BLZ6 dz_11_6 sky130_fd_pr_reram__reram_cell area_ox=0.0676
XMn_11_6 dn_11_6 WL11 SL6 VSS sky130_fd_pr__nfet_g5v0d10v5 w=1 l=0.5
XRn_11_6 BLN6 dn_11_6 sky130_fd_pr_reram__reram_cell area_ox=0.0676
XMp_11_7 dp_11_7 WL11 SL7 VSS sky130_fd_pr__nfet_g5v0d10v5 w=1 l=0.5
XRp_11_7 BLP7 dp_11_7 sky130_fd_pr_reram__reram_cell area_ox=0.0676
XMz_11_7 dz_11_7 WL11 SL7 VSS sky130_fd_pr__nfet_g5v0d10v5 w=1 l=0.5
XRz_11_7 BLZ7 dz_11_7 sky130_fd_pr_reram__reram_cell area_ox=0.0676
XMn_11_7 dn_11_7 WL11 SL7 VSS sky130_fd_pr__nfet_g5v0d10v5 w=1 l=0.5
XRn_11_7 BLN7 dn_11_7 sky130_fd_pr_reram__reram_cell area_ox=0.0676
XMp_11_8 dp_11_8 WL11 SL8 VSS sky130_fd_pr__nfet_g5v0d10v5 w=1 l=0.5
XRp_11_8 BLP8 dp_11_8 sky130_fd_pr_reram__reram_cell area_ox=0.0676
XMz_11_8 dz_11_8 WL11 SL8 VSS sky130_fd_pr__nfet_g5v0d10v5 w=1 l=0.5
XRz_11_8 BLZ8 dz_11_8 sky130_fd_pr_reram__reram_cell area_ox=0.0676
XMn_11_8 dn_11_8 WL11 SL8 VSS sky130_fd_pr__nfet_g5v0d10v5 w=1 l=0.5
XRn_11_8 BLN8 dn_11_8 sky130_fd_pr_reram__reram_cell area_ox=0.0676
XMp_11_9 dp_11_9 WL11 SL9 VSS sky130_fd_pr__nfet_g5v0d10v5 w=1 l=0.5
XRp_11_9 BLP9 dp_11_9 sky130_fd_pr_reram__reram_cell area_ox=0.0676
XMz_11_9 dz_11_9 WL11 SL9 VSS sky130_fd_pr__nfet_g5v0d10v5 w=1 l=0.5
XRz_11_9 BLZ9 dz_11_9 sky130_fd_pr_reram__reram_cell area_ox=0.0676
XMn_11_9 dn_11_9 WL11 SL9 VSS sky130_fd_pr__nfet_g5v0d10v5 w=1 l=0.5
XRn_11_9 BLN9 dn_11_9 sky130_fd_pr_reram__reram_cell area_ox=0.0676
XMp_11_10 dp_11_10 WL11 SL10 VSS sky130_fd_pr__nfet_g5v0d10v5 w=1 l=0.5
XRp_11_10 BLP10 dp_11_10 sky130_fd_pr_reram__reram_cell area_ox=0.0676
XMz_11_10 dz_11_10 WL11 SL10 VSS sky130_fd_pr__nfet_g5v0d10v5 w=1 l=0.5
XRz_11_10 BLZ10 dz_11_10 sky130_fd_pr_reram__reram_cell area_ox=0.0676
XMn_11_10 dn_11_10 WL11 SL10 VSS sky130_fd_pr__nfet_g5v0d10v5 w=1 l=0.5
XRn_11_10 BLN10 dn_11_10 sky130_fd_pr_reram__reram_cell area_ox=0.0676
XMp_11_11 dp_11_11 WL11 SL11 VSS sky130_fd_pr__nfet_g5v0d10v5 w=1 l=0.5
XRp_11_11 BLP11 dp_11_11 sky130_fd_pr_reram__reram_cell area_ox=0.0676
XMz_11_11 dz_11_11 WL11 SL11 VSS sky130_fd_pr__nfet_g5v0d10v5 w=1 l=0.5
XRz_11_11 BLZ11 dz_11_11 sky130_fd_pr_reram__reram_cell area_ox=0.0676
XMn_11_11 dn_11_11 WL11 SL11 VSS sky130_fd_pr__nfet_g5v0d10v5 w=1 l=0.5
XRn_11_11 BLN11 dn_11_11 sky130_fd_pr_reram__reram_cell area_ox=0.0676
XMp_11_12 dp_11_12 WL11 SL12 VSS sky130_fd_pr__nfet_g5v0d10v5 w=1 l=0.5
XRp_11_12 BLP12 dp_11_12 sky130_fd_pr_reram__reram_cell area_ox=0.0676
XMz_11_12 dz_11_12 WL11 SL12 VSS sky130_fd_pr__nfet_g5v0d10v5 w=1 l=0.5
XRz_11_12 BLZ12 dz_11_12 sky130_fd_pr_reram__reram_cell area_ox=0.0676
XMn_11_12 dn_11_12 WL11 SL12 VSS sky130_fd_pr__nfet_g5v0d10v5 w=1 l=0.5
XRn_11_12 BLN12 dn_11_12 sky130_fd_pr_reram__reram_cell area_ox=0.0676
XMp_11_13 dp_11_13 WL11 SL13 VSS sky130_fd_pr__nfet_g5v0d10v5 w=1 l=0.5
XRp_11_13 BLP13 dp_11_13 sky130_fd_pr_reram__reram_cell area_ox=0.0676
XMz_11_13 dz_11_13 WL11 SL13 VSS sky130_fd_pr__nfet_g5v0d10v5 w=1 l=0.5
XRz_11_13 BLZ13 dz_11_13 sky130_fd_pr_reram__reram_cell area_ox=0.0676
XMn_11_13 dn_11_13 WL11 SL13 VSS sky130_fd_pr__nfet_g5v0d10v5 w=1 l=0.5
XRn_11_13 BLN13 dn_11_13 sky130_fd_pr_reram__reram_cell area_ox=0.0676
XMp_11_14 dp_11_14 WL11 SL14 VSS sky130_fd_pr__nfet_g5v0d10v5 w=1 l=0.5
XRp_11_14 BLP14 dp_11_14 sky130_fd_pr_reram__reram_cell area_ox=0.0676
XMz_11_14 dz_11_14 WL11 SL14 VSS sky130_fd_pr__nfet_g5v0d10v5 w=1 l=0.5
XRz_11_14 BLZ14 dz_11_14 sky130_fd_pr_reram__reram_cell area_ox=0.0676
XMn_11_14 dn_11_14 WL11 SL14 VSS sky130_fd_pr__nfet_g5v0d10v5 w=1 l=0.5
XRn_11_14 BLN14 dn_11_14 sky130_fd_pr_reram__reram_cell area_ox=0.0676
XMp_11_15 dp_11_15 WL11 SL15 VSS sky130_fd_pr__nfet_g5v0d10v5 w=1 l=0.5
XRp_11_15 BLP15 dp_11_15 sky130_fd_pr_reram__reram_cell area_ox=0.0676
XMz_11_15 dz_11_15 WL11 SL15 VSS sky130_fd_pr__nfet_g5v0d10v5 w=1 l=0.5
XRz_11_15 BLZ15 dz_11_15 sky130_fd_pr_reram__reram_cell area_ox=0.0676
XMn_11_15 dn_11_15 WL11 SL15 VSS sky130_fd_pr__nfet_g5v0d10v5 w=1 l=0.5
XRn_11_15 BLN15 dn_11_15 sky130_fd_pr_reram__reram_cell area_ox=0.0676
XMp_11_16 dp_11_16 WL11 SL16 VSS sky130_fd_pr__nfet_g5v0d10v5 w=1 l=0.5
XRp_11_16 BLP16 dp_11_16 sky130_fd_pr_reram__reram_cell area_ox=0.0676
XMz_11_16 dz_11_16 WL11 SL16 VSS sky130_fd_pr__nfet_g5v0d10v5 w=1 l=0.5
XRz_11_16 BLZ16 dz_11_16 sky130_fd_pr_reram__reram_cell area_ox=0.0676
XMn_11_16 dn_11_16 WL11 SL16 VSS sky130_fd_pr__nfet_g5v0d10v5 w=1 l=0.5
XRn_11_16 BLN16 dn_11_16 sky130_fd_pr_reram__reram_cell area_ox=0.0676
XMp_11_17 dp_11_17 WL11 SL17 VSS sky130_fd_pr__nfet_g5v0d10v5 w=1 l=0.5
XRp_11_17 BLP17 dp_11_17 sky130_fd_pr_reram__reram_cell area_ox=0.0676
XMz_11_17 dz_11_17 WL11 SL17 VSS sky130_fd_pr__nfet_g5v0d10v5 w=1 l=0.5
XRz_11_17 BLZ17 dz_11_17 sky130_fd_pr_reram__reram_cell area_ox=0.0676
XMn_11_17 dn_11_17 WL11 SL17 VSS sky130_fd_pr__nfet_g5v0d10v5 w=1 l=0.5
XRn_11_17 BLN17 dn_11_17 sky130_fd_pr_reram__reram_cell area_ox=0.0676
XMp_11_18 dp_11_18 WL11 SL18 VSS sky130_fd_pr__nfet_g5v0d10v5 w=1 l=0.5
XRp_11_18 BLP18 dp_11_18 sky130_fd_pr_reram__reram_cell area_ox=0.0676
XMz_11_18 dz_11_18 WL11 SL18 VSS sky130_fd_pr__nfet_g5v0d10v5 w=1 l=0.5
XRz_11_18 BLZ18 dz_11_18 sky130_fd_pr_reram__reram_cell area_ox=0.0676
XMn_11_18 dn_11_18 WL11 SL18 VSS sky130_fd_pr__nfet_g5v0d10v5 w=1 l=0.5
XRn_11_18 BLN18 dn_11_18 sky130_fd_pr_reram__reram_cell area_ox=0.0676
XMp_11_19 dp_11_19 WL11 SL19 VSS sky130_fd_pr__nfet_g5v0d10v5 w=1 l=0.5
XRp_11_19 BLP19 dp_11_19 sky130_fd_pr_reram__reram_cell area_ox=0.0676
XMz_11_19 dz_11_19 WL11 SL19 VSS sky130_fd_pr__nfet_g5v0d10v5 w=1 l=0.5
XRz_11_19 BLZ19 dz_11_19 sky130_fd_pr_reram__reram_cell area_ox=0.0676
XMn_11_19 dn_11_19 WL11 SL19 VSS sky130_fd_pr__nfet_g5v0d10v5 w=1 l=0.5
XRn_11_19 BLN19 dn_11_19 sky130_fd_pr_reram__reram_cell area_ox=0.0676
XMp_11_20 dp_11_20 WL11 SL20 VSS sky130_fd_pr__nfet_g5v0d10v5 w=1 l=0.5
XRp_11_20 BLP20 dp_11_20 sky130_fd_pr_reram__reram_cell area_ox=0.0676
XMz_11_20 dz_11_20 WL11 SL20 VSS sky130_fd_pr__nfet_g5v0d10v5 w=1 l=0.5
XRz_11_20 BLZ20 dz_11_20 sky130_fd_pr_reram__reram_cell area_ox=0.0676
XMn_11_20 dn_11_20 WL11 SL20 VSS sky130_fd_pr__nfet_g5v0d10v5 w=1 l=0.5
XRn_11_20 BLN20 dn_11_20 sky130_fd_pr_reram__reram_cell area_ox=0.0676
XMp_11_21 dp_11_21 WL11 SL21 VSS sky130_fd_pr__nfet_g5v0d10v5 w=1 l=0.5
XRp_11_21 BLP21 dp_11_21 sky130_fd_pr_reram__reram_cell area_ox=0.0676
XMz_11_21 dz_11_21 WL11 SL21 VSS sky130_fd_pr__nfet_g5v0d10v5 w=1 l=0.5
XRz_11_21 BLZ21 dz_11_21 sky130_fd_pr_reram__reram_cell area_ox=0.0676
XMn_11_21 dn_11_21 WL11 SL21 VSS sky130_fd_pr__nfet_g5v0d10v5 w=1 l=0.5
XRn_11_21 BLN21 dn_11_21 sky130_fd_pr_reram__reram_cell area_ox=0.0676
XMp_11_22 dp_11_22 WL11 SL22 VSS sky130_fd_pr__nfet_g5v0d10v5 w=1 l=0.5
XRp_11_22 BLP22 dp_11_22 sky130_fd_pr_reram__reram_cell area_ox=0.0676
XMz_11_22 dz_11_22 WL11 SL22 VSS sky130_fd_pr__nfet_g5v0d10v5 w=1 l=0.5
XRz_11_22 BLZ22 dz_11_22 sky130_fd_pr_reram__reram_cell area_ox=0.0676
XMn_11_22 dn_11_22 WL11 SL22 VSS sky130_fd_pr__nfet_g5v0d10v5 w=1 l=0.5
XRn_11_22 BLN22 dn_11_22 sky130_fd_pr_reram__reram_cell area_ox=0.0676
XMp_11_23 dp_11_23 WL11 SL23 VSS sky130_fd_pr__nfet_g5v0d10v5 w=1 l=0.5
XRp_11_23 BLP23 dp_11_23 sky130_fd_pr_reram__reram_cell area_ox=0.0676
XMz_11_23 dz_11_23 WL11 SL23 VSS sky130_fd_pr__nfet_g5v0d10v5 w=1 l=0.5
XRz_11_23 BLZ23 dz_11_23 sky130_fd_pr_reram__reram_cell area_ox=0.0676
XMn_11_23 dn_11_23 WL11 SL23 VSS sky130_fd_pr__nfet_g5v0d10v5 w=1 l=0.5
XRn_11_23 BLN23 dn_11_23 sky130_fd_pr_reram__reram_cell area_ox=0.0676
XMp_12_0 dp_12_0 WL12 SL0 VSS sky130_fd_pr__nfet_g5v0d10v5 w=1 l=0.5
XRp_12_0 BLP0 dp_12_0 sky130_fd_pr_reram__reram_cell area_ox=0.0676
XMz_12_0 dz_12_0 WL12 SL0 VSS sky130_fd_pr__nfet_g5v0d10v5 w=1 l=0.5
XRz_12_0 BLZ0 dz_12_0 sky130_fd_pr_reram__reram_cell area_ox=0.0676
XMn_12_0 dn_12_0 WL12 SL0 VSS sky130_fd_pr__nfet_g5v0d10v5 w=1 l=0.5
XRn_12_0 BLN0 dn_12_0 sky130_fd_pr_reram__reram_cell area_ox=0.0676
XMp_12_1 dp_12_1 WL12 SL1 VSS sky130_fd_pr__nfet_g5v0d10v5 w=1 l=0.5
XRp_12_1 BLP1 dp_12_1 sky130_fd_pr_reram__reram_cell area_ox=0.0676
XMz_12_1 dz_12_1 WL12 SL1 VSS sky130_fd_pr__nfet_g5v0d10v5 w=1 l=0.5
XRz_12_1 BLZ1 dz_12_1 sky130_fd_pr_reram__reram_cell area_ox=0.0676
XMn_12_1 dn_12_1 WL12 SL1 VSS sky130_fd_pr__nfet_g5v0d10v5 w=1 l=0.5
XRn_12_1 BLN1 dn_12_1 sky130_fd_pr_reram__reram_cell area_ox=0.0676
XMp_12_2 dp_12_2 WL12 SL2 VSS sky130_fd_pr__nfet_g5v0d10v5 w=1 l=0.5
XRp_12_2 BLP2 dp_12_2 sky130_fd_pr_reram__reram_cell area_ox=0.0676
XMz_12_2 dz_12_2 WL12 SL2 VSS sky130_fd_pr__nfet_g5v0d10v5 w=1 l=0.5
XRz_12_2 BLZ2 dz_12_2 sky130_fd_pr_reram__reram_cell area_ox=0.0676
XMn_12_2 dn_12_2 WL12 SL2 VSS sky130_fd_pr__nfet_g5v0d10v5 w=1 l=0.5
XRn_12_2 BLN2 dn_12_2 sky130_fd_pr_reram__reram_cell area_ox=0.0676
XMp_12_3 dp_12_3 WL12 SL3 VSS sky130_fd_pr__nfet_g5v0d10v5 w=1 l=0.5
XRp_12_3 BLP3 dp_12_3 sky130_fd_pr_reram__reram_cell area_ox=0.0676
XMz_12_3 dz_12_3 WL12 SL3 VSS sky130_fd_pr__nfet_g5v0d10v5 w=1 l=0.5
XRz_12_3 BLZ3 dz_12_3 sky130_fd_pr_reram__reram_cell area_ox=0.0676
XMn_12_3 dn_12_3 WL12 SL3 VSS sky130_fd_pr__nfet_g5v0d10v5 w=1 l=0.5
XRn_12_3 BLN3 dn_12_3 sky130_fd_pr_reram__reram_cell area_ox=0.0676
XMp_12_4 dp_12_4 WL12 SL4 VSS sky130_fd_pr__nfet_g5v0d10v5 w=1 l=0.5
XRp_12_4 BLP4 dp_12_4 sky130_fd_pr_reram__reram_cell area_ox=0.0676
XMz_12_4 dz_12_4 WL12 SL4 VSS sky130_fd_pr__nfet_g5v0d10v5 w=1 l=0.5
XRz_12_4 BLZ4 dz_12_4 sky130_fd_pr_reram__reram_cell area_ox=0.0676
XMn_12_4 dn_12_4 WL12 SL4 VSS sky130_fd_pr__nfet_g5v0d10v5 w=1 l=0.5
XRn_12_4 BLN4 dn_12_4 sky130_fd_pr_reram__reram_cell area_ox=0.0676
XMp_12_5 dp_12_5 WL12 SL5 VSS sky130_fd_pr__nfet_g5v0d10v5 w=1 l=0.5
XRp_12_5 BLP5 dp_12_5 sky130_fd_pr_reram__reram_cell area_ox=0.0676
XMz_12_5 dz_12_5 WL12 SL5 VSS sky130_fd_pr__nfet_g5v0d10v5 w=1 l=0.5
XRz_12_5 BLZ5 dz_12_5 sky130_fd_pr_reram__reram_cell area_ox=0.0676
XMn_12_5 dn_12_5 WL12 SL5 VSS sky130_fd_pr__nfet_g5v0d10v5 w=1 l=0.5
XRn_12_5 BLN5 dn_12_5 sky130_fd_pr_reram__reram_cell area_ox=0.0676
XMp_12_6 dp_12_6 WL12 SL6 VSS sky130_fd_pr__nfet_g5v0d10v5 w=1 l=0.5
XRp_12_6 BLP6 dp_12_6 sky130_fd_pr_reram__reram_cell area_ox=0.0676
XMz_12_6 dz_12_6 WL12 SL6 VSS sky130_fd_pr__nfet_g5v0d10v5 w=1 l=0.5
XRz_12_6 BLZ6 dz_12_6 sky130_fd_pr_reram__reram_cell area_ox=0.0676
XMn_12_6 dn_12_6 WL12 SL6 VSS sky130_fd_pr__nfet_g5v0d10v5 w=1 l=0.5
XRn_12_6 BLN6 dn_12_6 sky130_fd_pr_reram__reram_cell area_ox=0.0676
XMp_12_7 dp_12_7 WL12 SL7 VSS sky130_fd_pr__nfet_g5v0d10v5 w=1 l=0.5
XRp_12_7 BLP7 dp_12_7 sky130_fd_pr_reram__reram_cell area_ox=0.0676
XMz_12_7 dz_12_7 WL12 SL7 VSS sky130_fd_pr__nfet_g5v0d10v5 w=1 l=0.5
XRz_12_7 BLZ7 dz_12_7 sky130_fd_pr_reram__reram_cell area_ox=0.0676
XMn_12_7 dn_12_7 WL12 SL7 VSS sky130_fd_pr__nfet_g5v0d10v5 w=1 l=0.5
XRn_12_7 BLN7 dn_12_7 sky130_fd_pr_reram__reram_cell area_ox=0.0676
XMp_12_8 dp_12_8 WL12 SL8 VSS sky130_fd_pr__nfet_g5v0d10v5 w=1 l=0.5
XRp_12_8 BLP8 dp_12_8 sky130_fd_pr_reram__reram_cell area_ox=0.0676
XMz_12_8 dz_12_8 WL12 SL8 VSS sky130_fd_pr__nfet_g5v0d10v5 w=1 l=0.5
XRz_12_8 BLZ8 dz_12_8 sky130_fd_pr_reram__reram_cell area_ox=0.0676
XMn_12_8 dn_12_8 WL12 SL8 VSS sky130_fd_pr__nfet_g5v0d10v5 w=1 l=0.5
XRn_12_8 BLN8 dn_12_8 sky130_fd_pr_reram__reram_cell area_ox=0.0676
XMp_12_9 dp_12_9 WL12 SL9 VSS sky130_fd_pr__nfet_g5v0d10v5 w=1 l=0.5
XRp_12_9 BLP9 dp_12_9 sky130_fd_pr_reram__reram_cell area_ox=0.0676
XMz_12_9 dz_12_9 WL12 SL9 VSS sky130_fd_pr__nfet_g5v0d10v5 w=1 l=0.5
XRz_12_9 BLZ9 dz_12_9 sky130_fd_pr_reram__reram_cell area_ox=0.0676
XMn_12_9 dn_12_9 WL12 SL9 VSS sky130_fd_pr__nfet_g5v0d10v5 w=1 l=0.5
XRn_12_9 BLN9 dn_12_9 sky130_fd_pr_reram__reram_cell area_ox=0.0676
XMp_12_10 dp_12_10 WL12 SL10 VSS sky130_fd_pr__nfet_g5v0d10v5 w=1 l=0.5
XRp_12_10 BLP10 dp_12_10 sky130_fd_pr_reram__reram_cell area_ox=0.0676
XMz_12_10 dz_12_10 WL12 SL10 VSS sky130_fd_pr__nfet_g5v0d10v5 w=1 l=0.5
XRz_12_10 BLZ10 dz_12_10 sky130_fd_pr_reram__reram_cell area_ox=0.0676
XMn_12_10 dn_12_10 WL12 SL10 VSS sky130_fd_pr__nfet_g5v0d10v5 w=1 l=0.5
XRn_12_10 BLN10 dn_12_10 sky130_fd_pr_reram__reram_cell area_ox=0.0676
XMp_12_11 dp_12_11 WL12 SL11 VSS sky130_fd_pr__nfet_g5v0d10v5 w=1 l=0.5
XRp_12_11 BLP11 dp_12_11 sky130_fd_pr_reram__reram_cell area_ox=0.0676
XMz_12_11 dz_12_11 WL12 SL11 VSS sky130_fd_pr__nfet_g5v0d10v5 w=1 l=0.5
XRz_12_11 BLZ11 dz_12_11 sky130_fd_pr_reram__reram_cell area_ox=0.0676
XMn_12_11 dn_12_11 WL12 SL11 VSS sky130_fd_pr__nfet_g5v0d10v5 w=1 l=0.5
XRn_12_11 BLN11 dn_12_11 sky130_fd_pr_reram__reram_cell area_ox=0.0676
XMp_12_12 dp_12_12 WL12 SL12 VSS sky130_fd_pr__nfet_g5v0d10v5 w=1 l=0.5
XRp_12_12 BLP12 dp_12_12 sky130_fd_pr_reram__reram_cell area_ox=0.0676
XMz_12_12 dz_12_12 WL12 SL12 VSS sky130_fd_pr__nfet_g5v0d10v5 w=1 l=0.5
XRz_12_12 BLZ12 dz_12_12 sky130_fd_pr_reram__reram_cell area_ox=0.0676
XMn_12_12 dn_12_12 WL12 SL12 VSS sky130_fd_pr__nfet_g5v0d10v5 w=1 l=0.5
XRn_12_12 BLN12 dn_12_12 sky130_fd_pr_reram__reram_cell area_ox=0.0676
XMp_12_13 dp_12_13 WL12 SL13 VSS sky130_fd_pr__nfet_g5v0d10v5 w=1 l=0.5
XRp_12_13 BLP13 dp_12_13 sky130_fd_pr_reram__reram_cell area_ox=0.0676
XMz_12_13 dz_12_13 WL12 SL13 VSS sky130_fd_pr__nfet_g5v0d10v5 w=1 l=0.5
XRz_12_13 BLZ13 dz_12_13 sky130_fd_pr_reram__reram_cell area_ox=0.0676
XMn_12_13 dn_12_13 WL12 SL13 VSS sky130_fd_pr__nfet_g5v0d10v5 w=1 l=0.5
XRn_12_13 BLN13 dn_12_13 sky130_fd_pr_reram__reram_cell area_ox=0.0676
XMp_12_14 dp_12_14 WL12 SL14 VSS sky130_fd_pr__nfet_g5v0d10v5 w=1 l=0.5
XRp_12_14 BLP14 dp_12_14 sky130_fd_pr_reram__reram_cell area_ox=0.0676
XMz_12_14 dz_12_14 WL12 SL14 VSS sky130_fd_pr__nfet_g5v0d10v5 w=1 l=0.5
XRz_12_14 BLZ14 dz_12_14 sky130_fd_pr_reram__reram_cell area_ox=0.0676
XMn_12_14 dn_12_14 WL12 SL14 VSS sky130_fd_pr__nfet_g5v0d10v5 w=1 l=0.5
XRn_12_14 BLN14 dn_12_14 sky130_fd_pr_reram__reram_cell area_ox=0.0676
XMp_12_15 dp_12_15 WL12 SL15 VSS sky130_fd_pr__nfet_g5v0d10v5 w=1 l=0.5
XRp_12_15 BLP15 dp_12_15 sky130_fd_pr_reram__reram_cell area_ox=0.0676
XMz_12_15 dz_12_15 WL12 SL15 VSS sky130_fd_pr__nfet_g5v0d10v5 w=1 l=0.5
XRz_12_15 BLZ15 dz_12_15 sky130_fd_pr_reram__reram_cell area_ox=0.0676
XMn_12_15 dn_12_15 WL12 SL15 VSS sky130_fd_pr__nfet_g5v0d10v5 w=1 l=0.5
XRn_12_15 BLN15 dn_12_15 sky130_fd_pr_reram__reram_cell area_ox=0.0676
XMp_12_16 dp_12_16 WL12 SL16 VSS sky130_fd_pr__nfet_g5v0d10v5 w=1 l=0.5
XRp_12_16 BLP16 dp_12_16 sky130_fd_pr_reram__reram_cell area_ox=0.0676
XMz_12_16 dz_12_16 WL12 SL16 VSS sky130_fd_pr__nfet_g5v0d10v5 w=1 l=0.5
XRz_12_16 BLZ16 dz_12_16 sky130_fd_pr_reram__reram_cell area_ox=0.0676
XMn_12_16 dn_12_16 WL12 SL16 VSS sky130_fd_pr__nfet_g5v0d10v5 w=1 l=0.5
XRn_12_16 BLN16 dn_12_16 sky130_fd_pr_reram__reram_cell area_ox=0.0676
XMp_12_17 dp_12_17 WL12 SL17 VSS sky130_fd_pr__nfet_g5v0d10v5 w=1 l=0.5
XRp_12_17 BLP17 dp_12_17 sky130_fd_pr_reram__reram_cell area_ox=0.0676
XMz_12_17 dz_12_17 WL12 SL17 VSS sky130_fd_pr__nfet_g5v0d10v5 w=1 l=0.5
XRz_12_17 BLZ17 dz_12_17 sky130_fd_pr_reram__reram_cell area_ox=0.0676
XMn_12_17 dn_12_17 WL12 SL17 VSS sky130_fd_pr__nfet_g5v0d10v5 w=1 l=0.5
XRn_12_17 BLN17 dn_12_17 sky130_fd_pr_reram__reram_cell area_ox=0.0676
XMp_12_18 dp_12_18 WL12 SL18 VSS sky130_fd_pr__nfet_g5v0d10v5 w=1 l=0.5
XRp_12_18 BLP18 dp_12_18 sky130_fd_pr_reram__reram_cell area_ox=0.0676
XMz_12_18 dz_12_18 WL12 SL18 VSS sky130_fd_pr__nfet_g5v0d10v5 w=1 l=0.5
XRz_12_18 BLZ18 dz_12_18 sky130_fd_pr_reram__reram_cell area_ox=0.0676
XMn_12_18 dn_12_18 WL12 SL18 VSS sky130_fd_pr__nfet_g5v0d10v5 w=1 l=0.5
XRn_12_18 BLN18 dn_12_18 sky130_fd_pr_reram__reram_cell area_ox=0.0676
XMp_12_19 dp_12_19 WL12 SL19 VSS sky130_fd_pr__nfet_g5v0d10v5 w=1 l=0.5
XRp_12_19 BLP19 dp_12_19 sky130_fd_pr_reram__reram_cell area_ox=0.0676
XMz_12_19 dz_12_19 WL12 SL19 VSS sky130_fd_pr__nfet_g5v0d10v5 w=1 l=0.5
XRz_12_19 BLZ19 dz_12_19 sky130_fd_pr_reram__reram_cell area_ox=0.0676
XMn_12_19 dn_12_19 WL12 SL19 VSS sky130_fd_pr__nfet_g5v0d10v5 w=1 l=0.5
XRn_12_19 BLN19 dn_12_19 sky130_fd_pr_reram__reram_cell area_ox=0.0676
XMp_12_20 dp_12_20 WL12 SL20 VSS sky130_fd_pr__nfet_g5v0d10v5 w=1 l=0.5
XRp_12_20 BLP20 dp_12_20 sky130_fd_pr_reram__reram_cell area_ox=0.0676
XMz_12_20 dz_12_20 WL12 SL20 VSS sky130_fd_pr__nfet_g5v0d10v5 w=1 l=0.5
XRz_12_20 BLZ20 dz_12_20 sky130_fd_pr_reram__reram_cell area_ox=0.0676
XMn_12_20 dn_12_20 WL12 SL20 VSS sky130_fd_pr__nfet_g5v0d10v5 w=1 l=0.5
XRn_12_20 BLN20 dn_12_20 sky130_fd_pr_reram__reram_cell area_ox=0.0676
XMp_12_21 dp_12_21 WL12 SL21 VSS sky130_fd_pr__nfet_g5v0d10v5 w=1 l=0.5
XRp_12_21 BLP21 dp_12_21 sky130_fd_pr_reram__reram_cell area_ox=0.0676
XMz_12_21 dz_12_21 WL12 SL21 VSS sky130_fd_pr__nfet_g5v0d10v5 w=1 l=0.5
XRz_12_21 BLZ21 dz_12_21 sky130_fd_pr_reram__reram_cell area_ox=0.0676
XMn_12_21 dn_12_21 WL12 SL21 VSS sky130_fd_pr__nfet_g5v0d10v5 w=1 l=0.5
XRn_12_21 BLN21 dn_12_21 sky130_fd_pr_reram__reram_cell area_ox=0.0676
XMp_12_22 dp_12_22 WL12 SL22 VSS sky130_fd_pr__nfet_g5v0d10v5 w=1 l=0.5
XRp_12_22 BLP22 dp_12_22 sky130_fd_pr_reram__reram_cell area_ox=0.0676
XMz_12_22 dz_12_22 WL12 SL22 VSS sky130_fd_pr__nfet_g5v0d10v5 w=1 l=0.5
XRz_12_22 BLZ22 dz_12_22 sky130_fd_pr_reram__reram_cell area_ox=0.0676
XMn_12_22 dn_12_22 WL12 SL22 VSS sky130_fd_pr__nfet_g5v0d10v5 w=1 l=0.5
XRn_12_22 BLN22 dn_12_22 sky130_fd_pr_reram__reram_cell area_ox=0.0676
XMp_12_23 dp_12_23 WL12 SL23 VSS sky130_fd_pr__nfet_g5v0d10v5 w=1 l=0.5
XRp_12_23 BLP23 dp_12_23 sky130_fd_pr_reram__reram_cell area_ox=0.0676
XMz_12_23 dz_12_23 WL12 SL23 VSS sky130_fd_pr__nfet_g5v0d10v5 w=1 l=0.5
XRz_12_23 BLZ23 dz_12_23 sky130_fd_pr_reram__reram_cell area_ox=0.0676
XMn_12_23 dn_12_23 WL12 SL23 VSS sky130_fd_pr__nfet_g5v0d10v5 w=1 l=0.5
XRn_12_23 BLN23 dn_12_23 sky130_fd_pr_reram__reram_cell area_ox=0.0676
XMp_13_0 dp_13_0 WL13 SL0 VSS sky130_fd_pr__nfet_g5v0d10v5 w=1 l=0.5
XRp_13_0 BLP0 dp_13_0 sky130_fd_pr_reram__reram_cell area_ox=0.0676
XMz_13_0 dz_13_0 WL13 SL0 VSS sky130_fd_pr__nfet_g5v0d10v5 w=1 l=0.5
XRz_13_0 BLZ0 dz_13_0 sky130_fd_pr_reram__reram_cell area_ox=0.0676
XMn_13_0 dn_13_0 WL13 SL0 VSS sky130_fd_pr__nfet_g5v0d10v5 w=1 l=0.5
XRn_13_0 BLN0 dn_13_0 sky130_fd_pr_reram__reram_cell area_ox=0.0676
XMp_13_1 dp_13_1 WL13 SL1 VSS sky130_fd_pr__nfet_g5v0d10v5 w=1 l=0.5
XRp_13_1 BLP1 dp_13_1 sky130_fd_pr_reram__reram_cell area_ox=0.0676
XMz_13_1 dz_13_1 WL13 SL1 VSS sky130_fd_pr__nfet_g5v0d10v5 w=1 l=0.5
XRz_13_1 BLZ1 dz_13_1 sky130_fd_pr_reram__reram_cell area_ox=0.0676
XMn_13_1 dn_13_1 WL13 SL1 VSS sky130_fd_pr__nfet_g5v0d10v5 w=1 l=0.5
XRn_13_1 BLN1 dn_13_1 sky130_fd_pr_reram__reram_cell area_ox=0.0676
XMp_13_2 dp_13_2 WL13 SL2 VSS sky130_fd_pr__nfet_g5v0d10v5 w=1 l=0.5
XRp_13_2 BLP2 dp_13_2 sky130_fd_pr_reram__reram_cell area_ox=0.0676
XMz_13_2 dz_13_2 WL13 SL2 VSS sky130_fd_pr__nfet_g5v0d10v5 w=1 l=0.5
XRz_13_2 BLZ2 dz_13_2 sky130_fd_pr_reram__reram_cell area_ox=0.0676
XMn_13_2 dn_13_2 WL13 SL2 VSS sky130_fd_pr__nfet_g5v0d10v5 w=1 l=0.5
XRn_13_2 BLN2 dn_13_2 sky130_fd_pr_reram__reram_cell area_ox=0.0676
XMp_13_3 dp_13_3 WL13 SL3 VSS sky130_fd_pr__nfet_g5v0d10v5 w=1 l=0.5
XRp_13_3 BLP3 dp_13_3 sky130_fd_pr_reram__reram_cell area_ox=0.0676
XMz_13_3 dz_13_3 WL13 SL3 VSS sky130_fd_pr__nfet_g5v0d10v5 w=1 l=0.5
XRz_13_3 BLZ3 dz_13_3 sky130_fd_pr_reram__reram_cell area_ox=0.0676
XMn_13_3 dn_13_3 WL13 SL3 VSS sky130_fd_pr__nfet_g5v0d10v5 w=1 l=0.5
XRn_13_3 BLN3 dn_13_3 sky130_fd_pr_reram__reram_cell area_ox=0.0676
XMp_13_4 dp_13_4 WL13 SL4 VSS sky130_fd_pr__nfet_g5v0d10v5 w=1 l=0.5
XRp_13_4 BLP4 dp_13_4 sky130_fd_pr_reram__reram_cell area_ox=0.0676
XMz_13_4 dz_13_4 WL13 SL4 VSS sky130_fd_pr__nfet_g5v0d10v5 w=1 l=0.5
XRz_13_4 BLZ4 dz_13_4 sky130_fd_pr_reram__reram_cell area_ox=0.0676
XMn_13_4 dn_13_4 WL13 SL4 VSS sky130_fd_pr__nfet_g5v0d10v5 w=1 l=0.5
XRn_13_4 BLN4 dn_13_4 sky130_fd_pr_reram__reram_cell area_ox=0.0676
XMp_13_5 dp_13_5 WL13 SL5 VSS sky130_fd_pr__nfet_g5v0d10v5 w=1 l=0.5
XRp_13_5 BLP5 dp_13_5 sky130_fd_pr_reram__reram_cell area_ox=0.0676
XMz_13_5 dz_13_5 WL13 SL5 VSS sky130_fd_pr__nfet_g5v0d10v5 w=1 l=0.5
XRz_13_5 BLZ5 dz_13_5 sky130_fd_pr_reram__reram_cell area_ox=0.0676
XMn_13_5 dn_13_5 WL13 SL5 VSS sky130_fd_pr__nfet_g5v0d10v5 w=1 l=0.5
XRn_13_5 BLN5 dn_13_5 sky130_fd_pr_reram__reram_cell area_ox=0.0676
XMp_13_6 dp_13_6 WL13 SL6 VSS sky130_fd_pr__nfet_g5v0d10v5 w=1 l=0.5
XRp_13_6 BLP6 dp_13_6 sky130_fd_pr_reram__reram_cell area_ox=0.0676
XMz_13_6 dz_13_6 WL13 SL6 VSS sky130_fd_pr__nfet_g5v0d10v5 w=1 l=0.5
XRz_13_6 BLZ6 dz_13_6 sky130_fd_pr_reram__reram_cell area_ox=0.0676
XMn_13_6 dn_13_6 WL13 SL6 VSS sky130_fd_pr__nfet_g5v0d10v5 w=1 l=0.5
XRn_13_6 BLN6 dn_13_6 sky130_fd_pr_reram__reram_cell area_ox=0.0676
XMp_13_7 dp_13_7 WL13 SL7 VSS sky130_fd_pr__nfet_g5v0d10v5 w=1 l=0.5
XRp_13_7 BLP7 dp_13_7 sky130_fd_pr_reram__reram_cell area_ox=0.0676
XMz_13_7 dz_13_7 WL13 SL7 VSS sky130_fd_pr__nfet_g5v0d10v5 w=1 l=0.5
XRz_13_7 BLZ7 dz_13_7 sky130_fd_pr_reram__reram_cell area_ox=0.0676
XMn_13_7 dn_13_7 WL13 SL7 VSS sky130_fd_pr__nfet_g5v0d10v5 w=1 l=0.5
XRn_13_7 BLN7 dn_13_7 sky130_fd_pr_reram__reram_cell area_ox=0.0676
XMp_13_8 dp_13_8 WL13 SL8 VSS sky130_fd_pr__nfet_g5v0d10v5 w=1 l=0.5
XRp_13_8 BLP8 dp_13_8 sky130_fd_pr_reram__reram_cell area_ox=0.0676
XMz_13_8 dz_13_8 WL13 SL8 VSS sky130_fd_pr__nfet_g5v0d10v5 w=1 l=0.5
XRz_13_8 BLZ8 dz_13_8 sky130_fd_pr_reram__reram_cell area_ox=0.0676
XMn_13_8 dn_13_8 WL13 SL8 VSS sky130_fd_pr__nfet_g5v0d10v5 w=1 l=0.5
XRn_13_8 BLN8 dn_13_8 sky130_fd_pr_reram__reram_cell area_ox=0.0676
XMp_13_9 dp_13_9 WL13 SL9 VSS sky130_fd_pr__nfet_g5v0d10v5 w=1 l=0.5
XRp_13_9 BLP9 dp_13_9 sky130_fd_pr_reram__reram_cell area_ox=0.0676
XMz_13_9 dz_13_9 WL13 SL9 VSS sky130_fd_pr__nfet_g5v0d10v5 w=1 l=0.5
XRz_13_9 BLZ9 dz_13_9 sky130_fd_pr_reram__reram_cell area_ox=0.0676
XMn_13_9 dn_13_9 WL13 SL9 VSS sky130_fd_pr__nfet_g5v0d10v5 w=1 l=0.5
XRn_13_9 BLN9 dn_13_9 sky130_fd_pr_reram__reram_cell area_ox=0.0676
XMp_13_10 dp_13_10 WL13 SL10 VSS sky130_fd_pr__nfet_g5v0d10v5 w=1 l=0.5
XRp_13_10 BLP10 dp_13_10 sky130_fd_pr_reram__reram_cell area_ox=0.0676
XMz_13_10 dz_13_10 WL13 SL10 VSS sky130_fd_pr__nfet_g5v0d10v5 w=1 l=0.5
XRz_13_10 BLZ10 dz_13_10 sky130_fd_pr_reram__reram_cell area_ox=0.0676
XMn_13_10 dn_13_10 WL13 SL10 VSS sky130_fd_pr__nfet_g5v0d10v5 w=1 l=0.5
XRn_13_10 BLN10 dn_13_10 sky130_fd_pr_reram__reram_cell area_ox=0.0676
XMp_13_11 dp_13_11 WL13 SL11 VSS sky130_fd_pr__nfet_g5v0d10v5 w=1 l=0.5
XRp_13_11 BLP11 dp_13_11 sky130_fd_pr_reram__reram_cell area_ox=0.0676
XMz_13_11 dz_13_11 WL13 SL11 VSS sky130_fd_pr__nfet_g5v0d10v5 w=1 l=0.5
XRz_13_11 BLZ11 dz_13_11 sky130_fd_pr_reram__reram_cell area_ox=0.0676
XMn_13_11 dn_13_11 WL13 SL11 VSS sky130_fd_pr__nfet_g5v0d10v5 w=1 l=0.5
XRn_13_11 BLN11 dn_13_11 sky130_fd_pr_reram__reram_cell area_ox=0.0676
XMp_13_12 dp_13_12 WL13 SL12 VSS sky130_fd_pr__nfet_g5v0d10v5 w=1 l=0.5
XRp_13_12 BLP12 dp_13_12 sky130_fd_pr_reram__reram_cell area_ox=0.0676
XMz_13_12 dz_13_12 WL13 SL12 VSS sky130_fd_pr__nfet_g5v0d10v5 w=1 l=0.5
XRz_13_12 BLZ12 dz_13_12 sky130_fd_pr_reram__reram_cell area_ox=0.0676
XMn_13_12 dn_13_12 WL13 SL12 VSS sky130_fd_pr__nfet_g5v0d10v5 w=1 l=0.5
XRn_13_12 BLN12 dn_13_12 sky130_fd_pr_reram__reram_cell area_ox=0.0676
XMp_13_13 dp_13_13 WL13 SL13 VSS sky130_fd_pr__nfet_g5v0d10v5 w=1 l=0.5
XRp_13_13 BLP13 dp_13_13 sky130_fd_pr_reram__reram_cell area_ox=0.0676
XMz_13_13 dz_13_13 WL13 SL13 VSS sky130_fd_pr__nfet_g5v0d10v5 w=1 l=0.5
XRz_13_13 BLZ13 dz_13_13 sky130_fd_pr_reram__reram_cell area_ox=0.0676
XMn_13_13 dn_13_13 WL13 SL13 VSS sky130_fd_pr__nfet_g5v0d10v5 w=1 l=0.5
XRn_13_13 BLN13 dn_13_13 sky130_fd_pr_reram__reram_cell area_ox=0.0676
XMp_13_14 dp_13_14 WL13 SL14 VSS sky130_fd_pr__nfet_g5v0d10v5 w=1 l=0.5
XRp_13_14 BLP14 dp_13_14 sky130_fd_pr_reram__reram_cell area_ox=0.0676
XMz_13_14 dz_13_14 WL13 SL14 VSS sky130_fd_pr__nfet_g5v0d10v5 w=1 l=0.5
XRz_13_14 BLZ14 dz_13_14 sky130_fd_pr_reram__reram_cell area_ox=0.0676
XMn_13_14 dn_13_14 WL13 SL14 VSS sky130_fd_pr__nfet_g5v0d10v5 w=1 l=0.5
XRn_13_14 BLN14 dn_13_14 sky130_fd_pr_reram__reram_cell area_ox=0.0676
XMp_13_15 dp_13_15 WL13 SL15 VSS sky130_fd_pr__nfet_g5v0d10v5 w=1 l=0.5
XRp_13_15 BLP15 dp_13_15 sky130_fd_pr_reram__reram_cell area_ox=0.0676
XMz_13_15 dz_13_15 WL13 SL15 VSS sky130_fd_pr__nfet_g5v0d10v5 w=1 l=0.5
XRz_13_15 BLZ15 dz_13_15 sky130_fd_pr_reram__reram_cell area_ox=0.0676
XMn_13_15 dn_13_15 WL13 SL15 VSS sky130_fd_pr__nfet_g5v0d10v5 w=1 l=0.5
XRn_13_15 BLN15 dn_13_15 sky130_fd_pr_reram__reram_cell area_ox=0.0676
XMp_13_16 dp_13_16 WL13 SL16 VSS sky130_fd_pr__nfet_g5v0d10v5 w=1 l=0.5
XRp_13_16 BLP16 dp_13_16 sky130_fd_pr_reram__reram_cell area_ox=0.0676
XMz_13_16 dz_13_16 WL13 SL16 VSS sky130_fd_pr__nfet_g5v0d10v5 w=1 l=0.5
XRz_13_16 BLZ16 dz_13_16 sky130_fd_pr_reram__reram_cell area_ox=0.0676
XMn_13_16 dn_13_16 WL13 SL16 VSS sky130_fd_pr__nfet_g5v0d10v5 w=1 l=0.5
XRn_13_16 BLN16 dn_13_16 sky130_fd_pr_reram__reram_cell area_ox=0.0676
XMp_13_17 dp_13_17 WL13 SL17 VSS sky130_fd_pr__nfet_g5v0d10v5 w=1 l=0.5
XRp_13_17 BLP17 dp_13_17 sky130_fd_pr_reram__reram_cell area_ox=0.0676
XMz_13_17 dz_13_17 WL13 SL17 VSS sky130_fd_pr__nfet_g5v0d10v5 w=1 l=0.5
XRz_13_17 BLZ17 dz_13_17 sky130_fd_pr_reram__reram_cell area_ox=0.0676
XMn_13_17 dn_13_17 WL13 SL17 VSS sky130_fd_pr__nfet_g5v0d10v5 w=1 l=0.5
XRn_13_17 BLN17 dn_13_17 sky130_fd_pr_reram__reram_cell area_ox=0.0676
XMp_13_18 dp_13_18 WL13 SL18 VSS sky130_fd_pr__nfet_g5v0d10v5 w=1 l=0.5
XRp_13_18 BLP18 dp_13_18 sky130_fd_pr_reram__reram_cell area_ox=0.0676
XMz_13_18 dz_13_18 WL13 SL18 VSS sky130_fd_pr__nfet_g5v0d10v5 w=1 l=0.5
XRz_13_18 BLZ18 dz_13_18 sky130_fd_pr_reram__reram_cell area_ox=0.0676
XMn_13_18 dn_13_18 WL13 SL18 VSS sky130_fd_pr__nfet_g5v0d10v5 w=1 l=0.5
XRn_13_18 BLN18 dn_13_18 sky130_fd_pr_reram__reram_cell area_ox=0.0676
XMp_13_19 dp_13_19 WL13 SL19 VSS sky130_fd_pr__nfet_g5v0d10v5 w=1 l=0.5
XRp_13_19 BLP19 dp_13_19 sky130_fd_pr_reram__reram_cell area_ox=0.0676
XMz_13_19 dz_13_19 WL13 SL19 VSS sky130_fd_pr__nfet_g5v0d10v5 w=1 l=0.5
XRz_13_19 BLZ19 dz_13_19 sky130_fd_pr_reram__reram_cell area_ox=0.0676
XMn_13_19 dn_13_19 WL13 SL19 VSS sky130_fd_pr__nfet_g5v0d10v5 w=1 l=0.5
XRn_13_19 BLN19 dn_13_19 sky130_fd_pr_reram__reram_cell area_ox=0.0676
XMp_13_20 dp_13_20 WL13 SL20 VSS sky130_fd_pr__nfet_g5v0d10v5 w=1 l=0.5
XRp_13_20 BLP20 dp_13_20 sky130_fd_pr_reram__reram_cell area_ox=0.0676
XMz_13_20 dz_13_20 WL13 SL20 VSS sky130_fd_pr__nfet_g5v0d10v5 w=1 l=0.5
XRz_13_20 BLZ20 dz_13_20 sky130_fd_pr_reram__reram_cell area_ox=0.0676
XMn_13_20 dn_13_20 WL13 SL20 VSS sky130_fd_pr__nfet_g5v0d10v5 w=1 l=0.5
XRn_13_20 BLN20 dn_13_20 sky130_fd_pr_reram__reram_cell area_ox=0.0676
XMp_13_21 dp_13_21 WL13 SL21 VSS sky130_fd_pr__nfet_g5v0d10v5 w=1 l=0.5
XRp_13_21 BLP21 dp_13_21 sky130_fd_pr_reram__reram_cell area_ox=0.0676
XMz_13_21 dz_13_21 WL13 SL21 VSS sky130_fd_pr__nfet_g5v0d10v5 w=1 l=0.5
XRz_13_21 BLZ21 dz_13_21 sky130_fd_pr_reram__reram_cell area_ox=0.0676
XMn_13_21 dn_13_21 WL13 SL21 VSS sky130_fd_pr__nfet_g5v0d10v5 w=1 l=0.5
XRn_13_21 BLN21 dn_13_21 sky130_fd_pr_reram__reram_cell area_ox=0.0676
XMp_13_22 dp_13_22 WL13 SL22 VSS sky130_fd_pr__nfet_g5v0d10v5 w=1 l=0.5
XRp_13_22 BLP22 dp_13_22 sky130_fd_pr_reram__reram_cell area_ox=0.0676
XMz_13_22 dz_13_22 WL13 SL22 VSS sky130_fd_pr__nfet_g5v0d10v5 w=1 l=0.5
XRz_13_22 BLZ22 dz_13_22 sky130_fd_pr_reram__reram_cell area_ox=0.0676
XMn_13_22 dn_13_22 WL13 SL22 VSS sky130_fd_pr__nfet_g5v0d10v5 w=1 l=0.5
XRn_13_22 BLN22 dn_13_22 sky130_fd_pr_reram__reram_cell area_ox=0.0676
XMp_13_23 dp_13_23 WL13 SL23 VSS sky130_fd_pr__nfet_g5v0d10v5 w=1 l=0.5
XRp_13_23 BLP23 dp_13_23 sky130_fd_pr_reram__reram_cell area_ox=0.0676
XMz_13_23 dz_13_23 WL13 SL23 VSS sky130_fd_pr__nfet_g5v0d10v5 w=1 l=0.5
XRz_13_23 BLZ23 dz_13_23 sky130_fd_pr_reram__reram_cell area_ox=0.0676
XMn_13_23 dn_13_23 WL13 SL23 VSS sky130_fd_pr__nfet_g5v0d10v5 w=1 l=0.5
XRn_13_23 BLN23 dn_13_23 sky130_fd_pr_reram__reram_cell area_ox=0.0676
XMp_14_0 dp_14_0 WL14 SL0 VSS sky130_fd_pr__nfet_g5v0d10v5 w=1 l=0.5
XRp_14_0 BLP0 dp_14_0 sky130_fd_pr_reram__reram_cell area_ox=0.0676
XMz_14_0 dz_14_0 WL14 SL0 VSS sky130_fd_pr__nfet_g5v0d10v5 w=1 l=0.5
XRz_14_0 BLZ0 dz_14_0 sky130_fd_pr_reram__reram_cell area_ox=0.0676
XMn_14_0 dn_14_0 WL14 SL0 VSS sky130_fd_pr__nfet_g5v0d10v5 w=1 l=0.5
XRn_14_0 BLN0 dn_14_0 sky130_fd_pr_reram__reram_cell area_ox=0.0676
XMp_14_1 dp_14_1 WL14 SL1 VSS sky130_fd_pr__nfet_g5v0d10v5 w=1 l=0.5
XRp_14_1 BLP1 dp_14_1 sky130_fd_pr_reram__reram_cell area_ox=0.0676
XMz_14_1 dz_14_1 WL14 SL1 VSS sky130_fd_pr__nfet_g5v0d10v5 w=1 l=0.5
XRz_14_1 BLZ1 dz_14_1 sky130_fd_pr_reram__reram_cell area_ox=0.0676
XMn_14_1 dn_14_1 WL14 SL1 VSS sky130_fd_pr__nfet_g5v0d10v5 w=1 l=0.5
XRn_14_1 BLN1 dn_14_1 sky130_fd_pr_reram__reram_cell area_ox=0.0676
XMp_14_2 dp_14_2 WL14 SL2 VSS sky130_fd_pr__nfet_g5v0d10v5 w=1 l=0.5
XRp_14_2 BLP2 dp_14_2 sky130_fd_pr_reram__reram_cell area_ox=0.0676
XMz_14_2 dz_14_2 WL14 SL2 VSS sky130_fd_pr__nfet_g5v0d10v5 w=1 l=0.5
XRz_14_2 BLZ2 dz_14_2 sky130_fd_pr_reram__reram_cell area_ox=0.0676
XMn_14_2 dn_14_2 WL14 SL2 VSS sky130_fd_pr__nfet_g5v0d10v5 w=1 l=0.5
XRn_14_2 BLN2 dn_14_2 sky130_fd_pr_reram__reram_cell area_ox=0.0676
XMp_14_3 dp_14_3 WL14 SL3 VSS sky130_fd_pr__nfet_g5v0d10v5 w=1 l=0.5
XRp_14_3 BLP3 dp_14_3 sky130_fd_pr_reram__reram_cell area_ox=0.0676
XMz_14_3 dz_14_3 WL14 SL3 VSS sky130_fd_pr__nfet_g5v0d10v5 w=1 l=0.5
XRz_14_3 BLZ3 dz_14_3 sky130_fd_pr_reram__reram_cell area_ox=0.0676
XMn_14_3 dn_14_3 WL14 SL3 VSS sky130_fd_pr__nfet_g5v0d10v5 w=1 l=0.5
XRn_14_3 BLN3 dn_14_3 sky130_fd_pr_reram__reram_cell area_ox=0.0676
XMp_14_4 dp_14_4 WL14 SL4 VSS sky130_fd_pr__nfet_g5v0d10v5 w=1 l=0.5
XRp_14_4 BLP4 dp_14_4 sky130_fd_pr_reram__reram_cell area_ox=0.0676
XMz_14_4 dz_14_4 WL14 SL4 VSS sky130_fd_pr__nfet_g5v0d10v5 w=1 l=0.5
XRz_14_4 BLZ4 dz_14_4 sky130_fd_pr_reram__reram_cell area_ox=0.0676
XMn_14_4 dn_14_4 WL14 SL4 VSS sky130_fd_pr__nfet_g5v0d10v5 w=1 l=0.5
XRn_14_4 BLN4 dn_14_4 sky130_fd_pr_reram__reram_cell area_ox=0.0676
XMp_14_5 dp_14_5 WL14 SL5 VSS sky130_fd_pr__nfet_g5v0d10v5 w=1 l=0.5
XRp_14_5 BLP5 dp_14_5 sky130_fd_pr_reram__reram_cell area_ox=0.0676
XMz_14_5 dz_14_5 WL14 SL5 VSS sky130_fd_pr__nfet_g5v0d10v5 w=1 l=0.5
XRz_14_5 BLZ5 dz_14_5 sky130_fd_pr_reram__reram_cell area_ox=0.0676
XMn_14_5 dn_14_5 WL14 SL5 VSS sky130_fd_pr__nfet_g5v0d10v5 w=1 l=0.5
XRn_14_5 BLN5 dn_14_5 sky130_fd_pr_reram__reram_cell area_ox=0.0676
XMp_14_6 dp_14_6 WL14 SL6 VSS sky130_fd_pr__nfet_g5v0d10v5 w=1 l=0.5
XRp_14_6 BLP6 dp_14_6 sky130_fd_pr_reram__reram_cell area_ox=0.0676
XMz_14_6 dz_14_6 WL14 SL6 VSS sky130_fd_pr__nfet_g5v0d10v5 w=1 l=0.5
XRz_14_6 BLZ6 dz_14_6 sky130_fd_pr_reram__reram_cell area_ox=0.0676
XMn_14_6 dn_14_6 WL14 SL6 VSS sky130_fd_pr__nfet_g5v0d10v5 w=1 l=0.5
XRn_14_6 BLN6 dn_14_6 sky130_fd_pr_reram__reram_cell area_ox=0.0676
XMp_14_7 dp_14_7 WL14 SL7 VSS sky130_fd_pr__nfet_g5v0d10v5 w=1 l=0.5
XRp_14_7 BLP7 dp_14_7 sky130_fd_pr_reram__reram_cell area_ox=0.0676
XMz_14_7 dz_14_7 WL14 SL7 VSS sky130_fd_pr__nfet_g5v0d10v5 w=1 l=0.5
XRz_14_7 BLZ7 dz_14_7 sky130_fd_pr_reram__reram_cell area_ox=0.0676
XMn_14_7 dn_14_7 WL14 SL7 VSS sky130_fd_pr__nfet_g5v0d10v5 w=1 l=0.5
XRn_14_7 BLN7 dn_14_7 sky130_fd_pr_reram__reram_cell area_ox=0.0676
XMp_14_8 dp_14_8 WL14 SL8 VSS sky130_fd_pr__nfet_g5v0d10v5 w=1 l=0.5
XRp_14_8 BLP8 dp_14_8 sky130_fd_pr_reram__reram_cell area_ox=0.0676
XMz_14_8 dz_14_8 WL14 SL8 VSS sky130_fd_pr__nfet_g5v0d10v5 w=1 l=0.5
XRz_14_8 BLZ8 dz_14_8 sky130_fd_pr_reram__reram_cell area_ox=0.0676
XMn_14_8 dn_14_8 WL14 SL8 VSS sky130_fd_pr__nfet_g5v0d10v5 w=1 l=0.5
XRn_14_8 BLN8 dn_14_8 sky130_fd_pr_reram__reram_cell area_ox=0.0676
XMp_14_9 dp_14_9 WL14 SL9 VSS sky130_fd_pr__nfet_g5v0d10v5 w=1 l=0.5
XRp_14_9 BLP9 dp_14_9 sky130_fd_pr_reram__reram_cell area_ox=0.0676
XMz_14_9 dz_14_9 WL14 SL9 VSS sky130_fd_pr__nfet_g5v0d10v5 w=1 l=0.5
XRz_14_9 BLZ9 dz_14_9 sky130_fd_pr_reram__reram_cell area_ox=0.0676
XMn_14_9 dn_14_9 WL14 SL9 VSS sky130_fd_pr__nfet_g5v0d10v5 w=1 l=0.5
XRn_14_9 BLN9 dn_14_9 sky130_fd_pr_reram__reram_cell area_ox=0.0676
XMp_14_10 dp_14_10 WL14 SL10 VSS sky130_fd_pr__nfet_g5v0d10v5 w=1 l=0.5
XRp_14_10 BLP10 dp_14_10 sky130_fd_pr_reram__reram_cell area_ox=0.0676
XMz_14_10 dz_14_10 WL14 SL10 VSS sky130_fd_pr__nfet_g5v0d10v5 w=1 l=0.5
XRz_14_10 BLZ10 dz_14_10 sky130_fd_pr_reram__reram_cell area_ox=0.0676
XMn_14_10 dn_14_10 WL14 SL10 VSS sky130_fd_pr__nfet_g5v0d10v5 w=1 l=0.5
XRn_14_10 BLN10 dn_14_10 sky130_fd_pr_reram__reram_cell area_ox=0.0676
XMp_14_11 dp_14_11 WL14 SL11 VSS sky130_fd_pr__nfet_g5v0d10v5 w=1 l=0.5
XRp_14_11 BLP11 dp_14_11 sky130_fd_pr_reram__reram_cell area_ox=0.0676
XMz_14_11 dz_14_11 WL14 SL11 VSS sky130_fd_pr__nfet_g5v0d10v5 w=1 l=0.5
XRz_14_11 BLZ11 dz_14_11 sky130_fd_pr_reram__reram_cell area_ox=0.0676
XMn_14_11 dn_14_11 WL14 SL11 VSS sky130_fd_pr__nfet_g5v0d10v5 w=1 l=0.5
XRn_14_11 BLN11 dn_14_11 sky130_fd_pr_reram__reram_cell area_ox=0.0676
XMp_14_12 dp_14_12 WL14 SL12 VSS sky130_fd_pr__nfet_g5v0d10v5 w=1 l=0.5
XRp_14_12 BLP12 dp_14_12 sky130_fd_pr_reram__reram_cell area_ox=0.0676
XMz_14_12 dz_14_12 WL14 SL12 VSS sky130_fd_pr__nfet_g5v0d10v5 w=1 l=0.5
XRz_14_12 BLZ12 dz_14_12 sky130_fd_pr_reram__reram_cell area_ox=0.0676
XMn_14_12 dn_14_12 WL14 SL12 VSS sky130_fd_pr__nfet_g5v0d10v5 w=1 l=0.5
XRn_14_12 BLN12 dn_14_12 sky130_fd_pr_reram__reram_cell area_ox=0.0676
XMp_14_13 dp_14_13 WL14 SL13 VSS sky130_fd_pr__nfet_g5v0d10v5 w=1 l=0.5
XRp_14_13 BLP13 dp_14_13 sky130_fd_pr_reram__reram_cell area_ox=0.0676
XMz_14_13 dz_14_13 WL14 SL13 VSS sky130_fd_pr__nfet_g5v0d10v5 w=1 l=0.5
XRz_14_13 BLZ13 dz_14_13 sky130_fd_pr_reram__reram_cell area_ox=0.0676
XMn_14_13 dn_14_13 WL14 SL13 VSS sky130_fd_pr__nfet_g5v0d10v5 w=1 l=0.5
XRn_14_13 BLN13 dn_14_13 sky130_fd_pr_reram__reram_cell area_ox=0.0676
XMp_14_14 dp_14_14 WL14 SL14 VSS sky130_fd_pr__nfet_g5v0d10v5 w=1 l=0.5
XRp_14_14 BLP14 dp_14_14 sky130_fd_pr_reram__reram_cell area_ox=0.0676
XMz_14_14 dz_14_14 WL14 SL14 VSS sky130_fd_pr__nfet_g5v0d10v5 w=1 l=0.5
XRz_14_14 BLZ14 dz_14_14 sky130_fd_pr_reram__reram_cell area_ox=0.0676
XMn_14_14 dn_14_14 WL14 SL14 VSS sky130_fd_pr__nfet_g5v0d10v5 w=1 l=0.5
XRn_14_14 BLN14 dn_14_14 sky130_fd_pr_reram__reram_cell area_ox=0.0676
XMp_14_15 dp_14_15 WL14 SL15 VSS sky130_fd_pr__nfet_g5v0d10v5 w=1 l=0.5
XRp_14_15 BLP15 dp_14_15 sky130_fd_pr_reram__reram_cell area_ox=0.0676
XMz_14_15 dz_14_15 WL14 SL15 VSS sky130_fd_pr__nfet_g5v0d10v5 w=1 l=0.5
XRz_14_15 BLZ15 dz_14_15 sky130_fd_pr_reram__reram_cell area_ox=0.0676
XMn_14_15 dn_14_15 WL14 SL15 VSS sky130_fd_pr__nfet_g5v0d10v5 w=1 l=0.5
XRn_14_15 BLN15 dn_14_15 sky130_fd_pr_reram__reram_cell area_ox=0.0676
XMp_14_16 dp_14_16 WL14 SL16 VSS sky130_fd_pr__nfet_g5v0d10v5 w=1 l=0.5
XRp_14_16 BLP16 dp_14_16 sky130_fd_pr_reram__reram_cell area_ox=0.0676
XMz_14_16 dz_14_16 WL14 SL16 VSS sky130_fd_pr__nfet_g5v0d10v5 w=1 l=0.5
XRz_14_16 BLZ16 dz_14_16 sky130_fd_pr_reram__reram_cell area_ox=0.0676
XMn_14_16 dn_14_16 WL14 SL16 VSS sky130_fd_pr__nfet_g5v0d10v5 w=1 l=0.5
XRn_14_16 BLN16 dn_14_16 sky130_fd_pr_reram__reram_cell area_ox=0.0676
XMp_14_17 dp_14_17 WL14 SL17 VSS sky130_fd_pr__nfet_g5v0d10v5 w=1 l=0.5
XRp_14_17 BLP17 dp_14_17 sky130_fd_pr_reram__reram_cell area_ox=0.0676
XMz_14_17 dz_14_17 WL14 SL17 VSS sky130_fd_pr__nfet_g5v0d10v5 w=1 l=0.5
XRz_14_17 BLZ17 dz_14_17 sky130_fd_pr_reram__reram_cell area_ox=0.0676
XMn_14_17 dn_14_17 WL14 SL17 VSS sky130_fd_pr__nfet_g5v0d10v5 w=1 l=0.5
XRn_14_17 BLN17 dn_14_17 sky130_fd_pr_reram__reram_cell area_ox=0.0676
XMp_14_18 dp_14_18 WL14 SL18 VSS sky130_fd_pr__nfet_g5v0d10v5 w=1 l=0.5
XRp_14_18 BLP18 dp_14_18 sky130_fd_pr_reram__reram_cell area_ox=0.0676
XMz_14_18 dz_14_18 WL14 SL18 VSS sky130_fd_pr__nfet_g5v0d10v5 w=1 l=0.5
XRz_14_18 BLZ18 dz_14_18 sky130_fd_pr_reram__reram_cell area_ox=0.0676
XMn_14_18 dn_14_18 WL14 SL18 VSS sky130_fd_pr__nfet_g5v0d10v5 w=1 l=0.5
XRn_14_18 BLN18 dn_14_18 sky130_fd_pr_reram__reram_cell area_ox=0.0676
XMp_14_19 dp_14_19 WL14 SL19 VSS sky130_fd_pr__nfet_g5v0d10v5 w=1 l=0.5
XRp_14_19 BLP19 dp_14_19 sky130_fd_pr_reram__reram_cell area_ox=0.0676
XMz_14_19 dz_14_19 WL14 SL19 VSS sky130_fd_pr__nfet_g5v0d10v5 w=1 l=0.5
XRz_14_19 BLZ19 dz_14_19 sky130_fd_pr_reram__reram_cell area_ox=0.0676
XMn_14_19 dn_14_19 WL14 SL19 VSS sky130_fd_pr__nfet_g5v0d10v5 w=1 l=0.5
XRn_14_19 BLN19 dn_14_19 sky130_fd_pr_reram__reram_cell area_ox=0.0676
XMp_14_20 dp_14_20 WL14 SL20 VSS sky130_fd_pr__nfet_g5v0d10v5 w=1 l=0.5
XRp_14_20 BLP20 dp_14_20 sky130_fd_pr_reram__reram_cell area_ox=0.0676
XMz_14_20 dz_14_20 WL14 SL20 VSS sky130_fd_pr__nfet_g5v0d10v5 w=1 l=0.5
XRz_14_20 BLZ20 dz_14_20 sky130_fd_pr_reram__reram_cell area_ox=0.0676
XMn_14_20 dn_14_20 WL14 SL20 VSS sky130_fd_pr__nfet_g5v0d10v5 w=1 l=0.5
XRn_14_20 BLN20 dn_14_20 sky130_fd_pr_reram__reram_cell area_ox=0.0676
XMp_14_21 dp_14_21 WL14 SL21 VSS sky130_fd_pr__nfet_g5v0d10v5 w=1 l=0.5
XRp_14_21 BLP21 dp_14_21 sky130_fd_pr_reram__reram_cell area_ox=0.0676
XMz_14_21 dz_14_21 WL14 SL21 VSS sky130_fd_pr__nfet_g5v0d10v5 w=1 l=0.5
XRz_14_21 BLZ21 dz_14_21 sky130_fd_pr_reram__reram_cell area_ox=0.0676
XMn_14_21 dn_14_21 WL14 SL21 VSS sky130_fd_pr__nfet_g5v0d10v5 w=1 l=0.5
XRn_14_21 BLN21 dn_14_21 sky130_fd_pr_reram__reram_cell area_ox=0.0676
XMp_14_22 dp_14_22 WL14 SL22 VSS sky130_fd_pr__nfet_g5v0d10v5 w=1 l=0.5
XRp_14_22 BLP22 dp_14_22 sky130_fd_pr_reram__reram_cell area_ox=0.0676
XMz_14_22 dz_14_22 WL14 SL22 VSS sky130_fd_pr__nfet_g5v0d10v5 w=1 l=0.5
XRz_14_22 BLZ22 dz_14_22 sky130_fd_pr_reram__reram_cell area_ox=0.0676
XMn_14_22 dn_14_22 WL14 SL22 VSS sky130_fd_pr__nfet_g5v0d10v5 w=1 l=0.5
XRn_14_22 BLN22 dn_14_22 sky130_fd_pr_reram__reram_cell area_ox=0.0676
XMp_14_23 dp_14_23 WL14 SL23 VSS sky130_fd_pr__nfet_g5v0d10v5 w=1 l=0.5
XRp_14_23 BLP23 dp_14_23 sky130_fd_pr_reram__reram_cell area_ox=0.0676
XMz_14_23 dz_14_23 WL14 SL23 VSS sky130_fd_pr__nfet_g5v0d10v5 w=1 l=0.5
XRz_14_23 BLZ23 dz_14_23 sky130_fd_pr_reram__reram_cell area_ox=0.0676
XMn_14_23 dn_14_23 WL14 SL23 VSS sky130_fd_pr__nfet_g5v0d10v5 w=1 l=0.5
XRn_14_23 BLN23 dn_14_23 sky130_fd_pr_reram__reram_cell area_ox=0.0676
XMp_15_0 dp_15_0 WL15 SL0 VSS sky130_fd_pr__nfet_g5v0d10v5 w=1 l=0.5
XRp_15_0 BLP0 dp_15_0 sky130_fd_pr_reram__reram_cell area_ox=0.0676
XMz_15_0 dz_15_0 WL15 SL0 VSS sky130_fd_pr__nfet_g5v0d10v5 w=1 l=0.5
XRz_15_0 BLZ0 dz_15_0 sky130_fd_pr_reram__reram_cell area_ox=0.0676
XMn_15_0 dn_15_0 WL15 SL0 VSS sky130_fd_pr__nfet_g5v0d10v5 w=1 l=0.5
XRn_15_0 BLN0 dn_15_0 sky130_fd_pr_reram__reram_cell area_ox=0.0676
XMp_15_1 dp_15_1 WL15 SL1 VSS sky130_fd_pr__nfet_g5v0d10v5 w=1 l=0.5
XRp_15_1 BLP1 dp_15_1 sky130_fd_pr_reram__reram_cell area_ox=0.0676
XMz_15_1 dz_15_1 WL15 SL1 VSS sky130_fd_pr__nfet_g5v0d10v5 w=1 l=0.5
XRz_15_1 BLZ1 dz_15_1 sky130_fd_pr_reram__reram_cell area_ox=0.0676
XMn_15_1 dn_15_1 WL15 SL1 VSS sky130_fd_pr__nfet_g5v0d10v5 w=1 l=0.5
XRn_15_1 BLN1 dn_15_1 sky130_fd_pr_reram__reram_cell area_ox=0.0676
XMp_15_2 dp_15_2 WL15 SL2 VSS sky130_fd_pr__nfet_g5v0d10v5 w=1 l=0.5
XRp_15_2 BLP2 dp_15_2 sky130_fd_pr_reram__reram_cell area_ox=0.0676
XMz_15_2 dz_15_2 WL15 SL2 VSS sky130_fd_pr__nfet_g5v0d10v5 w=1 l=0.5
XRz_15_2 BLZ2 dz_15_2 sky130_fd_pr_reram__reram_cell area_ox=0.0676
XMn_15_2 dn_15_2 WL15 SL2 VSS sky130_fd_pr__nfet_g5v0d10v5 w=1 l=0.5
XRn_15_2 BLN2 dn_15_2 sky130_fd_pr_reram__reram_cell area_ox=0.0676
XMp_15_3 dp_15_3 WL15 SL3 VSS sky130_fd_pr__nfet_g5v0d10v5 w=1 l=0.5
XRp_15_3 BLP3 dp_15_3 sky130_fd_pr_reram__reram_cell area_ox=0.0676
XMz_15_3 dz_15_3 WL15 SL3 VSS sky130_fd_pr__nfet_g5v0d10v5 w=1 l=0.5
XRz_15_3 BLZ3 dz_15_3 sky130_fd_pr_reram__reram_cell area_ox=0.0676
XMn_15_3 dn_15_3 WL15 SL3 VSS sky130_fd_pr__nfet_g5v0d10v5 w=1 l=0.5
XRn_15_3 BLN3 dn_15_3 sky130_fd_pr_reram__reram_cell area_ox=0.0676
XMp_15_4 dp_15_4 WL15 SL4 VSS sky130_fd_pr__nfet_g5v0d10v5 w=1 l=0.5
XRp_15_4 BLP4 dp_15_4 sky130_fd_pr_reram__reram_cell area_ox=0.0676
XMz_15_4 dz_15_4 WL15 SL4 VSS sky130_fd_pr__nfet_g5v0d10v5 w=1 l=0.5
XRz_15_4 BLZ4 dz_15_4 sky130_fd_pr_reram__reram_cell area_ox=0.0676
XMn_15_4 dn_15_4 WL15 SL4 VSS sky130_fd_pr__nfet_g5v0d10v5 w=1 l=0.5
XRn_15_4 BLN4 dn_15_4 sky130_fd_pr_reram__reram_cell area_ox=0.0676
XMp_15_5 dp_15_5 WL15 SL5 VSS sky130_fd_pr__nfet_g5v0d10v5 w=1 l=0.5
XRp_15_5 BLP5 dp_15_5 sky130_fd_pr_reram__reram_cell area_ox=0.0676
XMz_15_5 dz_15_5 WL15 SL5 VSS sky130_fd_pr__nfet_g5v0d10v5 w=1 l=0.5
XRz_15_5 BLZ5 dz_15_5 sky130_fd_pr_reram__reram_cell area_ox=0.0676
XMn_15_5 dn_15_5 WL15 SL5 VSS sky130_fd_pr__nfet_g5v0d10v5 w=1 l=0.5
XRn_15_5 BLN5 dn_15_5 sky130_fd_pr_reram__reram_cell area_ox=0.0676
XMp_15_6 dp_15_6 WL15 SL6 VSS sky130_fd_pr__nfet_g5v0d10v5 w=1 l=0.5
XRp_15_6 BLP6 dp_15_6 sky130_fd_pr_reram__reram_cell area_ox=0.0676
XMz_15_6 dz_15_6 WL15 SL6 VSS sky130_fd_pr__nfet_g5v0d10v5 w=1 l=0.5
XRz_15_6 BLZ6 dz_15_6 sky130_fd_pr_reram__reram_cell area_ox=0.0676
XMn_15_6 dn_15_6 WL15 SL6 VSS sky130_fd_pr__nfet_g5v0d10v5 w=1 l=0.5
XRn_15_6 BLN6 dn_15_6 sky130_fd_pr_reram__reram_cell area_ox=0.0676
XMp_15_7 dp_15_7 WL15 SL7 VSS sky130_fd_pr__nfet_g5v0d10v5 w=1 l=0.5
XRp_15_7 BLP7 dp_15_7 sky130_fd_pr_reram__reram_cell area_ox=0.0676
XMz_15_7 dz_15_7 WL15 SL7 VSS sky130_fd_pr__nfet_g5v0d10v5 w=1 l=0.5
XRz_15_7 BLZ7 dz_15_7 sky130_fd_pr_reram__reram_cell area_ox=0.0676
XMn_15_7 dn_15_7 WL15 SL7 VSS sky130_fd_pr__nfet_g5v0d10v5 w=1 l=0.5
XRn_15_7 BLN7 dn_15_7 sky130_fd_pr_reram__reram_cell area_ox=0.0676
XMp_15_8 dp_15_8 WL15 SL8 VSS sky130_fd_pr__nfet_g5v0d10v5 w=1 l=0.5
XRp_15_8 BLP8 dp_15_8 sky130_fd_pr_reram__reram_cell area_ox=0.0676
XMz_15_8 dz_15_8 WL15 SL8 VSS sky130_fd_pr__nfet_g5v0d10v5 w=1 l=0.5
XRz_15_8 BLZ8 dz_15_8 sky130_fd_pr_reram__reram_cell area_ox=0.0676
XMn_15_8 dn_15_8 WL15 SL8 VSS sky130_fd_pr__nfet_g5v0d10v5 w=1 l=0.5
XRn_15_8 BLN8 dn_15_8 sky130_fd_pr_reram__reram_cell area_ox=0.0676
XMp_15_9 dp_15_9 WL15 SL9 VSS sky130_fd_pr__nfet_g5v0d10v5 w=1 l=0.5
XRp_15_9 BLP9 dp_15_9 sky130_fd_pr_reram__reram_cell area_ox=0.0676
XMz_15_9 dz_15_9 WL15 SL9 VSS sky130_fd_pr__nfet_g5v0d10v5 w=1 l=0.5
XRz_15_9 BLZ9 dz_15_9 sky130_fd_pr_reram__reram_cell area_ox=0.0676
XMn_15_9 dn_15_9 WL15 SL9 VSS sky130_fd_pr__nfet_g5v0d10v5 w=1 l=0.5
XRn_15_9 BLN9 dn_15_9 sky130_fd_pr_reram__reram_cell area_ox=0.0676
XMp_15_10 dp_15_10 WL15 SL10 VSS sky130_fd_pr__nfet_g5v0d10v5 w=1 l=0.5
XRp_15_10 BLP10 dp_15_10 sky130_fd_pr_reram__reram_cell area_ox=0.0676
XMz_15_10 dz_15_10 WL15 SL10 VSS sky130_fd_pr__nfet_g5v0d10v5 w=1 l=0.5
XRz_15_10 BLZ10 dz_15_10 sky130_fd_pr_reram__reram_cell area_ox=0.0676
XMn_15_10 dn_15_10 WL15 SL10 VSS sky130_fd_pr__nfet_g5v0d10v5 w=1 l=0.5
XRn_15_10 BLN10 dn_15_10 sky130_fd_pr_reram__reram_cell area_ox=0.0676
XMp_15_11 dp_15_11 WL15 SL11 VSS sky130_fd_pr__nfet_g5v0d10v5 w=1 l=0.5
XRp_15_11 BLP11 dp_15_11 sky130_fd_pr_reram__reram_cell area_ox=0.0676
XMz_15_11 dz_15_11 WL15 SL11 VSS sky130_fd_pr__nfet_g5v0d10v5 w=1 l=0.5
XRz_15_11 BLZ11 dz_15_11 sky130_fd_pr_reram__reram_cell area_ox=0.0676
XMn_15_11 dn_15_11 WL15 SL11 VSS sky130_fd_pr__nfet_g5v0d10v5 w=1 l=0.5
XRn_15_11 BLN11 dn_15_11 sky130_fd_pr_reram__reram_cell area_ox=0.0676
XMp_15_12 dp_15_12 WL15 SL12 VSS sky130_fd_pr__nfet_g5v0d10v5 w=1 l=0.5
XRp_15_12 BLP12 dp_15_12 sky130_fd_pr_reram__reram_cell area_ox=0.0676
XMz_15_12 dz_15_12 WL15 SL12 VSS sky130_fd_pr__nfet_g5v0d10v5 w=1 l=0.5
XRz_15_12 BLZ12 dz_15_12 sky130_fd_pr_reram__reram_cell area_ox=0.0676
XMn_15_12 dn_15_12 WL15 SL12 VSS sky130_fd_pr__nfet_g5v0d10v5 w=1 l=0.5
XRn_15_12 BLN12 dn_15_12 sky130_fd_pr_reram__reram_cell area_ox=0.0676
XMp_15_13 dp_15_13 WL15 SL13 VSS sky130_fd_pr__nfet_g5v0d10v5 w=1 l=0.5
XRp_15_13 BLP13 dp_15_13 sky130_fd_pr_reram__reram_cell area_ox=0.0676
XMz_15_13 dz_15_13 WL15 SL13 VSS sky130_fd_pr__nfet_g5v0d10v5 w=1 l=0.5
XRz_15_13 BLZ13 dz_15_13 sky130_fd_pr_reram__reram_cell area_ox=0.0676
XMn_15_13 dn_15_13 WL15 SL13 VSS sky130_fd_pr__nfet_g5v0d10v5 w=1 l=0.5
XRn_15_13 BLN13 dn_15_13 sky130_fd_pr_reram__reram_cell area_ox=0.0676
XMp_15_14 dp_15_14 WL15 SL14 VSS sky130_fd_pr__nfet_g5v0d10v5 w=1 l=0.5
XRp_15_14 BLP14 dp_15_14 sky130_fd_pr_reram__reram_cell area_ox=0.0676
XMz_15_14 dz_15_14 WL15 SL14 VSS sky130_fd_pr__nfet_g5v0d10v5 w=1 l=0.5
XRz_15_14 BLZ14 dz_15_14 sky130_fd_pr_reram__reram_cell area_ox=0.0676
XMn_15_14 dn_15_14 WL15 SL14 VSS sky130_fd_pr__nfet_g5v0d10v5 w=1 l=0.5
XRn_15_14 BLN14 dn_15_14 sky130_fd_pr_reram__reram_cell area_ox=0.0676
XMp_15_15 dp_15_15 WL15 SL15 VSS sky130_fd_pr__nfet_g5v0d10v5 w=1 l=0.5
XRp_15_15 BLP15 dp_15_15 sky130_fd_pr_reram__reram_cell area_ox=0.0676
XMz_15_15 dz_15_15 WL15 SL15 VSS sky130_fd_pr__nfet_g5v0d10v5 w=1 l=0.5
XRz_15_15 BLZ15 dz_15_15 sky130_fd_pr_reram__reram_cell area_ox=0.0676
XMn_15_15 dn_15_15 WL15 SL15 VSS sky130_fd_pr__nfet_g5v0d10v5 w=1 l=0.5
XRn_15_15 BLN15 dn_15_15 sky130_fd_pr_reram__reram_cell area_ox=0.0676
XMp_15_16 dp_15_16 WL15 SL16 VSS sky130_fd_pr__nfet_g5v0d10v5 w=1 l=0.5
XRp_15_16 BLP16 dp_15_16 sky130_fd_pr_reram__reram_cell area_ox=0.0676
XMz_15_16 dz_15_16 WL15 SL16 VSS sky130_fd_pr__nfet_g5v0d10v5 w=1 l=0.5
XRz_15_16 BLZ16 dz_15_16 sky130_fd_pr_reram__reram_cell area_ox=0.0676
XMn_15_16 dn_15_16 WL15 SL16 VSS sky130_fd_pr__nfet_g5v0d10v5 w=1 l=0.5
XRn_15_16 BLN16 dn_15_16 sky130_fd_pr_reram__reram_cell area_ox=0.0676
XMp_15_17 dp_15_17 WL15 SL17 VSS sky130_fd_pr__nfet_g5v0d10v5 w=1 l=0.5
XRp_15_17 BLP17 dp_15_17 sky130_fd_pr_reram__reram_cell area_ox=0.0676
XMz_15_17 dz_15_17 WL15 SL17 VSS sky130_fd_pr__nfet_g5v0d10v5 w=1 l=0.5
XRz_15_17 BLZ17 dz_15_17 sky130_fd_pr_reram__reram_cell area_ox=0.0676
XMn_15_17 dn_15_17 WL15 SL17 VSS sky130_fd_pr__nfet_g5v0d10v5 w=1 l=0.5
XRn_15_17 BLN17 dn_15_17 sky130_fd_pr_reram__reram_cell area_ox=0.0676
XMp_15_18 dp_15_18 WL15 SL18 VSS sky130_fd_pr__nfet_g5v0d10v5 w=1 l=0.5
XRp_15_18 BLP18 dp_15_18 sky130_fd_pr_reram__reram_cell area_ox=0.0676
XMz_15_18 dz_15_18 WL15 SL18 VSS sky130_fd_pr__nfet_g5v0d10v5 w=1 l=0.5
XRz_15_18 BLZ18 dz_15_18 sky130_fd_pr_reram__reram_cell area_ox=0.0676
XMn_15_18 dn_15_18 WL15 SL18 VSS sky130_fd_pr__nfet_g5v0d10v5 w=1 l=0.5
XRn_15_18 BLN18 dn_15_18 sky130_fd_pr_reram__reram_cell area_ox=0.0676
XMp_15_19 dp_15_19 WL15 SL19 VSS sky130_fd_pr__nfet_g5v0d10v5 w=1 l=0.5
XRp_15_19 BLP19 dp_15_19 sky130_fd_pr_reram__reram_cell area_ox=0.0676
XMz_15_19 dz_15_19 WL15 SL19 VSS sky130_fd_pr__nfet_g5v0d10v5 w=1 l=0.5
XRz_15_19 BLZ19 dz_15_19 sky130_fd_pr_reram__reram_cell area_ox=0.0676
XMn_15_19 dn_15_19 WL15 SL19 VSS sky130_fd_pr__nfet_g5v0d10v5 w=1 l=0.5
XRn_15_19 BLN19 dn_15_19 sky130_fd_pr_reram__reram_cell area_ox=0.0676
XMp_15_20 dp_15_20 WL15 SL20 VSS sky130_fd_pr__nfet_g5v0d10v5 w=1 l=0.5
XRp_15_20 BLP20 dp_15_20 sky130_fd_pr_reram__reram_cell area_ox=0.0676
XMz_15_20 dz_15_20 WL15 SL20 VSS sky130_fd_pr__nfet_g5v0d10v5 w=1 l=0.5
XRz_15_20 BLZ20 dz_15_20 sky130_fd_pr_reram__reram_cell area_ox=0.0676
XMn_15_20 dn_15_20 WL15 SL20 VSS sky130_fd_pr__nfet_g5v0d10v5 w=1 l=0.5
XRn_15_20 BLN20 dn_15_20 sky130_fd_pr_reram__reram_cell area_ox=0.0676
XMp_15_21 dp_15_21 WL15 SL21 VSS sky130_fd_pr__nfet_g5v0d10v5 w=1 l=0.5
XRp_15_21 BLP21 dp_15_21 sky130_fd_pr_reram__reram_cell area_ox=0.0676
XMz_15_21 dz_15_21 WL15 SL21 VSS sky130_fd_pr__nfet_g5v0d10v5 w=1 l=0.5
XRz_15_21 BLZ21 dz_15_21 sky130_fd_pr_reram__reram_cell area_ox=0.0676
XMn_15_21 dn_15_21 WL15 SL21 VSS sky130_fd_pr__nfet_g5v0d10v5 w=1 l=0.5
XRn_15_21 BLN21 dn_15_21 sky130_fd_pr_reram__reram_cell area_ox=0.0676
XMp_15_22 dp_15_22 WL15 SL22 VSS sky130_fd_pr__nfet_g5v0d10v5 w=1 l=0.5
XRp_15_22 BLP22 dp_15_22 sky130_fd_pr_reram__reram_cell area_ox=0.0676
XMz_15_22 dz_15_22 WL15 SL22 VSS sky130_fd_pr__nfet_g5v0d10v5 w=1 l=0.5
XRz_15_22 BLZ22 dz_15_22 sky130_fd_pr_reram__reram_cell area_ox=0.0676
XMn_15_22 dn_15_22 WL15 SL22 VSS sky130_fd_pr__nfet_g5v0d10v5 w=1 l=0.5
XRn_15_22 BLN22 dn_15_22 sky130_fd_pr_reram__reram_cell area_ox=0.0676
XMp_15_23 dp_15_23 WL15 SL23 VSS sky130_fd_pr__nfet_g5v0d10v5 w=1 l=0.5
XRp_15_23 BLP23 dp_15_23 sky130_fd_pr_reram__reram_cell area_ox=0.0676
XMz_15_23 dz_15_23 WL15 SL23 VSS sky130_fd_pr__nfet_g5v0d10v5 w=1 l=0.5
XRz_15_23 BLZ23 dz_15_23 sky130_fd_pr_reram__reram_cell area_ox=0.0676
XMn_15_23 dn_15_23 WL15 SL23 VSS sky130_fd_pr__nfet_g5v0d10v5 w=1 l=0.5
XRn_15_23 BLN23 dn_15_23 sky130_fd_pr_reram__reram_cell area_ox=0.0676
XMp_16_0 dp_16_0 WL16 SL0 VSS sky130_fd_pr__nfet_g5v0d10v5 w=1 l=0.5
XRp_16_0 BLP0 dp_16_0 sky130_fd_pr_reram__reram_cell area_ox=0.0676
XMz_16_0 dz_16_0 WL16 SL0 VSS sky130_fd_pr__nfet_g5v0d10v5 w=1 l=0.5
XRz_16_0 BLZ0 dz_16_0 sky130_fd_pr_reram__reram_cell area_ox=0.0676
XMn_16_0 dn_16_0 WL16 SL0 VSS sky130_fd_pr__nfet_g5v0d10v5 w=1 l=0.5
XRn_16_0 BLN0 dn_16_0 sky130_fd_pr_reram__reram_cell area_ox=0.0676
XMp_16_1 dp_16_1 WL16 SL1 VSS sky130_fd_pr__nfet_g5v0d10v5 w=1 l=0.5
XRp_16_1 BLP1 dp_16_1 sky130_fd_pr_reram__reram_cell area_ox=0.0676
XMz_16_1 dz_16_1 WL16 SL1 VSS sky130_fd_pr__nfet_g5v0d10v5 w=1 l=0.5
XRz_16_1 BLZ1 dz_16_1 sky130_fd_pr_reram__reram_cell area_ox=0.0676
XMn_16_1 dn_16_1 WL16 SL1 VSS sky130_fd_pr__nfet_g5v0d10v5 w=1 l=0.5
XRn_16_1 BLN1 dn_16_1 sky130_fd_pr_reram__reram_cell area_ox=0.0676
XMp_16_2 dp_16_2 WL16 SL2 VSS sky130_fd_pr__nfet_g5v0d10v5 w=1 l=0.5
XRp_16_2 BLP2 dp_16_2 sky130_fd_pr_reram__reram_cell area_ox=0.0676
XMz_16_2 dz_16_2 WL16 SL2 VSS sky130_fd_pr__nfet_g5v0d10v5 w=1 l=0.5
XRz_16_2 BLZ2 dz_16_2 sky130_fd_pr_reram__reram_cell area_ox=0.0676
XMn_16_2 dn_16_2 WL16 SL2 VSS sky130_fd_pr__nfet_g5v0d10v5 w=1 l=0.5
XRn_16_2 BLN2 dn_16_2 sky130_fd_pr_reram__reram_cell area_ox=0.0676
XMp_16_3 dp_16_3 WL16 SL3 VSS sky130_fd_pr__nfet_g5v0d10v5 w=1 l=0.5
XRp_16_3 BLP3 dp_16_3 sky130_fd_pr_reram__reram_cell area_ox=0.0676
XMz_16_3 dz_16_3 WL16 SL3 VSS sky130_fd_pr__nfet_g5v0d10v5 w=1 l=0.5
XRz_16_3 BLZ3 dz_16_3 sky130_fd_pr_reram__reram_cell area_ox=0.0676
XMn_16_3 dn_16_3 WL16 SL3 VSS sky130_fd_pr__nfet_g5v0d10v5 w=1 l=0.5
XRn_16_3 BLN3 dn_16_3 sky130_fd_pr_reram__reram_cell area_ox=0.0676
XMp_16_4 dp_16_4 WL16 SL4 VSS sky130_fd_pr__nfet_g5v0d10v5 w=1 l=0.5
XRp_16_4 BLP4 dp_16_4 sky130_fd_pr_reram__reram_cell area_ox=0.0676
XMz_16_4 dz_16_4 WL16 SL4 VSS sky130_fd_pr__nfet_g5v0d10v5 w=1 l=0.5
XRz_16_4 BLZ4 dz_16_4 sky130_fd_pr_reram__reram_cell area_ox=0.0676
XMn_16_4 dn_16_4 WL16 SL4 VSS sky130_fd_pr__nfet_g5v0d10v5 w=1 l=0.5
XRn_16_4 BLN4 dn_16_4 sky130_fd_pr_reram__reram_cell area_ox=0.0676
XMp_16_5 dp_16_5 WL16 SL5 VSS sky130_fd_pr__nfet_g5v0d10v5 w=1 l=0.5
XRp_16_5 BLP5 dp_16_5 sky130_fd_pr_reram__reram_cell area_ox=0.0676
XMz_16_5 dz_16_5 WL16 SL5 VSS sky130_fd_pr__nfet_g5v0d10v5 w=1 l=0.5
XRz_16_5 BLZ5 dz_16_5 sky130_fd_pr_reram__reram_cell area_ox=0.0676
XMn_16_5 dn_16_5 WL16 SL5 VSS sky130_fd_pr__nfet_g5v0d10v5 w=1 l=0.5
XRn_16_5 BLN5 dn_16_5 sky130_fd_pr_reram__reram_cell area_ox=0.0676
XMp_16_6 dp_16_6 WL16 SL6 VSS sky130_fd_pr__nfet_g5v0d10v5 w=1 l=0.5
XRp_16_6 BLP6 dp_16_6 sky130_fd_pr_reram__reram_cell area_ox=0.0676
XMz_16_6 dz_16_6 WL16 SL6 VSS sky130_fd_pr__nfet_g5v0d10v5 w=1 l=0.5
XRz_16_6 BLZ6 dz_16_6 sky130_fd_pr_reram__reram_cell area_ox=0.0676
XMn_16_6 dn_16_6 WL16 SL6 VSS sky130_fd_pr__nfet_g5v0d10v5 w=1 l=0.5
XRn_16_6 BLN6 dn_16_6 sky130_fd_pr_reram__reram_cell area_ox=0.0676
XMp_16_7 dp_16_7 WL16 SL7 VSS sky130_fd_pr__nfet_g5v0d10v5 w=1 l=0.5
XRp_16_7 BLP7 dp_16_7 sky130_fd_pr_reram__reram_cell area_ox=0.0676
XMz_16_7 dz_16_7 WL16 SL7 VSS sky130_fd_pr__nfet_g5v0d10v5 w=1 l=0.5
XRz_16_7 BLZ7 dz_16_7 sky130_fd_pr_reram__reram_cell area_ox=0.0676
XMn_16_7 dn_16_7 WL16 SL7 VSS sky130_fd_pr__nfet_g5v0d10v5 w=1 l=0.5
XRn_16_7 BLN7 dn_16_7 sky130_fd_pr_reram__reram_cell area_ox=0.0676
XMp_16_8 dp_16_8 WL16 SL8 VSS sky130_fd_pr__nfet_g5v0d10v5 w=1 l=0.5
XRp_16_8 BLP8 dp_16_8 sky130_fd_pr_reram__reram_cell area_ox=0.0676
XMz_16_8 dz_16_8 WL16 SL8 VSS sky130_fd_pr__nfet_g5v0d10v5 w=1 l=0.5
XRz_16_8 BLZ8 dz_16_8 sky130_fd_pr_reram__reram_cell area_ox=0.0676
XMn_16_8 dn_16_8 WL16 SL8 VSS sky130_fd_pr__nfet_g5v0d10v5 w=1 l=0.5
XRn_16_8 BLN8 dn_16_8 sky130_fd_pr_reram__reram_cell area_ox=0.0676
XMp_16_9 dp_16_9 WL16 SL9 VSS sky130_fd_pr__nfet_g5v0d10v5 w=1 l=0.5
XRp_16_9 BLP9 dp_16_9 sky130_fd_pr_reram__reram_cell area_ox=0.0676
XMz_16_9 dz_16_9 WL16 SL9 VSS sky130_fd_pr__nfet_g5v0d10v5 w=1 l=0.5
XRz_16_9 BLZ9 dz_16_9 sky130_fd_pr_reram__reram_cell area_ox=0.0676
XMn_16_9 dn_16_9 WL16 SL9 VSS sky130_fd_pr__nfet_g5v0d10v5 w=1 l=0.5
XRn_16_9 BLN9 dn_16_9 sky130_fd_pr_reram__reram_cell area_ox=0.0676
XMp_16_10 dp_16_10 WL16 SL10 VSS sky130_fd_pr__nfet_g5v0d10v5 w=1 l=0.5
XRp_16_10 BLP10 dp_16_10 sky130_fd_pr_reram__reram_cell area_ox=0.0676
XMz_16_10 dz_16_10 WL16 SL10 VSS sky130_fd_pr__nfet_g5v0d10v5 w=1 l=0.5
XRz_16_10 BLZ10 dz_16_10 sky130_fd_pr_reram__reram_cell area_ox=0.0676
XMn_16_10 dn_16_10 WL16 SL10 VSS sky130_fd_pr__nfet_g5v0d10v5 w=1 l=0.5
XRn_16_10 BLN10 dn_16_10 sky130_fd_pr_reram__reram_cell area_ox=0.0676
XMp_16_11 dp_16_11 WL16 SL11 VSS sky130_fd_pr__nfet_g5v0d10v5 w=1 l=0.5
XRp_16_11 BLP11 dp_16_11 sky130_fd_pr_reram__reram_cell area_ox=0.0676
XMz_16_11 dz_16_11 WL16 SL11 VSS sky130_fd_pr__nfet_g5v0d10v5 w=1 l=0.5
XRz_16_11 BLZ11 dz_16_11 sky130_fd_pr_reram__reram_cell area_ox=0.0676
XMn_16_11 dn_16_11 WL16 SL11 VSS sky130_fd_pr__nfet_g5v0d10v5 w=1 l=0.5
XRn_16_11 BLN11 dn_16_11 sky130_fd_pr_reram__reram_cell area_ox=0.0676
XMp_16_12 dp_16_12 WL16 SL12 VSS sky130_fd_pr__nfet_g5v0d10v5 w=1 l=0.5
XRp_16_12 BLP12 dp_16_12 sky130_fd_pr_reram__reram_cell area_ox=0.0676
XMz_16_12 dz_16_12 WL16 SL12 VSS sky130_fd_pr__nfet_g5v0d10v5 w=1 l=0.5
XRz_16_12 BLZ12 dz_16_12 sky130_fd_pr_reram__reram_cell area_ox=0.0676
XMn_16_12 dn_16_12 WL16 SL12 VSS sky130_fd_pr__nfet_g5v0d10v5 w=1 l=0.5
XRn_16_12 BLN12 dn_16_12 sky130_fd_pr_reram__reram_cell area_ox=0.0676
XMp_16_13 dp_16_13 WL16 SL13 VSS sky130_fd_pr__nfet_g5v0d10v5 w=1 l=0.5
XRp_16_13 BLP13 dp_16_13 sky130_fd_pr_reram__reram_cell area_ox=0.0676
XMz_16_13 dz_16_13 WL16 SL13 VSS sky130_fd_pr__nfet_g5v0d10v5 w=1 l=0.5
XRz_16_13 BLZ13 dz_16_13 sky130_fd_pr_reram__reram_cell area_ox=0.0676
XMn_16_13 dn_16_13 WL16 SL13 VSS sky130_fd_pr__nfet_g5v0d10v5 w=1 l=0.5
XRn_16_13 BLN13 dn_16_13 sky130_fd_pr_reram__reram_cell area_ox=0.0676
XMp_16_14 dp_16_14 WL16 SL14 VSS sky130_fd_pr__nfet_g5v0d10v5 w=1 l=0.5
XRp_16_14 BLP14 dp_16_14 sky130_fd_pr_reram__reram_cell area_ox=0.0676
XMz_16_14 dz_16_14 WL16 SL14 VSS sky130_fd_pr__nfet_g5v0d10v5 w=1 l=0.5
XRz_16_14 BLZ14 dz_16_14 sky130_fd_pr_reram__reram_cell area_ox=0.0676
XMn_16_14 dn_16_14 WL16 SL14 VSS sky130_fd_pr__nfet_g5v0d10v5 w=1 l=0.5
XRn_16_14 BLN14 dn_16_14 sky130_fd_pr_reram__reram_cell area_ox=0.0676
XMp_16_15 dp_16_15 WL16 SL15 VSS sky130_fd_pr__nfet_g5v0d10v5 w=1 l=0.5
XRp_16_15 BLP15 dp_16_15 sky130_fd_pr_reram__reram_cell area_ox=0.0676
XMz_16_15 dz_16_15 WL16 SL15 VSS sky130_fd_pr__nfet_g5v0d10v5 w=1 l=0.5
XRz_16_15 BLZ15 dz_16_15 sky130_fd_pr_reram__reram_cell area_ox=0.0676
XMn_16_15 dn_16_15 WL16 SL15 VSS sky130_fd_pr__nfet_g5v0d10v5 w=1 l=0.5
XRn_16_15 BLN15 dn_16_15 sky130_fd_pr_reram__reram_cell area_ox=0.0676
XMp_16_16 dp_16_16 WL16 SL16 VSS sky130_fd_pr__nfet_g5v0d10v5 w=1 l=0.5
XRp_16_16 BLP16 dp_16_16 sky130_fd_pr_reram__reram_cell area_ox=0.0676
XMz_16_16 dz_16_16 WL16 SL16 VSS sky130_fd_pr__nfet_g5v0d10v5 w=1 l=0.5
XRz_16_16 BLZ16 dz_16_16 sky130_fd_pr_reram__reram_cell area_ox=0.0676
XMn_16_16 dn_16_16 WL16 SL16 VSS sky130_fd_pr__nfet_g5v0d10v5 w=1 l=0.5
XRn_16_16 BLN16 dn_16_16 sky130_fd_pr_reram__reram_cell area_ox=0.0676
XMp_16_17 dp_16_17 WL16 SL17 VSS sky130_fd_pr__nfet_g5v0d10v5 w=1 l=0.5
XRp_16_17 BLP17 dp_16_17 sky130_fd_pr_reram__reram_cell area_ox=0.0676
XMz_16_17 dz_16_17 WL16 SL17 VSS sky130_fd_pr__nfet_g5v0d10v5 w=1 l=0.5
XRz_16_17 BLZ17 dz_16_17 sky130_fd_pr_reram__reram_cell area_ox=0.0676
XMn_16_17 dn_16_17 WL16 SL17 VSS sky130_fd_pr__nfet_g5v0d10v5 w=1 l=0.5
XRn_16_17 BLN17 dn_16_17 sky130_fd_pr_reram__reram_cell area_ox=0.0676
XMp_16_18 dp_16_18 WL16 SL18 VSS sky130_fd_pr__nfet_g5v0d10v5 w=1 l=0.5
XRp_16_18 BLP18 dp_16_18 sky130_fd_pr_reram__reram_cell area_ox=0.0676
XMz_16_18 dz_16_18 WL16 SL18 VSS sky130_fd_pr__nfet_g5v0d10v5 w=1 l=0.5
XRz_16_18 BLZ18 dz_16_18 sky130_fd_pr_reram__reram_cell area_ox=0.0676
XMn_16_18 dn_16_18 WL16 SL18 VSS sky130_fd_pr__nfet_g5v0d10v5 w=1 l=0.5
XRn_16_18 BLN18 dn_16_18 sky130_fd_pr_reram__reram_cell area_ox=0.0676
XMp_16_19 dp_16_19 WL16 SL19 VSS sky130_fd_pr__nfet_g5v0d10v5 w=1 l=0.5
XRp_16_19 BLP19 dp_16_19 sky130_fd_pr_reram__reram_cell area_ox=0.0676
XMz_16_19 dz_16_19 WL16 SL19 VSS sky130_fd_pr__nfet_g5v0d10v5 w=1 l=0.5
XRz_16_19 BLZ19 dz_16_19 sky130_fd_pr_reram__reram_cell area_ox=0.0676
XMn_16_19 dn_16_19 WL16 SL19 VSS sky130_fd_pr__nfet_g5v0d10v5 w=1 l=0.5
XRn_16_19 BLN19 dn_16_19 sky130_fd_pr_reram__reram_cell area_ox=0.0676
XMp_16_20 dp_16_20 WL16 SL20 VSS sky130_fd_pr__nfet_g5v0d10v5 w=1 l=0.5
XRp_16_20 BLP20 dp_16_20 sky130_fd_pr_reram__reram_cell area_ox=0.0676
XMz_16_20 dz_16_20 WL16 SL20 VSS sky130_fd_pr__nfet_g5v0d10v5 w=1 l=0.5
XRz_16_20 BLZ20 dz_16_20 sky130_fd_pr_reram__reram_cell area_ox=0.0676
XMn_16_20 dn_16_20 WL16 SL20 VSS sky130_fd_pr__nfet_g5v0d10v5 w=1 l=0.5
XRn_16_20 BLN20 dn_16_20 sky130_fd_pr_reram__reram_cell area_ox=0.0676
XMp_16_21 dp_16_21 WL16 SL21 VSS sky130_fd_pr__nfet_g5v0d10v5 w=1 l=0.5
XRp_16_21 BLP21 dp_16_21 sky130_fd_pr_reram__reram_cell area_ox=0.0676
XMz_16_21 dz_16_21 WL16 SL21 VSS sky130_fd_pr__nfet_g5v0d10v5 w=1 l=0.5
XRz_16_21 BLZ21 dz_16_21 sky130_fd_pr_reram__reram_cell area_ox=0.0676
XMn_16_21 dn_16_21 WL16 SL21 VSS sky130_fd_pr__nfet_g5v0d10v5 w=1 l=0.5
XRn_16_21 BLN21 dn_16_21 sky130_fd_pr_reram__reram_cell area_ox=0.0676
XMp_16_22 dp_16_22 WL16 SL22 VSS sky130_fd_pr__nfet_g5v0d10v5 w=1 l=0.5
XRp_16_22 BLP22 dp_16_22 sky130_fd_pr_reram__reram_cell area_ox=0.0676
XMz_16_22 dz_16_22 WL16 SL22 VSS sky130_fd_pr__nfet_g5v0d10v5 w=1 l=0.5
XRz_16_22 BLZ22 dz_16_22 sky130_fd_pr_reram__reram_cell area_ox=0.0676
XMn_16_22 dn_16_22 WL16 SL22 VSS sky130_fd_pr__nfet_g5v0d10v5 w=1 l=0.5
XRn_16_22 BLN22 dn_16_22 sky130_fd_pr_reram__reram_cell area_ox=0.0676
XMp_16_23 dp_16_23 WL16 SL23 VSS sky130_fd_pr__nfet_g5v0d10v5 w=1 l=0.5
XRp_16_23 BLP23 dp_16_23 sky130_fd_pr_reram__reram_cell area_ox=0.0676
XMz_16_23 dz_16_23 WL16 SL23 VSS sky130_fd_pr__nfet_g5v0d10v5 w=1 l=0.5
XRz_16_23 BLZ23 dz_16_23 sky130_fd_pr_reram__reram_cell area_ox=0.0676
XMn_16_23 dn_16_23 WL16 SL23 VSS sky130_fd_pr__nfet_g5v0d10v5 w=1 l=0.5
XRn_16_23 BLN23 dn_16_23 sky130_fd_pr_reram__reram_cell area_ox=0.0676
XMp_17_0 dp_17_0 WL17 SL0 VSS sky130_fd_pr__nfet_g5v0d10v5 w=1 l=0.5
XRp_17_0 BLP0 dp_17_0 sky130_fd_pr_reram__reram_cell area_ox=0.0676
XMz_17_0 dz_17_0 WL17 SL0 VSS sky130_fd_pr__nfet_g5v0d10v5 w=1 l=0.5
XRz_17_0 BLZ0 dz_17_0 sky130_fd_pr_reram__reram_cell area_ox=0.0676
XMn_17_0 dn_17_0 WL17 SL0 VSS sky130_fd_pr__nfet_g5v0d10v5 w=1 l=0.5
XRn_17_0 BLN0 dn_17_0 sky130_fd_pr_reram__reram_cell area_ox=0.0676
XMp_17_1 dp_17_1 WL17 SL1 VSS sky130_fd_pr__nfet_g5v0d10v5 w=1 l=0.5
XRp_17_1 BLP1 dp_17_1 sky130_fd_pr_reram__reram_cell area_ox=0.0676
XMz_17_1 dz_17_1 WL17 SL1 VSS sky130_fd_pr__nfet_g5v0d10v5 w=1 l=0.5
XRz_17_1 BLZ1 dz_17_1 sky130_fd_pr_reram__reram_cell area_ox=0.0676
XMn_17_1 dn_17_1 WL17 SL1 VSS sky130_fd_pr__nfet_g5v0d10v5 w=1 l=0.5
XRn_17_1 BLN1 dn_17_1 sky130_fd_pr_reram__reram_cell area_ox=0.0676
XMp_17_2 dp_17_2 WL17 SL2 VSS sky130_fd_pr__nfet_g5v0d10v5 w=1 l=0.5
XRp_17_2 BLP2 dp_17_2 sky130_fd_pr_reram__reram_cell area_ox=0.0676
XMz_17_2 dz_17_2 WL17 SL2 VSS sky130_fd_pr__nfet_g5v0d10v5 w=1 l=0.5
XRz_17_2 BLZ2 dz_17_2 sky130_fd_pr_reram__reram_cell area_ox=0.0676
XMn_17_2 dn_17_2 WL17 SL2 VSS sky130_fd_pr__nfet_g5v0d10v5 w=1 l=0.5
XRn_17_2 BLN2 dn_17_2 sky130_fd_pr_reram__reram_cell area_ox=0.0676
XMp_17_3 dp_17_3 WL17 SL3 VSS sky130_fd_pr__nfet_g5v0d10v5 w=1 l=0.5
XRp_17_3 BLP3 dp_17_3 sky130_fd_pr_reram__reram_cell area_ox=0.0676
XMz_17_3 dz_17_3 WL17 SL3 VSS sky130_fd_pr__nfet_g5v0d10v5 w=1 l=0.5
XRz_17_3 BLZ3 dz_17_3 sky130_fd_pr_reram__reram_cell area_ox=0.0676
XMn_17_3 dn_17_3 WL17 SL3 VSS sky130_fd_pr__nfet_g5v0d10v5 w=1 l=0.5
XRn_17_3 BLN3 dn_17_3 sky130_fd_pr_reram__reram_cell area_ox=0.0676
XMp_17_4 dp_17_4 WL17 SL4 VSS sky130_fd_pr__nfet_g5v0d10v5 w=1 l=0.5
XRp_17_4 BLP4 dp_17_4 sky130_fd_pr_reram__reram_cell area_ox=0.0676
XMz_17_4 dz_17_4 WL17 SL4 VSS sky130_fd_pr__nfet_g5v0d10v5 w=1 l=0.5
XRz_17_4 BLZ4 dz_17_4 sky130_fd_pr_reram__reram_cell area_ox=0.0676
XMn_17_4 dn_17_4 WL17 SL4 VSS sky130_fd_pr__nfet_g5v0d10v5 w=1 l=0.5
XRn_17_4 BLN4 dn_17_4 sky130_fd_pr_reram__reram_cell area_ox=0.0676
XMp_17_5 dp_17_5 WL17 SL5 VSS sky130_fd_pr__nfet_g5v0d10v5 w=1 l=0.5
XRp_17_5 BLP5 dp_17_5 sky130_fd_pr_reram__reram_cell area_ox=0.0676
XMz_17_5 dz_17_5 WL17 SL5 VSS sky130_fd_pr__nfet_g5v0d10v5 w=1 l=0.5
XRz_17_5 BLZ5 dz_17_5 sky130_fd_pr_reram__reram_cell area_ox=0.0676
XMn_17_5 dn_17_5 WL17 SL5 VSS sky130_fd_pr__nfet_g5v0d10v5 w=1 l=0.5
XRn_17_5 BLN5 dn_17_5 sky130_fd_pr_reram__reram_cell area_ox=0.0676
XMp_17_6 dp_17_6 WL17 SL6 VSS sky130_fd_pr__nfet_g5v0d10v5 w=1 l=0.5
XRp_17_6 BLP6 dp_17_6 sky130_fd_pr_reram__reram_cell area_ox=0.0676
XMz_17_6 dz_17_6 WL17 SL6 VSS sky130_fd_pr__nfet_g5v0d10v5 w=1 l=0.5
XRz_17_6 BLZ6 dz_17_6 sky130_fd_pr_reram__reram_cell area_ox=0.0676
XMn_17_6 dn_17_6 WL17 SL6 VSS sky130_fd_pr__nfet_g5v0d10v5 w=1 l=0.5
XRn_17_6 BLN6 dn_17_6 sky130_fd_pr_reram__reram_cell area_ox=0.0676
XMp_17_7 dp_17_7 WL17 SL7 VSS sky130_fd_pr__nfet_g5v0d10v5 w=1 l=0.5
XRp_17_7 BLP7 dp_17_7 sky130_fd_pr_reram__reram_cell area_ox=0.0676
XMz_17_7 dz_17_7 WL17 SL7 VSS sky130_fd_pr__nfet_g5v0d10v5 w=1 l=0.5
XRz_17_7 BLZ7 dz_17_7 sky130_fd_pr_reram__reram_cell area_ox=0.0676
XMn_17_7 dn_17_7 WL17 SL7 VSS sky130_fd_pr__nfet_g5v0d10v5 w=1 l=0.5
XRn_17_7 BLN7 dn_17_7 sky130_fd_pr_reram__reram_cell area_ox=0.0676
XMp_17_8 dp_17_8 WL17 SL8 VSS sky130_fd_pr__nfet_g5v0d10v5 w=1 l=0.5
XRp_17_8 BLP8 dp_17_8 sky130_fd_pr_reram__reram_cell area_ox=0.0676
XMz_17_8 dz_17_8 WL17 SL8 VSS sky130_fd_pr__nfet_g5v0d10v5 w=1 l=0.5
XRz_17_8 BLZ8 dz_17_8 sky130_fd_pr_reram__reram_cell area_ox=0.0676
XMn_17_8 dn_17_8 WL17 SL8 VSS sky130_fd_pr__nfet_g5v0d10v5 w=1 l=0.5
XRn_17_8 BLN8 dn_17_8 sky130_fd_pr_reram__reram_cell area_ox=0.0676
XMp_17_9 dp_17_9 WL17 SL9 VSS sky130_fd_pr__nfet_g5v0d10v5 w=1 l=0.5
XRp_17_9 BLP9 dp_17_9 sky130_fd_pr_reram__reram_cell area_ox=0.0676
XMz_17_9 dz_17_9 WL17 SL9 VSS sky130_fd_pr__nfet_g5v0d10v5 w=1 l=0.5
XRz_17_9 BLZ9 dz_17_9 sky130_fd_pr_reram__reram_cell area_ox=0.0676
XMn_17_9 dn_17_9 WL17 SL9 VSS sky130_fd_pr__nfet_g5v0d10v5 w=1 l=0.5
XRn_17_9 BLN9 dn_17_9 sky130_fd_pr_reram__reram_cell area_ox=0.0676
XMp_17_10 dp_17_10 WL17 SL10 VSS sky130_fd_pr__nfet_g5v0d10v5 w=1 l=0.5
XRp_17_10 BLP10 dp_17_10 sky130_fd_pr_reram__reram_cell area_ox=0.0676
XMz_17_10 dz_17_10 WL17 SL10 VSS sky130_fd_pr__nfet_g5v0d10v5 w=1 l=0.5
XRz_17_10 BLZ10 dz_17_10 sky130_fd_pr_reram__reram_cell area_ox=0.0676
XMn_17_10 dn_17_10 WL17 SL10 VSS sky130_fd_pr__nfet_g5v0d10v5 w=1 l=0.5
XRn_17_10 BLN10 dn_17_10 sky130_fd_pr_reram__reram_cell area_ox=0.0676
XMp_17_11 dp_17_11 WL17 SL11 VSS sky130_fd_pr__nfet_g5v0d10v5 w=1 l=0.5
XRp_17_11 BLP11 dp_17_11 sky130_fd_pr_reram__reram_cell area_ox=0.0676
XMz_17_11 dz_17_11 WL17 SL11 VSS sky130_fd_pr__nfet_g5v0d10v5 w=1 l=0.5
XRz_17_11 BLZ11 dz_17_11 sky130_fd_pr_reram__reram_cell area_ox=0.0676
XMn_17_11 dn_17_11 WL17 SL11 VSS sky130_fd_pr__nfet_g5v0d10v5 w=1 l=0.5
XRn_17_11 BLN11 dn_17_11 sky130_fd_pr_reram__reram_cell area_ox=0.0676
XMp_17_12 dp_17_12 WL17 SL12 VSS sky130_fd_pr__nfet_g5v0d10v5 w=1 l=0.5
XRp_17_12 BLP12 dp_17_12 sky130_fd_pr_reram__reram_cell area_ox=0.0676
XMz_17_12 dz_17_12 WL17 SL12 VSS sky130_fd_pr__nfet_g5v0d10v5 w=1 l=0.5
XRz_17_12 BLZ12 dz_17_12 sky130_fd_pr_reram__reram_cell area_ox=0.0676
XMn_17_12 dn_17_12 WL17 SL12 VSS sky130_fd_pr__nfet_g5v0d10v5 w=1 l=0.5
XRn_17_12 BLN12 dn_17_12 sky130_fd_pr_reram__reram_cell area_ox=0.0676
XMp_17_13 dp_17_13 WL17 SL13 VSS sky130_fd_pr__nfet_g5v0d10v5 w=1 l=0.5
XRp_17_13 BLP13 dp_17_13 sky130_fd_pr_reram__reram_cell area_ox=0.0676
XMz_17_13 dz_17_13 WL17 SL13 VSS sky130_fd_pr__nfet_g5v0d10v5 w=1 l=0.5
XRz_17_13 BLZ13 dz_17_13 sky130_fd_pr_reram__reram_cell area_ox=0.0676
XMn_17_13 dn_17_13 WL17 SL13 VSS sky130_fd_pr__nfet_g5v0d10v5 w=1 l=0.5
XRn_17_13 BLN13 dn_17_13 sky130_fd_pr_reram__reram_cell area_ox=0.0676
XMp_17_14 dp_17_14 WL17 SL14 VSS sky130_fd_pr__nfet_g5v0d10v5 w=1 l=0.5
XRp_17_14 BLP14 dp_17_14 sky130_fd_pr_reram__reram_cell area_ox=0.0676
XMz_17_14 dz_17_14 WL17 SL14 VSS sky130_fd_pr__nfet_g5v0d10v5 w=1 l=0.5
XRz_17_14 BLZ14 dz_17_14 sky130_fd_pr_reram__reram_cell area_ox=0.0676
XMn_17_14 dn_17_14 WL17 SL14 VSS sky130_fd_pr__nfet_g5v0d10v5 w=1 l=0.5
XRn_17_14 BLN14 dn_17_14 sky130_fd_pr_reram__reram_cell area_ox=0.0676
XMp_17_15 dp_17_15 WL17 SL15 VSS sky130_fd_pr__nfet_g5v0d10v5 w=1 l=0.5
XRp_17_15 BLP15 dp_17_15 sky130_fd_pr_reram__reram_cell area_ox=0.0676
XMz_17_15 dz_17_15 WL17 SL15 VSS sky130_fd_pr__nfet_g5v0d10v5 w=1 l=0.5
XRz_17_15 BLZ15 dz_17_15 sky130_fd_pr_reram__reram_cell area_ox=0.0676
XMn_17_15 dn_17_15 WL17 SL15 VSS sky130_fd_pr__nfet_g5v0d10v5 w=1 l=0.5
XRn_17_15 BLN15 dn_17_15 sky130_fd_pr_reram__reram_cell area_ox=0.0676
XMp_17_16 dp_17_16 WL17 SL16 VSS sky130_fd_pr__nfet_g5v0d10v5 w=1 l=0.5
XRp_17_16 BLP16 dp_17_16 sky130_fd_pr_reram__reram_cell area_ox=0.0676
XMz_17_16 dz_17_16 WL17 SL16 VSS sky130_fd_pr__nfet_g5v0d10v5 w=1 l=0.5
XRz_17_16 BLZ16 dz_17_16 sky130_fd_pr_reram__reram_cell area_ox=0.0676
XMn_17_16 dn_17_16 WL17 SL16 VSS sky130_fd_pr__nfet_g5v0d10v5 w=1 l=0.5
XRn_17_16 BLN16 dn_17_16 sky130_fd_pr_reram__reram_cell area_ox=0.0676
XMp_17_17 dp_17_17 WL17 SL17 VSS sky130_fd_pr__nfet_g5v0d10v5 w=1 l=0.5
XRp_17_17 BLP17 dp_17_17 sky130_fd_pr_reram__reram_cell area_ox=0.0676
XMz_17_17 dz_17_17 WL17 SL17 VSS sky130_fd_pr__nfet_g5v0d10v5 w=1 l=0.5
XRz_17_17 BLZ17 dz_17_17 sky130_fd_pr_reram__reram_cell area_ox=0.0676
XMn_17_17 dn_17_17 WL17 SL17 VSS sky130_fd_pr__nfet_g5v0d10v5 w=1 l=0.5
XRn_17_17 BLN17 dn_17_17 sky130_fd_pr_reram__reram_cell area_ox=0.0676
XMp_17_18 dp_17_18 WL17 SL18 VSS sky130_fd_pr__nfet_g5v0d10v5 w=1 l=0.5
XRp_17_18 BLP18 dp_17_18 sky130_fd_pr_reram__reram_cell area_ox=0.0676
XMz_17_18 dz_17_18 WL17 SL18 VSS sky130_fd_pr__nfet_g5v0d10v5 w=1 l=0.5
XRz_17_18 BLZ18 dz_17_18 sky130_fd_pr_reram__reram_cell area_ox=0.0676
XMn_17_18 dn_17_18 WL17 SL18 VSS sky130_fd_pr__nfet_g5v0d10v5 w=1 l=0.5
XRn_17_18 BLN18 dn_17_18 sky130_fd_pr_reram__reram_cell area_ox=0.0676
XMp_17_19 dp_17_19 WL17 SL19 VSS sky130_fd_pr__nfet_g5v0d10v5 w=1 l=0.5
XRp_17_19 BLP19 dp_17_19 sky130_fd_pr_reram__reram_cell area_ox=0.0676
XMz_17_19 dz_17_19 WL17 SL19 VSS sky130_fd_pr__nfet_g5v0d10v5 w=1 l=0.5
XRz_17_19 BLZ19 dz_17_19 sky130_fd_pr_reram__reram_cell area_ox=0.0676
XMn_17_19 dn_17_19 WL17 SL19 VSS sky130_fd_pr__nfet_g5v0d10v5 w=1 l=0.5
XRn_17_19 BLN19 dn_17_19 sky130_fd_pr_reram__reram_cell area_ox=0.0676
XMp_17_20 dp_17_20 WL17 SL20 VSS sky130_fd_pr__nfet_g5v0d10v5 w=1 l=0.5
XRp_17_20 BLP20 dp_17_20 sky130_fd_pr_reram__reram_cell area_ox=0.0676
XMz_17_20 dz_17_20 WL17 SL20 VSS sky130_fd_pr__nfet_g5v0d10v5 w=1 l=0.5
XRz_17_20 BLZ20 dz_17_20 sky130_fd_pr_reram__reram_cell area_ox=0.0676
XMn_17_20 dn_17_20 WL17 SL20 VSS sky130_fd_pr__nfet_g5v0d10v5 w=1 l=0.5
XRn_17_20 BLN20 dn_17_20 sky130_fd_pr_reram__reram_cell area_ox=0.0676
XMp_17_21 dp_17_21 WL17 SL21 VSS sky130_fd_pr__nfet_g5v0d10v5 w=1 l=0.5
XRp_17_21 BLP21 dp_17_21 sky130_fd_pr_reram__reram_cell area_ox=0.0676
XMz_17_21 dz_17_21 WL17 SL21 VSS sky130_fd_pr__nfet_g5v0d10v5 w=1 l=0.5
XRz_17_21 BLZ21 dz_17_21 sky130_fd_pr_reram__reram_cell area_ox=0.0676
XMn_17_21 dn_17_21 WL17 SL21 VSS sky130_fd_pr__nfet_g5v0d10v5 w=1 l=0.5
XRn_17_21 BLN21 dn_17_21 sky130_fd_pr_reram__reram_cell area_ox=0.0676
XMp_17_22 dp_17_22 WL17 SL22 VSS sky130_fd_pr__nfet_g5v0d10v5 w=1 l=0.5
XRp_17_22 BLP22 dp_17_22 sky130_fd_pr_reram__reram_cell area_ox=0.0676
XMz_17_22 dz_17_22 WL17 SL22 VSS sky130_fd_pr__nfet_g5v0d10v5 w=1 l=0.5
XRz_17_22 BLZ22 dz_17_22 sky130_fd_pr_reram__reram_cell area_ox=0.0676
XMn_17_22 dn_17_22 WL17 SL22 VSS sky130_fd_pr__nfet_g5v0d10v5 w=1 l=0.5
XRn_17_22 BLN22 dn_17_22 sky130_fd_pr_reram__reram_cell area_ox=0.0676
XMp_17_23 dp_17_23 WL17 SL23 VSS sky130_fd_pr__nfet_g5v0d10v5 w=1 l=0.5
XRp_17_23 BLP23 dp_17_23 sky130_fd_pr_reram__reram_cell area_ox=0.0676
XMz_17_23 dz_17_23 WL17 SL23 VSS sky130_fd_pr__nfet_g5v0d10v5 w=1 l=0.5
XRz_17_23 BLZ23 dz_17_23 sky130_fd_pr_reram__reram_cell area_ox=0.0676
XMn_17_23 dn_17_23 WL17 SL23 VSS sky130_fd_pr__nfet_g5v0d10v5 w=1 l=0.5
XRn_17_23 BLN23 dn_17_23 sky130_fd_pr_reram__reram_cell area_ox=0.0676
XMp_18_0 dp_18_0 WL18 SL0 VSS sky130_fd_pr__nfet_g5v0d10v5 w=1 l=0.5
XRp_18_0 BLP0 dp_18_0 sky130_fd_pr_reram__reram_cell area_ox=0.0676
XMz_18_0 dz_18_0 WL18 SL0 VSS sky130_fd_pr__nfet_g5v0d10v5 w=1 l=0.5
XRz_18_0 BLZ0 dz_18_0 sky130_fd_pr_reram__reram_cell area_ox=0.0676
XMn_18_0 dn_18_0 WL18 SL0 VSS sky130_fd_pr__nfet_g5v0d10v5 w=1 l=0.5
XRn_18_0 BLN0 dn_18_0 sky130_fd_pr_reram__reram_cell area_ox=0.0676
XMp_18_1 dp_18_1 WL18 SL1 VSS sky130_fd_pr__nfet_g5v0d10v5 w=1 l=0.5
XRp_18_1 BLP1 dp_18_1 sky130_fd_pr_reram__reram_cell area_ox=0.0676
XMz_18_1 dz_18_1 WL18 SL1 VSS sky130_fd_pr__nfet_g5v0d10v5 w=1 l=0.5
XRz_18_1 BLZ1 dz_18_1 sky130_fd_pr_reram__reram_cell area_ox=0.0676
XMn_18_1 dn_18_1 WL18 SL1 VSS sky130_fd_pr__nfet_g5v0d10v5 w=1 l=0.5
XRn_18_1 BLN1 dn_18_1 sky130_fd_pr_reram__reram_cell area_ox=0.0676
XMp_18_2 dp_18_2 WL18 SL2 VSS sky130_fd_pr__nfet_g5v0d10v5 w=1 l=0.5
XRp_18_2 BLP2 dp_18_2 sky130_fd_pr_reram__reram_cell area_ox=0.0676
XMz_18_2 dz_18_2 WL18 SL2 VSS sky130_fd_pr__nfet_g5v0d10v5 w=1 l=0.5
XRz_18_2 BLZ2 dz_18_2 sky130_fd_pr_reram__reram_cell area_ox=0.0676
XMn_18_2 dn_18_2 WL18 SL2 VSS sky130_fd_pr__nfet_g5v0d10v5 w=1 l=0.5
XRn_18_2 BLN2 dn_18_2 sky130_fd_pr_reram__reram_cell area_ox=0.0676
XMp_18_3 dp_18_3 WL18 SL3 VSS sky130_fd_pr__nfet_g5v0d10v5 w=1 l=0.5
XRp_18_3 BLP3 dp_18_3 sky130_fd_pr_reram__reram_cell area_ox=0.0676
XMz_18_3 dz_18_3 WL18 SL3 VSS sky130_fd_pr__nfet_g5v0d10v5 w=1 l=0.5
XRz_18_3 BLZ3 dz_18_3 sky130_fd_pr_reram__reram_cell area_ox=0.0676
XMn_18_3 dn_18_3 WL18 SL3 VSS sky130_fd_pr__nfet_g5v0d10v5 w=1 l=0.5
XRn_18_3 BLN3 dn_18_3 sky130_fd_pr_reram__reram_cell area_ox=0.0676
XMp_18_4 dp_18_4 WL18 SL4 VSS sky130_fd_pr__nfet_g5v0d10v5 w=1 l=0.5
XRp_18_4 BLP4 dp_18_4 sky130_fd_pr_reram__reram_cell area_ox=0.0676
XMz_18_4 dz_18_4 WL18 SL4 VSS sky130_fd_pr__nfet_g5v0d10v5 w=1 l=0.5
XRz_18_4 BLZ4 dz_18_4 sky130_fd_pr_reram__reram_cell area_ox=0.0676
XMn_18_4 dn_18_4 WL18 SL4 VSS sky130_fd_pr__nfet_g5v0d10v5 w=1 l=0.5
XRn_18_4 BLN4 dn_18_4 sky130_fd_pr_reram__reram_cell area_ox=0.0676
XMp_18_5 dp_18_5 WL18 SL5 VSS sky130_fd_pr__nfet_g5v0d10v5 w=1 l=0.5
XRp_18_5 BLP5 dp_18_5 sky130_fd_pr_reram__reram_cell area_ox=0.0676
XMz_18_5 dz_18_5 WL18 SL5 VSS sky130_fd_pr__nfet_g5v0d10v5 w=1 l=0.5
XRz_18_5 BLZ5 dz_18_5 sky130_fd_pr_reram__reram_cell area_ox=0.0676
XMn_18_5 dn_18_5 WL18 SL5 VSS sky130_fd_pr__nfet_g5v0d10v5 w=1 l=0.5
XRn_18_5 BLN5 dn_18_5 sky130_fd_pr_reram__reram_cell area_ox=0.0676
XMp_18_6 dp_18_6 WL18 SL6 VSS sky130_fd_pr__nfet_g5v0d10v5 w=1 l=0.5
XRp_18_6 BLP6 dp_18_6 sky130_fd_pr_reram__reram_cell area_ox=0.0676
XMz_18_6 dz_18_6 WL18 SL6 VSS sky130_fd_pr__nfet_g5v0d10v5 w=1 l=0.5
XRz_18_6 BLZ6 dz_18_6 sky130_fd_pr_reram__reram_cell area_ox=0.0676
XMn_18_6 dn_18_6 WL18 SL6 VSS sky130_fd_pr__nfet_g5v0d10v5 w=1 l=0.5
XRn_18_6 BLN6 dn_18_6 sky130_fd_pr_reram__reram_cell area_ox=0.0676
XMp_18_7 dp_18_7 WL18 SL7 VSS sky130_fd_pr__nfet_g5v0d10v5 w=1 l=0.5
XRp_18_7 BLP7 dp_18_7 sky130_fd_pr_reram__reram_cell area_ox=0.0676
XMz_18_7 dz_18_7 WL18 SL7 VSS sky130_fd_pr__nfet_g5v0d10v5 w=1 l=0.5
XRz_18_7 BLZ7 dz_18_7 sky130_fd_pr_reram__reram_cell area_ox=0.0676
XMn_18_7 dn_18_7 WL18 SL7 VSS sky130_fd_pr__nfet_g5v0d10v5 w=1 l=0.5
XRn_18_7 BLN7 dn_18_7 sky130_fd_pr_reram__reram_cell area_ox=0.0676
XMp_18_8 dp_18_8 WL18 SL8 VSS sky130_fd_pr__nfet_g5v0d10v5 w=1 l=0.5
XRp_18_8 BLP8 dp_18_8 sky130_fd_pr_reram__reram_cell area_ox=0.0676
XMz_18_8 dz_18_8 WL18 SL8 VSS sky130_fd_pr__nfet_g5v0d10v5 w=1 l=0.5
XRz_18_8 BLZ8 dz_18_8 sky130_fd_pr_reram__reram_cell area_ox=0.0676
XMn_18_8 dn_18_8 WL18 SL8 VSS sky130_fd_pr__nfet_g5v0d10v5 w=1 l=0.5
XRn_18_8 BLN8 dn_18_8 sky130_fd_pr_reram__reram_cell area_ox=0.0676
XMp_18_9 dp_18_9 WL18 SL9 VSS sky130_fd_pr__nfet_g5v0d10v5 w=1 l=0.5
XRp_18_9 BLP9 dp_18_9 sky130_fd_pr_reram__reram_cell area_ox=0.0676
XMz_18_9 dz_18_9 WL18 SL9 VSS sky130_fd_pr__nfet_g5v0d10v5 w=1 l=0.5
XRz_18_9 BLZ9 dz_18_9 sky130_fd_pr_reram__reram_cell area_ox=0.0676
XMn_18_9 dn_18_9 WL18 SL9 VSS sky130_fd_pr__nfet_g5v0d10v5 w=1 l=0.5
XRn_18_9 BLN9 dn_18_9 sky130_fd_pr_reram__reram_cell area_ox=0.0676
XMp_18_10 dp_18_10 WL18 SL10 VSS sky130_fd_pr__nfet_g5v0d10v5 w=1 l=0.5
XRp_18_10 BLP10 dp_18_10 sky130_fd_pr_reram__reram_cell area_ox=0.0676
XMz_18_10 dz_18_10 WL18 SL10 VSS sky130_fd_pr__nfet_g5v0d10v5 w=1 l=0.5
XRz_18_10 BLZ10 dz_18_10 sky130_fd_pr_reram__reram_cell area_ox=0.0676
XMn_18_10 dn_18_10 WL18 SL10 VSS sky130_fd_pr__nfet_g5v0d10v5 w=1 l=0.5
XRn_18_10 BLN10 dn_18_10 sky130_fd_pr_reram__reram_cell area_ox=0.0676
XMp_18_11 dp_18_11 WL18 SL11 VSS sky130_fd_pr__nfet_g5v0d10v5 w=1 l=0.5
XRp_18_11 BLP11 dp_18_11 sky130_fd_pr_reram__reram_cell area_ox=0.0676
XMz_18_11 dz_18_11 WL18 SL11 VSS sky130_fd_pr__nfet_g5v0d10v5 w=1 l=0.5
XRz_18_11 BLZ11 dz_18_11 sky130_fd_pr_reram__reram_cell area_ox=0.0676
XMn_18_11 dn_18_11 WL18 SL11 VSS sky130_fd_pr__nfet_g5v0d10v5 w=1 l=0.5
XRn_18_11 BLN11 dn_18_11 sky130_fd_pr_reram__reram_cell area_ox=0.0676
XMp_18_12 dp_18_12 WL18 SL12 VSS sky130_fd_pr__nfet_g5v0d10v5 w=1 l=0.5
XRp_18_12 BLP12 dp_18_12 sky130_fd_pr_reram__reram_cell area_ox=0.0676
XMz_18_12 dz_18_12 WL18 SL12 VSS sky130_fd_pr__nfet_g5v0d10v5 w=1 l=0.5
XRz_18_12 BLZ12 dz_18_12 sky130_fd_pr_reram__reram_cell area_ox=0.0676
XMn_18_12 dn_18_12 WL18 SL12 VSS sky130_fd_pr__nfet_g5v0d10v5 w=1 l=0.5
XRn_18_12 BLN12 dn_18_12 sky130_fd_pr_reram__reram_cell area_ox=0.0676
XMp_18_13 dp_18_13 WL18 SL13 VSS sky130_fd_pr__nfet_g5v0d10v5 w=1 l=0.5
XRp_18_13 BLP13 dp_18_13 sky130_fd_pr_reram__reram_cell area_ox=0.0676
XMz_18_13 dz_18_13 WL18 SL13 VSS sky130_fd_pr__nfet_g5v0d10v5 w=1 l=0.5
XRz_18_13 BLZ13 dz_18_13 sky130_fd_pr_reram__reram_cell area_ox=0.0676
XMn_18_13 dn_18_13 WL18 SL13 VSS sky130_fd_pr__nfet_g5v0d10v5 w=1 l=0.5
XRn_18_13 BLN13 dn_18_13 sky130_fd_pr_reram__reram_cell area_ox=0.0676
XMp_18_14 dp_18_14 WL18 SL14 VSS sky130_fd_pr__nfet_g5v0d10v5 w=1 l=0.5
XRp_18_14 BLP14 dp_18_14 sky130_fd_pr_reram__reram_cell area_ox=0.0676
XMz_18_14 dz_18_14 WL18 SL14 VSS sky130_fd_pr__nfet_g5v0d10v5 w=1 l=0.5
XRz_18_14 BLZ14 dz_18_14 sky130_fd_pr_reram__reram_cell area_ox=0.0676
XMn_18_14 dn_18_14 WL18 SL14 VSS sky130_fd_pr__nfet_g5v0d10v5 w=1 l=0.5
XRn_18_14 BLN14 dn_18_14 sky130_fd_pr_reram__reram_cell area_ox=0.0676
XMp_18_15 dp_18_15 WL18 SL15 VSS sky130_fd_pr__nfet_g5v0d10v5 w=1 l=0.5
XRp_18_15 BLP15 dp_18_15 sky130_fd_pr_reram__reram_cell area_ox=0.0676
XMz_18_15 dz_18_15 WL18 SL15 VSS sky130_fd_pr__nfet_g5v0d10v5 w=1 l=0.5
XRz_18_15 BLZ15 dz_18_15 sky130_fd_pr_reram__reram_cell area_ox=0.0676
XMn_18_15 dn_18_15 WL18 SL15 VSS sky130_fd_pr__nfet_g5v0d10v5 w=1 l=0.5
XRn_18_15 BLN15 dn_18_15 sky130_fd_pr_reram__reram_cell area_ox=0.0676
XMp_18_16 dp_18_16 WL18 SL16 VSS sky130_fd_pr__nfet_g5v0d10v5 w=1 l=0.5
XRp_18_16 BLP16 dp_18_16 sky130_fd_pr_reram__reram_cell area_ox=0.0676
XMz_18_16 dz_18_16 WL18 SL16 VSS sky130_fd_pr__nfet_g5v0d10v5 w=1 l=0.5
XRz_18_16 BLZ16 dz_18_16 sky130_fd_pr_reram__reram_cell area_ox=0.0676
XMn_18_16 dn_18_16 WL18 SL16 VSS sky130_fd_pr__nfet_g5v0d10v5 w=1 l=0.5
XRn_18_16 BLN16 dn_18_16 sky130_fd_pr_reram__reram_cell area_ox=0.0676
XMp_18_17 dp_18_17 WL18 SL17 VSS sky130_fd_pr__nfet_g5v0d10v5 w=1 l=0.5
XRp_18_17 BLP17 dp_18_17 sky130_fd_pr_reram__reram_cell area_ox=0.0676
XMz_18_17 dz_18_17 WL18 SL17 VSS sky130_fd_pr__nfet_g5v0d10v5 w=1 l=0.5
XRz_18_17 BLZ17 dz_18_17 sky130_fd_pr_reram__reram_cell area_ox=0.0676
XMn_18_17 dn_18_17 WL18 SL17 VSS sky130_fd_pr__nfet_g5v0d10v5 w=1 l=0.5
XRn_18_17 BLN17 dn_18_17 sky130_fd_pr_reram__reram_cell area_ox=0.0676
XMp_18_18 dp_18_18 WL18 SL18 VSS sky130_fd_pr__nfet_g5v0d10v5 w=1 l=0.5
XRp_18_18 BLP18 dp_18_18 sky130_fd_pr_reram__reram_cell area_ox=0.0676
XMz_18_18 dz_18_18 WL18 SL18 VSS sky130_fd_pr__nfet_g5v0d10v5 w=1 l=0.5
XRz_18_18 BLZ18 dz_18_18 sky130_fd_pr_reram__reram_cell area_ox=0.0676
XMn_18_18 dn_18_18 WL18 SL18 VSS sky130_fd_pr__nfet_g5v0d10v5 w=1 l=0.5
XRn_18_18 BLN18 dn_18_18 sky130_fd_pr_reram__reram_cell area_ox=0.0676
XMp_18_19 dp_18_19 WL18 SL19 VSS sky130_fd_pr__nfet_g5v0d10v5 w=1 l=0.5
XRp_18_19 BLP19 dp_18_19 sky130_fd_pr_reram__reram_cell area_ox=0.0676
XMz_18_19 dz_18_19 WL18 SL19 VSS sky130_fd_pr__nfet_g5v0d10v5 w=1 l=0.5
XRz_18_19 BLZ19 dz_18_19 sky130_fd_pr_reram__reram_cell area_ox=0.0676
XMn_18_19 dn_18_19 WL18 SL19 VSS sky130_fd_pr__nfet_g5v0d10v5 w=1 l=0.5
XRn_18_19 BLN19 dn_18_19 sky130_fd_pr_reram__reram_cell area_ox=0.0676
XMp_18_20 dp_18_20 WL18 SL20 VSS sky130_fd_pr__nfet_g5v0d10v5 w=1 l=0.5
XRp_18_20 BLP20 dp_18_20 sky130_fd_pr_reram__reram_cell area_ox=0.0676
XMz_18_20 dz_18_20 WL18 SL20 VSS sky130_fd_pr__nfet_g5v0d10v5 w=1 l=0.5
XRz_18_20 BLZ20 dz_18_20 sky130_fd_pr_reram__reram_cell area_ox=0.0676
XMn_18_20 dn_18_20 WL18 SL20 VSS sky130_fd_pr__nfet_g5v0d10v5 w=1 l=0.5
XRn_18_20 BLN20 dn_18_20 sky130_fd_pr_reram__reram_cell area_ox=0.0676
XMp_18_21 dp_18_21 WL18 SL21 VSS sky130_fd_pr__nfet_g5v0d10v5 w=1 l=0.5
XRp_18_21 BLP21 dp_18_21 sky130_fd_pr_reram__reram_cell area_ox=0.0676
XMz_18_21 dz_18_21 WL18 SL21 VSS sky130_fd_pr__nfet_g5v0d10v5 w=1 l=0.5
XRz_18_21 BLZ21 dz_18_21 sky130_fd_pr_reram__reram_cell area_ox=0.0676
XMn_18_21 dn_18_21 WL18 SL21 VSS sky130_fd_pr__nfet_g5v0d10v5 w=1 l=0.5
XRn_18_21 BLN21 dn_18_21 sky130_fd_pr_reram__reram_cell area_ox=0.0676
XMp_18_22 dp_18_22 WL18 SL22 VSS sky130_fd_pr__nfet_g5v0d10v5 w=1 l=0.5
XRp_18_22 BLP22 dp_18_22 sky130_fd_pr_reram__reram_cell area_ox=0.0676
XMz_18_22 dz_18_22 WL18 SL22 VSS sky130_fd_pr__nfet_g5v0d10v5 w=1 l=0.5
XRz_18_22 BLZ22 dz_18_22 sky130_fd_pr_reram__reram_cell area_ox=0.0676
XMn_18_22 dn_18_22 WL18 SL22 VSS sky130_fd_pr__nfet_g5v0d10v5 w=1 l=0.5
XRn_18_22 BLN22 dn_18_22 sky130_fd_pr_reram__reram_cell area_ox=0.0676
XMp_18_23 dp_18_23 WL18 SL23 VSS sky130_fd_pr__nfet_g5v0d10v5 w=1 l=0.5
XRp_18_23 BLP23 dp_18_23 sky130_fd_pr_reram__reram_cell area_ox=0.0676
XMz_18_23 dz_18_23 WL18 SL23 VSS sky130_fd_pr__nfet_g5v0d10v5 w=1 l=0.5
XRz_18_23 BLZ23 dz_18_23 sky130_fd_pr_reram__reram_cell area_ox=0.0676
XMn_18_23 dn_18_23 WL18 SL23 VSS sky130_fd_pr__nfet_g5v0d10v5 w=1 l=0.5
XRn_18_23 BLN23 dn_18_23 sky130_fd_pr_reram__reram_cell area_ox=0.0676
XMp_19_0 dp_19_0 WL19 SL0 VSS sky130_fd_pr__nfet_g5v0d10v5 w=1 l=0.5
XRp_19_0 BLP0 dp_19_0 sky130_fd_pr_reram__reram_cell area_ox=0.0676
XMz_19_0 dz_19_0 WL19 SL0 VSS sky130_fd_pr__nfet_g5v0d10v5 w=1 l=0.5
XRz_19_0 BLZ0 dz_19_0 sky130_fd_pr_reram__reram_cell area_ox=0.0676
XMn_19_0 dn_19_0 WL19 SL0 VSS sky130_fd_pr__nfet_g5v0d10v5 w=1 l=0.5
XRn_19_0 BLN0 dn_19_0 sky130_fd_pr_reram__reram_cell area_ox=0.0676
XMp_19_1 dp_19_1 WL19 SL1 VSS sky130_fd_pr__nfet_g5v0d10v5 w=1 l=0.5
XRp_19_1 BLP1 dp_19_1 sky130_fd_pr_reram__reram_cell area_ox=0.0676
XMz_19_1 dz_19_1 WL19 SL1 VSS sky130_fd_pr__nfet_g5v0d10v5 w=1 l=0.5
XRz_19_1 BLZ1 dz_19_1 sky130_fd_pr_reram__reram_cell area_ox=0.0676
XMn_19_1 dn_19_1 WL19 SL1 VSS sky130_fd_pr__nfet_g5v0d10v5 w=1 l=0.5
XRn_19_1 BLN1 dn_19_1 sky130_fd_pr_reram__reram_cell area_ox=0.0676
XMp_19_2 dp_19_2 WL19 SL2 VSS sky130_fd_pr__nfet_g5v0d10v5 w=1 l=0.5
XRp_19_2 BLP2 dp_19_2 sky130_fd_pr_reram__reram_cell area_ox=0.0676
XMz_19_2 dz_19_2 WL19 SL2 VSS sky130_fd_pr__nfet_g5v0d10v5 w=1 l=0.5
XRz_19_2 BLZ2 dz_19_2 sky130_fd_pr_reram__reram_cell area_ox=0.0676
XMn_19_2 dn_19_2 WL19 SL2 VSS sky130_fd_pr__nfet_g5v0d10v5 w=1 l=0.5
XRn_19_2 BLN2 dn_19_2 sky130_fd_pr_reram__reram_cell area_ox=0.0676
XMp_19_3 dp_19_3 WL19 SL3 VSS sky130_fd_pr__nfet_g5v0d10v5 w=1 l=0.5
XRp_19_3 BLP3 dp_19_3 sky130_fd_pr_reram__reram_cell area_ox=0.0676
XMz_19_3 dz_19_3 WL19 SL3 VSS sky130_fd_pr__nfet_g5v0d10v5 w=1 l=0.5
XRz_19_3 BLZ3 dz_19_3 sky130_fd_pr_reram__reram_cell area_ox=0.0676
XMn_19_3 dn_19_3 WL19 SL3 VSS sky130_fd_pr__nfet_g5v0d10v5 w=1 l=0.5
XRn_19_3 BLN3 dn_19_3 sky130_fd_pr_reram__reram_cell area_ox=0.0676
XMp_19_4 dp_19_4 WL19 SL4 VSS sky130_fd_pr__nfet_g5v0d10v5 w=1 l=0.5
XRp_19_4 BLP4 dp_19_4 sky130_fd_pr_reram__reram_cell area_ox=0.0676
XMz_19_4 dz_19_4 WL19 SL4 VSS sky130_fd_pr__nfet_g5v0d10v5 w=1 l=0.5
XRz_19_4 BLZ4 dz_19_4 sky130_fd_pr_reram__reram_cell area_ox=0.0676
XMn_19_4 dn_19_4 WL19 SL4 VSS sky130_fd_pr__nfet_g5v0d10v5 w=1 l=0.5
XRn_19_4 BLN4 dn_19_4 sky130_fd_pr_reram__reram_cell area_ox=0.0676
XMp_19_5 dp_19_5 WL19 SL5 VSS sky130_fd_pr__nfet_g5v0d10v5 w=1 l=0.5
XRp_19_5 BLP5 dp_19_5 sky130_fd_pr_reram__reram_cell area_ox=0.0676
XMz_19_5 dz_19_5 WL19 SL5 VSS sky130_fd_pr__nfet_g5v0d10v5 w=1 l=0.5
XRz_19_5 BLZ5 dz_19_5 sky130_fd_pr_reram__reram_cell area_ox=0.0676
XMn_19_5 dn_19_5 WL19 SL5 VSS sky130_fd_pr__nfet_g5v0d10v5 w=1 l=0.5
XRn_19_5 BLN5 dn_19_5 sky130_fd_pr_reram__reram_cell area_ox=0.0676
XMp_19_6 dp_19_6 WL19 SL6 VSS sky130_fd_pr__nfet_g5v0d10v5 w=1 l=0.5
XRp_19_6 BLP6 dp_19_6 sky130_fd_pr_reram__reram_cell area_ox=0.0676
XMz_19_6 dz_19_6 WL19 SL6 VSS sky130_fd_pr__nfet_g5v0d10v5 w=1 l=0.5
XRz_19_6 BLZ6 dz_19_6 sky130_fd_pr_reram__reram_cell area_ox=0.0676
XMn_19_6 dn_19_6 WL19 SL6 VSS sky130_fd_pr__nfet_g5v0d10v5 w=1 l=0.5
XRn_19_6 BLN6 dn_19_6 sky130_fd_pr_reram__reram_cell area_ox=0.0676
XMp_19_7 dp_19_7 WL19 SL7 VSS sky130_fd_pr__nfet_g5v0d10v5 w=1 l=0.5
XRp_19_7 BLP7 dp_19_7 sky130_fd_pr_reram__reram_cell area_ox=0.0676
XMz_19_7 dz_19_7 WL19 SL7 VSS sky130_fd_pr__nfet_g5v0d10v5 w=1 l=0.5
XRz_19_7 BLZ7 dz_19_7 sky130_fd_pr_reram__reram_cell area_ox=0.0676
XMn_19_7 dn_19_7 WL19 SL7 VSS sky130_fd_pr__nfet_g5v0d10v5 w=1 l=0.5
XRn_19_7 BLN7 dn_19_7 sky130_fd_pr_reram__reram_cell area_ox=0.0676
XMp_19_8 dp_19_8 WL19 SL8 VSS sky130_fd_pr__nfet_g5v0d10v5 w=1 l=0.5
XRp_19_8 BLP8 dp_19_8 sky130_fd_pr_reram__reram_cell area_ox=0.0676
XMz_19_8 dz_19_8 WL19 SL8 VSS sky130_fd_pr__nfet_g5v0d10v5 w=1 l=0.5
XRz_19_8 BLZ8 dz_19_8 sky130_fd_pr_reram__reram_cell area_ox=0.0676
XMn_19_8 dn_19_8 WL19 SL8 VSS sky130_fd_pr__nfet_g5v0d10v5 w=1 l=0.5
XRn_19_8 BLN8 dn_19_8 sky130_fd_pr_reram__reram_cell area_ox=0.0676
XMp_19_9 dp_19_9 WL19 SL9 VSS sky130_fd_pr__nfet_g5v0d10v5 w=1 l=0.5
XRp_19_9 BLP9 dp_19_9 sky130_fd_pr_reram__reram_cell area_ox=0.0676
XMz_19_9 dz_19_9 WL19 SL9 VSS sky130_fd_pr__nfet_g5v0d10v5 w=1 l=0.5
XRz_19_9 BLZ9 dz_19_9 sky130_fd_pr_reram__reram_cell area_ox=0.0676
XMn_19_9 dn_19_9 WL19 SL9 VSS sky130_fd_pr__nfet_g5v0d10v5 w=1 l=0.5
XRn_19_9 BLN9 dn_19_9 sky130_fd_pr_reram__reram_cell area_ox=0.0676
XMp_19_10 dp_19_10 WL19 SL10 VSS sky130_fd_pr__nfet_g5v0d10v5 w=1 l=0.5
XRp_19_10 BLP10 dp_19_10 sky130_fd_pr_reram__reram_cell area_ox=0.0676
XMz_19_10 dz_19_10 WL19 SL10 VSS sky130_fd_pr__nfet_g5v0d10v5 w=1 l=0.5
XRz_19_10 BLZ10 dz_19_10 sky130_fd_pr_reram__reram_cell area_ox=0.0676
XMn_19_10 dn_19_10 WL19 SL10 VSS sky130_fd_pr__nfet_g5v0d10v5 w=1 l=0.5
XRn_19_10 BLN10 dn_19_10 sky130_fd_pr_reram__reram_cell area_ox=0.0676
XMp_19_11 dp_19_11 WL19 SL11 VSS sky130_fd_pr__nfet_g5v0d10v5 w=1 l=0.5
XRp_19_11 BLP11 dp_19_11 sky130_fd_pr_reram__reram_cell area_ox=0.0676
XMz_19_11 dz_19_11 WL19 SL11 VSS sky130_fd_pr__nfet_g5v0d10v5 w=1 l=0.5
XRz_19_11 BLZ11 dz_19_11 sky130_fd_pr_reram__reram_cell area_ox=0.0676
XMn_19_11 dn_19_11 WL19 SL11 VSS sky130_fd_pr__nfet_g5v0d10v5 w=1 l=0.5
XRn_19_11 BLN11 dn_19_11 sky130_fd_pr_reram__reram_cell area_ox=0.0676
XMp_19_12 dp_19_12 WL19 SL12 VSS sky130_fd_pr__nfet_g5v0d10v5 w=1 l=0.5
XRp_19_12 BLP12 dp_19_12 sky130_fd_pr_reram__reram_cell area_ox=0.0676
XMz_19_12 dz_19_12 WL19 SL12 VSS sky130_fd_pr__nfet_g5v0d10v5 w=1 l=0.5
XRz_19_12 BLZ12 dz_19_12 sky130_fd_pr_reram__reram_cell area_ox=0.0676
XMn_19_12 dn_19_12 WL19 SL12 VSS sky130_fd_pr__nfet_g5v0d10v5 w=1 l=0.5
XRn_19_12 BLN12 dn_19_12 sky130_fd_pr_reram__reram_cell area_ox=0.0676
XMp_19_13 dp_19_13 WL19 SL13 VSS sky130_fd_pr__nfet_g5v0d10v5 w=1 l=0.5
XRp_19_13 BLP13 dp_19_13 sky130_fd_pr_reram__reram_cell area_ox=0.0676
XMz_19_13 dz_19_13 WL19 SL13 VSS sky130_fd_pr__nfet_g5v0d10v5 w=1 l=0.5
XRz_19_13 BLZ13 dz_19_13 sky130_fd_pr_reram__reram_cell area_ox=0.0676
XMn_19_13 dn_19_13 WL19 SL13 VSS sky130_fd_pr__nfet_g5v0d10v5 w=1 l=0.5
XRn_19_13 BLN13 dn_19_13 sky130_fd_pr_reram__reram_cell area_ox=0.0676
XMp_19_14 dp_19_14 WL19 SL14 VSS sky130_fd_pr__nfet_g5v0d10v5 w=1 l=0.5
XRp_19_14 BLP14 dp_19_14 sky130_fd_pr_reram__reram_cell area_ox=0.0676
XMz_19_14 dz_19_14 WL19 SL14 VSS sky130_fd_pr__nfet_g5v0d10v5 w=1 l=0.5
XRz_19_14 BLZ14 dz_19_14 sky130_fd_pr_reram__reram_cell area_ox=0.0676
XMn_19_14 dn_19_14 WL19 SL14 VSS sky130_fd_pr__nfet_g5v0d10v5 w=1 l=0.5
XRn_19_14 BLN14 dn_19_14 sky130_fd_pr_reram__reram_cell area_ox=0.0676
XMp_19_15 dp_19_15 WL19 SL15 VSS sky130_fd_pr__nfet_g5v0d10v5 w=1 l=0.5
XRp_19_15 BLP15 dp_19_15 sky130_fd_pr_reram__reram_cell area_ox=0.0676
XMz_19_15 dz_19_15 WL19 SL15 VSS sky130_fd_pr__nfet_g5v0d10v5 w=1 l=0.5
XRz_19_15 BLZ15 dz_19_15 sky130_fd_pr_reram__reram_cell area_ox=0.0676
XMn_19_15 dn_19_15 WL19 SL15 VSS sky130_fd_pr__nfet_g5v0d10v5 w=1 l=0.5
XRn_19_15 BLN15 dn_19_15 sky130_fd_pr_reram__reram_cell area_ox=0.0676
XMp_19_16 dp_19_16 WL19 SL16 VSS sky130_fd_pr__nfet_g5v0d10v5 w=1 l=0.5
XRp_19_16 BLP16 dp_19_16 sky130_fd_pr_reram__reram_cell area_ox=0.0676
XMz_19_16 dz_19_16 WL19 SL16 VSS sky130_fd_pr__nfet_g5v0d10v5 w=1 l=0.5
XRz_19_16 BLZ16 dz_19_16 sky130_fd_pr_reram__reram_cell area_ox=0.0676
XMn_19_16 dn_19_16 WL19 SL16 VSS sky130_fd_pr__nfet_g5v0d10v5 w=1 l=0.5
XRn_19_16 BLN16 dn_19_16 sky130_fd_pr_reram__reram_cell area_ox=0.0676
XMp_19_17 dp_19_17 WL19 SL17 VSS sky130_fd_pr__nfet_g5v0d10v5 w=1 l=0.5
XRp_19_17 BLP17 dp_19_17 sky130_fd_pr_reram__reram_cell area_ox=0.0676
XMz_19_17 dz_19_17 WL19 SL17 VSS sky130_fd_pr__nfet_g5v0d10v5 w=1 l=0.5
XRz_19_17 BLZ17 dz_19_17 sky130_fd_pr_reram__reram_cell area_ox=0.0676
XMn_19_17 dn_19_17 WL19 SL17 VSS sky130_fd_pr__nfet_g5v0d10v5 w=1 l=0.5
XRn_19_17 BLN17 dn_19_17 sky130_fd_pr_reram__reram_cell area_ox=0.0676
XMp_19_18 dp_19_18 WL19 SL18 VSS sky130_fd_pr__nfet_g5v0d10v5 w=1 l=0.5
XRp_19_18 BLP18 dp_19_18 sky130_fd_pr_reram__reram_cell area_ox=0.0676
XMz_19_18 dz_19_18 WL19 SL18 VSS sky130_fd_pr__nfet_g5v0d10v5 w=1 l=0.5
XRz_19_18 BLZ18 dz_19_18 sky130_fd_pr_reram__reram_cell area_ox=0.0676
XMn_19_18 dn_19_18 WL19 SL18 VSS sky130_fd_pr__nfet_g5v0d10v5 w=1 l=0.5
XRn_19_18 BLN18 dn_19_18 sky130_fd_pr_reram__reram_cell area_ox=0.0676
XMp_19_19 dp_19_19 WL19 SL19 VSS sky130_fd_pr__nfet_g5v0d10v5 w=1 l=0.5
XRp_19_19 BLP19 dp_19_19 sky130_fd_pr_reram__reram_cell area_ox=0.0676
XMz_19_19 dz_19_19 WL19 SL19 VSS sky130_fd_pr__nfet_g5v0d10v5 w=1 l=0.5
XRz_19_19 BLZ19 dz_19_19 sky130_fd_pr_reram__reram_cell area_ox=0.0676
XMn_19_19 dn_19_19 WL19 SL19 VSS sky130_fd_pr__nfet_g5v0d10v5 w=1 l=0.5
XRn_19_19 BLN19 dn_19_19 sky130_fd_pr_reram__reram_cell area_ox=0.0676
XMp_19_20 dp_19_20 WL19 SL20 VSS sky130_fd_pr__nfet_g5v0d10v5 w=1 l=0.5
XRp_19_20 BLP20 dp_19_20 sky130_fd_pr_reram__reram_cell area_ox=0.0676
XMz_19_20 dz_19_20 WL19 SL20 VSS sky130_fd_pr__nfet_g5v0d10v5 w=1 l=0.5
XRz_19_20 BLZ20 dz_19_20 sky130_fd_pr_reram__reram_cell area_ox=0.0676
XMn_19_20 dn_19_20 WL19 SL20 VSS sky130_fd_pr__nfet_g5v0d10v5 w=1 l=0.5
XRn_19_20 BLN20 dn_19_20 sky130_fd_pr_reram__reram_cell area_ox=0.0676
XMp_19_21 dp_19_21 WL19 SL21 VSS sky130_fd_pr__nfet_g5v0d10v5 w=1 l=0.5
XRp_19_21 BLP21 dp_19_21 sky130_fd_pr_reram__reram_cell area_ox=0.0676
XMz_19_21 dz_19_21 WL19 SL21 VSS sky130_fd_pr__nfet_g5v0d10v5 w=1 l=0.5
XRz_19_21 BLZ21 dz_19_21 sky130_fd_pr_reram__reram_cell area_ox=0.0676
XMn_19_21 dn_19_21 WL19 SL21 VSS sky130_fd_pr__nfet_g5v0d10v5 w=1 l=0.5
XRn_19_21 BLN21 dn_19_21 sky130_fd_pr_reram__reram_cell area_ox=0.0676
XMp_19_22 dp_19_22 WL19 SL22 VSS sky130_fd_pr__nfet_g5v0d10v5 w=1 l=0.5
XRp_19_22 BLP22 dp_19_22 sky130_fd_pr_reram__reram_cell area_ox=0.0676
XMz_19_22 dz_19_22 WL19 SL22 VSS sky130_fd_pr__nfet_g5v0d10v5 w=1 l=0.5
XRz_19_22 BLZ22 dz_19_22 sky130_fd_pr_reram__reram_cell area_ox=0.0676
XMn_19_22 dn_19_22 WL19 SL22 VSS sky130_fd_pr__nfet_g5v0d10v5 w=1 l=0.5
XRn_19_22 BLN22 dn_19_22 sky130_fd_pr_reram__reram_cell area_ox=0.0676
XMp_19_23 dp_19_23 WL19 SL23 VSS sky130_fd_pr__nfet_g5v0d10v5 w=1 l=0.5
XRp_19_23 BLP23 dp_19_23 sky130_fd_pr_reram__reram_cell area_ox=0.0676
XMz_19_23 dz_19_23 WL19 SL23 VSS sky130_fd_pr__nfet_g5v0d10v5 w=1 l=0.5
XRz_19_23 BLZ23 dz_19_23 sky130_fd_pr_reram__reram_cell area_ox=0.0676
XMn_19_23 dn_19_23 WL19 SL23 VSS sky130_fd_pr__nfet_g5v0d10v5 w=1 l=0.5
XRn_19_23 BLN23 dn_19_23 sky130_fd_pr_reram__reram_cell area_ox=0.0676
XMp_20_0 dp_20_0 WL20 SL0 VSS sky130_fd_pr__nfet_g5v0d10v5 w=1 l=0.5
XRp_20_0 BLP0 dp_20_0 sky130_fd_pr_reram__reram_cell area_ox=0.0676
XMz_20_0 dz_20_0 WL20 SL0 VSS sky130_fd_pr__nfet_g5v0d10v5 w=1 l=0.5
XRz_20_0 BLZ0 dz_20_0 sky130_fd_pr_reram__reram_cell area_ox=0.0676
XMn_20_0 dn_20_0 WL20 SL0 VSS sky130_fd_pr__nfet_g5v0d10v5 w=1 l=0.5
XRn_20_0 BLN0 dn_20_0 sky130_fd_pr_reram__reram_cell area_ox=0.0676
XMp_20_1 dp_20_1 WL20 SL1 VSS sky130_fd_pr__nfet_g5v0d10v5 w=1 l=0.5
XRp_20_1 BLP1 dp_20_1 sky130_fd_pr_reram__reram_cell area_ox=0.0676
XMz_20_1 dz_20_1 WL20 SL1 VSS sky130_fd_pr__nfet_g5v0d10v5 w=1 l=0.5
XRz_20_1 BLZ1 dz_20_1 sky130_fd_pr_reram__reram_cell area_ox=0.0676
XMn_20_1 dn_20_1 WL20 SL1 VSS sky130_fd_pr__nfet_g5v0d10v5 w=1 l=0.5
XRn_20_1 BLN1 dn_20_1 sky130_fd_pr_reram__reram_cell area_ox=0.0676
XMp_20_2 dp_20_2 WL20 SL2 VSS sky130_fd_pr__nfet_g5v0d10v5 w=1 l=0.5
XRp_20_2 BLP2 dp_20_2 sky130_fd_pr_reram__reram_cell area_ox=0.0676
XMz_20_2 dz_20_2 WL20 SL2 VSS sky130_fd_pr__nfet_g5v0d10v5 w=1 l=0.5
XRz_20_2 BLZ2 dz_20_2 sky130_fd_pr_reram__reram_cell area_ox=0.0676
XMn_20_2 dn_20_2 WL20 SL2 VSS sky130_fd_pr__nfet_g5v0d10v5 w=1 l=0.5
XRn_20_2 BLN2 dn_20_2 sky130_fd_pr_reram__reram_cell area_ox=0.0676
XMp_20_3 dp_20_3 WL20 SL3 VSS sky130_fd_pr__nfet_g5v0d10v5 w=1 l=0.5
XRp_20_3 BLP3 dp_20_3 sky130_fd_pr_reram__reram_cell area_ox=0.0676
XMz_20_3 dz_20_3 WL20 SL3 VSS sky130_fd_pr__nfet_g5v0d10v5 w=1 l=0.5
XRz_20_3 BLZ3 dz_20_3 sky130_fd_pr_reram__reram_cell area_ox=0.0676
XMn_20_3 dn_20_3 WL20 SL3 VSS sky130_fd_pr__nfet_g5v0d10v5 w=1 l=0.5
XRn_20_3 BLN3 dn_20_3 sky130_fd_pr_reram__reram_cell area_ox=0.0676
XMp_20_4 dp_20_4 WL20 SL4 VSS sky130_fd_pr__nfet_g5v0d10v5 w=1 l=0.5
XRp_20_4 BLP4 dp_20_4 sky130_fd_pr_reram__reram_cell area_ox=0.0676
XMz_20_4 dz_20_4 WL20 SL4 VSS sky130_fd_pr__nfet_g5v0d10v5 w=1 l=0.5
XRz_20_4 BLZ4 dz_20_4 sky130_fd_pr_reram__reram_cell area_ox=0.0676
XMn_20_4 dn_20_4 WL20 SL4 VSS sky130_fd_pr__nfet_g5v0d10v5 w=1 l=0.5
XRn_20_4 BLN4 dn_20_4 sky130_fd_pr_reram__reram_cell area_ox=0.0676
XMp_20_5 dp_20_5 WL20 SL5 VSS sky130_fd_pr__nfet_g5v0d10v5 w=1 l=0.5
XRp_20_5 BLP5 dp_20_5 sky130_fd_pr_reram__reram_cell area_ox=0.0676
XMz_20_5 dz_20_5 WL20 SL5 VSS sky130_fd_pr__nfet_g5v0d10v5 w=1 l=0.5
XRz_20_5 BLZ5 dz_20_5 sky130_fd_pr_reram__reram_cell area_ox=0.0676
XMn_20_5 dn_20_5 WL20 SL5 VSS sky130_fd_pr__nfet_g5v0d10v5 w=1 l=0.5
XRn_20_5 BLN5 dn_20_5 sky130_fd_pr_reram__reram_cell area_ox=0.0676
XMp_20_6 dp_20_6 WL20 SL6 VSS sky130_fd_pr__nfet_g5v0d10v5 w=1 l=0.5
XRp_20_6 BLP6 dp_20_6 sky130_fd_pr_reram__reram_cell area_ox=0.0676
XMz_20_6 dz_20_6 WL20 SL6 VSS sky130_fd_pr__nfet_g5v0d10v5 w=1 l=0.5
XRz_20_6 BLZ6 dz_20_6 sky130_fd_pr_reram__reram_cell area_ox=0.0676
XMn_20_6 dn_20_6 WL20 SL6 VSS sky130_fd_pr__nfet_g5v0d10v5 w=1 l=0.5
XRn_20_6 BLN6 dn_20_6 sky130_fd_pr_reram__reram_cell area_ox=0.0676
XMp_20_7 dp_20_7 WL20 SL7 VSS sky130_fd_pr__nfet_g5v0d10v5 w=1 l=0.5
XRp_20_7 BLP7 dp_20_7 sky130_fd_pr_reram__reram_cell area_ox=0.0676
XMz_20_7 dz_20_7 WL20 SL7 VSS sky130_fd_pr__nfet_g5v0d10v5 w=1 l=0.5
XRz_20_7 BLZ7 dz_20_7 sky130_fd_pr_reram__reram_cell area_ox=0.0676
XMn_20_7 dn_20_7 WL20 SL7 VSS sky130_fd_pr__nfet_g5v0d10v5 w=1 l=0.5
XRn_20_7 BLN7 dn_20_7 sky130_fd_pr_reram__reram_cell area_ox=0.0676
XMp_20_8 dp_20_8 WL20 SL8 VSS sky130_fd_pr__nfet_g5v0d10v5 w=1 l=0.5
XRp_20_8 BLP8 dp_20_8 sky130_fd_pr_reram__reram_cell area_ox=0.0676
XMz_20_8 dz_20_8 WL20 SL8 VSS sky130_fd_pr__nfet_g5v0d10v5 w=1 l=0.5
XRz_20_8 BLZ8 dz_20_8 sky130_fd_pr_reram__reram_cell area_ox=0.0676
XMn_20_8 dn_20_8 WL20 SL8 VSS sky130_fd_pr__nfet_g5v0d10v5 w=1 l=0.5
XRn_20_8 BLN8 dn_20_8 sky130_fd_pr_reram__reram_cell area_ox=0.0676
XMp_20_9 dp_20_9 WL20 SL9 VSS sky130_fd_pr__nfet_g5v0d10v5 w=1 l=0.5
XRp_20_9 BLP9 dp_20_9 sky130_fd_pr_reram__reram_cell area_ox=0.0676
XMz_20_9 dz_20_9 WL20 SL9 VSS sky130_fd_pr__nfet_g5v0d10v5 w=1 l=0.5
XRz_20_9 BLZ9 dz_20_9 sky130_fd_pr_reram__reram_cell area_ox=0.0676
XMn_20_9 dn_20_9 WL20 SL9 VSS sky130_fd_pr__nfet_g5v0d10v5 w=1 l=0.5
XRn_20_9 BLN9 dn_20_9 sky130_fd_pr_reram__reram_cell area_ox=0.0676
XMp_20_10 dp_20_10 WL20 SL10 VSS sky130_fd_pr__nfet_g5v0d10v5 w=1 l=0.5
XRp_20_10 BLP10 dp_20_10 sky130_fd_pr_reram__reram_cell area_ox=0.0676
XMz_20_10 dz_20_10 WL20 SL10 VSS sky130_fd_pr__nfet_g5v0d10v5 w=1 l=0.5
XRz_20_10 BLZ10 dz_20_10 sky130_fd_pr_reram__reram_cell area_ox=0.0676
XMn_20_10 dn_20_10 WL20 SL10 VSS sky130_fd_pr__nfet_g5v0d10v5 w=1 l=0.5
XRn_20_10 BLN10 dn_20_10 sky130_fd_pr_reram__reram_cell area_ox=0.0676
XMp_20_11 dp_20_11 WL20 SL11 VSS sky130_fd_pr__nfet_g5v0d10v5 w=1 l=0.5
XRp_20_11 BLP11 dp_20_11 sky130_fd_pr_reram__reram_cell area_ox=0.0676
XMz_20_11 dz_20_11 WL20 SL11 VSS sky130_fd_pr__nfet_g5v0d10v5 w=1 l=0.5
XRz_20_11 BLZ11 dz_20_11 sky130_fd_pr_reram__reram_cell area_ox=0.0676
XMn_20_11 dn_20_11 WL20 SL11 VSS sky130_fd_pr__nfet_g5v0d10v5 w=1 l=0.5
XRn_20_11 BLN11 dn_20_11 sky130_fd_pr_reram__reram_cell area_ox=0.0676
XMp_20_12 dp_20_12 WL20 SL12 VSS sky130_fd_pr__nfet_g5v0d10v5 w=1 l=0.5
XRp_20_12 BLP12 dp_20_12 sky130_fd_pr_reram__reram_cell area_ox=0.0676
XMz_20_12 dz_20_12 WL20 SL12 VSS sky130_fd_pr__nfet_g5v0d10v5 w=1 l=0.5
XRz_20_12 BLZ12 dz_20_12 sky130_fd_pr_reram__reram_cell area_ox=0.0676
XMn_20_12 dn_20_12 WL20 SL12 VSS sky130_fd_pr__nfet_g5v0d10v5 w=1 l=0.5
XRn_20_12 BLN12 dn_20_12 sky130_fd_pr_reram__reram_cell area_ox=0.0676
XMp_20_13 dp_20_13 WL20 SL13 VSS sky130_fd_pr__nfet_g5v0d10v5 w=1 l=0.5
XRp_20_13 BLP13 dp_20_13 sky130_fd_pr_reram__reram_cell area_ox=0.0676
XMz_20_13 dz_20_13 WL20 SL13 VSS sky130_fd_pr__nfet_g5v0d10v5 w=1 l=0.5
XRz_20_13 BLZ13 dz_20_13 sky130_fd_pr_reram__reram_cell area_ox=0.0676
XMn_20_13 dn_20_13 WL20 SL13 VSS sky130_fd_pr__nfet_g5v0d10v5 w=1 l=0.5
XRn_20_13 BLN13 dn_20_13 sky130_fd_pr_reram__reram_cell area_ox=0.0676
XMp_20_14 dp_20_14 WL20 SL14 VSS sky130_fd_pr__nfet_g5v0d10v5 w=1 l=0.5
XRp_20_14 BLP14 dp_20_14 sky130_fd_pr_reram__reram_cell area_ox=0.0676
XMz_20_14 dz_20_14 WL20 SL14 VSS sky130_fd_pr__nfet_g5v0d10v5 w=1 l=0.5
XRz_20_14 BLZ14 dz_20_14 sky130_fd_pr_reram__reram_cell area_ox=0.0676
XMn_20_14 dn_20_14 WL20 SL14 VSS sky130_fd_pr__nfet_g5v0d10v5 w=1 l=0.5
XRn_20_14 BLN14 dn_20_14 sky130_fd_pr_reram__reram_cell area_ox=0.0676
XMp_20_15 dp_20_15 WL20 SL15 VSS sky130_fd_pr__nfet_g5v0d10v5 w=1 l=0.5
XRp_20_15 BLP15 dp_20_15 sky130_fd_pr_reram__reram_cell area_ox=0.0676
XMz_20_15 dz_20_15 WL20 SL15 VSS sky130_fd_pr__nfet_g5v0d10v5 w=1 l=0.5
XRz_20_15 BLZ15 dz_20_15 sky130_fd_pr_reram__reram_cell area_ox=0.0676
XMn_20_15 dn_20_15 WL20 SL15 VSS sky130_fd_pr__nfet_g5v0d10v5 w=1 l=0.5
XRn_20_15 BLN15 dn_20_15 sky130_fd_pr_reram__reram_cell area_ox=0.0676
XMp_20_16 dp_20_16 WL20 SL16 VSS sky130_fd_pr__nfet_g5v0d10v5 w=1 l=0.5
XRp_20_16 BLP16 dp_20_16 sky130_fd_pr_reram__reram_cell area_ox=0.0676
XMz_20_16 dz_20_16 WL20 SL16 VSS sky130_fd_pr__nfet_g5v0d10v5 w=1 l=0.5
XRz_20_16 BLZ16 dz_20_16 sky130_fd_pr_reram__reram_cell area_ox=0.0676
XMn_20_16 dn_20_16 WL20 SL16 VSS sky130_fd_pr__nfet_g5v0d10v5 w=1 l=0.5
XRn_20_16 BLN16 dn_20_16 sky130_fd_pr_reram__reram_cell area_ox=0.0676
XMp_20_17 dp_20_17 WL20 SL17 VSS sky130_fd_pr__nfet_g5v0d10v5 w=1 l=0.5
XRp_20_17 BLP17 dp_20_17 sky130_fd_pr_reram__reram_cell area_ox=0.0676
XMz_20_17 dz_20_17 WL20 SL17 VSS sky130_fd_pr__nfet_g5v0d10v5 w=1 l=0.5
XRz_20_17 BLZ17 dz_20_17 sky130_fd_pr_reram__reram_cell area_ox=0.0676
XMn_20_17 dn_20_17 WL20 SL17 VSS sky130_fd_pr__nfet_g5v0d10v5 w=1 l=0.5
XRn_20_17 BLN17 dn_20_17 sky130_fd_pr_reram__reram_cell area_ox=0.0676
XMp_20_18 dp_20_18 WL20 SL18 VSS sky130_fd_pr__nfet_g5v0d10v5 w=1 l=0.5
XRp_20_18 BLP18 dp_20_18 sky130_fd_pr_reram__reram_cell area_ox=0.0676
XMz_20_18 dz_20_18 WL20 SL18 VSS sky130_fd_pr__nfet_g5v0d10v5 w=1 l=0.5
XRz_20_18 BLZ18 dz_20_18 sky130_fd_pr_reram__reram_cell area_ox=0.0676
XMn_20_18 dn_20_18 WL20 SL18 VSS sky130_fd_pr__nfet_g5v0d10v5 w=1 l=0.5
XRn_20_18 BLN18 dn_20_18 sky130_fd_pr_reram__reram_cell area_ox=0.0676
XMp_20_19 dp_20_19 WL20 SL19 VSS sky130_fd_pr__nfet_g5v0d10v5 w=1 l=0.5
XRp_20_19 BLP19 dp_20_19 sky130_fd_pr_reram__reram_cell area_ox=0.0676
XMz_20_19 dz_20_19 WL20 SL19 VSS sky130_fd_pr__nfet_g5v0d10v5 w=1 l=0.5
XRz_20_19 BLZ19 dz_20_19 sky130_fd_pr_reram__reram_cell area_ox=0.0676
XMn_20_19 dn_20_19 WL20 SL19 VSS sky130_fd_pr__nfet_g5v0d10v5 w=1 l=0.5
XRn_20_19 BLN19 dn_20_19 sky130_fd_pr_reram__reram_cell area_ox=0.0676
XMp_20_20 dp_20_20 WL20 SL20 VSS sky130_fd_pr__nfet_g5v0d10v5 w=1 l=0.5
XRp_20_20 BLP20 dp_20_20 sky130_fd_pr_reram__reram_cell area_ox=0.0676
XMz_20_20 dz_20_20 WL20 SL20 VSS sky130_fd_pr__nfet_g5v0d10v5 w=1 l=0.5
XRz_20_20 BLZ20 dz_20_20 sky130_fd_pr_reram__reram_cell area_ox=0.0676
XMn_20_20 dn_20_20 WL20 SL20 VSS sky130_fd_pr__nfet_g5v0d10v5 w=1 l=0.5
XRn_20_20 BLN20 dn_20_20 sky130_fd_pr_reram__reram_cell area_ox=0.0676
XMp_20_21 dp_20_21 WL20 SL21 VSS sky130_fd_pr__nfet_g5v0d10v5 w=1 l=0.5
XRp_20_21 BLP21 dp_20_21 sky130_fd_pr_reram__reram_cell area_ox=0.0676
XMz_20_21 dz_20_21 WL20 SL21 VSS sky130_fd_pr__nfet_g5v0d10v5 w=1 l=0.5
XRz_20_21 BLZ21 dz_20_21 sky130_fd_pr_reram__reram_cell area_ox=0.0676
XMn_20_21 dn_20_21 WL20 SL21 VSS sky130_fd_pr__nfet_g5v0d10v5 w=1 l=0.5
XRn_20_21 BLN21 dn_20_21 sky130_fd_pr_reram__reram_cell area_ox=0.0676
XMp_20_22 dp_20_22 WL20 SL22 VSS sky130_fd_pr__nfet_g5v0d10v5 w=1 l=0.5
XRp_20_22 BLP22 dp_20_22 sky130_fd_pr_reram__reram_cell area_ox=0.0676
XMz_20_22 dz_20_22 WL20 SL22 VSS sky130_fd_pr__nfet_g5v0d10v5 w=1 l=0.5
XRz_20_22 BLZ22 dz_20_22 sky130_fd_pr_reram__reram_cell area_ox=0.0676
XMn_20_22 dn_20_22 WL20 SL22 VSS sky130_fd_pr__nfet_g5v0d10v5 w=1 l=0.5
XRn_20_22 BLN22 dn_20_22 sky130_fd_pr_reram__reram_cell area_ox=0.0676
XMp_20_23 dp_20_23 WL20 SL23 VSS sky130_fd_pr__nfet_g5v0d10v5 w=1 l=0.5
XRp_20_23 BLP23 dp_20_23 sky130_fd_pr_reram__reram_cell area_ox=0.0676
XMz_20_23 dz_20_23 WL20 SL23 VSS sky130_fd_pr__nfet_g5v0d10v5 w=1 l=0.5
XRz_20_23 BLZ23 dz_20_23 sky130_fd_pr_reram__reram_cell area_ox=0.0676
XMn_20_23 dn_20_23 WL20 SL23 VSS sky130_fd_pr__nfet_g5v0d10v5 w=1 l=0.5
XRn_20_23 BLN23 dn_20_23 sky130_fd_pr_reram__reram_cell area_ox=0.0676
XMp_21_0 dp_21_0 WL21 SL0 VSS sky130_fd_pr__nfet_g5v0d10v5 w=1 l=0.5
XRp_21_0 BLP0 dp_21_0 sky130_fd_pr_reram__reram_cell area_ox=0.0676
XMz_21_0 dz_21_0 WL21 SL0 VSS sky130_fd_pr__nfet_g5v0d10v5 w=1 l=0.5
XRz_21_0 BLZ0 dz_21_0 sky130_fd_pr_reram__reram_cell area_ox=0.0676
XMn_21_0 dn_21_0 WL21 SL0 VSS sky130_fd_pr__nfet_g5v0d10v5 w=1 l=0.5
XRn_21_0 BLN0 dn_21_0 sky130_fd_pr_reram__reram_cell area_ox=0.0676
XMp_21_1 dp_21_1 WL21 SL1 VSS sky130_fd_pr__nfet_g5v0d10v5 w=1 l=0.5
XRp_21_1 BLP1 dp_21_1 sky130_fd_pr_reram__reram_cell area_ox=0.0676
XMz_21_1 dz_21_1 WL21 SL1 VSS sky130_fd_pr__nfet_g5v0d10v5 w=1 l=0.5
XRz_21_1 BLZ1 dz_21_1 sky130_fd_pr_reram__reram_cell area_ox=0.0676
XMn_21_1 dn_21_1 WL21 SL1 VSS sky130_fd_pr__nfet_g5v0d10v5 w=1 l=0.5
XRn_21_1 BLN1 dn_21_1 sky130_fd_pr_reram__reram_cell area_ox=0.0676
XMp_21_2 dp_21_2 WL21 SL2 VSS sky130_fd_pr__nfet_g5v0d10v5 w=1 l=0.5
XRp_21_2 BLP2 dp_21_2 sky130_fd_pr_reram__reram_cell area_ox=0.0676
XMz_21_2 dz_21_2 WL21 SL2 VSS sky130_fd_pr__nfet_g5v0d10v5 w=1 l=0.5
XRz_21_2 BLZ2 dz_21_2 sky130_fd_pr_reram__reram_cell area_ox=0.0676
XMn_21_2 dn_21_2 WL21 SL2 VSS sky130_fd_pr__nfet_g5v0d10v5 w=1 l=0.5
XRn_21_2 BLN2 dn_21_2 sky130_fd_pr_reram__reram_cell area_ox=0.0676
XMp_21_3 dp_21_3 WL21 SL3 VSS sky130_fd_pr__nfet_g5v0d10v5 w=1 l=0.5
XRp_21_3 BLP3 dp_21_3 sky130_fd_pr_reram__reram_cell area_ox=0.0676
XMz_21_3 dz_21_3 WL21 SL3 VSS sky130_fd_pr__nfet_g5v0d10v5 w=1 l=0.5
XRz_21_3 BLZ3 dz_21_3 sky130_fd_pr_reram__reram_cell area_ox=0.0676
XMn_21_3 dn_21_3 WL21 SL3 VSS sky130_fd_pr__nfet_g5v0d10v5 w=1 l=0.5
XRn_21_3 BLN3 dn_21_3 sky130_fd_pr_reram__reram_cell area_ox=0.0676
XMp_21_4 dp_21_4 WL21 SL4 VSS sky130_fd_pr__nfet_g5v0d10v5 w=1 l=0.5
XRp_21_4 BLP4 dp_21_4 sky130_fd_pr_reram__reram_cell area_ox=0.0676
XMz_21_4 dz_21_4 WL21 SL4 VSS sky130_fd_pr__nfet_g5v0d10v5 w=1 l=0.5
XRz_21_4 BLZ4 dz_21_4 sky130_fd_pr_reram__reram_cell area_ox=0.0676
XMn_21_4 dn_21_4 WL21 SL4 VSS sky130_fd_pr__nfet_g5v0d10v5 w=1 l=0.5
XRn_21_4 BLN4 dn_21_4 sky130_fd_pr_reram__reram_cell area_ox=0.0676
XMp_21_5 dp_21_5 WL21 SL5 VSS sky130_fd_pr__nfet_g5v0d10v5 w=1 l=0.5
XRp_21_5 BLP5 dp_21_5 sky130_fd_pr_reram__reram_cell area_ox=0.0676
XMz_21_5 dz_21_5 WL21 SL5 VSS sky130_fd_pr__nfet_g5v0d10v5 w=1 l=0.5
XRz_21_5 BLZ5 dz_21_5 sky130_fd_pr_reram__reram_cell area_ox=0.0676
XMn_21_5 dn_21_5 WL21 SL5 VSS sky130_fd_pr__nfet_g5v0d10v5 w=1 l=0.5
XRn_21_5 BLN5 dn_21_5 sky130_fd_pr_reram__reram_cell area_ox=0.0676
XMp_21_6 dp_21_6 WL21 SL6 VSS sky130_fd_pr__nfet_g5v0d10v5 w=1 l=0.5
XRp_21_6 BLP6 dp_21_6 sky130_fd_pr_reram__reram_cell area_ox=0.0676
XMz_21_6 dz_21_6 WL21 SL6 VSS sky130_fd_pr__nfet_g5v0d10v5 w=1 l=0.5
XRz_21_6 BLZ6 dz_21_6 sky130_fd_pr_reram__reram_cell area_ox=0.0676
XMn_21_6 dn_21_6 WL21 SL6 VSS sky130_fd_pr__nfet_g5v0d10v5 w=1 l=0.5
XRn_21_6 BLN6 dn_21_6 sky130_fd_pr_reram__reram_cell area_ox=0.0676
XMp_21_7 dp_21_7 WL21 SL7 VSS sky130_fd_pr__nfet_g5v0d10v5 w=1 l=0.5
XRp_21_7 BLP7 dp_21_7 sky130_fd_pr_reram__reram_cell area_ox=0.0676
XMz_21_7 dz_21_7 WL21 SL7 VSS sky130_fd_pr__nfet_g5v0d10v5 w=1 l=0.5
XRz_21_7 BLZ7 dz_21_7 sky130_fd_pr_reram__reram_cell area_ox=0.0676
XMn_21_7 dn_21_7 WL21 SL7 VSS sky130_fd_pr__nfet_g5v0d10v5 w=1 l=0.5
XRn_21_7 BLN7 dn_21_7 sky130_fd_pr_reram__reram_cell area_ox=0.0676
XMp_21_8 dp_21_8 WL21 SL8 VSS sky130_fd_pr__nfet_g5v0d10v5 w=1 l=0.5
XRp_21_8 BLP8 dp_21_8 sky130_fd_pr_reram__reram_cell area_ox=0.0676
XMz_21_8 dz_21_8 WL21 SL8 VSS sky130_fd_pr__nfet_g5v0d10v5 w=1 l=0.5
XRz_21_8 BLZ8 dz_21_8 sky130_fd_pr_reram__reram_cell area_ox=0.0676
XMn_21_8 dn_21_8 WL21 SL8 VSS sky130_fd_pr__nfet_g5v0d10v5 w=1 l=0.5
XRn_21_8 BLN8 dn_21_8 sky130_fd_pr_reram__reram_cell area_ox=0.0676
XMp_21_9 dp_21_9 WL21 SL9 VSS sky130_fd_pr__nfet_g5v0d10v5 w=1 l=0.5
XRp_21_9 BLP9 dp_21_9 sky130_fd_pr_reram__reram_cell area_ox=0.0676
XMz_21_9 dz_21_9 WL21 SL9 VSS sky130_fd_pr__nfet_g5v0d10v5 w=1 l=0.5
XRz_21_9 BLZ9 dz_21_9 sky130_fd_pr_reram__reram_cell area_ox=0.0676
XMn_21_9 dn_21_9 WL21 SL9 VSS sky130_fd_pr__nfet_g5v0d10v5 w=1 l=0.5
XRn_21_9 BLN9 dn_21_9 sky130_fd_pr_reram__reram_cell area_ox=0.0676
XMp_21_10 dp_21_10 WL21 SL10 VSS sky130_fd_pr__nfet_g5v0d10v5 w=1 l=0.5
XRp_21_10 BLP10 dp_21_10 sky130_fd_pr_reram__reram_cell area_ox=0.0676
XMz_21_10 dz_21_10 WL21 SL10 VSS sky130_fd_pr__nfet_g5v0d10v5 w=1 l=0.5
XRz_21_10 BLZ10 dz_21_10 sky130_fd_pr_reram__reram_cell area_ox=0.0676
XMn_21_10 dn_21_10 WL21 SL10 VSS sky130_fd_pr__nfet_g5v0d10v5 w=1 l=0.5
XRn_21_10 BLN10 dn_21_10 sky130_fd_pr_reram__reram_cell area_ox=0.0676
XMp_21_11 dp_21_11 WL21 SL11 VSS sky130_fd_pr__nfet_g5v0d10v5 w=1 l=0.5
XRp_21_11 BLP11 dp_21_11 sky130_fd_pr_reram__reram_cell area_ox=0.0676
XMz_21_11 dz_21_11 WL21 SL11 VSS sky130_fd_pr__nfet_g5v0d10v5 w=1 l=0.5
XRz_21_11 BLZ11 dz_21_11 sky130_fd_pr_reram__reram_cell area_ox=0.0676
XMn_21_11 dn_21_11 WL21 SL11 VSS sky130_fd_pr__nfet_g5v0d10v5 w=1 l=0.5
XRn_21_11 BLN11 dn_21_11 sky130_fd_pr_reram__reram_cell area_ox=0.0676
XMp_21_12 dp_21_12 WL21 SL12 VSS sky130_fd_pr__nfet_g5v0d10v5 w=1 l=0.5
XRp_21_12 BLP12 dp_21_12 sky130_fd_pr_reram__reram_cell area_ox=0.0676
XMz_21_12 dz_21_12 WL21 SL12 VSS sky130_fd_pr__nfet_g5v0d10v5 w=1 l=0.5
XRz_21_12 BLZ12 dz_21_12 sky130_fd_pr_reram__reram_cell area_ox=0.0676
XMn_21_12 dn_21_12 WL21 SL12 VSS sky130_fd_pr__nfet_g5v0d10v5 w=1 l=0.5
XRn_21_12 BLN12 dn_21_12 sky130_fd_pr_reram__reram_cell area_ox=0.0676
XMp_21_13 dp_21_13 WL21 SL13 VSS sky130_fd_pr__nfet_g5v0d10v5 w=1 l=0.5
XRp_21_13 BLP13 dp_21_13 sky130_fd_pr_reram__reram_cell area_ox=0.0676
XMz_21_13 dz_21_13 WL21 SL13 VSS sky130_fd_pr__nfet_g5v0d10v5 w=1 l=0.5
XRz_21_13 BLZ13 dz_21_13 sky130_fd_pr_reram__reram_cell area_ox=0.0676
XMn_21_13 dn_21_13 WL21 SL13 VSS sky130_fd_pr__nfet_g5v0d10v5 w=1 l=0.5
XRn_21_13 BLN13 dn_21_13 sky130_fd_pr_reram__reram_cell area_ox=0.0676
XMp_21_14 dp_21_14 WL21 SL14 VSS sky130_fd_pr__nfet_g5v0d10v5 w=1 l=0.5
XRp_21_14 BLP14 dp_21_14 sky130_fd_pr_reram__reram_cell area_ox=0.0676
XMz_21_14 dz_21_14 WL21 SL14 VSS sky130_fd_pr__nfet_g5v0d10v5 w=1 l=0.5
XRz_21_14 BLZ14 dz_21_14 sky130_fd_pr_reram__reram_cell area_ox=0.0676
XMn_21_14 dn_21_14 WL21 SL14 VSS sky130_fd_pr__nfet_g5v0d10v5 w=1 l=0.5
XRn_21_14 BLN14 dn_21_14 sky130_fd_pr_reram__reram_cell area_ox=0.0676
XMp_21_15 dp_21_15 WL21 SL15 VSS sky130_fd_pr__nfet_g5v0d10v5 w=1 l=0.5
XRp_21_15 BLP15 dp_21_15 sky130_fd_pr_reram__reram_cell area_ox=0.0676
XMz_21_15 dz_21_15 WL21 SL15 VSS sky130_fd_pr__nfet_g5v0d10v5 w=1 l=0.5
XRz_21_15 BLZ15 dz_21_15 sky130_fd_pr_reram__reram_cell area_ox=0.0676
XMn_21_15 dn_21_15 WL21 SL15 VSS sky130_fd_pr__nfet_g5v0d10v5 w=1 l=0.5
XRn_21_15 BLN15 dn_21_15 sky130_fd_pr_reram__reram_cell area_ox=0.0676
XMp_21_16 dp_21_16 WL21 SL16 VSS sky130_fd_pr__nfet_g5v0d10v5 w=1 l=0.5
XRp_21_16 BLP16 dp_21_16 sky130_fd_pr_reram__reram_cell area_ox=0.0676
XMz_21_16 dz_21_16 WL21 SL16 VSS sky130_fd_pr__nfet_g5v0d10v5 w=1 l=0.5
XRz_21_16 BLZ16 dz_21_16 sky130_fd_pr_reram__reram_cell area_ox=0.0676
XMn_21_16 dn_21_16 WL21 SL16 VSS sky130_fd_pr__nfet_g5v0d10v5 w=1 l=0.5
XRn_21_16 BLN16 dn_21_16 sky130_fd_pr_reram__reram_cell area_ox=0.0676
XMp_21_17 dp_21_17 WL21 SL17 VSS sky130_fd_pr__nfet_g5v0d10v5 w=1 l=0.5
XRp_21_17 BLP17 dp_21_17 sky130_fd_pr_reram__reram_cell area_ox=0.0676
XMz_21_17 dz_21_17 WL21 SL17 VSS sky130_fd_pr__nfet_g5v0d10v5 w=1 l=0.5
XRz_21_17 BLZ17 dz_21_17 sky130_fd_pr_reram__reram_cell area_ox=0.0676
XMn_21_17 dn_21_17 WL21 SL17 VSS sky130_fd_pr__nfet_g5v0d10v5 w=1 l=0.5
XRn_21_17 BLN17 dn_21_17 sky130_fd_pr_reram__reram_cell area_ox=0.0676
XMp_21_18 dp_21_18 WL21 SL18 VSS sky130_fd_pr__nfet_g5v0d10v5 w=1 l=0.5
XRp_21_18 BLP18 dp_21_18 sky130_fd_pr_reram__reram_cell area_ox=0.0676
XMz_21_18 dz_21_18 WL21 SL18 VSS sky130_fd_pr__nfet_g5v0d10v5 w=1 l=0.5
XRz_21_18 BLZ18 dz_21_18 sky130_fd_pr_reram__reram_cell area_ox=0.0676
XMn_21_18 dn_21_18 WL21 SL18 VSS sky130_fd_pr__nfet_g5v0d10v5 w=1 l=0.5
XRn_21_18 BLN18 dn_21_18 sky130_fd_pr_reram__reram_cell area_ox=0.0676
XMp_21_19 dp_21_19 WL21 SL19 VSS sky130_fd_pr__nfet_g5v0d10v5 w=1 l=0.5
XRp_21_19 BLP19 dp_21_19 sky130_fd_pr_reram__reram_cell area_ox=0.0676
XMz_21_19 dz_21_19 WL21 SL19 VSS sky130_fd_pr__nfet_g5v0d10v5 w=1 l=0.5
XRz_21_19 BLZ19 dz_21_19 sky130_fd_pr_reram__reram_cell area_ox=0.0676
XMn_21_19 dn_21_19 WL21 SL19 VSS sky130_fd_pr__nfet_g5v0d10v5 w=1 l=0.5
XRn_21_19 BLN19 dn_21_19 sky130_fd_pr_reram__reram_cell area_ox=0.0676
XMp_21_20 dp_21_20 WL21 SL20 VSS sky130_fd_pr__nfet_g5v0d10v5 w=1 l=0.5
XRp_21_20 BLP20 dp_21_20 sky130_fd_pr_reram__reram_cell area_ox=0.0676
XMz_21_20 dz_21_20 WL21 SL20 VSS sky130_fd_pr__nfet_g5v0d10v5 w=1 l=0.5
XRz_21_20 BLZ20 dz_21_20 sky130_fd_pr_reram__reram_cell area_ox=0.0676
XMn_21_20 dn_21_20 WL21 SL20 VSS sky130_fd_pr__nfet_g5v0d10v5 w=1 l=0.5
XRn_21_20 BLN20 dn_21_20 sky130_fd_pr_reram__reram_cell area_ox=0.0676
XMp_21_21 dp_21_21 WL21 SL21 VSS sky130_fd_pr__nfet_g5v0d10v5 w=1 l=0.5
XRp_21_21 BLP21 dp_21_21 sky130_fd_pr_reram__reram_cell area_ox=0.0676
XMz_21_21 dz_21_21 WL21 SL21 VSS sky130_fd_pr__nfet_g5v0d10v5 w=1 l=0.5
XRz_21_21 BLZ21 dz_21_21 sky130_fd_pr_reram__reram_cell area_ox=0.0676
XMn_21_21 dn_21_21 WL21 SL21 VSS sky130_fd_pr__nfet_g5v0d10v5 w=1 l=0.5
XRn_21_21 BLN21 dn_21_21 sky130_fd_pr_reram__reram_cell area_ox=0.0676
XMp_21_22 dp_21_22 WL21 SL22 VSS sky130_fd_pr__nfet_g5v0d10v5 w=1 l=0.5
XRp_21_22 BLP22 dp_21_22 sky130_fd_pr_reram__reram_cell area_ox=0.0676
XMz_21_22 dz_21_22 WL21 SL22 VSS sky130_fd_pr__nfet_g5v0d10v5 w=1 l=0.5
XRz_21_22 BLZ22 dz_21_22 sky130_fd_pr_reram__reram_cell area_ox=0.0676
XMn_21_22 dn_21_22 WL21 SL22 VSS sky130_fd_pr__nfet_g5v0d10v5 w=1 l=0.5
XRn_21_22 BLN22 dn_21_22 sky130_fd_pr_reram__reram_cell area_ox=0.0676
XMp_21_23 dp_21_23 WL21 SL23 VSS sky130_fd_pr__nfet_g5v0d10v5 w=1 l=0.5
XRp_21_23 BLP23 dp_21_23 sky130_fd_pr_reram__reram_cell area_ox=0.0676
XMz_21_23 dz_21_23 WL21 SL23 VSS sky130_fd_pr__nfet_g5v0d10v5 w=1 l=0.5
XRz_21_23 BLZ23 dz_21_23 sky130_fd_pr_reram__reram_cell area_ox=0.0676
XMn_21_23 dn_21_23 WL21 SL23 VSS sky130_fd_pr__nfet_g5v0d10v5 w=1 l=0.5
XRn_21_23 BLN23 dn_21_23 sky130_fd_pr_reram__reram_cell area_ox=0.0676
XMp_22_0 dp_22_0 WL22 SL0 VSS sky130_fd_pr__nfet_g5v0d10v5 w=1 l=0.5
XRp_22_0 BLP0 dp_22_0 sky130_fd_pr_reram__reram_cell area_ox=0.0676
XMz_22_0 dz_22_0 WL22 SL0 VSS sky130_fd_pr__nfet_g5v0d10v5 w=1 l=0.5
XRz_22_0 BLZ0 dz_22_0 sky130_fd_pr_reram__reram_cell area_ox=0.0676
XMn_22_0 dn_22_0 WL22 SL0 VSS sky130_fd_pr__nfet_g5v0d10v5 w=1 l=0.5
XRn_22_0 BLN0 dn_22_0 sky130_fd_pr_reram__reram_cell area_ox=0.0676
XMp_22_1 dp_22_1 WL22 SL1 VSS sky130_fd_pr__nfet_g5v0d10v5 w=1 l=0.5
XRp_22_1 BLP1 dp_22_1 sky130_fd_pr_reram__reram_cell area_ox=0.0676
XMz_22_1 dz_22_1 WL22 SL1 VSS sky130_fd_pr__nfet_g5v0d10v5 w=1 l=0.5
XRz_22_1 BLZ1 dz_22_1 sky130_fd_pr_reram__reram_cell area_ox=0.0676
XMn_22_1 dn_22_1 WL22 SL1 VSS sky130_fd_pr__nfet_g5v0d10v5 w=1 l=0.5
XRn_22_1 BLN1 dn_22_1 sky130_fd_pr_reram__reram_cell area_ox=0.0676
XMp_22_2 dp_22_2 WL22 SL2 VSS sky130_fd_pr__nfet_g5v0d10v5 w=1 l=0.5
XRp_22_2 BLP2 dp_22_2 sky130_fd_pr_reram__reram_cell area_ox=0.0676
XMz_22_2 dz_22_2 WL22 SL2 VSS sky130_fd_pr__nfet_g5v0d10v5 w=1 l=0.5
XRz_22_2 BLZ2 dz_22_2 sky130_fd_pr_reram__reram_cell area_ox=0.0676
XMn_22_2 dn_22_2 WL22 SL2 VSS sky130_fd_pr__nfet_g5v0d10v5 w=1 l=0.5
XRn_22_2 BLN2 dn_22_2 sky130_fd_pr_reram__reram_cell area_ox=0.0676
XMp_22_3 dp_22_3 WL22 SL3 VSS sky130_fd_pr__nfet_g5v0d10v5 w=1 l=0.5
XRp_22_3 BLP3 dp_22_3 sky130_fd_pr_reram__reram_cell area_ox=0.0676
XMz_22_3 dz_22_3 WL22 SL3 VSS sky130_fd_pr__nfet_g5v0d10v5 w=1 l=0.5
XRz_22_3 BLZ3 dz_22_3 sky130_fd_pr_reram__reram_cell area_ox=0.0676
XMn_22_3 dn_22_3 WL22 SL3 VSS sky130_fd_pr__nfet_g5v0d10v5 w=1 l=0.5
XRn_22_3 BLN3 dn_22_3 sky130_fd_pr_reram__reram_cell area_ox=0.0676
XMp_22_4 dp_22_4 WL22 SL4 VSS sky130_fd_pr__nfet_g5v0d10v5 w=1 l=0.5
XRp_22_4 BLP4 dp_22_4 sky130_fd_pr_reram__reram_cell area_ox=0.0676
XMz_22_4 dz_22_4 WL22 SL4 VSS sky130_fd_pr__nfet_g5v0d10v5 w=1 l=0.5
XRz_22_4 BLZ4 dz_22_4 sky130_fd_pr_reram__reram_cell area_ox=0.0676
XMn_22_4 dn_22_4 WL22 SL4 VSS sky130_fd_pr__nfet_g5v0d10v5 w=1 l=0.5
XRn_22_4 BLN4 dn_22_4 sky130_fd_pr_reram__reram_cell area_ox=0.0676
XMp_22_5 dp_22_5 WL22 SL5 VSS sky130_fd_pr__nfet_g5v0d10v5 w=1 l=0.5
XRp_22_5 BLP5 dp_22_5 sky130_fd_pr_reram__reram_cell area_ox=0.0676
XMz_22_5 dz_22_5 WL22 SL5 VSS sky130_fd_pr__nfet_g5v0d10v5 w=1 l=0.5
XRz_22_5 BLZ5 dz_22_5 sky130_fd_pr_reram__reram_cell area_ox=0.0676
XMn_22_5 dn_22_5 WL22 SL5 VSS sky130_fd_pr__nfet_g5v0d10v5 w=1 l=0.5
XRn_22_5 BLN5 dn_22_5 sky130_fd_pr_reram__reram_cell area_ox=0.0676
XMp_22_6 dp_22_6 WL22 SL6 VSS sky130_fd_pr__nfet_g5v0d10v5 w=1 l=0.5
XRp_22_6 BLP6 dp_22_6 sky130_fd_pr_reram__reram_cell area_ox=0.0676
XMz_22_6 dz_22_6 WL22 SL6 VSS sky130_fd_pr__nfet_g5v0d10v5 w=1 l=0.5
XRz_22_6 BLZ6 dz_22_6 sky130_fd_pr_reram__reram_cell area_ox=0.0676
XMn_22_6 dn_22_6 WL22 SL6 VSS sky130_fd_pr__nfet_g5v0d10v5 w=1 l=0.5
XRn_22_6 BLN6 dn_22_6 sky130_fd_pr_reram__reram_cell area_ox=0.0676
XMp_22_7 dp_22_7 WL22 SL7 VSS sky130_fd_pr__nfet_g5v0d10v5 w=1 l=0.5
XRp_22_7 BLP7 dp_22_7 sky130_fd_pr_reram__reram_cell area_ox=0.0676
XMz_22_7 dz_22_7 WL22 SL7 VSS sky130_fd_pr__nfet_g5v0d10v5 w=1 l=0.5
XRz_22_7 BLZ7 dz_22_7 sky130_fd_pr_reram__reram_cell area_ox=0.0676
XMn_22_7 dn_22_7 WL22 SL7 VSS sky130_fd_pr__nfet_g5v0d10v5 w=1 l=0.5
XRn_22_7 BLN7 dn_22_7 sky130_fd_pr_reram__reram_cell area_ox=0.0676
XMp_22_8 dp_22_8 WL22 SL8 VSS sky130_fd_pr__nfet_g5v0d10v5 w=1 l=0.5
XRp_22_8 BLP8 dp_22_8 sky130_fd_pr_reram__reram_cell area_ox=0.0676
XMz_22_8 dz_22_8 WL22 SL8 VSS sky130_fd_pr__nfet_g5v0d10v5 w=1 l=0.5
XRz_22_8 BLZ8 dz_22_8 sky130_fd_pr_reram__reram_cell area_ox=0.0676
XMn_22_8 dn_22_8 WL22 SL8 VSS sky130_fd_pr__nfet_g5v0d10v5 w=1 l=0.5
XRn_22_8 BLN8 dn_22_8 sky130_fd_pr_reram__reram_cell area_ox=0.0676
XMp_22_9 dp_22_9 WL22 SL9 VSS sky130_fd_pr__nfet_g5v0d10v5 w=1 l=0.5
XRp_22_9 BLP9 dp_22_9 sky130_fd_pr_reram__reram_cell area_ox=0.0676
XMz_22_9 dz_22_9 WL22 SL9 VSS sky130_fd_pr__nfet_g5v0d10v5 w=1 l=0.5
XRz_22_9 BLZ9 dz_22_9 sky130_fd_pr_reram__reram_cell area_ox=0.0676
XMn_22_9 dn_22_9 WL22 SL9 VSS sky130_fd_pr__nfet_g5v0d10v5 w=1 l=0.5
XRn_22_9 BLN9 dn_22_9 sky130_fd_pr_reram__reram_cell area_ox=0.0676
XMp_22_10 dp_22_10 WL22 SL10 VSS sky130_fd_pr__nfet_g5v0d10v5 w=1 l=0.5
XRp_22_10 BLP10 dp_22_10 sky130_fd_pr_reram__reram_cell area_ox=0.0676
XMz_22_10 dz_22_10 WL22 SL10 VSS sky130_fd_pr__nfet_g5v0d10v5 w=1 l=0.5
XRz_22_10 BLZ10 dz_22_10 sky130_fd_pr_reram__reram_cell area_ox=0.0676
XMn_22_10 dn_22_10 WL22 SL10 VSS sky130_fd_pr__nfet_g5v0d10v5 w=1 l=0.5
XRn_22_10 BLN10 dn_22_10 sky130_fd_pr_reram__reram_cell area_ox=0.0676
XMp_22_11 dp_22_11 WL22 SL11 VSS sky130_fd_pr__nfet_g5v0d10v5 w=1 l=0.5
XRp_22_11 BLP11 dp_22_11 sky130_fd_pr_reram__reram_cell area_ox=0.0676
XMz_22_11 dz_22_11 WL22 SL11 VSS sky130_fd_pr__nfet_g5v0d10v5 w=1 l=0.5
XRz_22_11 BLZ11 dz_22_11 sky130_fd_pr_reram__reram_cell area_ox=0.0676
XMn_22_11 dn_22_11 WL22 SL11 VSS sky130_fd_pr__nfet_g5v0d10v5 w=1 l=0.5
XRn_22_11 BLN11 dn_22_11 sky130_fd_pr_reram__reram_cell area_ox=0.0676
XMp_22_12 dp_22_12 WL22 SL12 VSS sky130_fd_pr__nfet_g5v0d10v5 w=1 l=0.5
XRp_22_12 BLP12 dp_22_12 sky130_fd_pr_reram__reram_cell area_ox=0.0676
XMz_22_12 dz_22_12 WL22 SL12 VSS sky130_fd_pr__nfet_g5v0d10v5 w=1 l=0.5
XRz_22_12 BLZ12 dz_22_12 sky130_fd_pr_reram__reram_cell area_ox=0.0676
XMn_22_12 dn_22_12 WL22 SL12 VSS sky130_fd_pr__nfet_g5v0d10v5 w=1 l=0.5
XRn_22_12 BLN12 dn_22_12 sky130_fd_pr_reram__reram_cell area_ox=0.0676
XMp_22_13 dp_22_13 WL22 SL13 VSS sky130_fd_pr__nfet_g5v0d10v5 w=1 l=0.5
XRp_22_13 BLP13 dp_22_13 sky130_fd_pr_reram__reram_cell area_ox=0.0676
XMz_22_13 dz_22_13 WL22 SL13 VSS sky130_fd_pr__nfet_g5v0d10v5 w=1 l=0.5
XRz_22_13 BLZ13 dz_22_13 sky130_fd_pr_reram__reram_cell area_ox=0.0676
XMn_22_13 dn_22_13 WL22 SL13 VSS sky130_fd_pr__nfet_g5v0d10v5 w=1 l=0.5
XRn_22_13 BLN13 dn_22_13 sky130_fd_pr_reram__reram_cell area_ox=0.0676
XMp_22_14 dp_22_14 WL22 SL14 VSS sky130_fd_pr__nfet_g5v0d10v5 w=1 l=0.5
XRp_22_14 BLP14 dp_22_14 sky130_fd_pr_reram__reram_cell area_ox=0.0676
XMz_22_14 dz_22_14 WL22 SL14 VSS sky130_fd_pr__nfet_g5v0d10v5 w=1 l=0.5
XRz_22_14 BLZ14 dz_22_14 sky130_fd_pr_reram__reram_cell area_ox=0.0676
XMn_22_14 dn_22_14 WL22 SL14 VSS sky130_fd_pr__nfet_g5v0d10v5 w=1 l=0.5
XRn_22_14 BLN14 dn_22_14 sky130_fd_pr_reram__reram_cell area_ox=0.0676
XMp_22_15 dp_22_15 WL22 SL15 VSS sky130_fd_pr__nfet_g5v0d10v5 w=1 l=0.5
XRp_22_15 BLP15 dp_22_15 sky130_fd_pr_reram__reram_cell area_ox=0.0676
XMz_22_15 dz_22_15 WL22 SL15 VSS sky130_fd_pr__nfet_g5v0d10v5 w=1 l=0.5
XRz_22_15 BLZ15 dz_22_15 sky130_fd_pr_reram__reram_cell area_ox=0.0676
XMn_22_15 dn_22_15 WL22 SL15 VSS sky130_fd_pr__nfet_g5v0d10v5 w=1 l=0.5
XRn_22_15 BLN15 dn_22_15 sky130_fd_pr_reram__reram_cell area_ox=0.0676
XMp_22_16 dp_22_16 WL22 SL16 VSS sky130_fd_pr__nfet_g5v0d10v5 w=1 l=0.5
XRp_22_16 BLP16 dp_22_16 sky130_fd_pr_reram__reram_cell area_ox=0.0676
XMz_22_16 dz_22_16 WL22 SL16 VSS sky130_fd_pr__nfet_g5v0d10v5 w=1 l=0.5
XRz_22_16 BLZ16 dz_22_16 sky130_fd_pr_reram__reram_cell area_ox=0.0676
XMn_22_16 dn_22_16 WL22 SL16 VSS sky130_fd_pr__nfet_g5v0d10v5 w=1 l=0.5
XRn_22_16 BLN16 dn_22_16 sky130_fd_pr_reram__reram_cell area_ox=0.0676
XMp_22_17 dp_22_17 WL22 SL17 VSS sky130_fd_pr__nfet_g5v0d10v5 w=1 l=0.5
XRp_22_17 BLP17 dp_22_17 sky130_fd_pr_reram__reram_cell area_ox=0.0676
XMz_22_17 dz_22_17 WL22 SL17 VSS sky130_fd_pr__nfet_g5v0d10v5 w=1 l=0.5
XRz_22_17 BLZ17 dz_22_17 sky130_fd_pr_reram__reram_cell area_ox=0.0676
XMn_22_17 dn_22_17 WL22 SL17 VSS sky130_fd_pr__nfet_g5v0d10v5 w=1 l=0.5
XRn_22_17 BLN17 dn_22_17 sky130_fd_pr_reram__reram_cell area_ox=0.0676
XMp_22_18 dp_22_18 WL22 SL18 VSS sky130_fd_pr__nfet_g5v0d10v5 w=1 l=0.5
XRp_22_18 BLP18 dp_22_18 sky130_fd_pr_reram__reram_cell area_ox=0.0676
XMz_22_18 dz_22_18 WL22 SL18 VSS sky130_fd_pr__nfet_g5v0d10v5 w=1 l=0.5
XRz_22_18 BLZ18 dz_22_18 sky130_fd_pr_reram__reram_cell area_ox=0.0676
XMn_22_18 dn_22_18 WL22 SL18 VSS sky130_fd_pr__nfet_g5v0d10v5 w=1 l=0.5
XRn_22_18 BLN18 dn_22_18 sky130_fd_pr_reram__reram_cell area_ox=0.0676
XMp_22_19 dp_22_19 WL22 SL19 VSS sky130_fd_pr__nfet_g5v0d10v5 w=1 l=0.5
XRp_22_19 BLP19 dp_22_19 sky130_fd_pr_reram__reram_cell area_ox=0.0676
XMz_22_19 dz_22_19 WL22 SL19 VSS sky130_fd_pr__nfet_g5v0d10v5 w=1 l=0.5
XRz_22_19 BLZ19 dz_22_19 sky130_fd_pr_reram__reram_cell area_ox=0.0676
XMn_22_19 dn_22_19 WL22 SL19 VSS sky130_fd_pr__nfet_g5v0d10v5 w=1 l=0.5
XRn_22_19 BLN19 dn_22_19 sky130_fd_pr_reram__reram_cell area_ox=0.0676
XMp_22_20 dp_22_20 WL22 SL20 VSS sky130_fd_pr__nfet_g5v0d10v5 w=1 l=0.5
XRp_22_20 BLP20 dp_22_20 sky130_fd_pr_reram__reram_cell area_ox=0.0676
XMz_22_20 dz_22_20 WL22 SL20 VSS sky130_fd_pr__nfet_g5v0d10v5 w=1 l=0.5
XRz_22_20 BLZ20 dz_22_20 sky130_fd_pr_reram__reram_cell area_ox=0.0676
XMn_22_20 dn_22_20 WL22 SL20 VSS sky130_fd_pr__nfet_g5v0d10v5 w=1 l=0.5
XRn_22_20 BLN20 dn_22_20 sky130_fd_pr_reram__reram_cell area_ox=0.0676
XMp_22_21 dp_22_21 WL22 SL21 VSS sky130_fd_pr__nfet_g5v0d10v5 w=1 l=0.5
XRp_22_21 BLP21 dp_22_21 sky130_fd_pr_reram__reram_cell area_ox=0.0676
XMz_22_21 dz_22_21 WL22 SL21 VSS sky130_fd_pr__nfet_g5v0d10v5 w=1 l=0.5
XRz_22_21 BLZ21 dz_22_21 sky130_fd_pr_reram__reram_cell area_ox=0.0676
XMn_22_21 dn_22_21 WL22 SL21 VSS sky130_fd_pr__nfet_g5v0d10v5 w=1 l=0.5
XRn_22_21 BLN21 dn_22_21 sky130_fd_pr_reram__reram_cell area_ox=0.0676
XMp_22_22 dp_22_22 WL22 SL22 VSS sky130_fd_pr__nfet_g5v0d10v5 w=1 l=0.5
XRp_22_22 BLP22 dp_22_22 sky130_fd_pr_reram__reram_cell area_ox=0.0676
XMz_22_22 dz_22_22 WL22 SL22 VSS sky130_fd_pr__nfet_g5v0d10v5 w=1 l=0.5
XRz_22_22 BLZ22 dz_22_22 sky130_fd_pr_reram__reram_cell area_ox=0.0676
XMn_22_22 dn_22_22 WL22 SL22 VSS sky130_fd_pr__nfet_g5v0d10v5 w=1 l=0.5
XRn_22_22 BLN22 dn_22_22 sky130_fd_pr_reram__reram_cell area_ox=0.0676
XMp_22_23 dp_22_23 WL22 SL23 VSS sky130_fd_pr__nfet_g5v0d10v5 w=1 l=0.5
XRp_22_23 BLP23 dp_22_23 sky130_fd_pr_reram__reram_cell area_ox=0.0676
XMz_22_23 dz_22_23 WL22 SL23 VSS sky130_fd_pr__nfet_g5v0d10v5 w=1 l=0.5
XRz_22_23 BLZ23 dz_22_23 sky130_fd_pr_reram__reram_cell area_ox=0.0676
XMn_22_23 dn_22_23 WL22 SL23 VSS sky130_fd_pr__nfet_g5v0d10v5 w=1 l=0.5
XRn_22_23 BLN23 dn_22_23 sky130_fd_pr_reram__reram_cell area_ox=0.0676
XMp_23_0 dp_23_0 WL23 SL0 VSS sky130_fd_pr__nfet_g5v0d10v5 w=1 l=0.5
XRp_23_0 BLP0 dp_23_0 sky130_fd_pr_reram__reram_cell area_ox=0.0676
XMz_23_0 dz_23_0 WL23 SL0 VSS sky130_fd_pr__nfet_g5v0d10v5 w=1 l=0.5
XRz_23_0 BLZ0 dz_23_0 sky130_fd_pr_reram__reram_cell area_ox=0.0676
XMn_23_0 dn_23_0 WL23 SL0 VSS sky130_fd_pr__nfet_g5v0d10v5 w=1 l=0.5
XRn_23_0 BLN0 dn_23_0 sky130_fd_pr_reram__reram_cell area_ox=0.0676
XMp_23_1 dp_23_1 WL23 SL1 VSS sky130_fd_pr__nfet_g5v0d10v5 w=1 l=0.5
XRp_23_1 BLP1 dp_23_1 sky130_fd_pr_reram__reram_cell area_ox=0.0676
XMz_23_1 dz_23_1 WL23 SL1 VSS sky130_fd_pr__nfet_g5v0d10v5 w=1 l=0.5
XRz_23_1 BLZ1 dz_23_1 sky130_fd_pr_reram__reram_cell area_ox=0.0676
XMn_23_1 dn_23_1 WL23 SL1 VSS sky130_fd_pr__nfet_g5v0d10v5 w=1 l=0.5
XRn_23_1 BLN1 dn_23_1 sky130_fd_pr_reram__reram_cell area_ox=0.0676
XMp_23_2 dp_23_2 WL23 SL2 VSS sky130_fd_pr__nfet_g5v0d10v5 w=1 l=0.5
XRp_23_2 BLP2 dp_23_2 sky130_fd_pr_reram__reram_cell area_ox=0.0676
XMz_23_2 dz_23_2 WL23 SL2 VSS sky130_fd_pr__nfet_g5v0d10v5 w=1 l=0.5
XRz_23_2 BLZ2 dz_23_2 sky130_fd_pr_reram__reram_cell area_ox=0.0676
XMn_23_2 dn_23_2 WL23 SL2 VSS sky130_fd_pr__nfet_g5v0d10v5 w=1 l=0.5
XRn_23_2 BLN2 dn_23_2 sky130_fd_pr_reram__reram_cell area_ox=0.0676
XMp_23_3 dp_23_3 WL23 SL3 VSS sky130_fd_pr__nfet_g5v0d10v5 w=1 l=0.5
XRp_23_3 BLP3 dp_23_3 sky130_fd_pr_reram__reram_cell area_ox=0.0676
XMz_23_3 dz_23_3 WL23 SL3 VSS sky130_fd_pr__nfet_g5v0d10v5 w=1 l=0.5
XRz_23_3 BLZ3 dz_23_3 sky130_fd_pr_reram__reram_cell area_ox=0.0676
XMn_23_3 dn_23_3 WL23 SL3 VSS sky130_fd_pr__nfet_g5v0d10v5 w=1 l=0.5
XRn_23_3 BLN3 dn_23_3 sky130_fd_pr_reram__reram_cell area_ox=0.0676
XMp_23_4 dp_23_4 WL23 SL4 VSS sky130_fd_pr__nfet_g5v0d10v5 w=1 l=0.5
XRp_23_4 BLP4 dp_23_4 sky130_fd_pr_reram__reram_cell area_ox=0.0676
XMz_23_4 dz_23_4 WL23 SL4 VSS sky130_fd_pr__nfet_g5v0d10v5 w=1 l=0.5
XRz_23_4 BLZ4 dz_23_4 sky130_fd_pr_reram__reram_cell area_ox=0.0676
XMn_23_4 dn_23_4 WL23 SL4 VSS sky130_fd_pr__nfet_g5v0d10v5 w=1 l=0.5
XRn_23_4 BLN4 dn_23_4 sky130_fd_pr_reram__reram_cell area_ox=0.0676
XMp_23_5 dp_23_5 WL23 SL5 VSS sky130_fd_pr__nfet_g5v0d10v5 w=1 l=0.5
XRp_23_5 BLP5 dp_23_5 sky130_fd_pr_reram__reram_cell area_ox=0.0676
XMz_23_5 dz_23_5 WL23 SL5 VSS sky130_fd_pr__nfet_g5v0d10v5 w=1 l=0.5
XRz_23_5 BLZ5 dz_23_5 sky130_fd_pr_reram__reram_cell area_ox=0.0676
XMn_23_5 dn_23_5 WL23 SL5 VSS sky130_fd_pr__nfet_g5v0d10v5 w=1 l=0.5
XRn_23_5 BLN5 dn_23_5 sky130_fd_pr_reram__reram_cell area_ox=0.0676
XMp_23_6 dp_23_6 WL23 SL6 VSS sky130_fd_pr__nfet_g5v0d10v5 w=1 l=0.5
XRp_23_6 BLP6 dp_23_6 sky130_fd_pr_reram__reram_cell area_ox=0.0676
XMz_23_6 dz_23_6 WL23 SL6 VSS sky130_fd_pr__nfet_g5v0d10v5 w=1 l=0.5
XRz_23_6 BLZ6 dz_23_6 sky130_fd_pr_reram__reram_cell area_ox=0.0676
XMn_23_6 dn_23_6 WL23 SL6 VSS sky130_fd_pr__nfet_g5v0d10v5 w=1 l=0.5
XRn_23_6 BLN6 dn_23_6 sky130_fd_pr_reram__reram_cell area_ox=0.0676
XMp_23_7 dp_23_7 WL23 SL7 VSS sky130_fd_pr__nfet_g5v0d10v5 w=1 l=0.5
XRp_23_7 BLP7 dp_23_7 sky130_fd_pr_reram__reram_cell area_ox=0.0676
XMz_23_7 dz_23_7 WL23 SL7 VSS sky130_fd_pr__nfet_g5v0d10v5 w=1 l=0.5
XRz_23_7 BLZ7 dz_23_7 sky130_fd_pr_reram__reram_cell area_ox=0.0676
XMn_23_7 dn_23_7 WL23 SL7 VSS sky130_fd_pr__nfet_g5v0d10v5 w=1 l=0.5
XRn_23_7 BLN7 dn_23_7 sky130_fd_pr_reram__reram_cell area_ox=0.0676
XMp_23_8 dp_23_8 WL23 SL8 VSS sky130_fd_pr__nfet_g5v0d10v5 w=1 l=0.5
XRp_23_8 BLP8 dp_23_8 sky130_fd_pr_reram__reram_cell area_ox=0.0676
XMz_23_8 dz_23_8 WL23 SL8 VSS sky130_fd_pr__nfet_g5v0d10v5 w=1 l=0.5
XRz_23_8 BLZ8 dz_23_8 sky130_fd_pr_reram__reram_cell area_ox=0.0676
XMn_23_8 dn_23_8 WL23 SL8 VSS sky130_fd_pr__nfet_g5v0d10v5 w=1 l=0.5
XRn_23_8 BLN8 dn_23_8 sky130_fd_pr_reram__reram_cell area_ox=0.0676
XMp_23_9 dp_23_9 WL23 SL9 VSS sky130_fd_pr__nfet_g5v0d10v5 w=1 l=0.5
XRp_23_9 BLP9 dp_23_9 sky130_fd_pr_reram__reram_cell area_ox=0.0676
XMz_23_9 dz_23_9 WL23 SL9 VSS sky130_fd_pr__nfet_g5v0d10v5 w=1 l=0.5
XRz_23_9 BLZ9 dz_23_9 sky130_fd_pr_reram__reram_cell area_ox=0.0676
XMn_23_9 dn_23_9 WL23 SL9 VSS sky130_fd_pr__nfet_g5v0d10v5 w=1 l=0.5
XRn_23_9 BLN9 dn_23_9 sky130_fd_pr_reram__reram_cell area_ox=0.0676
XMp_23_10 dp_23_10 WL23 SL10 VSS sky130_fd_pr__nfet_g5v0d10v5 w=1 l=0.5
XRp_23_10 BLP10 dp_23_10 sky130_fd_pr_reram__reram_cell area_ox=0.0676
XMz_23_10 dz_23_10 WL23 SL10 VSS sky130_fd_pr__nfet_g5v0d10v5 w=1 l=0.5
XRz_23_10 BLZ10 dz_23_10 sky130_fd_pr_reram__reram_cell area_ox=0.0676
XMn_23_10 dn_23_10 WL23 SL10 VSS sky130_fd_pr__nfet_g5v0d10v5 w=1 l=0.5
XRn_23_10 BLN10 dn_23_10 sky130_fd_pr_reram__reram_cell area_ox=0.0676
XMp_23_11 dp_23_11 WL23 SL11 VSS sky130_fd_pr__nfet_g5v0d10v5 w=1 l=0.5
XRp_23_11 BLP11 dp_23_11 sky130_fd_pr_reram__reram_cell area_ox=0.0676
XMz_23_11 dz_23_11 WL23 SL11 VSS sky130_fd_pr__nfet_g5v0d10v5 w=1 l=0.5
XRz_23_11 BLZ11 dz_23_11 sky130_fd_pr_reram__reram_cell area_ox=0.0676
XMn_23_11 dn_23_11 WL23 SL11 VSS sky130_fd_pr__nfet_g5v0d10v5 w=1 l=0.5
XRn_23_11 BLN11 dn_23_11 sky130_fd_pr_reram__reram_cell area_ox=0.0676
XMp_23_12 dp_23_12 WL23 SL12 VSS sky130_fd_pr__nfet_g5v0d10v5 w=1 l=0.5
XRp_23_12 BLP12 dp_23_12 sky130_fd_pr_reram__reram_cell area_ox=0.0676
XMz_23_12 dz_23_12 WL23 SL12 VSS sky130_fd_pr__nfet_g5v0d10v5 w=1 l=0.5
XRz_23_12 BLZ12 dz_23_12 sky130_fd_pr_reram__reram_cell area_ox=0.0676
XMn_23_12 dn_23_12 WL23 SL12 VSS sky130_fd_pr__nfet_g5v0d10v5 w=1 l=0.5
XRn_23_12 BLN12 dn_23_12 sky130_fd_pr_reram__reram_cell area_ox=0.0676
XMp_23_13 dp_23_13 WL23 SL13 VSS sky130_fd_pr__nfet_g5v0d10v5 w=1 l=0.5
XRp_23_13 BLP13 dp_23_13 sky130_fd_pr_reram__reram_cell area_ox=0.0676
XMz_23_13 dz_23_13 WL23 SL13 VSS sky130_fd_pr__nfet_g5v0d10v5 w=1 l=0.5
XRz_23_13 BLZ13 dz_23_13 sky130_fd_pr_reram__reram_cell area_ox=0.0676
XMn_23_13 dn_23_13 WL23 SL13 VSS sky130_fd_pr__nfet_g5v0d10v5 w=1 l=0.5
XRn_23_13 BLN13 dn_23_13 sky130_fd_pr_reram__reram_cell area_ox=0.0676
XMp_23_14 dp_23_14 WL23 SL14 VSS sky130_fd_pr__nfet_g5v0d10v5 w=1 l=0.5
XRp_23_14 BLP14 dp_23_14 sky130_fd_pr_reram__reram_cell area_ox=0.0676
XMz_23_14 dz_23_14 WL23 SL14 VSS sky130_fd_pr__nfet_g5v0d10v5 w=1 l=0.5
XRz_23_14 BLZ14 dz_23_14 sky130_fd_pr_reram__reram_cell area_ox=0.0676
XMn_23_14 dn_23_14 WL23 SL14 VSS sky130_fd_pr__nfet_g5v0d10v5 w=1 l=0.5
XRn_23_14 BLN14 dn_23_14 sky130_fd_pr_reram__reram_cell area_ox=0.0676
XMp_23_15 dp_23_15 WL23 SL15 VSS sky130_fd_pr__nfet_g5v0d10v5 w=1 l=0.5
XRp_23_15 BLP15 dp_23_15 sky130_fd_pr_reram__reram_cell area_ox=0.0676
XMz_23_15 dz_23_15 WL23 SL15 VSS sky130_fd_pr__nfet_g5v0d10v5 w=1 l=0.5
XRz_23_15 BLZ15 dz_23_15 sky130_fd_pr_reram__reram_cell area_ox=0.0676
XMn_23_15 dn_23_15 WL23 SL15 VSS sky130_fd_pr__nfet_g5v0d10v5 w=1 l=0.5
XRn_23_15 BLN15 dn_23_15 sky130_fd_pr_reram__reram_cell area_ox=0.0676
XMp_23_16 dp_23_16 WL23 SL16 VSS sky130_fd_pr__nfet_g5v0d10v5 w=1 l=0.5
XRp_23_16 BLP16 dp_23_16 sky130_fd_pr_reram__reram_cell area_ox=0.0676
XMz_23_16 dz_23_16 WL23 SL16 VSS sky130_fd_pr__nfet_g5v0d10v5 w=1 l=0.5
XRz_23_16 BLZ16 dz_23_16 sky130_fd_pr_reram__reram_cell area_ox=0.0676
XMn_23_16 dn_23_16 WL23 SL16 VSS sky130_fd_pr__nfet_g5v0d10v5 w=1 l=0.5
XRn_23_16 BLN16 dn_23_16 sky130_fd_pr_reram__reram_cell area_ox=0.0676
XMp_23_17 dp_23_17 WL23 SL17 VSS sky130_fd_pr__nfet_g5v0d10v5 w=1 l=0.5
XRp_23_17 BLP17 dp_23_17 sky130_fd_pr_reram__reram_cell area_ox=0.0676
XMz_23_17 dz_23_17 WL23 SL17 VSS sky130_fd_pr__nfet_g5v0d10v5 w=1 l=0.5
XRz_23_17 BLZ17 dz_23_17 sky130_fd_pr_reram__reram_cell area_ox=0.0676
XMn_23_17 dn_23_17 WL23 SL17 VSS sky130_fd_pr__nfet_g5v0d10v5 w=1 l=0.5
XRn_23_17 BLN17 dn_23_17 sky130_fd_pr_reram__reram_cell area_ox=0.0676
XMp_23_18 dp_23_18 WL23 SL18 VSS sky130_fd_pr__nfet_g5v0d10v5 w=1 l=0.5
XRp_23_18 BLP18 dp_23_18 sky130_fd_pr_reram__reram_cell area_ox=0.0676
XMz_23_18 dz_23_18 WL23 SL18 VSS sky130_fd_pr__nfet_g5v0d10v5 w=1 l=0.5
XRz_23_18 BLZ18 dz_23_18 sky130_fd_pr_reram__reram_cell area_ox=0.0676
XMn_23_18 dn_23_18 WL23 SL18 VSS sky130_fd_pr__nfet_g5v0d10v5 w=1 l=0.5
XRn_23_18 BLN18 dn_23_18 sky130_fd_pr_reram__reram_cell area_ox=0.0676
XMp_23_19 dp_23_19 WL23 SL19 VSS sky130_fd_pr__nfet_g5v0d10v5 w=1 l=0.5
XRp_23_19 BLP19 dp_23_19 sky130_fd_pr_reram__reram_cell area_ox=0.0676
XMz_23_19 dz_23_19 WL23 SL19 VSS sky130_fd_pr__nfet_g5v0d10v5 w=1 l=0.5
XRz_23_19 BLZ19 dz_23_19 sky130_fd_pr_reram__reram_cell area_ox=0.0676
XMn_23_19 dn_23_19 WL23 SL19 VSS sky130_fd_pr__nfet_g5v0d10v5 w=1 l=0.5
XRn_23_19 BLN19 dn_23_19 sky130_fd_pr_reram__reram_cell area_ox=0.0676
XMp_23_20 dp_23_20 WL23 SL20 VSS sky130_fd_pr__nfet_g5v0d10v5 w=1 l=0.5
XRp_23_20 BLP20 dp_23_20 sky130_fd_pr_reram__reram_cell area_ox=0.0676
XMz_23_20 dz_23_20 WL23 SL20 VSS sky130_fd_pr__nfet_g5v0d10v5 w=1 l=0.5
XRz_23_20 BLZ20 dz_23_20 sky130_fd_pr_reram__reram_cell area_ox=0.0676
XMn_23_20 dn_23_20 WL23 SL20 VSS sky130_fd_pr__nfet_g5v0d10v5 w=1 l=0.5
XRn_23_20 BLN20 dn_23_20 sky130_fd_pr_reram__reram_cell area_ox=0.0676
XMp_23_21 dp_23_21 WL23 SL21 VSS sky130_fd_pr__nfet_g5v0d10v5 w=1 l=0.5
XRp_23_21 BLP21 dp_23_21 sky130_fd_pr_reram__reram_cell area_ox=0.0676
XMz_23_21 dz_23_21 WL23 SL21 VSS sky130_fd_pr__nfet_g5v0d10v5 w=1 l=0.5
XRz_23_21 BLZ21 dz_23_21 sky130_fd_pr_reram__reram_cell area_ox=0.0676
XMn_23_21 dn_23_21 WL23 SL21 VSS sky130_fd_pr__nfet_g5v0d10v5 w=1 l=0.5
XRn_23_21 BLN21 dn_23_21 sky130_fd_pr_reram__reram_cell area_ox=0.0676
XMp_23_22 dp_23_22 WL23 SL22 VSS sky130_fd_pr__nfet_g5v0d10v5 w=1 l=0.5
XRp_23_22 BLP22 dp_23_22 sky130_fd_pr_reram__reram_cell area_ox=0.0676
XMz_23_22 dz_23_22 WL23 SL22 VSS sky130_fd_pr__nfet_g5v0d10v5 w=1 l=0.5
XRz_23_22 BLZ22 dz_23_22 sky130_fd_pr_reram__reram_cell area_ox=0.0676
XMn_23_22 dn_23_22 WL23 SL22 VSS sky130_fd_pr__nfet_g5v0d10v5 w=1 l=0.5
XRn_23_22 BLN22 dn_23_22 sky130_fd_pr_reram__reram_cell area_ox=0.0676
XMp_23_23 dp_23_23 WL23 SL23 VSS sky130_fd_pr__nfet_g5v0d10v5 w=1 l=0.5
XRp_23_23 BLP23 dp_23_23 sky130_fd_pr_reram__reram_cell area_ox=0.0676
XMz_23_23 dz_23_23 WL23 SL23 VSS sky130_fd_pr__nfet_g5v0d10v5 w=1 l=0.5
XRz_23_23 BLZ23 dz_23_23 sky130_fd_pr_reram__reram_cell area_ox=0.0676
XMn_23_23 dn_23_23 WL23 SL23 VSS sky130_fd_pr__nfet_g5v0d10v5 w=1 l=0.5
XRn_23_23 BLN23 dn_23_23 sky130_fd_pr_reram__reram_cell area_ox=0.0676
XMp_24_0 dp_24_0 WL24 SL0 VSS sky130_fd_pr__nfet_g5v0d10v5 w=1 l=0.5
XRp_24_0 BLP0 dp_24_0 sky130_fd_pr_reram__reram_cell area_ox=0.0676
XMz_24_0 dz_24_0 WL24 SL0 VSS sky130_fd_pr__nfet_g5v0d10v5 w=1 l=0.5
XRz_24_0 BLZ0 dz_24_0 sky130_fd_pr_reram__reram_cell area_ox=0.0676
XMn_24_0 dn_24_0 WL24 SL0 VSS sky130_fd_pr__nfet_g5v0d10v5 w=1 l=0.5
XRn_24_0 BLN0 dn_24_0 sky130_fd_pr_reram__reram_cell area_ox=0.0676
XMp_24_1 dp_24_1 WL24 SL1 VSS sky130_fd_pr__nfet_g5v0d10v5 w=1 l=0.5
XRp_24_1 BLP1 dp_24_1 sky130_fd_pr_reram__reram_cell area_ox=0.0676
XMz_24_1 dz_24_1 WL24 SL1 VSS sky130_fd_pr__nfet_g5v0d10v5 w=1 l=0.5
XRz_24_1 BLZ1 dz_24_1 sky130_fd_pr_reram__reram_cell area_ox=0.0676
XMn_24_1 dn_24_1 WL24 SL1 VSS sky130_fd_pr__nfet_g5v0d10v5 w=1 l=0.5
XRn_24_1 BLN1 dn_24_1 sky130_fd_pr_reram__reram_cell area_ox=0.0676
XMp_24_2 dp_24_2 WL24 SL2 VSS sky130_fd_pr__nfet_g5v0d10v5 w=1 l=0.5
XRp_24_2 BLP2 dp_24_2 sky130_fd_pr_reram__reram_cell area_ox=0.0676
XMz_24_2 dz_24_2 WL24 SL2 VSS sky130_fd_pr__nfet_g5v0d10v5 w=1 l=0.5
XRz_24_2 BLZ2 dz_24_2 sky130_fd_pr_reram__reram_cell area_ox=0.0676
XMn_24_2 dn_24_2 WL24 SL2 VSS sky130_fd_pr__nfet_g5v0d10v5 w=1 l=0.5
XRn_24_2 BLN2 dn_24_2 sky130_fd_pr_reram__reram_cell area_ox=0.0676
XMp_24_3 dp_24_3 WL24 SL3 VSS sky130_fd_pr__nfet_g5v0d10v5 w=1 l=0.5
XRp_24_3 BLP3 dp_24_3 sky130_fd_pr_reram__reram_cell area_ox=0.0676
XMz_24_3 dz_24_3 WL24 SL3 VSS sky130_fd_pr__nfet_g5v0d10v5 w=1 l=0.5
XRz_24_3 BLZ3 dz_24_3 sky130_fd_pr_reram__reram_cell area_ox=0.0676
XMn_24_3 dn_24_3 WL24 SL3 VSS sky130_fd_pr__nfet_g5v0d10v5 w=1 l=0.5
XRn_24_3 BLN3 dn_24_3 sky130_fd_pr_reram__reram_cell area_ox=0.0676
XMp_24_4 dp_24_4 WL24 SL4 VSS sky130_fd_pr__nfet_g5v0d10v5 w=1 l=0.5
XRp_24_4 BLP4 dp_24_4 sky130_fd_pr_reram__reram_cell area_ox=0.0676
XMz_24_4 dz_24_4 WL24 SL4 VSS sky130_fd_pr__nfet_g5v0d10v5 w=1 l=0.5
XRz_24_4 BLZ4 dz_24_4 sky130_fd_pr_reram__reram_cell area_ox=0.0676
XMn_24_4 dn_24_4 WL24 SL4 VSS sky130_fd_pr__nfet_g5v0d10v5 w=1 l=0.5
XRn_24_4 BLN4 dn_24_4 sky130_fd_pr_reram__reram_cell area_ox=0.0676
XMp_24_5 dp_24_5 WL24 SL5 VSS sky130_fd_pr__nfet_g5v0d10v5 w=1 l=0.5
XRp_24_5 BLP5 dp_24_5 sky130_fd_pr_reram__reram_cell area_ox=0.0676
XMz_24_5 dz_24_5 WL24 SL5 VSS sky130_fd_pr__nfet_g5v0d10v5 w=1 l=0.5
XRz_24_5 BLZ5 dz_24_5 sky130_fd_pr_reram__reram_cell area_ox=0.0676
XMn_24_5 dn_24_5 WL24 SL5 VSS sky130_fd_pr__nfet_g5v0d10v5 w=1 l=0.5
XRn_24_5 BLN5 dn_24_5 sky130_fd_pr_reram__reram_cell area_ox=0.0676
XMp_24_6 dp_24_6 WL24 SL6 VSS sky130_fd_pr__nfet_g5v0d10v5 w=1 l=0.5
XRp_24_6 BLP6 dp_24_6 sky130_fd_pr_reram__reram_cell area_ox=0.0676
XMz_24_6 dz_24_6 WL24 SL6 VSS sky130_fd_pr__nfet_g5v0d10v5 w=1 l=0.5
XRz_24_6 BLZ6 dz_24_6 sky130_fd_pr_reram__reram_cell area_ox=0.0676
XMn_24_6 dn_24_6 WL24 SL6 VSS sky130_fd_pr__nfet_g5v0d10v5 w=1 l=0.5
XRn_24_6 BLN6 dn_24_6 sky130_fd_pr_reram__reram_cell area_ox=0.0676
XMp_24_7 dp_24_7 WL24 SL7 VSS sky130_fd_pr__nfet_g5v0d10v5 w=1 l=0.5
XRp_24_7 BLP7 dp_24_7 sky130_fd_pr_reram__reram_cell area_ox=0.0676
XMz_24_7 dz_24_7 WL24 SL7 VSS sky130_fd_pr__nfet_g5v0d10v5 w=1 l=0.5
XRz_24_7 BLZ7 dz_24_7 sky130_fd_pr_reram__reram_cell area_ox=0.0676
XMn_24_7 dn_24_7 WL24 SL7 VSS sky130_fd_pr__nfet_g5v0d10v5 w=1 l=0.5
XRn_24_7 BLN7 dn_24_7 sky130_fd_pr_reram__reram_cell area_ox=0.0676
XMp_24_8 dp_24_8 WL24 SL8 VSS sky130_fd_pr__nfet_g5v0d10v5 w=1 l=0.5
XRp_24_8 BLP8 dp_24_8 sky130_fd_pr_reram__reram_cell area_ox=0.0676
XMz_24_8 dz_24_8 WL24 SL8 VSS sky130_fd_pr__nfet_g5v0d10v5 w=1 l=0.5
XRz_24_8 BLZ8 dz_24_8 sky130_fd_pr_reram__reram_cell area_ox=0.0676
XMn_24_8 dn_24_8 WL24 SL8 VSS sky130_fd_pr__nfet_g5v0d10v5 w=1 l=0.5
XRn_24_8 BLN8 dn_24_8 sky130_fd_pr_reram__reram_cell area_ox=0.0676
XMp_24_9 dp_24_9 WL24 SL9 VSS sky130_fd_pr__nfet_g5v0d10v5 w=1 l=0.5
XRp_24_9 BLP9 dp_24_9 sky130_fd_pr_reram__reram_cell area_ox=0.0676
XMz_24_9 dz_24_9 WL24 SL9 VSS sky130_fd_pr__nfet_g5v0d10v5 w=1 l=0.5
XRz_24_9 BLZ9 dz_24_9 sky130_fd_pr_reram__reram_cell area_ox=0.0676
XMn_24_9 dn_24_9 WL24 SL9 VSS sky130_fd_pr__nfet_g5v0d10v5 w=1 l=0.5
XRn_24_9 BLN9 dn_24_9 sky130_fd_pr_reram__reram_cell area_ox=0.0676
XMp_24_10 dp_24_10 WL24 SL10 VSS sky130_fd_pr__nfet_g5v0d10v5 w=1 l=0.5
XRp_24_10 BLP10 dp_24_10 sky130_fd_pr_reram__reram_cell area_ox=0.0676
XMz_24_10 dz_24_10 WL24 SL10 VSS sky130_fd_pr__nfet_g5v0d10v5 w=1 l=0.5
XRz_24_10 BLZ10 dz_24_10 sky130_fd_pr_reram__reram_cell area_ox=0.0676
XMn_24_10 dn_24_10 WL24 SL10 VSS sky130_fd_pr__nfet_g5v0d10v5 w=1 l=0.5
XRn_24_10 BLN10 dn_24_10 sky130_fd_pr_reram__reram_cell area_ox=0.0676
XMp_24_11 dp_24_11 WL24 SL11 VSS sky130_fd_pr__nfet_g5v0d10v5 w=1 l=0.5
XRp_24_11 BLP11 dp_24_11 sky130_fd_pr_reram__reram_cell area_ox=0.0676
XMz_24_11 dz_24_11 WL24 SL11 VSS sky130_fd_pr__nfet_g5v0d10v5 w=1 l=0.5
XRz_24_11 BLZ11 dz_24_11 sky130_fd_pr_reram__reram_cell area_ox=0.0676
XMn_24_11 dn_24_11 WL24 SL11 VSS sky130_fd_pr__nfet_g5v0d10v5 w=1 l=0.5
XRn_24_11 BLN11 dn_24_11 sky130_fd_pr_reram__reram_cell area_ox=0.0676
XMp_24_12 dp_24_12 WL24 SL12 VSS sky130_fd_pr__nfet_g5v0d10v5 w=1 l=0.5
XRp_24_12 BLP12 dp_24_12 sky130_fd_pr_reram__reram_cell area_ox=0.0676
XMz_24_12 dz_24_12 WL24 SL12 VSS sky130_fd_pr__nfet_g5v0d10v5 w=1 l=0.5
XRz_24_12 BLZ12 dz_24_12 sky130_fd_pr_reram__reram_cell area_ox=0.0676
XMn_24_12 dn_24_12 WL24 SL12 VSS sky130_fd_pr__nfet_g5v0d10v5 w=1 l=0.5
XRn_24_12 BLN12 dn_24_12 sky130_fd_pr_reram__reram_cell area_ox=0.0676
XMp_24_13 dp_24_13 WL24 SL13 VSS sky130_fd_pr__nfet_g5v0d10v5 w=1 l=0.5
XRp_24_13 BLP13 dp_24_13 sky130_fd_pr_reram__reram_cell area_ox=0.0676
XMz_24_13 dz_24_13 WL24 SL13 VSS sky130_fd_pr__nfet_g5v0d10v5 w=1 l=0.5
XRz_24_13 BLZ13 dz_24_13 sky130_fd_pr_reram__reram_cell area_ox=0.0676
XMn_24_13 dn_24_13 WL24 SL13 VSS sky130_fd_pr__nfet_g5v0d10v5 w=1 l=0.5
XRn_24_13 BLN13 dn_24_13 sky130_fd_pr_reram__reram_cell area_ox=0.0676
XMp_24_14 dp_24_14 WL24 SL14 VSS sky130_fd_pr__nfet_g5v0d10v5 w=1 l=0.5
XRp_24_14 BLP14 dp_24_14 sky130_fd_pr_reram__reram_cell area_ox=0.0676
XMz_24_14 dz_24_14 WL24 SL14 VSS sky130_fd_pr__nfet_g5v0d10v5 w=1 l=0.5
XRz_24_14 BLZ14 dz_24_14 sky130_fd_pr_reram__reram_cell area_ox=0.0676
XMn_24_14 dn_24_14 WL24 SL14 VSS sky130_fd_pr__nfet_g5v0d10v5 w=1 l=0.5
XRn_24_14 BLN14 dn_24_14 sky130_fd_pr_reram__reram_cell area_ox=0.0676
XMp_24_15 dp_24_15 WL24 SL15 VSS sky130_fd_pr__nfet_g5v0d10v5 w=1 l=0.5
XRp_24_15 BLP15 dp_24_15 sky130_fd_pr_reram__reram_cell area_ox=0.0676
XMz_24_15 dz_24_15 WL24 SL15 VSS sky130_fd_pr__nfet_g5v0d10v5 w=1 l=0.5
XRz_24_15 BLZ15 dz_24_15 sky130_fd_pr_reram__reram_cell area_ox=0.0676
XMn_24_15 dn_24_15 WL24 SL15 VSS sky130_fd_pr__nfet_g5v0d10v5 w=1 l=0.5
XRn_24_15 BLN15 dn_24_15 sky130_fd_pr_reram__reram_cell area_ox=0.0676
XMp_24_16 dp_24_16 WL24 SL16 VSS sky130_fd_pr__nfet_g5v0d10v5 w=1 l=0.5
XRp_24_16 BLP16 dp_24_16 sky130_fd_pr_reram__reram_cell area_ox=0.0676
XMz_24_16 dz_24_16 WL24 SL16 VSS sky130_fd_pr__nfet_g5v0d10v5 w=1 l=0.5
XRz_24_16 BLZ16 dz_24_16 sky130_fd_pr_reram__reram_cell area_ox=0.0676
XMn_24_16 dn_24_16 WL24 SL16 VSS sky130_fd_pr__nfet_g5v0d10v5 w=1 l=0.5
XRn_24_16 BLN16 dn_24_16 sky130_fd_pr_reram__reram_cell area_ox=0.0676
XMp_24_17 dp_24_17 WL24 SL17 VSS sky130_fd_pr__nfet_g5v0d10v5 w=1 l=0.5
XRp_24_17 BLP17 dp_24_17 sky130_fd_pr_reram__reram_cell area_ox=0.0676
XMz_24_17 dz_24_17 WL24 SL17 VSS sky130_fd_pr__nfet_g5v0d10v5 w=1 l=0.5
XRz_24_17 BLZ17 dz_24_17 sky130_fd_pr_reram__reram_cell area_ox=0.0676
XMn_24_17 dn_24_17 WL24 SL17 VSS sky130_fd_pr__nfet_g5v0d10v5 w=1 l=0.5
XRn_24_17 BLN17 dn_24_17 sky130_fd_pr_reram__reram_cell area_ox=0.0676
XMp_24_18 dp_24_18 WL24 SL18 VSS sky130_fd_pr__nfet_g5v0d10v5 w=1 l=0.5
XRp_24_18 BLP18 dp_24_18 sky130_fd_pr_reram__reram_cell area_ox=0.0676
XMz_24_18 dz_24_18 WL24 SL18 VSS sky130_fd_pr__nfet_g5v0d10v5 w=1 l=0.5
XRz_24_18 BLZ18 dz_24_18 sky130_fd_pr_reram__reram_cell area_ox=0.0676
XMn_24_18 dn_24_18 WL24 SL18 VSS sky130_fd_pr__nfet_g5v0d10v5 w=1 l=0.5
XRn_24_18 BLN18 dn_24_18 sky130_fd_pr_reram__reram_cell area_ox=0.0676
XMp_24_19 dp_24_19 WL24 SL19 VSS sky130_fd_pr__nfet_g5v0d10v5 w=1 l=0.5
XRp_24_19 BLP19 dp_24_19 sky130_fd_pr_reram__reram_cell area_ox=0.0676
XMz_24_19 dz_24_19 WL24 SL19 VSS sky130_fd_pr__nfet_g5v0d10v5 w=1 l=0.5
XRz_24_19 BLZ19 dz_24_19 sky130_fd_pr_reram__reram_cell area_ox=0.0676
XMn_24_19 dn_24_19 WL24 SL19 VSS sky130_fd_pr__nfet_g5v0d10v5 w=1 l=0.5
XRn_24_19 BLN19 dn_24_19 sky130_fd_pr_reram__reram_cell area_ox=0.0676
XMp_24_20 dp_24_20 WL24 SL20 VSS sky130_fd_pr__nfet_g5v0d10v5 w=1 l=0.5
XRp_24_20 BLP20 dp_24_20 sky130_fd_pr_reram__reram_cell area_ox=0.0676
XMz_24_20 dz_24_20 WL24 SL20 VSS sky130_fd_pr__nfet_g5v0d10v5 w=1 l=0.5
XRz_24_20 BLZ20 dz_24_20 sky130_fd_pr_reram__reram_cell area_ox=0.0676
XMn_24_20 dn_24_20 WL24 SL20 VSS sky130_fd_pr__nfet_g5v0d10v5 w=1 l=0.5
XRn_24_20 BLN20 dn_24_20 sky130_fd_pr_reram__reram_cell area_ox=0.0676
XMp_24_21 dp_24_21 WL24 SL21 VSS sky130_fd_pr__nfet_g5v0d10v5 w=1 l=0.5
XRp_24_21 BLP21 dp_24_21 sky130_fd_pr_reram__reram_cell area_ox=0.0676
XMz_24_21 dz_24_21 WL24 SL21 VSS sky130_fd_pr__nfet_g5v0d10v5 w=1 l=0.5
XRz_24_21 BLZ21 dz_24_21 sky130_fd_pr_reram__reram_cell area_ox=0.0676
XMn_24_21 dn_24_21 WL24 SL21 VSS sky130_fd_pr__nfet_g5v0d10v5 w=1 l=0.5
XRn_24_21 BLN21 dn_24_21 sky130_fd_pr_reram__reram_cell area_ox=0.0676
XMp_24_22 dp_24_22 WL24 SL22 VSS sky130_fd_pr__nfet_g5v0d10v5 w=1 l=0.5
XRp_24_22 BLP22 dp_24_22 sky130_fd_pr_reram__reram_cell area_ox=0.0676
XMz_24_22 dz_24_22 WL24 SL22 VSS sky130_fd_pr__nfet_g5v0d10v5 w=1 l=0.5
XRz_24_22 BLZ22 dz_24_22 sky130_fd_pr_reram__reram_cell area_ox=0.0676
XMn_24_22 dn_24_22 WL24 SL22 VSS sky130_fd_pr__nfet_g5v0d10v5 w=1 l=0.5
XRn_24_22 BLN22 dn_24_22 sky130_fd_pr_reram__reram_cell area_ox=0.0676
XMp_24_23 dp_24_23 WL24 SL23 VSS sky130_fd_pr__nfet_g5v0d10v5 w=1 l=0.5
XRp_24_23 BLP23 dp_24_23 sky130_fd_pr_reram__reram_cell area_ox=0.0676
XMz_24_23 dz_24_23 WL24 SL23 VSS sky130_fd_pr__nfet_g5v0d10v5 w=1 l=0.5
XRz_24_23 BLZ23 dz_24_23 sky130_fd_pr_reram__reram_cell area_ox=0.0676
XMn_24_23 dn_24_23 WL24 SL23 VSS sky130_fd_pr__nfet_g5v0d10v5 w=1 l=0.5
XRn_24_23 BLN23 dn_24_23 sky130_fd_pr_reram__reram_cell area_ox=0.0676
XMp_25_0 dp_25_0 WL25 SL0 VSS sky130_fd_pr__nfet_g5v0d10v5 w=1 l=0.5
XRp_25_0 BLP0 dp_25_0 sky130_fd_pr_reram__reram_cell area_ox=0.0676
XMz_25_0 dz_25_0 WL25 SL0 VSS sky130_fd_pr__nfet_g5v0d10v5 w=1 l=0.5
XRz_25_0 BLZ0 dz_25_0 sky130_fd_pr_reram__reram_cell area_ox=0.0676
XMn_25_0 dn_25_0 WL25 SL0 VSS sky130_fd_pr__nfet_g5v0d10v5 w=1 l=0.5
XRn_25_0 BLN0 dn_25_0 sky130_fd_pr_reram__reram_cell area_ox=0.0676
XMp_25_1 dp_25_1 WL25 SL1 VSS sky130_fd_pr__nfet_g5v0d10v5 w=1 l=0.5
XRp_25_1 BLP1 dp_25_1 sky130_fd_pr_reram__reram_cell area_ox=0.0676
XMz_25_1 dz_25_1 WL25 SL1 VSS sky130_fd_pr__nfet_g5v0d10v5 w=1 l=0.5
XRz_25_1 BLZ1 dz_25_1 sky130_fd_pr_reram__reram_cell area_ox=0.0676
XMn_25_1 dn_25_1 WL25 SL1 VSS sky130_fd_pr__nfet_g5v0d10v5 w=1 l=0.5
XRn_25_1 BLN1 dn_25_1 sky130_fd_pr_reram__reram_cell area_ox=0.0676
XMp_25_2 dp_25_2 WL25 SL2 VSS sky130_fd_pr__nfet_g5v0d10v5 w=1 l=0.5
XRp_25_2 BLP2 dp_25_2 sky130_fd_pr_reram__reram_cell area_ox=0.0676
XMz_25_2 dz_25_2 WL25 SL2 VSS sky130_fd_pr__nfet_g5v0d10v5 w=1 l=0.5
XRz_25_2 BLZ2 dz_25_2 sky130_fd_pr_reram__reram_cell area_ox=0.0676
XMn_25_2 dn_25_2 WL25 SL2 VSS sky130_fd_pr__nfet_g5v0d10v5 w=1 l=0.5
XRn_25_2 BLN2 dn_25_2 sky130_fd_pr_reram__reram_cell area_ox=0.0676
XMp_25_3 dp_25_3 WL25 SL3 VSS sky130_fd_pr__nfet_g5v0d10v5 w=1 l=0.5
XRp_25_3 BLP3 dp_25_3 sky130_fd_pr_reram__reram_cell area_ox=0.0676
XMz_25_3 dz_25_3 WL25 SL3 VSS sky130_fd_pr__nfet_g5v0d10v5 w=1 l=0.5
XRz_25_3 BLZ3 dz_25_3 sky130_fd_pr_reram__reram_cell area_ox=0.0676
XMn_25_3 dn_25_3 WL25 SL3 VSS sky130_fd_pr__nfet_g5v0d10v5 w=1 l=0.5
XRn_25_3 BLN3 dn_25_3 sky130_fd_pr_reram__reram_cell area_ox=0.0676
XMp_25_4 dp_25_4 WL25 SL4 VSS sky130_fd_pr__nfet_g5v0d10v5 w=1 l=0.5
XRp_25_4 BLP4 dp_25_4 sky130_fd_pr_reram__reram_cell area_ox=0.0676
XMz_25_4 dz_25_4 WL25 SL4 VSS sky130_fd_pr__nfet_g5v0d10v5 w=1 l=0.5
XRz_25_4 BLZ4 dz_25_4 sky130_fd_pr_reram__reram_cell area_ox=0.0676
XMn_25_4 dn_25_4 WL25 SL4 VSS sky130_fd_pr__nfet_g5v0d10v5 w=1 l=0.5
XRn_25_4 BLN4 dn_25_4 sky130_fd_pr_reram__reram_cell area_ox=0.0676
XMp_25_5 dp_25_5 WL25 SL5 VSS sky130_fd_pr__nfet_g5v0d10v5 w=1 l=0.5
XRp_25_5 BLP5 dp_25_5 sky130_fd_pr_reram__reram_cell area_ox=0.0676
XMz_25_5 dz_25_5 WL25 SL5 VSS sky130_fd_pr__nfet_g5v0d10v5 w=1 l=0.5
XRz_25_5 BLZ5 dz_25_5 sky130_fd_pr_reram__reram_cell area_ox=0.0676
XMn_25_5 dn_25_5 WL25 SL5 VSS sky130_fd_pr__nfet_g5v0d10v5 w=1 l=0.5
XRn_25_5 BLN5 dn_25_5 sky130_fd_pr_reram__reram_cell area_ox=0.0676
XMp_25_6 dp_25_6 WL25 SL6 VSS sky130_fd_pr__nfet_g5v0d10v5 w=1 l=0.5
XRp_25_6 BLP6 dp_25_6 sky130_fd_pr_reram__reram_cell area_ox=0.0676
XMz_25_6 dz_25_6 WL25 SL6 VSS sky130_fd_pr__nfet_g5v0d10v5 w=1 l=0.5
XRz_25_6 BLZ6 dz_25_6 sky130_fd_pr_reram__reram_cell area_ox=0.0676
XMn_25_6 dn_25_6 WL25 SL6 VSS sky130_fd_pr__nfet_g5v0d10v5 w=1 l=0.5
XRn_25_6 BLN6 dn_25_6 sky130_fd_pr_reram__reram_cell area_ox=0.0676
XMp_25_7 dp_25_7 WL25 SL7 VSS sky130_fd_pr__nfet_g5v0d10v5 w=1 l=0.5
XRp_25_7 BLP7 dp_25_7 sky130_fd_pr_reram__reram_cell area_ox=0.0676
XMz_25_7 dz_25_7 WL25 SL7 VSS sky130_fd_pr__nfet_g5v0d10v5 w=1 l=0.5
XRz_25_7 BLZ7 dz_25_7 sky130_fd_pr_reram__reram_cell area_ox=0.0676
XMn_25_7 dn_25_7 WL25 SL7 VSS sky130_fd_pr__nfet_g5v0d10v5 w=1 l=0.5
XRn_25_7 BLN7 dn_25_7 sky130_fd_pr_reram__reram_cell area_ox=0.0676
XMp_25_8 dp_25_8 WL25 SL8 VSS sky130_fd_pr__nfet_g5v0d10v5 w=1 l=0.5
XRp_25_8 BLP8 dp_25_8 sky130_fd_pr_reram__reram_cell area_ox=0.0676
XMz_25_8 dz_25_8 WL25 SL8 VSS sky130_fd_pr__nfet_g5v0d10v5 w=1 l=0.5
XRz_25_8 BLZ8 dz_25_8 sky130_fd_pr_reram__reram_cell area_ox=0.0676
XMn_25_8 dn_25_8 WL25 SL8 VSS sky130_fd_pr__nfet_g5v0d10v5 w=1 l=0.5
XRn_25_8 BLN8 dn_25_8 sky130_fd_pr_reram__reram_cell area_ox=0.0676
XMp_25_9 dp_25_9 WL25 SL9 VSS sky130_fd_pr__nfet_g5v0d10v5 w=1 l=0.5
XRp_25_9 BLP9 dp_25_9 sky130_fd_pr_reram__reram_cell area_ox=0.0676
XMz_25_9 dz_25_9 WL25 SL9 VSS sky130_fd_pr__nfet_g5v0d10v5 w=1 l=0.5
XRz_25_9 BLZ9 dz_25_9 sky130_fd_pr_reram__reram_cell area_ox=0.0676
XMn_25_9 dn_25_9 WL25 SL9 VSS sky130_fd_pr__nfet_g5v0d10v5 w=1 l=0.5
XRn_25_9 BLN9 dn_25_9 sky130_fd_pr_reram__reram_cell area_ox=0.0676
XMp_25_10 dp_25_10 WL25 SL10 VSS sky130_fd_pr__nfet_g5v0d10v5 w=1 l=0.5
XRp_25_10 BLP10 dp_25_10 sky130_fd_pr_reram__reram_cell area_ox=0.0676
XMz_25_10 dz_25_10 WL25 SL10 VSS sky130_fd_pr__nfet_g5v0d10v5 w=1 l=0.5
XRz_25_10 BLZ10 dz_25_10 sky130_fd_pr_reram__reram_cell area_ox=0.0676
XMn_25_10 dn_25_10 WL25 SL10 VSS sky130_fd_pr__nfet_g5v0d10v5 w=1 l=0.5
XRn_25_10 BLN10 dn_25_10 sky130_fd_pr_reram__reram_cell area_ox=0.0676
XMp_25_11 dp_25_11 WL25 SL11 VSS sky130_fd_pr__nfet_g5v0d10v5 w=1 l=0.5
XRp_25_11 BLP11 dp_25_11 sky130_fd_pr_reram__reram_cell area_ox=0.0676
XMz_25_11 dz_25_11 WL25 SL11 VSS sky130_fd_pr__nfet_g5v0d10v5 w=1 l=0.5
XRz_25_11 BLZ11 dz_25_11 sky130_fd_pr_reram__reram_cell area_ox=0.0676
XMn_25_11 dn_25_11 WL25 SL11 VSS sky130_fd_pr__nfet_g5v0d10v5 w=1 l=0.5
XRn_25_11 BLN11 dn_25_11 sky130_fd_pr_reram__reram_cell area_ox=0.0676
XMp_25_12 dp_25_12 WL25 SL12 VSS sky130_fd_pr__nfet_g5v0d10v5 w=1 l=0.5
XRp_25_12 BLP12 dp_25_12 sky130_fd_pr_reram__reram_cell area_ox=0.0676
XMz_25_12 dz_25_12 WL25 SL12 VSS sky130_fd_pr__nfet_g5v0d10v5 w=1 l=0.5
XRz_25_12 BLZ12 dz_25_12 sky130_fd_pr_reram__reram_cell area_ox=0.0676
XMn_25_12 dn_25_12 WL25 SL12 VSS sky130_fd_pr__nfet_g5v0d10v5 w=1 l=0.5
XRn_25_12 BLN12 dn_25_12 sky130_fd_pr_reram__reram_cell area_ox=0.0676
XMp_25_13 dp_25_13 WL25 SL13 VSS sky130_fd_pr__nfet_g5v0d10v5 w=1 l=0.5
XRp_25_13 BLP13 dp_25_13 sky130_fd_pr_reram__reram_cell area_ox=0.0676
XMz_25_13 dz_25_13 WL25 SL13 VSS sky130_fd_pr__nfet_g5v0d10v5 w=1 l=0.5
XRz_25_13 BLZ13 dz_25_13 sky130_fd_pr_reram__reram_cell area_ox=0.0676
XMn_25_13 dn_25_13 WL25 SL13 VSS sky130_fd_pr__nfet_g5v0d10v5 w=1 l=0.5
XRn_25_13 BLN13 dn_25_13 sky130_fd_pr_reram__reram_cell area_ox=0.0676
XMp_25_14 dp_25_14 WL25 SL14 VSS sky130_fd_pr__nfet_g5v0d10v5 w=1 l=0.5
XRp_25_14 BLP14 dp_25_14 sky130_fd_pr_reram__reram_cell area_ox=0.0676
XMz_25_14 dz_25_14 WL25 SL14 VSS sky130_fd_pr__nfet_g5v0d10v5 w=1 l=0.5
XRz_25_14 BLZ14 dz_25_14 sky130_fd_pr_reram__reram_cell area_ox=0.0676
XMn_25_14 dn_25_14 WL25 SL14 VSS sky130_fd_pr__nfet_g5v0d10v5 w=1 l=0.5
XRn_25_14 BLN14 dn_25_14 sky130_fd_pr_reram__reram_cell area_ox=0.0676
XMp_25_15 dp_25_15 WL25 SL15 VSS sky130_fd_pr__nfet_g5v0d10v5 w=1 l=0.5
XRp_25_15 BLP15 dp_25_15 sky130_fd_pr_reram__reram_cell area_ox=0.0676
XMz_25_15 dz_25_15 WL25 SL15 VSS sky130_fd_pr__nfet_g5v0d10v5 w=1 l=0.5
XRz_25_15 BLZ15 dz_25_15 sky130_fd_pr_reram__reram_cell area_ox=0.0676
XMn_25_15 dn_25_15 WL25 SL15 VSS sky130_fd_pr__nfet_g5v0d10v5 w=1 l=0.5
XRn_25_15 BLN15 dn_25_15 sky130_fd_pr_reram__reram_cell area_ox=0.0676
XMp_25_16 dp_25_16 WL25 SL16 VSS sky130_fd_pr__nfet_g5v0d10v5 w=1 l=0.5
XRp_25_16 BLP16 dp_25_16 sky130_fd_pr_reram__reram_cell area_ox=0.0676
XMz_25_16 dz_25_16 WL25 SL16 VSS sky130_fd_pr__nfet_g5v0d10v5 w=1 l=0.5
XRz_25_16 BLZ16 dz_25_16 sky130_fd_pr_reram__reram_cell area_ox=0.0676
XMn_25_16 dn_25_16 WL25 SL16 VSS sky130_fd_pr__nfet_g5v0d10v5 w=1 l=0.5
XRn_25_16 BLN16 dn_25_16 sky130_fd_pr_reram__reram_cell area_ox=0.0676
XMp_25_17 dp_25_17 WL25 SL17 VSS sky130_fd_pr__nfet_g5v0d10v5 w=1 l=0.5
XRp_25_17 BLP17 dp_25_17 sky130_fd_pr_reram__reram_cell area_ox=0.0676
XMz_25_17 dz_25_17 WL25 SL17 VSS sky130_fd_pr__nfet_g5v0d10v5 w=1 l=0.5
XRz_25_17 BLZ17 dz_25_17 sky130_fd_pr_reram__reram_cell area_ox=0.0676
XMn_25_17 dn_25_17 WL25 SL17 VSS sky130_fd_pr__nfet_g5v0d10v5 w=1 l=0.5
XRn_25_17 BLN17 dn_25_17 sky130_fd_pr_reram__reram_cell area_ox=0.0676
XMp_25_18 dp_25_18 WL25 SL18 VSS sky130_fd_pr__nfet_g5v0d10v5 w=1 l=0.5
XRp_25_18 BLP18 dp_25_18 sky130_fd_pr_reram__reram_cell area_ox=0.0676
XMz_25_18 dz_25_18 WL25 SL18 VSS sky130_fd_pr__nfet_g5v0d10v5 w=1 l=0.5
XRz_25_18 BLZ18 dz_25_18 sky130_fd_pr_reram__reram_cell area_ox=0.0676
XMn_25_18 dn_25_18 WL25 SL18 VSS sky130_fd_pr__nfet_g5v0d10v5 w=1 l=0.5
XRn_25_18 BLN18 dn_25_18 sky130_fd_pr_reram__reram_cell area_ox=0.0676
XMp_25_19 dp_25_19 WL25 SL19 VSS sky130_fd_pr__nfet_g5v0d10v5 w=1 l=0.5
XRp_25_19 BLP19 dp_25_19 sky130_fd_pr_reram__reram_cell area_ox=0.0676
XMz_25_19 dz_25_19 WL25 SL19 VSS sky130_fd_pr__nfet_g5v0d10v5 w=1 l=0.5
XRz_25_19 BLZ19 dz_25_19 sky130_fd_pr_reram__reram_cell area_ox=0.0676
XMn_25_19 dn_25_19 WL25 SL19 VSS sky130_fd_pr__nfet_g5v0d10v5 w=1 l=0.5
XRn_25_19 BLN19 dn_25_19 sky130_fd_pr_reram__reram_cell area_ox=0.0676
XMp_25_20 dp_25_20 WL25 SL20 VSS sky130_fd_pr__nfet_g5v0d10v5 w=1 l=0.5
XRp_25_20 BLP20 dp_25_20 sky130_fd_pr_reram__reram_cell area_ox=0.0676
XMz_25_20 dz_25_20 WL25 SL20 VSS sky130_fd_pr__nfet_g5v0d10v5 w=1 l=0.5
XRz_25_20 BLZ20 dz_25_20 sky130_fd_pr_reram__reram_cell area_ox=0.0676
XMn_25_20 dn_25_20 WL25 SL20 VSS sky130_fd_pr__nfet_g5v0d10v5 w=1 l=0.5
XRn_25_20 BLN20 dn_25_20 sky130_fd_pr_reram__reram_cell area_ox=0.0676
XMp_25_21 dp_25_21 WL25 SL21 VSS sky130_fd_pr__nfet_g5v0d10v5 w=1 l=0.5
XRp_25_21 BLP21 dp_25_21 sky130_fd_pr_reram__reram_cell area_ox=0.0676
XMz_25_21 dz_25_21 WL25 SL21 VSS sky130_fd_pr__nfet_g5v0d10v5 w=1 l=0.5
XRz_25_21 BLZ21 dz_25_21 sky130_fd_pr_reram__reram_cell area_ox=0.0676
XMn_25_21 dn_25_21 WL25 SL21 VSS sky130_fd_pr__nfet_g5v0d10v5 w=1 l=0.5
XRn_25_21 BLN21 dn_25_21 sky130_fd_pr_reram__reram_cell area_ox=0.0676
XMp_25_22 dp_25_22 WL25 SL22 VSS sky130_fd_pr__nfet_g5v0d10v5 w=1 l=0.5
XRp_25_22 BLP22 dp_25_22 sky130_fd_pr_reram__reram_cell area_ox=0.0676
XMz_25_22 dz_25_22 WL25 SL22 VSS sky130_fd_pr__nfet_g5v0d10v5 w=1 l=0.5
XRz_25_22 BLZ22 dz_25_22 sky130_fd_pr_reram__reram_cell area_ox=0.0676
XMn_25_22 dn_25_22 WL25 SL22 VSS sky130_fd_pr__nfet_g5v0d10v5 w=1 l=0.5
XRn_25_22 BLN22 dn_25_22 sky130_fd_pr_reram__reram_cell area_ox=0.0676
XMp_25_23 dp_25_23 WL25 SL23 VSS sky130_fd_pr__nfet_g5v0d10v5 w=1 l=0.5
XRp_25_23 BLP23 dp_25_23 sky130_fd_pr_reram__reram_cell area_ox=0.0676
XMz_25_23 dz_25_23 WL25 SL23 VSS sky130_fd_pr__nfet_g5v0d10v5 w=1 l=0.5
XRz_25_23 BLZ23 dz_25_23 sky130_fd_pr_reram__reram_cell area_ox=0.0676
XMn_25_23 dn_25_23 WL25 SL23 VSS sky130_fd_pr__nfet_g5v0d10v5 w=1 l=0.5
XRn_25_23 BLN23 dn_25_23 sky130_fd_pr_reram__reram_cell area_ox=0.0676
XMp_26_0 dp_26_0 WL26 SL0 VSS sky130_fd_pr__nfet_g5v0d10v5 w=1 l=0.5
XRp_26_0 BLP0 dp_26_0 sky130_fd_pr_reram__reram_cell area_ox=0.0676
XMz_26_0 dz_26_0 WL26 SL0 VSS sky130_fd_pr__nfet_g5v0d10v5 w=1 l=0.5
XRz_26_0 BLZ0 dz_26_0 sky130_fd_pr_reram__reram_cell area_ox=0.0676
XMn_26_0 dn_26_0 WL26 SL0 VSS sky130_fd_pr__nfet_g5v0d10v5 w=1 l=0.5
XRn_26_0 BLN0 dn_26_0 sky130_fd_pr_reram__reram_cell area_ox=0.0676
XMp_26_1 dp_26_1 WL26 SL1 VSS sky130_fd_pr__nfet_g5v0d10v5 w=1 l=0.5
XRp_26_1 BLP1 dp_26_1 sky130_fd_pr_reram__reram_cell area_ox=0.0676
XMz_26_1 dz_26_1 WL26 SL1 VSS sky130_fd_pr__nfet_g5v0d10v5 w=1 l=0.5
XRz_26_1 BLZ1 dz_26_1 sky130_fd_pr_reram__reram_cell area_ox=0.0676
XMn_26_1 dn_26_1 WL26 SL1 VSS sky130_fd_pr__nfet_g5v0d10v5 w=1 l=0.5
XRn_26_1 BLN1 dn_26_1 sky130_fd_pr_reram__reram_cell area_ox=0.0676
XMp_26_2 dp_26_2 WL26 SL2 VSS sky130_fd_pr__nfet_g5v0d10v5 w=1 l=0.5
XRp_26_2 BLP2 dp_26_2 sky130_fd_pr_reram__reram_cell area_ox=0.0676
XMz_26_2 dz_26_2 WL26 SL2 VSS sky130_fd_pr__nfet_g5v0d10v5 w=1 l=0.5
XRz_26_2 BLZ2 dz_26_2 sky130_fd_pr_reram__reram_cell area_ox=0.0676
XMn_26_2 dn_26_2 WL26 SL2 VSS sky130_fd_pr__nfet_g5v0d10v5 w=1 l=0.5
XRn_26_2 BLN2 dn_26_2 sky130_fd_pr_reram__reram_cell area_ox=0.0676
XMp_26_3 dp_26_3 WL26 SL3 VSS sky130_fd_pr__nfet_g5v0d10v5 w=1 l=0.5
XRp_26_3 BLP3 dp_26_3 sky130_fd_pr_reram__reram_cell area_ox=0.0676
XMz_26_3 dz_26_3 WL26 SL3 VSS sky130_fd_pr__nfet_g5v0d10v5 w=1 l=0.5
XRz_26_3 BLZ3 dz_26_3 sky130_fd_pr_reram__reram_cell area_ox=0.0676
XMn_26_3 dn_26_3 WL26 SL3 VSS sky130_fd_pr__nfet_g5v0d10v5 w=1 l=0.5
XRn_26_3 BLN3 dn_26_3 sky130_fd_pr_reram__reram_cell area_ox=0.0676
XMp_26_4 dp_26_4 WL26 SL4 VSS sky130_fd_pr__nfet_g5v0d10v5 w=1 l=0.5
XRp_26_4 BLP4 dp_26_4 sky130_fd_pr_reram__reram_cell area_ox=0.0676
XMz_26_4 dz_26_4 WL26 SL4 VSS sky130_fd_pr__nfet_g5v0d10v5 w=1 l=0.5
XRz_26_4 BLZ4 dz_26_4 sky130_fd_pr_reram__reram_cell area_ox=0.0676
XMn_26_4 dn_26_4 WL26 SL4 VSS sky130_fd_pr__nfet_g5v0d10v5 w=1 l=0.5
XRn_26_4 BLN4 dn_26_4 sky130_fd_pr_reram__reram_cell area_ox=0.0676
XMp_26_5 dp_26_5 WL26 SL5 VSS sky130_fd_pr__nfet_g5v0d10v5 w=1 l=0.5
XRp_26_5 BLP5 dp_26_5 sky130_fd_pr_reram__reram_cell area_ox=0.0676
XMz_26_5 dz_26_5 WL26 SL5 VSS sky130_fd_pr__nfet_g5v0d10v5 w=1 l=0.5
XRz_26_5 BLZ5 dz_26_5 sky130_fd_pr_reram__reram_cell area_ox=0.0676
XMn_26_5 dn_26_5 WL26 SL5 VSS sky130_fd_pr__nfet_g5v0d10v5 w=1 l=0.5
XRn_26_5 BLN5 dn_26_5 sky130_fd_pr_reram__reram_cell area_ox=0.0676
XMp_26_6 dp_26_6 WL26 SL6 VSS sky130_fd_pr__nfet_g5v0d10v5 w=1 l=0.5
XRp_26_6 BLP6 dp_26_6 sky130_fd_pr_reram__reram_cell area_ox=0.0676
XMz_26_6 dz_26_6 WL26 SL6 VSS sky130_fd_pr__nfet_g5v0d10v5 w=1 l=0.5
XRz_26_6 BLZ6 dz_26_6 sky130_fd_pr_reram__reram_cell area_ox=0.0676
XMn_26_6 dn_26_6 WL26 SL6 VSS sky130_fd_pr__nfet_g5v0d10v5 w=1 l=0.5
XRn_26_6 BLN6 dn_26_6 sky130_fd_pr_reram__reram_cell area_ox=0.0676
XMp_26_7 dp_26_7 WL26 SL7 VSS sky130_fd_pr__nfet_g5v0d10v5 w=1 l=0.5
XRp_26_7 BLP7 dp_26_7 sky130_fd_pr_reram__reram_cell area_ox=0.0676
XMz_26_7 dz_26_7 WL26 SL7 VSS sky130_fd_pr__nfet_g5v0d10v5 w=1 l=0.5
XRz_26_7 BLZ7 dz_26_7 sky130_fd_pr_reram__reram_cell area_ox=0.0676
XMn_26_7 dn_26_7 WL26 SL7 VSS sky130_fd_pr__nfet_g5v0d10v5 w=1 l=0.5
XRn_26_7 BLN7 dn_26_7 sky130_fd_pr_reram__reram_cell area_ox=0.0676
XMp_26_8 dp_26_8 WL26 SL8 VSS sky130_fd_pr__nfet_g5v0d10v5 w=1 l=0.5
XRp_26_8 BLP8 dp_26_8 sky130_fd_pr_reram__reram_cell area_ox=0.0676
XMz_26_8 dz_26_8 WL26 SL8 VSS sky130_fd_pr__nfet_g5v0d10v5 w=1 l=0.5
XRz_26_8 BLZ8 dz_26_8 sky130_fd_pr_reram__reram_cell area_ox=0.0676
XMn_26_8 dn_26_8 WL26 SL8 VSS sky130_fd_pr__nfet_g5v0d10v5 w=1 l=0.5
XRn_26_8 BLN8 dn_26_8 sky130_fd_pr_reram__reram_cell area_ox=0.0676
XMp_26_9 dp_26_9 WL26 SL9 VSS sky130_fd_pr__nfet_g5v0d10v5 w=1 l=0.5
XRp_26_9 BLP9 dp_26_9 sky130_fd_pr_reram__reram_cell area_ox=0.0676
XMz_26_9 dz_26_9 WL26 SL9 VSS sky130_fd_pr__nfet_g5v0d10v5 w=1 l=0.5
XRz_26_9 BLZ9 dz_26_9 sky130_fd_pr_reram__reram_cell area_ox=0.0676
XMn_26_9 dn_26_9 WL26 SL9 VSS sky130_fd_pr__nfet_g5v0d10v5 w=1 l=0.5
XRn_26_9 BLN9 dn_26_9 sky130_fd_pr_reram__reram_cell area_ox=0.0676
XMp_26_10 dp_26_10 WL26 SL10 VSS sky130_fd_pr__nfet_g5v0d10v5 w=1 l=0.5
XRp_26_10 BLP10 dp_26_10 sky130_fd_pr_reram__reram_cell area_ox=0.0676
XMz_26_10 dz_26_10 WL26 SL10 VSS sky130_fd_pr__nfet_g5v0d10v5 w=1 l=0.5
XRz_26_10 BLZ10 dz_26_10 sky130_fd_pr_reram__reram_cell area_ox=0.0676
XMn_26_10 dn_26_10 WL26 SL10 VSS sky130_fd_pr__nfet_g5v0d10v5 w=1 l=0.5
XRn_26_10 BLN10 dn_26_10 sky130_fd_pr_reram__reram_cell area_ox=0.0676
XMp_26_11 dp_26_11 WL26 SL11 VSS sky130_fd_pr__nfet_g5v0d10v5 w=1 l=0.5
XRp_26_11 BLP11 dp_26_11 sky130_fd_pr_reram__reram_cell area_ox=0.0676
XMz_26_11 dz_26_11 WL26 SL11 VSS sky130_fd_pr__nfet_g5v0d10v5 w=1 l=0.5
XRz_26_11 BLZ11 dz_26_11 sky130_fd_pr_reram__reram_cell area_ox=0.0676
XMn_26_11 dn_26_11 WL26 SL11 VSS sky130_fd_pr__nfet_g5v0d10v5 w=1 l=0.5
XRn_26_11 BLN11 dn_26_11 sky130_fd_pr_reram__reram_cell area_ox=0.0676
XMp_26_12 dp_26_12 WL26 SL12 VSS sky130_fd_pr__nfet_g5v0d10v5 w=1 l=0.5
XRp_26_12 BLP12 dp_26_12 sky130_fd_pr_reram__reram_cell area_ox=0.0676
XMz_26_12 dz_26_12 WL26 SL12 VSS sky130_fd_pr__nfet_g5v0d10v5 w=1 l=0.5
XRz_26_12 BLZ12 dz_26_12 sky130_fd_pr_reram__reram_cell area_ox=0.0676
XMn_26_12 dn_26_12 WL26 SL12 VSS sky130_fd_pr__nfet_g5v0d10v5 w=1 l=0.5
XRn_26_12 BLN12 dn_26_12 sky130_fd_pr_reram__reram_cell area_ox=0.0676
XMp_26_13 dp_26_13 WL26 SL13 VSS sky130_fd_pr__nfet_g5v0d10v5 w=1 l=0.5
XRp_26_13 BLP13 dp_26_13 sky130_fd_pr_reram__reram_cell area_ox=0.0676
XMz_26_13 dz_26_13 WL26 SL13 VSS sky130_fd_pr__nfet_g5v0d10v5 w=1 l=0.5
XRz_26_13 BLZ13 dz_26_13 sky130_fd_pr_reram__reram_cell area_ox=0.0676
XMn_26_13 dn_26_13 WL26 SL13 VSS sky130_fd_pr__nfet_g5v0d10v5 w=1 l=0.5
XRn_26_13 BLN13 dn_26_13 sky130_fd_pr_reram__reram_cell area_ox=0.0676
XMp_26_14 dp_26_14 WL26 SL14 VSS sky130_fd_pr__nfet_g5v0d10v5 w=1 l=0.5
XRp_26_14 BLP14 dp_26_14 sky130_fd_pr_reram__reram_cell area_ox=0.0676
XMz_26_14 dz_26_14 WL26 SL14 VSS sky130_fd_pr__nfet_g5v0d10v5 w=1 l=0.5
XRz_26_14 BLZ14 dz_26_14 sky130_fd_pr_reram__reram_cell area_ox=0.0676
XMn_26_14 dn_26_14 WL26 SL14 VSS sky130_fd_pr__nfet_g5v0d10v5 w=1 l=0.5
XRn_26_14 BLN14 dn_26_14 sky130_fd_pr_reram__reram_cell area_ox=0.0676
XMp_26_15 dp_26_15 WL26 SL15 VSS sky130_fd_pr__nfet_g5v0d10v5 w=1 l=0.5
XRp_26_15 BLP15 dp_26_15 sky130_fd_pr_reram__reram_cell area_ox=0.0676
XMz_26_15 dz_26_15 WL26 SL15 VSS sky130_fd_pr__nfet_g5v0d10v5 w=1 l=0.5
XRz_26_15 BLZ15 dz_26_15 sky130_fd_pr_reram__reram_cell area_ox=0.0676
XMn_26_15 dn_26_15 WL26 SL15 VSS sky130_fd_pr__nfet_g5v0d10v5 w=1 l=0.5
XRn_26_15 BLN15 dn_26_15 sky130_fd_pr_reram__reram_cell area_ox=0.0676
XMp_26_16 dp_26_16 WL26 SL16 VSS sky130_fd_pr__nfet_g5v0d10v5 w=1 l=0.5
XRp_26_16 BLP16 dp_26_16 sky130_fd_pr_reram__reram_cell area_ox=0.0676
XMz_26_16 dz_26_16 WL26 SL16 VSS sky130_fd_pr__nfet_g5v0d10v5 w=1 l=0.5
XRz_26_16 BLZ16 dz_26_16 sky130_fd_pr_reram__reram_cell area_ox=0.0676
XMn_26_16 dn_26_16 WL26 SL16 VSS sky130_fd_pr__nfet_g5v0d10v5 w=1 l=0.5
XRn_26_16 BLN16 dn_26_16 sky130_fd_pr_reram__reram_cell area_ox=0.0676
XMp_26_17 dp_26_17 WL26 SL17 VSS sky130_fd_pr__nfet_g5v0d10v5 w=1 l=0.5
XRp_26_17 BLP17 dp_26_17 sky130_fd_pr_reram__reram_cell area_ox=0.0676
XMz_26_17 dz_26_17 WL26 SL17 VSS sky130_fd_pr__nfet_g5v0d10v5 w=1 l=0.5
XRz_26_17 BLZ17 dz_26_17 sky130_fd_pr_reram__reram_cell area_ox=0.0676
XMn_26_17 dn_26_17 WL26 SL17 VSS sky130_fd_pr__nfet_g5v0d10v5 w=1 l=0.5
XRn_26_17 BLN17 dn_26_17 sky130_fd_pr_reram__reram_cell area_ox=0.0676
XMp_26_18 dp_26_18 WL26 SL18 VSS sky130_fd_pr__nfet_g5v0d10v5 w=1 l=0.5
XRp_26_18 BLP18 dp_26_18 sky130_fd_pr_reram__reram_cell area_ox=0.0676
XMz_26_18 dz_26_18 WL26 SL18 VSS sky130_fd_pr__nfet_g5v0d10v5 w=1 l=0.5
XRz_26_18 BLZ18 dz_26_18 sky130_fd_pr_reram__reram_cell area_ox=0.0676
XMn_26_18 dn_26_18 WL26 SL18 VSS sky130_fd_pr__nfet_g5v0d10v5 w=1 l=0.5
XRn_26_18 BLN18 dn_26_18 sky130_fd_pr_reram__reram_cell area_ox=0.0676
XMp_26_19 dp_26_19 WL26 SL19 VSS sky130_fd_pr__nfet_g5v0d10v5 w=1 l=0.5
XRp_26_19 BLP19 dp_26_19 sky130_fd_pr_reram__reram_cell area_ox=0.0676
XMz_26_19 dz_26_19 WL26 SL19 VSS sky130_fd_pr__nfet_g5v0d10v5 w=1 l=0.5
XRz_26_19 BLZ19 dz_26_19 sky130_fd_pr_reram__reram_cell area_ox=0.0676
XMn_26_19 dn_26_19 WL26 SL19 VSS sky130_fd_pr__nfet_g5v0d10v5 w=1 l=0.5
XRn_26_19 BLN19 dn_26_19 sky130_fd_pr_reram__reram_cell area_ox=0.0676
XMp_26_20 dp_26_20 WL26 SL20 VSS sky130_fd_pr__nfet_g5v0d10v5 w=1 l=0.5
XRp_26_20 BLP20 dp_26_20 sky130_fd_pr_reram__reram_cell area_ox=0.0676
XMz_26_20 dz_26_20 WL26 SL20 VSS sky130_fd_pr__nfet_g5v0d10v5 w=1 l=0.5
XRz_26_20 BLZ20 dz_26_20 sky130_fd_pr_reram__reram_cell area_ox=0.0676
XMn_26_20 dn_26_20 WL26 SL20 VSS sky130_fd_pr__nfet_g5v0d10v5 w=1 l=0.5
XRn_26_20 BLN20 dn_26_20 sky130_fd_pr_reram__reram_cell area_ox=0.0676
XMp_26_21 dp_26_21 WL26 SL21 VSS sky130_fd_pr__nfet_g5v0d10v5 w=1 l=0.5
XRp_26_21 BLP21 dp_26_21 sky130_fd_pr_reram__reram_cell area_ox=0.0676
XMz_26_21 dz_26_21 WL26 SL21 VSS sky130_fd_pr__nfet_g5v0d10v5 w=1 l=0.5
XRz_26_21 BLZ21 dz_26_21 sky130_fd_pr_reram__reram_cell area_ox=0.0676
XMn_26_21 dn_26_21 WL26 SL21 VSS sky130_fd_pr__nfet_g5v0d10v5 w=1 l=0.5
XRn_26_21 BLN21 dn_26_21 sky130_fd_pr_reram__reram_cell area_ox=0.0676
XMp_26_22 dp_26_22 WL26 SL22 VSS sky130_fd_pr__nfet_g5v0d10v5 w=1 l=0.5
XRp_26_22 BLP22 dp_26_22 sky130_fd_pr_reram__reram_cell area_ox=0.0676
XMz_26_22 dz_26_22 WL26 SL22 VSS sky130_fd_pr__nfet_g5v0d10v5 w=1 l=0.5
XRz_26_22 BLZ22 dz_26_22 sky130_fd_pr_reram__reram_cell area_ox=0.0676
XMn_26_22 dn_26_22 WL26 SL22 VSS sky130_fd_pr__nfet_g5v0d10v5 w=1 l=0.5
XRn_26_22 BLN22 dn_26_22 sky130_fd_pr_reram__reram_cell area_ox=0.0676
XMp_26_23 dp_26_23 WL26 SL23 VSS sky130_fd_pr__nfet_g5v0d10v5 w=1 l=0.5
XRp_26_23 BLP23 dp_26_23 sky130_fd_pr_reram__reram_cell area_ox=0.0676
XMz_26_23 dz_26_23 WL26 SL23 VSS sky130_fd_pr__nfet_g5v0d10v5 w=1 l=0.5
XRz_26_23 BLZ23 dz_26_23 sky130_fd_pr_reram__reram_cell area_ox=0.0676
XMn_26_23 dn_26_23 WL26 SL23 VSS sky130_fd_pr__nfet_g5v0d10v5 w=1 l=0.5
XRn_26_23 BLN23 dn_26_23 sky130_fd_pr_reram__reram_cell area_ox=0.0676
XMp_27_0 dp_27_0 WL27 SL0 VSS sky130_fd_pr__nfet_g5v0d10v5 w=1 l=0.5
XRp_27_0 BLP0 dp_27_0 sky130_fd_pr_reram__reram_cell area_ox=0.0676
XMz_27_0 dz_27_0 WL27 SL0 VSS sky130_fd_pr__nfet_g5v0d10v5 w=1 l=0.5
XRz_27_0 BLZ0 dz_27_0 sky130_fd_pr_reram__reram_cell area_ox=0.0676
XMn_27_0 dn_27_0 WL27 SL0 VSS sky130_fd_pr__nfet_g5v0d10v5 w=1 l=0.5
XRn_27_0 BLN0 dn_27_0 sky130_fd_pr_reram__reram_cell area_ox=0.0676
XMp_27_1 dp_27_1 WL27 SL1 VSS sky130_fd_pr__nfet_g5v0d10v5 w=1 l=0.5
XRp_27_1 BLP1 dp_27_1 sky130_fd_pr_reram__reram_cell area_ox=0.0676
XMz_27_1 dz_27_1 WL27 SL1 VSS sky130_fd_pr__nfet_g5v0d10v5 w=1 l=0.5
XRz_27_1 BLZ1 dz_27_1 sky130_fd_pr_reram__reram_cell area_ox=0.0676
XMn_27_1 dn_27_1 WL27 SL1 VSS sky130_fd_pr__nfet_g5v0d10v5 w=1 l=0.5
XRn_27_1 BLN1 dn_27_1 sky130_fd_pr_reram__reram_cell area_ox=0.0676
XMp_27_2 dp_27_2 WL27 SL2 VSS sky130_fd_pr__nfet_g5v0d10v5 w=1 l=0.5
XRp_27_2 BLP2 dp_27_2 sky130_fd_pr_reram__reram_cell area_ox=0.0676
XMz_27_2 dz_27_2 WL27 SL2 VSS sky130_fd_pr__nfet_g5v0d10v5 w=1 l=0.5
XRz_27_2 BLZ2 dz_27_2 sky130_fd_pr_reram__reram_cell area_ox=0.0676
XMn_27_2 dn_27_2 WL27 SL2 VSS sky130_fd_pr__nfet_g5v0d10v5 w=1 l=0.5
XRn_27_2 BLN2 dn_27_2 sky130_fd_pr_reram__reram_cell area_ox=0.0676
XMp_27_3 dp_27_3 WL27 SL3 VSS sky130_fd_pr__nfet_g5v0d10v5 w=1 l=0.5
XRp_27_3 BLP3 dp_27_3 sky130_fd_pr_reram__reram_cell area_ox=0.0676
XMz_27_3 dz_27_3 WL27 SL3 VSS sky130_fd_pr__nfet_g5v0d10v5 w=1 l=0.5
XRz_27_3 BLZ3 dz_27_3 sky130_fd_pr_reram__reram_cell area_ox=0.0676
XMn_27_3 dn_27_3 WL27 SL3 VSS sky130_fd_pr__nfet_g5v0d10v5 w=1 l=0.5
XRn_27_3 BLN3 dn_27_3 sky130_fd_pr_reram__reram_cell area_ox=0.0676
XMp_27_4 dp_27_4 WL27 SL4 VSS sky130_fd_pr__nfet_g5v0d10v5 w=1 l=0.5
XRp_27_4 BLP4 dp_27_4 sky130_fd_pr_reram__reram_cell area_ox=0.0676
XMz_27_4 dz_27_4 WL27 SL4 VSS sky130_fd_pr__nfet_g5v0d10v5 w=1 l=0.5
XRz_27_4 BLZ4 dz_27_4 sky130_fd_pr_reram__reram_cell area_ox=0.0676
XMn_27_4 dn_27_4 WL27 SL4 VSS sky130_fd_pr__nfet_g5v0d10v5 w=1 l=0.5
XRn_27_4 BLN4 dn_27_4 sky130_fd_pr_reram__reram_cell area_ox=0.0676
XMp_27_5 dp_27_5 WL27 SL5 VSS sky130_fd_pr__nfet_g5v0d10v5 w=1 l=0.5
XRp_27_5 BLP5 dp_27_5 sky130_fd_pr_reram__reram_cell area_ox=0.0676
XMz_27_5 dz_27_5 WL27 SL5 VSS sky130_fd_pr__nfet_g5v0d10v5 w=1 l=0.5
XRz_27_5 BLZ5 dz_27_5 sky130_fd_pr_reram__reram_cell area_ox=0.0676
XMn_27_5 dn_27_5 WL27 SL5 VSS sky130_fd_pr__nfet_g5v0d10v5 w=1 l=0.5
XRn_27_5 BLN5 dn_27_5 sky130_fd_pr_reram__reram_cell area_ox=0.0676
XMp_27_6 dp_27_6 WL27 SL6 VSS sky130_fd_pr__nfet_g5v0d10v5 w=1 l=0.5
XRp_27_6 BLP6 dp_27_6 sky130_fd_pr_reram__reram_cell area_ox=0.0676
XMz_27_6 dz_27_6 WL27 SL6 VSS sky130_fd_pr__nfet_g5v0d10v5 w=1 l=0.5
XRz_27_6 BLZ6 dz_27_6 sky130_fd_pr_reram__reram_cell area_ox=0.0676
XMn_27_6 dn_27_6 WL27 SL6 VSS sky130_fd_pr__nfet_g5v0d10v5 w=1 l=0.5
XRn_27_6 BLN6 dn_27_6 sky130_fd_pr_reram__reram_cell area_ox=0.0676
XMp_27_7 dp_27_7 WL27 SL7 VSS sky130_fd_pr__nfet_g5v0d10v5 w=1 l=0.5
XRp_27_7 BLP7 dp_27_7 sky130_fd_pr_reram__reram_cell area_ox=0.0676
XMz_27_7 dz_27_7 WL27 SL7 VSS sky130_fd_pr__nfet_g5v0d10v5 w=1 l=0.5
XRz_27_7 BLZ7 dz_27_7 sky130_fd_pr_reram__reram_cell area_ox=0.0676
XMn_27_7 dn_27_7 WL27 SL7 VSS sky130_fd_pr__nfet_g5v0d10v5 w=1 l=0.5
XRn_27_7 BLN7 dn_27_7 sky130_fd_pr_reram__reram_cell area_ox=0.0676
XMp_27_8 dp_27_8 WL27 SL8 VSS sky130_fd_pr__nfet_g5v0d10v5 w=1 l=0.5
XRp_27_8 BLP8 dp_27_8 sky130_fd_pr_reram__reram_cell area_ox=0.0676
XMz_27_8 dz_27_8 WL27 SL8 VSS sky130_fd_pr__nfet_g5v0d10v5 w=1 l=0.5
XRz_27_8 BLZ8 dz_27_8 sky130_fd_pr_reram__reram_cell area_ox=0.0676
XMn_27_8 dn_27_8 WL27 SL8 VSS sky130_fd_pr__nfet_g5v0d10v5 w=1 l=0.5
XRn_27_8 BLN8 dn_27_8 sky130_fd_pr_reram__reram_cell area_ox=0.0676
XMp_27_9 dp_27_9 WL27 SL9 VSS sky130_fd_pr__nfet_g5v0d10v5 w=1 l=0.5
XRp_27_9 BLP9 dp_27_9 sky130_fd_pr_reram__reram_cell area_ox=0.0676
XMz_27_9 dz_27_9 WL27 SL9 VSS sky130_fd_pr__nfet_g5v0d10v5 w=1 l=0.5
XRz_27_9 BLZ9 dz_27_9 sky130_fd_pr_reram__reram_cell area_ox=0.0676
XMn_27_9 dn_27_9 WL27 SL9 VSS sky130_fd_pr__nfet_g5v0d10v5 w=1 l=0.5
XRn_27_9 BLN9 dn_27_9 sky130_fd_pr_reram__reram_cell area_ox=0.0676
XMp_27_10 dp_27_10 WL27 SL10 VSS sky130_fd_pr__nfet_g5v0d10v5 w=1 l=0.5
XRp_27_10 BLP10 dp_27_10 sky130_fd_pr_reram__reram_cell area_ox=0.0676
XMz_27_10 dz_27_10 WL27 SL10 VSS sky130_fd_pr__nfet_g5v0d10v5 w=1 l=0.5
XRz_27_10 BLZ10 dz_27_10 sky130_fd_pr_reram__reram_cell area_ox=0.0676
XMn_27_10 dn_27_10 WL27 SL10 VSS sky130_fd_pr__nfet_g5v0d10v5 w=1 l=0.5
XRn_27_10 BLN10 dn_27_10 sky130_fd_pr_reram__reram_cell area_ox=0.0676
XMp_27_11 dp_27_11 WL27 SL11 VSS sky130_fd_pr__nfet_g5v0d10v5 w=1 l=0.5
XRp_27_11 BLP11 dp_27_11 sky130_fd_pr_reram__reram_cell area_ox=0.0676
XMz_27_11 dz_27_11 WL27 SL11 VSS sky130_fd_pr__nfet_g5v0d10v5 w=1 l=0.5
XRz_27_11 BLZ11 dz_27_11 sky130_fd_pr_reram__reram_cell area_ox=0.0676
XMn_27_11 dn_27_11 WL27 SL11 VSS sky130_fd_pr__nfet_g5v0d10v5 w=1 l=0.5
XRn_27_11 BLN11 dn_27_11 sky130_fd_pr_reram__reram_cell area_ox=0.0676
XMp_27_12 dp_27_12 WL27 SL12 VSS sky130_fd_pr__nfet_g5v0d10v5 w=1 l=0.5
XRp_27_12 BLP12 dp_27_12 sky130_fd_pr_reram__reram_cell area_ox=0.0676
XMz_27_12 dz_27_12 WL27 SL12 VSS sky130_fd_pr__nfet_g5v0d10v5 w=1 l=0.5
XRz_27_12 BLZ12 dz_27_12 sky130_fd_pr_reram__reram_cell area_ox=0.0676
XMn_27_12 dn_27_12 WL27 SL12 VSS sky130_fd_pr__nfet_g5v0d10v5 w=1 l=0.5
XRn_27_12 BLN12 dn_27_12 sky130_fd_pr_reram__reram_cell area_ox=0.0676
XMp_27_13 dp_27_13 WL27 SL13 VSS sky130_fd_pr__nfet_g5v0d10v5 w=1 l=0.5
XRp_27_13 BLP13 dp_27_13 sky130_fd_pr_reram__reram_cell area_ox=0.0676
XMz_27_13 dz_27_13 WL27 SL13 VSS sky130_fd_pr__nfet_g5v0d10v5 w=1 l=0.5
XRz_27_13 BLZ13 dz_27_13 sky130_fd_pr_reram__reram_cell area_ox=0.0676
XMn_27_13 dn_27_13 WL27 SL13 VSS sky130_fd_pr__nfet_g5v0d10v5 w=1 l=0.5
XRn_27_13 BLN13 dn_27_13 sky130_fd_pr_reram__reram_cell area_ox=0.0676
XMp_27_14 dp_27_14 WL27 SL14 VSS sky130_fd_pr__nfet_g5v0d10v5 w=1 l=0.5
XRp_27_14 BLP14 dp_27_14 sky130_fd_pr_reram__reram_cell area_ox=0.0676
XMz_27_14 dz_27_14 WL27 SL14 VSS sky130_fd_pr__nfet_g5v0d10v5 w=1 l=0.5
XRz_27_14 BLZ14 dz_27_14 sky130_fd_pr_reram__reram_cell area_ox=0.0676
XMn_27_14 dn_27_14 WL27 SL14 VSS sky130_fd_pr__nfet_g5v0d10v5 w=1 l=0.5
XRn_27_14 BLN14 dn_27_14 sky130_fd_pr_reram__reram_cell area_ox=0.0676
XMp_27_15 dp_27_15 WL27 SL15 VSS sky130_fd_pr__nfet_g5v0d10v5 w=1 l=0.5
XRp_27_15 BLP15 dp_27_15 sky130_fd_pr_reram__reram_cell area_ox=0.0676
XMz_27_15 dz_27_15 WL27 SL15 VSS sky130_fd_pr__nfet_g5v0d10v5 w=1 l=0.5
XRz_27_15 BLZ15 dz_27_15 sky130_fd_pr_reram__reram_cell area_ox=0.0676
XMn_27_15 dn_27_15 WL27 SL15 VSS sky130_fd_pr__nfet_g5v0d10v5 w=1 l=0.5
XRn_27_15 BLN15 dn_27_15 sky130_fd_pr_reram__reram_cell area_ox=0.0676
XMp_27_16 dp_27_16 WL27 SL16 VSS sky130_fd_pr__nfet_g5v0d10v5 w=1 l=0.5
XRp_27_16 BLP16 dp_27_16 sky130_fd_pr_reram__reram_cell area_ox=0.0676
XMz_27_16 dz_27_16 WL27 SL16 VSS sky130_fd_pr__nfet_g5v0d10v5 w=1 l=0.5
XRz_27_16 BLZ16 dz_27_16 sky130_fd_pr_reram__reram_cell area_ox=0.0676
XMn_27_16 dn_27_16 WL27 SL16 VSS sky130_fd_pr__nfet_g5v0d10v5 w=1 l=0.5
XRn_27_16 BLN16 dn_27_16 sky130_fd_pr_reram__reram_cell area_ox=0.0676
XMp_27_17 dp_27_17 WL27 SL17 VSS sky130_fd_pr__nfet_g5v0d10v5 w=1 l=0.5
XRp_27_17 BLP17 dp_27_17 sky130_fd_pr_reram__reram_cell area_ox=0.0676
XMz_27_17 dz_27_17 WL27 SL17 VSS sky130_fd_pr__nfet_g5v0d10v5 w=1 l=0.5
XRz_27_17 BLZ17 dz_27_17 sky130_fd_pr_reram__reram_cell area_ox=0.0676
XMn_27_17 dn_27_17 WL27 SL17 VSS sky130_fd_pr__nfet_g5v0d10v5 w=1 l=0.5
XRn_27_17 BLN17 dn_27_17 sky130_fd_pr_reram__reram_cell area_ox=0.0676
XMp_27_18 dp_27_18 WL27 SL18 VSS sky130_fd_pr__nfet_g5v0d10v5 w=1 l=0.5
XRp_27_18 BLP18 dp_27_18 sky130_fd_pr_reram__reram_cell area_ox=0.0676
XMz_27_18 dz_27_18 WL27 SL18 VSS sky130_fd_pr__nfet_g5v0d10v5 w=1 l=0.5
XRz_27_18 BLZ18 dz_27_18 sky130_fd_pr_reram__reram_cell area_ox=0.0676
XMn_27_18 dn_27_18 WL27 SL18 VSS sky130_fd_pr__nfet_g5v0d10v5 w=1 l=0.5
XRn_27_18 BLN18 dn_27_18 sky130_fd_pr_reram__reram_cell area_ox=0.0676
XMp_27_19 dp_27_19 WL27 SL19 VSS sky130_fd_pr__nfet_g5v0d10v5 w=1 l=0.5
XRp_27_19 BLP19 dp_27_19 sky130_fd_pr_reram__reram_cell area_ox=0.0676
XMz_27_19 dz_27_19 WL27 SL19 VSS sky130_fd_pr__nfet_g5v0d10v5 w=1 l=0.5
XRz_27_19 BLZ19 dz_27_19 sky130_fd_pr_reram__reram_cell area_ox=0.0676
XMn_27_19 dn_27_19 WL27 SL19 VSS sky130_fd_pr__nfet_g5v0d10v5 w=1 l=0.5
XRn_27_19 BLN19 dn_27_19 sky130_fd_pr_reram__reram_cell area_ox=0.0676
XMp_27_20 dp_27_20 WL27 SL20 VSS sky130_fd_pr__nfet_g5v0d10v5 w=1 l=0.5
XRp_27_20 BLP20 dp_27_20 sky130_fd_pr_reram__reram_cell area_ox=0.0676
XMz_27_20 dz_27_20 WL27 SL20 VSS sky130_fd_pr__nfet_g5v0d10v5 w=1 l=0.5
XRz_27_20 BLZ20 dz_27_20 sky130_fd_pr_reram__reram_cell area_ox=0.0676
XMn_27_20 dn_27_20 WL27 SL20 VSS sky130_fd_pr__nfet_g5v0d10v5 w=1 l=0.5
XRn_27_20 BLN20 dn_27_20 sky130_fd_pr_reram__reram_cell area_ox=0.0676
XMp_27_21 dp_27_21 WL27 SL21 VSS sky130_fd_pr__nfet_g5v0d10v5 w=1 l=0.5
XRp_27_21 BLP21 dp_27_21 sky130_fd_pr_reram__reram_cell area_ox=0.0676
XMz_27_21 dz_27_21 WL27 SL21 VSS sky130_fd_pr__nfet_g5v0d10v5 w=1 l=0.5
XRz_27_21 BLZ21 dz_27_21 sky130_fd_pr_reram__reram_cell area_ox=0.0676
XMn_27_21 dn_27_21 WL27 SL21 VSS sky130_fd_pr__nfet_g5v0d10v5 w=1 l=0.5
XRn_27_21 BLN21 dn_27_21 sky130_fd_pr_reram__reram_cell area_ox=0.0676
XMp_27_22 dp_27_22 WL27 SL22 VSS sky130_fd_pr__nfet_g5v0d10v5 w=1 l=0.5
XRp_27_22 BLP22 dp_27_22 sky130_fd_pr_reram__reram_cell area_ox=0.0676
XMz_27_22 dz_27_22 WL27 SL22 VSS sky130_fd_pr__nfet_g5v0d10v5 w=1 l=0.5
XRz_27_22 BLZ22 dz_27_22 sky130_fd_pr_reram__reram_cell area_ox=0.0676
XMn_27_22 dn_27_22 WL27 SL22 VSS sky130_fd_pr__nfet_g5v0d10v5 w=1 l=0.5
XRn_27_22 BLN22 dn_27_22 sky130_fd_pr_reram__reram_cell area_ox=0.0676
XMp_27_23 dp_27_23 WL27 SL23 VSS sky130_fd_pr__nfet_g5v0d10v5 w=1 l=0.5
XRp_27_23 BLP23 dp_27_23 sky130_fd_pr_reram__reram_cell area_ox=0.0676
XMz_27_23 dz_27_23 WL27 SL23 VSS sky130_fd_pr__nfet_g5v0d10v5 w=1 l=0.5
XRz_27_23 BLZ23 dz_27_23 sky130_fd_pr_reram__reram_cell area_ox=0.0676
XMn_27_23 dn_27_23 WL27 SL23 VSS sky130_fd_pr__nfet_g5v0d10v5 w=1 l=0.5
XRn_27_23 BLN23 dn_27_23 sky130_fd_pr_reram__reram_cell area_ox=0.0676
XMp_28_0 dp_28_0 WL28 SL0 VSS sky130_fd_pr__nfet_g5v0d10v5 w=1 l=0.5
XRp_28_0 BLP0 dp_28_0 sky130_fd_pr_reram__reram_cell area_ox=0.0676
XMz_28_0 dz_28_0 WL28 SL0 VSS sky130_fd_pr__nfet_g5v0d10v5 w=1 l=0.5
XRz_28_0 BLZ0 dz_28_0 sky130_fd_pr_reram__reram_cell area_ox=0.0676
XMn_28_0 dn_28_0 WL28 SL0 VSS sky130_fd_pr__nfet_g5v0d10v5 w=1 l=0.5
XRn_28_0 BLN0 dn_28_0 sky130_fd_pr_reram__reram_cell area_ox=0.0676
XMp_28_1 dp_28_1 WL28 SL1 VSS sky130_fd_pr__nfet_g5v0d10v5 w=1 l=0.5
XRp_28_1 BLP1 dp_28_1 sky130_fd_pr_reram__reram_cell area_ox=0.0676
XMz_28_1 dz_28_1 WL28 SL1 VSS sky130_fd_pr__nfet_g5v0d10v5 w=1 l=0.5
XRz_28_1 BLZ1 dz_28_1 sky130_fd_pr_reram__reram_cell area_ox=0.0676
XMn_28_1 dn_28_1 WL28 SL1 VSS sky130_fd_pr__nfet_g5v0d10v5 w=1 l=0.5
XRn_28_1 BLN1 dn_28_1 sky130_fd_pr_reram__reram_cell area_ox=0.0676
XMp_28_2 dp_28_2 WL28 SL2 VSS sky130_fd_pr__nfet_g5v0d10v5 w=1 l=0.5
XRp_28_2 BLP2 dp_28_2 sky130_fd_pr_reram__reram_cell area_ox=0.0676
XMz_28_2 dz_28_2 WL28 SL2 VSS sky130_fd_pr__nfet_g5v0d10v5 w=1 l=0.5
XRz_28_2 BLZ2 dz_28_2 sky130_fd_pr_reram__reram_cell area_ox=0.0676
XMn_28_2 dn_28_2 WL28 SL2 VSS sky130_fd_pr__nfet_g5v0d10v5 w=1 l=0.5
XRn_28_2 BLN2 dn_28_2 sky130_fd_pr_reram__reram_cell area_ox=0.0676
XMp_28_3 dp_28_3 WL28 SL3 VSS sky130_fd_pr__nfet_g5v0d10v5 w=1 l=0.5
XRp_28_3 BLP3 dp_28_3 sky130_fd_pr_reram__reram_cell area_ox=0.0676
XMz_28_3 dz_28_3 WL28 SL3 VSS sky130_fd_pr__nfet_g5v0d10v5 w=1 l=0.5
XRz_28_3 BLZ3 dz_28_3 sky130_fd_pr_reram__reram_cell area_ox=0.0676
XMn_28_3 dn_28_3 WL28 SL3 VSS sky130_fd_pr__nfet_g5v0d10v5 w=1 l=0.5
XRn_28_3 BLN3 dn_28_3 sky130_fd_pr_reram__reram_cell area_ox=0.0676
XMp_28_4 dp_28_4 WL28 SL4 VSS sky130_fd_pr__nfet_g5v0d10v5 w=1 l=0.5
XRp_28_4 BLP4 dp_28_4 sky130_fd_pr_reram__reram_cell area_ox=0.0676
XMz_28_4 dz_28_4 WL28 SL4 VSS sky130_fd_pr__nfet_g5v0d10v5 w=1 l=0.5
XRz_28_4 BLZ4 dz_28_4 sky130_fd_pr_reram__reram_cell area_ox=0.0676
XMn_28_4 dn_28_4 WL28 SL4 VSS sky130_fd_pr__nfet_g5v0d10v5 w=1 l=0.5
XRn_28_4 BLN4 dn_28_4 sky130_fd_pr_reram__reram_cell area_ox=0.0676
XMp_28_5 dp_28_5 WL28 SL5 VSS sky130_fd_pr__nfet_g5v0d10v5 w=1 l=0.5
XRp_28_5 BLP5 dp_28_5 sky130_fd_pr_reram__reram_cell area_ox=0.0676
XMz_28_5 dz_28_5 WL28 SL5 VSS sky130_fd_pr__nfet_g5v0d10v5 w=1 l=0.5
XRz_28_5 BLZ5 dz_28_5 sky130_fd_pr_reram__reram_cell area_ox=0.0676
XMn_28_5 dn_28_5 WL28 SL5 VSS sky130_fd_pr__nfet_g5v0d10v5 w=1 l=0.5
XRn_28_5 BLN5 dn_28_5 sky130_fd_pr_reram__reram_cell area_ox=0.0676
XMp_28_6 dp_28_6 WL28 SL6 VSS sky130_fd_pr__nfet_g5v0d10v5 w=1 l=0.5
XRp_28_6 BLP6 dp_28_6 sky130_fd_pr_reram__reram_cell area_ox=0.0676
XMz_28_6 dz_28_6 WL28 SL6 VSS sky130_fd_pr__nfet_g5v0d10v5 w=1 l=0.5
XRz_28_6 BLZ6 dz_28_6 sky130_fd_pr_reram__reram_cell area_ox=0.0676
XMn_28_6 dn_28_6 WL28 SL6 VSS sky130_fd_pr__nfet_g5v0d10v5 w=1 l=0.5
XRn_28_6 BLN6 dn_28_6 sky130_fd_pr_reram__reram_cell area_ox=0.0676
XMp_28_7 dp_28_7 WL28 SL7 VSS sky130_fd_pr__nfet_g5v0d10v5 w=1 l=0.5
XRp_28_7 BLP7 dp_28_7 sky130_fd_pr_reram__reram_cell area_ox=0.0676
XMz_28_7 dz_28_7 WL28 SL7 VSS sky130_fd_pr__nfet_g5v0d10v5 w=1 l=0.5
XRz_28_7 BLZ7 dz_28_7 sky130_fd_pr_reram__reram_cell area_ox=0.0676
XMn_28_7 dn_28_7 WL28 SL7 VSS sky130_fd_pr__nfet_g5v0d10v5 w=1 l=0.5
XRn_28_7 BLN7 dn_28_7 sky130_fd_pr_reram__reram_cell area_ox=0.0676
XMp_28_8 dp_28_8 WL28 SL8 VSS sky130_fd_pr__nfet_g5v0d10v5 w=1 l=0.5
XRp_28_8 BLP8 dp_28_8 sky130_fd_pr_reram__reram_cell area_ox=0.0676
XMz_28_8 dz_28_8 WL28 SL8 VSS sky130_fd_pr__nfet_g5v0d10v5 w=1 l=0.5
XRz_28_8 BLZ8 dz_28_8 sky130_fd_pr_reram__reram_cell area_ox=0.0676
XMn_28_8 dn_28_8 WL28 SL8 VSS sky130_fd_pr__nfet_g5v0d10v5 w=1 l=0.5
XRn_28_8 BLN8 dn_28_8 sky130_fd_pr_reram__reram_cell area_ox=0.0676
XMp_28_9 dp_28_9 WL28 SL9 VSS sky130_fd_pr__nfet_g5v0d10v5 w=1 l=0.5
XRp_28_9 BLP9 dp_28_9 sky130_fd_pr_reram__reram_cell area_ox=0.0676
XMz_28_9 dz_28_9 WL28 SL9 VSS sky130_fd_pr__nfet_g5v0d10v5 w=1 l=0.5
XRz_28_9 BLZ9 dz_28_9 sky130_fd_pr_reram__reram_cell area_ox=0.0676
XMn_28_9 dn_28_9 WL28 SL9 VSS sky130_fd_pr__nfet_g5v0d10v5 w=1 l=0.5
XRn_28_9 BLN9 dn_28_9 sky130_fd_pr_reram__reram_cell area_ox=0.0676
XMp_28_10 dp_28_10 WL28 SL10 VSS sky130_fd_pr__nfet_g5v0d10v5 w=1 l=0.5
XRp_28_10 BLP10 dp_28_10 sky130_fd_pr_reram__reram_cell area_ox=0.0676
XMz_28_10 dz_28_10 WL28 SL10 VSS sky130_fd_pr__nfet_g5v0d10v5 w=1 l=0.5
XRz_28_10 BLZ10 dz_28_10 sky130_fd_pr_reram__reram_cell area_ox=0.0676
XMn_28_10 dn_28_10 WL28 SL10 VSS sky130_fd_pr__nfet_g5v0d10v5 w=1 l=0.5
XRn_28_10 BLN10 dn_28_10 sky130_fd_pr_reram__reram_cell area_ox=0.0676
XMp_28_11 dp_28_11 WL28 SL11 VSS sky130_fd_pr__nfet_g5v0d10v5 w=1 l=0.5
XRp_28_11 BLP11 dp_28_11 sky130_fd_pr_reram__reram_cell area_ox=0.0676
XMz_28_11 dz_28_11 WL28 SL11 VSS sky130_fd_pr__nfet_g5v0d10v5 w=1 l=0.5
XRz_28_11 BLZ11 dz_28_11 sky130_fd_pr_reram__reram_cell area_ox=0.0676
XMn_28_11 dn_28_11 WL28 SL11 VSS sky130_fd_pr__nfet_g5v0d10v5 w=1 l=0.5
XRn_28_11 BLN11 dn_28_11 sky130_fd_pr_reram__reram_cell area_ox=0.0676
XMp_28_12 dp_28_12 WL28 SL12 VSS sky130_fd_pr__nfet_g5v0d10v5 w=1 l=0.5
XRp_28_12 BLP12 dp_28_12 sky130_fd_pr_reram__reram_cell area_ox=0.0676
XMz_28_12 dz_28_12 WL28 SL12 VSS sky130_fd_pr__nfet_g5v0d10v5 w=1 l=0.5
XRz_28_12 BLZ12 dz_28_12 sky130_fd_pr_reram__reram_cell area_ox=0.0676
XMn_28_12 dn_28_12 WL28 SL12 VSS sky130_fd_pr__nfet_g5v0d10v5 w=1 l=0.5
XRn_28_12 BLN12 dn_28_12 sky130_fd_pr_reram__reram_cell area_ox=0.0676
XMp_28_13 dp_28_13 WL28 SL13 VSS sky130_fd_pr__nfet_g5v0d10v5 w=1 l=0.5
XRp_28_13 BLP13 dp_28_13 sky130_fd_pr_reram__reram_cell area_ox=0.0676
XMz_28_13 dz_28_13 WL28 SL13 VSS sky130_fd_pr__nfet_g5v0d10v5 w=1 l=0.5
XRz_28_13 BLZ13 dz_28_13 sky130_fd_pr_reram__reram_cell area_ox=0.0676
XMn_28_13 dn_28_13 WL28 SL13 VSS sky130_fd_pr__nfet_g5v0d10v5 w=1 l=0.5
XRn_28_13 BLN13 dn_28_13 sky130_fd_pr_reram__reram_cell area_ox=0.0676
XMp_28_14 dp_28_14 WL28 SL14 VSS sky130_fd_pr__nfet_g5v0d10v5 w=1 l=0.5
XRp_28_14 BLP14 dp_28_14 sky130_fd_pr_reram__reram_cell area_ox=0.0676
XMz_28_14 dz_28_14 WL28 SL14 VSS sky130_fd_pr__nfet_g5v0d10v5 w=1 l=0.5
XRz_28_14 BLZ14 dz_28_14 sky130_fd_pr_reram__reram_cell area_ox=0.0676
XMn_28_14 dn_28_14 WL28 SL14 VSS sky130_fd_pr__nfet_g5v0d10v5 w=1 l=0.5
XRn_28_14 BLN14 dn_28_14 sky130_fd_pr_reram__reram_cell area_ox=0.0676
XMp_28_15 dp_28_15 WL28 SL15 VSS sky130_fd_pr__nfet_g5v0d10v5 w=1 l=0.5
XRp_28_15 BLP15 dp_28_15 sky130_fd_pr_reram__reram_cell area_ox=0.0676
XMz_28_15 dz_28_15 WL28 SL15 VSS sky130_fd_pr__nfet_g5v0d10v5 w=1 l=0.5
XRz_28_15 BLZ15 dz_28_15 sky130_fd_pr_reram__reram_cell area_ox=0.0676
XMn_28_15 dn_28_15 WL28 SL15 VSS sky130_fd_pr__nfet_g5v0d10v5 w=1 l=0.5
XRn_28_15 BLN15 dn_28_15 sky130_fd_pr_reram__reram_cell area_ox=0.0676
XMp_28_16 dp_28_16 WL28 SL16 VSS sky130_fd_pr__nfet_g5v0d10v5 w=1 l=0.5
XRp_28_16 BLP16 dp_28_16 sky130_fd_pr_reram__reram_cell area_ox=0.0676
XMz_28_16 dz_28_16 WL28 SL16 VSS sky130_fd_pr__nfet_g5v0d10v5 w=1 l=0.5
XRz_28_16 BLZ16 dz_28_16 sky130_fd_pr_reram__reram_cell area_ox=0.0676
XMn_28_16 dn_28_16 WL28 SL16 VSS sky130_fd_pr__nfet_g5v0d10v5 w=1 l=0.5
XRn_28_16 BLN16 dn_28_16 sky130_fd_pr_reram__reram_cell area_ox=0.0676
XMp_28_17 dp_28_17 WL28 SL17 VSS sky130_fd_pr__nfet_g5v0d10v5 w=1 l=0.5
XRp_28_17 BLP17 dp_28_17 sky130_fd_pr_reram__reram_cell area_ox=0.0676
XMz_28_17 dz_28_17 WL28 SL17 VSS sky130_fd_pr__nfet_g5v0d10v5 w=1 l=0.5
XRz_28_17 BLZ17 dz_28_17 sky130_fd_pr_reram__reram_cell area_ox=0.0676
XMn_28_17 dn_28_17 WL28 SL17 VSS sky130_fd_pr__nfet_g5v0d10v5 w=1 l=0.5
XRn_28_17 BLN17 dn_28_17 sky130_fd_pr_reram__reram_cell area_ox=0.0676
XMp_28_18 dp_28_18 WL28 SL18 VSS sky130_fd_pr__nfet_g5v0d10v5 w=1 l=0.5
XRp_28_18 BLP18 dp_28_18 sky130_fd_pr_reram__reram_cell area_ox=0.0676
XMz_28_18 dz_28_18 WL28 SL18 VSS sky130_fd_pr__nfet_g5v0d10v5 w=1 l=0.5
XRz_28_18 BLZ18 dz_28_18 sky130_fd_pr_reram__reram_cell area_ox=0.0676
XMn_28_18 dn_28_18 WL28 SL18 VSS sky130_fd_pr__nfet_g5v0d10v5 w=1 l=0.5
XRn_28_18 BLN18 dn_28_18 sky130_fd_pr_reram__reram_cell area_ox=0.0676
XMp_28_19 dp_28_19 WL28 SL19 VSS sky130_fd_pr__nfet_g5v0d10v5 w=1 l=0.5
XRp_28_19 BLP19 dp_28_19 sky130_fd_pr_reram__reram_cell area_ox=0.0676
XMz_28_19 dz_28_19 WL28 SL19 VSS sky130_fd_pr__nfet_g5v0d10v5 w=1 l=0.5
XRz_28_19 BLZ19 dz_28_19 sky130_fd_pr_reram__reram_cell area_ox=0.0676
XMn_28_19 dn_28_19 WL28 SL19 VSS sky130_fd_pr__nfet_g5v0d10v5 w=1 l=0.5
XRn_28_19 BLN19 dn_28_19 sky130_fd_pr_reram__reram_cell area_ox=0.0676
XMp_28_20 dp_28_20 WL28 SL20 VSS sky130_fd_pr__nfet_g5v0d10v5 w=1 l=0.5
XRp_28_20 BLP20 dp_28_20 sky130_fd_pr_reram__reram_cell area_ox=0.0676
XMz_28_20 dz_28_20 WL28 SL20 VSS sky130_fd_pr__nfet_g5v0d10v5 w=1 l=0.5
XRz_28_20 BLZ20 dz_28_20 sky130_fd_pr_reram__reram_cell area_ox=0.0676
XMn_28_20 dn_28_20 WL28 SL20 VSS sky130_fd_pr__nfet_g5v0d10v5 w=1 l=0.5
XRn_28_20 BLN20 dn_28_20 sky130_fd_pr_reram__reram_cell area_ox=0.0676
XMp_28_21 dp_28_21 WL28 SL21 VSS sky130_fd_pr__nfet_g5v0d10v5 w=1 l=0.5
XRp_28_21 BLP21 dp_28_21 sky130_fd_pr_reram__reram_cell area_ox=0.0676
XMz_28_21 dz_28_21 WL28 SL21 VSS sky130_fd_pr__nfet_g5v0d10v5 w=1 l=0.5
XRz_28_21 BLZ21 dz_28_21 sky130_fd_pr_reram__reram_cell area_ox=0.0676
XMn_28_21 dn_28_21 WL28 SL21 VSS sky130_fd_pr__nfet_g5v0d10v5 w=1 l=0.5
XRn_28_21 BLN21 dn_28_21 sky130_fd_pr_reram__reram_cell area_ox=0.0676
XMp_28_22 dp_28_22 WL28 SL22 VSS sky130_fd_pr__nfet_g5v0d10v5 w=1 l=0.5
XRp_28_22 BLP22 dp_28_22 sky130_fd_pr_reram__reram_cell area_ox=0.0676
XMz_28_22 dz_28_22 WL28 SL22 VSS sky130_fd_pr__nfet_g5v0d10v5 w=1 l=0.5
XRz_28_22 BLZ22 dz_28_22 sky130_fd_pr_reram__reram_cell area_ox=0.0676
XMn_28_22 dn_28_22 WL28 SL22 VSS sky130_fd_pr__nfet_g5v0d10v5 w=1 l=0.5
XRn_28_22 BLN22 dn_28_22 sky130_fd_pr_reram__reram_cell area_ox=0.0676
XMp_28_23 dp_28_23 WL28 SL23 VSS sky130_fd_pr__nfet_g5v0d10v5 w=1 l=0.5
XRp_28_23 BLP23 dp_28_23 sky130_fd_pr_reram__reram_cell area_ox=0.0676
XMz_28_23 dz_28_23 WL28 SL23 VSS sky130_fd_pr__nfet_g5v0d10v5 w=1 l=0.5
XRz_28_23 BLZ23 dz_28_23 sky130_fd_pr_reram__reram_cell area_ox=0.0676
XMn_28_23 dn_28_23 WL28 SL23 VSS sky130_fd_pr__nfet_g5v0d10v5 w=1 l=0.5
XRn_28_23 BLN23 dn_28_23 sky130_fd_pr_reram__reram_cell area_ox=0.0676
XMp_29_0 dp_29_0 WL29 SL0 VSS sky130_fd_pr__nfet_g5v0d10v5 w=1 l=0.5
XRp_29_0 BLP0 dp_29_0 sky130_fd_pr_reram__reram_cell area_ox=0.0676
XMz_29_0 dz_29_0 WL29 SL0 VSS sky130_fd_pr__nfet_g5v0d10v5 w=1 l=0.5
XRz_29_0 BLZ0 dz_29_0 sky130_fd_pr_reram__reram_cell area_ox=0.0676
XMn_29_0 dn_29_0 WL29 SL0 VSS sky130_fd_pr__nfet_g5v0d10v5 w=1 l=0.5
XRn_29_0 BLN0 dn_29_0 sky130_fd_pr_reram__reram_cell area_ox=0.0676
XMp_29_1 dp_29_1 WL29 SL1 VSS sky130_fd_pr__nfet_g5v0d10v5 w=1 l=0.5
XRp_29_1 BLP1 dp_29_1 sky130_fd_pr_reram__reram_cell area_ox=0.0676
XMz_29_1 dz_29_1 WL29 SL1 VSS sky130_fd_pr__nfet_g5v0d10v5 w=1 l=0.5
XRz_29_1 BLZ1 dz_29_1 sky130_fd_pr_reram__reram_cell area_ox=0.0676
XMn_29_1 dn_29_1 WL29 SL1 VSS sky130_fd_pr__nfet_g5v0d10v5 w=1 l=0.5
XRn_29_1 BLN1 dn_29_1 sky130_fd_pr_reram__reram_cell area_ox=0.0676
XMp_29_2 dp_29_2 WL29 SL2 VSS sky130_fd_pr__nfet_g5v0d10v5 w=1 l=0.5
XRp_29_2 BLP2 dp_29_2 sky130_fd_pr_reram__reram_cell area_ox=0.0676
XMz_29_2 dz_29_2 WL29 SL2 VSS sky130_fd_pr__nfet_g5v0d10v5 w=1 l=0.5
XRz_29_2 BLZ2 dz_29_2 sky130_fd_pr_reram__reram_cell area_ox=0.0676
XMn_29_2 dn_29_2 WL29 SL2 VSS sky130_fd_pr__nfet_g5v0d10v5 w=1 l=0.5
XRn_29_2 BLN2 dn_29_2 sky130_fd_pr_reram__reram_cell area_ox=0.0676
XMp_29_3 dp_29_3 WL29 SL3 VSS sky130_fd_pr__nfet_g5v0d10v5 w=1 l=0.5
XRp_29_3 BLP3 dp_29_3 sky130_fd_pr_reram__reram_cell area_ox=0.0676
XMz_29_3 dz_29_3 WL29 SL3 VSS sky130_fd_pr__nfet_g5v0d10v5 w=1 l=0.5
XRz_29_3 BLZ3 dz_29_3 sky130_fd_pr_reram__reram_cell area_ox=0.0676
XMn_29_3 dn_29_3 WL29 SL3 VSS sky130_fd_pr__nfet_g5v0d10v5 w=1 l=0.5
XRn_29_3 BLN3 dn_29_3 sky130_fd_pr_reram__reram_cell area_ox=0.0676
XMp_29_4 dp_29_4 WL29 SL4 VSS sky130_fd_pr__nfet_g5v0d10v5 w=1 l=0.5
XRp_29_4 BLP4 dp_29_4 sky130_fd_pr_reram__reram_cell area_ox=0.0676
XMz_29_4 dz_29_4 WL29 SL4 VSS sky130_fd_pr__nfet_g5v0d10v5 w=1 l=0.5
XRz_29_4 BLZ4 dz_29_4 sky130_fd_pr_reram__reram_cell area_ox=0.0676
XMn_29_4 dn_29_4 WL29 SL4 VSS sky130_fd_pr__nfet_g5v0d10v5 w=1 l=0.5
XRn_29_4 BLN4 dn_29_4 sky130_fd_pr_reram__reram_cell area_ox=0.0676
XMp_29_5 dp_29_5 WL29 SL5 VSS sky130_fd_pr__nfet_g5v0d10v5 w=1 l=0.5
XRp_29_5 BLP5 dp_29_5 sky130_fd_pr_reram__reram_cell area_ox=0.0676
XMz_29_5 dz_29_5 WL29 SL5 VSS sky130_fd_pr__nfet_g5v0d10v5 w=1 l=0.5
XRz_29_5 BLZ5 dz_29_5 sky130_fd_pr_reram__reram_cell area_ox=0.0676
XMn_29_5 dn_29_5 WL29 SL5 VSS sky130_fd_pr__nfet_g5v0d10v5 w=1 l=0.5
XRn_29_5 BLN5 dn_29_5 sky130_fd_pr_reram__reram_cell area_ox=0.0676
XMp_29_6 dp_29_6 WL29 SL6 VSS sky130_fd_pr__nfet_g5v0d10v5 w=1 l=0.5
XRp_29_6 BLP6 dp_29_6 sky130_fd_pr_reram__reram_cell area_ox=0.0676
XMz_29_6 dz_29_6 WL29 SL6 VSS sky130_fd_pr__nfet_g5v0d10v5 w=1 l=0.5
XRz_29_6 BLZ6 dz_29_6 sky130_fd_pr_reram__reram_cell area_ox=0.0676
XMn_29_6 dn_29_6 WL29 SL6 VSS sky130_fd_pr__nfet_g5v0d10v5 w=1 l=0.5
XRn_29_6 BLN6 dn_29_6 sky130_fd_pr_reram__reram_cell area_ox=0.0676
XMp_29_7 dp_29_7 WL29 SL7 VSS sky130_fd_pr__nfet_g5v0d10v5 w=1 l=0.5
XRp_29_7 BLP7 dp_29_7 sky130_fd_pr_reram__reram_cell area_ox=0.0676
XMz_29_7 dz_29_7 WL29 SL7 VSS sky130_fd_pr__nfet_g5v0d10v5 w=1 l=0.5
XRz_29_7 BLZ7 dz_29_7 sky130_fd_pr_reram__reram_cell area_ox=0.0676
XMn_29_7 dn_29_7 WL29 SL7 VSS sky130_fd_pr__nfet_g5v0d10v5 w=1 l=0.5
XRn_29_7 BLN7 dn_29_7 sky130_fd_pr_reram__reram_cell area_ox=0.0676
XMp_29_8 dp_29_8 WL29 SL8 VSS sky130_fd_pr__nfet_g5v0d10v5 w=1 l=0.5
XRp_29_8 BLP8 dp_29_8 sky130_fd_pr_reram__reram_cell area_ox=0.0676
XMz_29_8 dz_29_8 WL29 SL8 VSS sky130_fd_pr__nfet_g5v0d10v5 w=1 l=0.5
XRz_29_8 BLZ8 dz_29_8 sky130_fd_pr_reram__reram_cell area_ox=0.0676
XMn_29_8 dn_29_8 WL29 SL8 VSS sky130_fd_pr__nfet_g5v0d10v5 w=1 l=0.5
XRn_29_8 BLN8 dn_29_8 sky130_fd_pr_reram__reram_cell area_ox=0.0676
XMp_29_9 dp_29_9 WL29 SL9 VSS sky130_fd_pr__nfet_g5v0d10v5 w=1 l=0.5
XRp_29_9 BLP9 dp_29_9 sky130_fd_pr_reram__reram_cell area_ox=0.0676
XMz_29_9 dz_29_9 WL29 SL9 VSS sky130_fd_pr__nfet_g5v0d10v5 w=1 l=0.5
XRz_29_9 BLZ9 dz_29_9 sky130_fd_pr_reram__reram_cell area_ox=0.0676
XMn_29_9 dn_29_9 WL29 SL9 VSS sky130_fd_pr__nfet_g5v0d10v5 w=1 l=0.5
XRn_29_9 BLN9 dn_29_9 sky130_fd_pr_reram__reram_cell area_ox=0.0676
XMp_29_10 dp_29_10 WL29 SL10 VSS sky130_fd_pr__nfet_g5v0d10v5 w=1 l=0.5
XRp_29_10 BLP10 dp_29_10 sky130_fd_pr_reram__reram_cell area_ox=0.0676
XMz_29_10 dz_29_10 WL29 SL10 VSS sky130_fd_pr__nfet_g5v0d10v5 w=1 l=0.5
XRz_29_10 BLZ10 dz_29_10 sky130_fd_pr_reram__reram_cell area_ox=0.0676
XMn_29_10 dn_29_10 WL29 SL10 VSS sky130_fd_pr__nfet_g5v0d10v5 w=1 l=0.5
XRn_29_10 BLN10 dn_29_10 sky130_fd_pr_reram__reram_cell area_ox=0.0676
XMp_29_11 dp_29_11 WL29 SL11 VSS sky130_fd_pr__nfet_g5v0d10v5 w=1 l=0.5
XRp_29_11 BLP11 dp_29_11 sky130_fd_pr_reram__reram_cell area_ox=0.0676
XMz_29_11 dz_29_11 WL29 SL11 VSS sky130_fd_pr__nfet_g5v0d10v5 w=1 l=0.5
XRz_29_11 BLZ11 dz_29_11 sky130_fd_pr_reram__reram_cell area_ox=0.0676
XMn_29_11 dn_29_11 WL29 SL11 VSS sky130_fd_pr__nfet_g5v0d10v5 w=1 l=0.5
XRn_29_11 BLN11 dn_29_11 sky130_fd_pr_reram__reram_cell area_ox=0.0676
XMp_29_12 dp_29_12 WL29 SL12 VSS sky130_fd_pr__nfet_g5v0d10v5 w=1 l=0.5
XRp_29_12 BLP12 dp_29_12 sky130_fd_pr_reram__reram_cell area_ox=0.0676
XMz_29_12 dz_29_12 WL29 SL12 VSS sky130_fd_pr__nfet_g5v0d10v5 w=1 l=0.5
XRz_29_12 BLZ12 dz_29_12 sky130_fd_pr_reram__reram_cell area_ox=0.0676
XMn_29_12 dn_29_12 WL29 SL12 VSS sky130_fd_pr__nfet_g5v0d10v5 w=1 l=0.5
XRn_29_12 BLN12 dn_29_12 sky130_fd_pr_reram__reram_cell area_ox=0.0676
XMp_29_13 dp_29_13 WL29 SL13 VSS sky130_fd_pr__nfet_g5v0d10v5 w=1 l=0.5
XRp_29_13 BLP13 dp_29_13 sky130_fd_pr_reram__reram_cell area_ox=0.0676
XMz_29_13 dz_29_13 WL29 SL13 VSS sky130_fd_pr__nfet_g5v0d10v5 w=1 l=0.5
XRz_29_13 BLZ13 dz_29_13 sky130_fd_pr_reram__reram_cell area_ox=0.0676
XMn_29_13 dn_29_13 WL29 SL13 VSS sky130_fd_pr__nfet_g5v0d10v5 w=1 l=0.5
XRn_29_13 BLN13 dn_29_13 sky130_fd_pr_reram__reram_cell area_ox=0.0676
XMp_29_14 dp_29_14 WL29 SL14 VSS sky130_fd_pr__nfet_g5v0d10v5 w=1 l=0.5
XRp_29_14 BLP14 dp_29_14 sky130_fd_pr_reram__reram_cell area_ox=0.0676
XMz_29_14 dz_29_14 WL29 SL14 VSS sky130_fd_pr__nfet_g5v0d10v5 w=1 l=0.5
XRz_29_14 BLZ14 dz_29_14 sky130_fd_pr_reram__reram_cell area_ox=0.0676
XMn_29_14 dn_29_14 WL29 SL14 VSS sky130_fd_pr__nfet_g5v0d10v5 w=1 l=0.5
XRn_29_14 BLN14 dn_29_14 sky130_fd_pr_reram__reram_cell area_ox=0.0676
XMp_29_15 dp_29_15 WL29 SL15 VSS sky130_fd_pr__nfet_g5v0d10v5 w=1 l=0.5
XRp_29_15 BLP15 dp_29_15 sky130_fd_pr_reram__reram_cell area_ox=0.0676
XMz_29_15 dz_29_15 WL29 SL15 VSS sky130_fd_pr__nfet_g5v0d10v5 w=1 l=0.5
XRz_29_15 BLZ15 dz_29_15 sky130_fd_pr_reram__reram_cell area_ox=0.0676
XMn_29_15 dn_29_15 WL29 SL15 VSS sky130_fd_pr__nfet_g5v0d10v5 w=1 l=0.5
XRn_29_15 BLN15 dn_29_15 sky130_fd_pr_reram__reram_cell area_ox=0.0676
XMp_29_16 dp_29_16 WL29 SL16 VSS sky130_fd_pr__nfet_g5v0d10v5 w=1 l=0.5
XRp_29_16 BLP16 dp_29_16 sky130_fd_pr_reram__reram_cell area_ox=0.0676
XMz_29_16 dz_29_16 WL29 SL16 VSS sky130_fd_pr__nfet_g5v0d10v5 w=1 l=0.5
XRz_29_16 BLZ16 dz_29_16 sky130_fd_pr_reram__reram_cell area_ox=0.0676
XMn_29_16 dn_29_16 WL29 SL16 VSS sky130_fd_pr__nfet_g5v0d10v5 w=1 l=0.5
XRn_29_16 BLN16 dn_29_16 sky130_fd_pr_reram__reram_cell area_ox=0.0676
XMp_29_17 dp_29_17 WL29 SL17 VSS sky130_fd_pr__nfet_g5v0d10v5 w=1 l=0.5
XRp_29_17 BLP17 dp_29_17 sky130_fd_pr_reram__reram_cell area_ox=0.0676
XMz_29_17 dz_29_17 WL29 SL17 VSS sky130_fd_pr__nfet_g5v0d10v5 w=1 l=0.5
XRz_29_17 BLZ17 dz_29_17 sky130_fd_pr_reram__reram_cell area_ox=0.0676
XMn_29_17 dn_29_17 WL29 SL17 VSS sky130_fd_pr__nfet_g5v0d10v5 w=1 l=0.5
XRn_29_17 BLN17 dn_29_17 sky130_fd_pr_reram__reram_cell area_ox=0.0676
XMp_29_18 dp_29_18 WL29 SL18 VSS sky130_fd_pr__nfet_g5v0d10v5 w=1 l=0.5
XRp_29_18 BLP18 dp_29_18 sky130_fd_pr_reram__reram_cell area_ox=0.0676
XMz_29_18 dz_29_18 WL29 SL18 VSS sky130_fd_pr__nfet_g5v0d10v5 w=1 l=0.5
XRz_29_18 BLZ18 dz_29_18 sky130_fd_pr_reram__reram_cell area_ox=0.0676
XMn_29_18 dn_29_18 WL29 SL18 VSS sky130_fd_pr__nfet_g5v0d10v5 w=1 l=0.5
XRn_29_18 BLN18 dn_29_18 sky130_fd_pr_reram__reram_cell area_ox=0.0676
XMp_29_19 dp_29_19 WL29 SL19 VSS sky130_fd_pr__nfet_g5v0d10v5 w=1 l=0.5
XRp_29_19 BLP19 dp_29_19 sky130_fd_pr_reram__reram_cell area_ox=0.0676
XMz_29_19 dz_29_19 WL29 SL19 VSS sky130_fd_pr__nfet_g5v0d10v5 w=1 l=0.5
XRz_29_19 BLZ19 dz_29_19 sky130_fd_pr_reram__reram_cell area_ox=0.0676
XMn_29_19 dn_29_19 WL29 SL19 VSS sky130_fd_pr__nfet_g5v0d10v5 w=1 l=0.5
XRn_29_19 BLN19 dn_29_19 sky130_fd_pr_reram__reram_cell area_ox=0.0676
XMp_29_20 dp_29_20 WL29 SL20 VSS sky130_fd_pr__nfet_g5v0d10v5 w=1 l=0.5
XRp_29_20 BLP20 dp_29_20 sky130_fd_pr_reram__reram_cell area_ox=0.0676
XMz_29_20 dz_29_20 WL29 SL20 VSS sky130_fd_pr__nfet_g5v0d10v5 w=1 l=0.5
XRz_29_20 BLZ20 dz_29_20 sky130_fd_pr_reram__reram_cell area_ox=0.0676
XMn_29_20 dn_29_20 WL29 SL20 VSS sky130_fd_pr__nfet_g5v0d10v5 w=1 l=0.5
XRn_29_20 BLN20 dn_29_20 sky130_fd_pr_reram__reram_cell area_ox=0.0676
XMp_29_21 dp_29_21 WL29 SL21 VSS sky130_fd_pr__nfet_g5v0d10v5 w=1 l=0.5
XRp_29_21 BLP21 dp_29_21 sky130_fd_pr_reram__reram_cell area_ox=0.0676
XMz_29_21 dz_29_21 WL29 SL21 VSS sky130_fd_pr__nfet_g5v0d10v5 w=1 l=0.5
XRz_29_21 BLZ21 dz_29_21 sky130_fd_pr_reram__reram_cell area_ox=0.0676
XMn_29_21 dn_29_21 WL29 SL21 VSS sky130_fd_pr__nfet_g5v0d10v5 w=1 l=0.5
XRn_29_21 BLN21 dn_29_21 sky130_fd_pr_reram__reram_cell area_ox=0.0676
XMp_29_22 dp_29_22 WL29 SL22 VSS sky130_fd_pr__nfet_g5v0d10v5 w=1 l=0.5
XRp_29_22 BLP22 dp_29_22 sky130_fd_pr_reram__reram_cell area_ox=0.0676
XMz_29_22 dz_29_22 WL29 SL22 VSS sky130_fd_pr__nfet_g5v0d10v5 w=1 l=0.5
XRz_29_22 BLZ22 dz_29_22 sky130_fd_pr_reram__reram_cell area_ox=0.0676
XMn_29_22 dn_29_22 WL29 SL22 VSS sky130_fd_pr__nfet_g5v0d10v5 w=1 l=0.5
XRn_29_22 BLN22 dn_29_22 sky130_fd_pr_reram__reram_cell area_ox=0.0676
XMp_29_23 dp_29_23 WL29 SL23 VSS sky130_fd_pr__nfet_g5v0d10v5 w=1 l=0.5
XRp_29_23 BLP23 dp_29_23 sky130_fd_pr_reram__reram_cell area_ox=0.0676
XMz_29_23 dz_29_23 WL29 SL23 VSS sky130_fd_pr__nfet_g5v0d10v5 w=1 l=0.5
XRz_29_23 BLZ23 dz_29_23 sky130_fd_pr_reram__reram_cell area_ox=0.0676
XMn_29_23 dn_29_23 WL29 SL23 VSS sky130_fd_pr__nfet_g5v0d10v5 w=1 l=0.5
XRn_29_23 BLN23 dn_29_23 sky130_fd_pr_reram__reram_cell area_ox=0.0676
XMp_30_0 dp_30_0 WL30 SL0 VSS sky130_fd_pr__nfet_g5v0d10v5 w=1 l=0.5
XRp_30_0 BLP0 dp_30_0 sky130_fd_pr_reram__reram_cell area_ox=0.0676
XMz_30_0 dz_30_0 WL30 SL0 VSS sky130_fd_pr__nfet_g5v0d10v5 w=1 l=0.5
XRz_30_0 BLZ0 dz_30_0 sky130_fd_pr_reram__reram_cell area_ox=0.0676
XMn_30_0 dn_30_0 WL30 SL0 VSS sky130_fd_pr__nfet_g5v0d10v5 w=1 l=0.5
XRn_30_0 BLN0 dn_30_0 sky130_fd_pr_reram__reram_cell area_ox=0.0676
XMp_30_1 dp_30_1 WL30 SL1 VSS sky130_fd_pr__nfet_g5v0d10v5 w=1 l=0.5
XRp_30_1 BLP1 dp_30_1 sky130_fd_pr_reram__reram_cell area_ox=0.0676
XMz_30_1 dz_30_1 WL30 SL1 VSS sky130_fd_pr__nfet_g5v0d10v5 w=1 l=0.5
XRz_30_1 BLZ1 dz_30_1 sky130_fd_pr_reram__reram_cell area_ox=0.0676
XMn_30_1 dn_30_1 WL30 SL1 VSS sky130_fd_pr__nfet_g5v0d10v5 w=1 l=0.5
XRn_30_1 BLN1 dn_30_1 sky130_fd_pr_reram__reram_cell area_ox=0.0676
XMp_30_2 dp_30_2 WL30 SL2 VSS sky130_fd_pr__nfet_g5v0d10v5 w=1 l=0.5
XRp_30_2 BLP2 dp_30_2 sky130_fd_pr_reram__reram_cell area_ox=0.0676
XMz_30_2 dz_30_2 WL30 SL2 VSS sky130_fd_pr__nfet_g5v0d10v5 w=1 l=0.5
XRz_30_2 BLZ2 dz_30_2 sky130_fd_pr_reram__reram_cell area_ox=0.0676
XMn_30_2 dn_30_2 WL30 SL2 VSS sky130_fd_pr__nfet_g5v0d10v5 w=1 l=0.5
XRn_30_2 BLN2 dn_30_2 sky130_fd_pr_reram__reram_cell area_ox=0.0676
XMp_30_3 dp_30_3 WL30 SL3 VSS sky130_fd_pr__nfet_g5v0d10v5 w=1 l=0.5
XRp_30_3 BLP3 dp_30_3 sky130_fd_pr_reram__reram_cell area_ox=0.0676
XMz_30_3 dz_30_3 WL30 SL3 VSS sky130_fd_pr__nfet_g5v0d10v5 w=1 l=0.5
XRz_30_3 BLZ3 dz_30_3 sky130_fd_pr_reram__reram_cell area_ox=0.0676
XMn_30_3 dn_30_3 WL30 SL3 VSS sky130_fd_pr__nfet_g5v0d10v5 w=1 l=0.5
XRn_30_3 BLN3 dn_30_3 sky130_fd_pr_reram__reram_cell area_ox=0.0676
XMp_30_4 dp_30_4 WL30 SL4 VSS sky130_fd_pr__nfet_g5v0d10v5 w=1 l=0.5
XRp_30_4 BLP4 dp_30_4 sky130_fd_pr_reram__reram_cell area_ox=0.0676
XMz_30_4 dz_30_4 WL30 SL4 VSS sky130_fd_pr__nfet_g5v0d10v5 w=1 l=0.5
XRz_30_4 BLZ4 dz_30_4 sky130_fd_pr_reram__reram_cell area_ox=0.0676
XMn_30_4 dn_30_4 WL30 SL4 VSS sky130_fd_pr__nfet_g5v0d10v5 w=1 l=0.5
XRn_30_4 BLN4 dn_30_4 sky130_fd_pr_reram__reram_cell area_ox=0.0676
XMp_30_5 dp_30_5 WL30 SL5 VSS sky130_fd_pr__nfet_g5v0d10v5 w=1 l=0.5
XRp_30_5 BLP5 dp_30_5 sky130_fd_pr_reram__reram_cell area_ox=0.0676
XMz_30_5 dz_30_5 WL30 SL5 VSS sky130_fd_pr__nfet_g5v0d10v5 w=1 l=0.5
XRz_30_5 BLZ5 dz_30_5 sky130_fd_pr_reram__reram_cell area_ox=0.0676
XMn_30_5 dn_30_5 WL30 SL5 VSS sky130_fd_pr__nfet_g5v0d10v5 w=1 l=0.5
XRn_30_5 BLN5 dn_30_5 sky130_fd_pr_reram__reram_cell area_ox=0.0676
XMp_30_6 dp_30_6 WL30 SL6 VSS sky130_fd_pr__nfet_g5v0d10v5 w=1 l=0.5
XRp_30_6 BLP6 dp_30_6 sky130_fd_pr_reram__reram_cell area_ox=0.0676
XMz_30_6 dz_30_6 WL30 SL6 VSS sky130_fd_pr__nfet_g5v0d10v5 w=1 l=0.5
XRz_30_6 BLZ6 dz_30_6 sky130_fd_pr_reram__reram_cell area_ox=0.0676
XMn_30_6 dn_30_6 WL30 SL6 VSS sky130_fd_pr__nfet_g5v0d10v5 w=1 l=0.5
XRn_30_6 BLN6 dn_30_6 sky130_fd_pr_reram__reram_cell area_ox=0.0676
XMp_30_7 dp_30_7 WL30 SL7 VSS sky130_fd_pr__nfet_g5v0d10v5 w=1 l=0.5
XRp_30_7 BLP7 dp_30_7 sky130_fd_pr_reram__reram_cell area_ox=0.0676
XMz_30_7 dz_30_7 WL30 SL7 VSS sky130_fd_pr__nfet_g5v0d10v5 w=1 l=0.5
XRz_30_7 BLZ7 dz_30_7 sky130_fd_pr_reram__reram_cell area_ox=0.0676
XMn_30_7 dn_30_7 WL30 SL7 VSS sky130_fd_pr__nfet_g5v0d10v5 w=1 l=0.5
XRn_30_7 BLN7 dn_30_7 sky130_fd_pr_reram__reram_cell area_ox=0.0676
XMp_30_8 dp_30_8 WL30 SL8 VSS sky130_fd_pr__nfet_g5v0d10v5 w=1 l=0.5
XRp_30_8 BLP8 dp_30_8 sky130_fd_pr_reram__reram_cell area_ox=0.0676
XMz_30_8 dz_30_8 WL30 SL8 VSS sky130_fd_pr__nfet_g5v0d10v5 w=1 l=0.5
XRz_30_8 BLZ8 dz_30_8 sky130_fd_pr_reram__reram_cell area_ox=0.0676
XMn_30_8 dn_30_8 WL30 SL8 VSS sky130_fd_pr__nfet_g5v0d10v5 w=1 l=0.5
XRn_30_8 BLN8 dn_30_8 sky130_fd_pr_reram__reram_cell area_ox=0.0676
XMp_30_9 dp_30_9 WL30 SL9 VSS sky130_fd_pr__nfet_g5v0d10v5 w=1 l=0.5
XRp_30_9 BLP9 dp_30_9 sky130_fd_pr_reram__reram_cell area_ox=0.0676
XMz_30_9 dz_30_9 WL30 SL9 VSS sky130_fd_pr__nfet_g5v0d10v5 w=1 l=0.5
XRz_30_9 BLZ9 dz_30_9 sky130_fd_pr_reram__reram_cell area_ox=0.0676
XMn_30_9 dn_30_9 WL30 SL9 VSS sky130_fd_pr__nfet_g5v0d10v5 w=1 l=0.5
XRn_30_9 BLN9 dn_30_9 sky130_fd_pr_reram__reram_cell area_ox=0.0676
XMp_30_10 dp_30_10 WL30 SL10 VSS sky130_fd_pr__nfet_g5v0d10v5 w=1 l=0.5
XRp_30_10 BLP10 dp_30_10 sky130_fd_pr_reram__reram_cell area_ox=0.0676
XMz_30_10 dz_30_10 WL30 SL10 VSS sky130_fd_pr__nfet_g5v0d10v5 w=1 l=0.5
XRz_30_10 BLZ10 dz_30_10 sky130_fd_pr_reram__reram_cell area_ox=0.0676
XMn_30_10 dn_30_10 WL30 SL10 VSS sky130_fd_pr__nfet_g5v0d10v5 w=1 l=0.5
XRn_30_10 BLN10 dn_30_10 sky130_fd_pr_reram__reram_cell area_ox=0.0676
XMp_30_11 dp_30_11 WL30 SL11 VSS sky130_fd_pr__nfet_g5v0d10v5 w=1 l=0.5
XRp_30_11 BLP11 dp_30_11 sky130_fd_pr_reram__reram_cell area_ox=0.0676
XMz_30_11 dz_30_11 WL30 SL11 VSS sky130_fd_pr__nfet_g5v0d10v5 w=1 l=0.5
XRz_30_11 BLZ11 dz_30_11 sky130_fd_pr_reram__reram_cell area_ox=0.0676
XMn_30_11 dn_30_11 WL30 SL11 VSS sky130_fd_pr__nfet_g5v0d10v5 w=1 l=0.5
XRn_30_11 BLN11 dn_30_11 sky130_fd_pr_reram__reram_cell area_ox=0.0676
XMp_30_12 dp_30_12 WL30 SL12 VSS sky130_fd_pr__nfet_g5v0d10v5 w=1 l=0.5
XRp_30_12 BLP12 dp_30_12 sky130_fd_pr_reram__reram_cell area_ox=0.0676
XMz_30_12 dz_30_12 WL30 SL12 VSS sky130_fd_pr__nfet_g5v0d10v5 w=1 l=0.5
XRz_30_12 BLZ12 dz_30_12 sky130_fd_pr_reram__reram_cell area_ox=0.0676
XMn_30_12 dn_30_12 WL30 SL12 VSS sky130_fd_pr__nfet_g5v0d10v5 w=1 l=0.5
XRn_30_12 BLN12 dn_30_12 sky130_fd_pr_reram__reram_cell area_ox=0.0676
XMp_30_13 dp_30_13 WL30 SL13 VSS sky130_fd_pr__nfet_g5v0d10v5 w=1 l=0.5
XRp_30_13 BLP13 dp_30_13 sky130_fd_pr_reram__reram_cell area_ox=0.0676
XMz_30_13 dz_30_13 WL30 SL13 VSS sky130_fd_pr__nfet_g5v0d10v5 w=1 l=0.5
XRz_30_13 BLZ13 dz_30_13 sky130_fd_pr_reram__reram_cell area_ox=0.0676
XMn_30_13 dn_30_13 WL30 SL13 VSS sky130_fd_pr__nfet_g5v0d10v5 w=1 l=0.5
XRn_30_13 BLN13 dn_30_13 sky130_fd_pr_reram__reram_cell area_ox=0.0676
XMp_30_14 dp_30_14 WL30 SL14 VSS sky130_fd_pr__nfet_g5v0d10v5 w=1 l=0.5
XRp_30_14 BLP14 dp_30_14 sky130_fd_pr_reram__reram_cell area_ox=0.0676
XMz_30_14 dz_30_14 WL30 SL14 VSS sky130_fd_pr__nfet_g5v0d10v5 w=1 l=0.5
XRz_30_14 BLZ14 dz_30_14 sky130_fd_pr_reram__reram_cell area_ox=0.0676
XMn_30_14 dn_30_14 WL30 SL14 VSS sky130_fd_pr__nfet_g5v0d10v5 w=1 l=0.5
XRn_30_14 BLN14 dn_30_14 sky130_fd_pr_reram__reram_cell area_ox=0.0676
XMp_30_15 dp_30_15 WL30 SL15 VSS sky130_fd_pr__nfet_g5v0d10v5 w=1 l=0.5
XRp_30_15 BLP15 dp_30_15 sky130_fd_pr_reram__reram_cell area_ox=0.0676
XMz_30_15 dz_30_15 WL30 SL15 VSS sky130_fd_pr__nfet_g5v0d10v5 w=1 l=0.5
XRz_30_15 BLZ15 dz_30_15 sky130_fd_pr_reram__reram_cell area_ox=0.0676
XMn_30_15 dn_30_15 WL30 SL15 VSS sky130_fd_pr__nfet_g5v0d10v5 w=1 l=0.5
XRn_30_15 BLN15 dn_30_15 sky130_fd_pr_reram__reram_cell area_ox=0.0676
XMp_30_16 dp_30_16 WL30 SL16 VSS sky130_fd_pr__nfet_g5v0d10v5 w=1 l=0.5
XRp_30_16 BLP16 dp_30_16 sky130_fd_pr_reram__reram_cell area_ox=0.0676
XMz_30_16 dz_30_16 WL30 SL16 VSS sky130_fd_pr__nfet_g5v0d10v5 w=1 l=0.5
XRz_30_16 BLZ16 dz_30_16 sky130_fd_pr_reram__reram_cell area_ox=0.0676
XMn_30_16 dn_30_16 WL30 SL16 VSS sky130_fd_pr__nfet_g5v0d10v5 w=1 l=0.5
XRn_30_16 BLN16 dn_30_16 sky130_fd_pr_reram__reram_cell area_ox=0.0676
XMp_30_17 dp_30_17 WL30 SL17 VSS sky130_fd_pr__nfet_g5v0d10v5 w=1 l=0.5
XRp_30_17 BLP17 dp_30_17 sky130_fd_pr_reram__reram_cell area_ox=0.0676
XMz_30_17 dz_30_17 WL30 SL17 VSS sky130_fd_pr__nfet_g5v0d10v5 w=1 l=0.5
XRz_30_17 BLZ17 dz_30_17 sky130_fd_pr_reram__reram_cell area_ox=0.0676
XMn_30_17 dn_30_17 WL30 SL17 VSS sky130_fd_pr__nfet_g5v0d10v5 w=1 l=0.5
XRn_30_17 BLN17 dn_30_17 sky130_fd_pr_reram__reram_cell area_ox=0.0676
XMp_30_18 dp_30_18 WL30 SL18 VSS sky130_fd_pr__nfet_g5v0d10v5 w=1 l=0.5
XRp_30_18 BLP18 dp_30_18 sky130_fd_pr_reram__reram_cell area_ox=0.0676
XMz_30_18 dz_30_18 WL30 SL18 VSS sky130_fd_pr__nfet_g5v0d10v5 w=1 l=0.5
XRz_30_18 BLZ18 dz_30_18 sky130_fd_pr_reram__reram_cell area_ox=0.0676
XMn_30_18 dn_30_18 WL30 SL18 VSS sky130_fd_pr__nfet_g5v0d10v5 w=1 l=0.5
XRn_30_18 BLN18 dn_30_18 sky130_fd_pr_reram__reram_cell area_ox=0.0676
XMp_30_19 dp_30_19 WL30 SL19 VSS sky130_fd_pr__nfet_g5v0d10v5 w=1 l=0.5
XRp_30_19 BLP19 dp_30_19 sky130_fd_pr_reram__reram_cell area_ox=0.0676
XMz_30_19 dz_30_19 WL30 SL19 VSS sky130_fd_pr__nfet_g5v0d10v5 w=1 l=0.5
XRz_30_19 BLZ19 dz_30_19 sky130_fd_pr_reram__reram_cell area_ox=0.0676
XMn_30_19 dn_30_19 WL30 SL19 VSS sky130_fd_pr__nfet_g5v0d10v5 w=1 l=0.5
XRn_30_19 BLN19 dn_30_19 sky130_fd_pr_reram__reram_cell area_ox=0.0676
XMp_30_20 dp_30_20 WL30 SL20 VSS sky130_fd_pr__nfet_g5v0d10v5 w=1 l=0.5
XRp_30_20 BLP20 dp_30_20 sky130_fd_pr_reram__reram_cell area_ox=0.0676
XMz_30_20 dz_30_20 WL30 SL20 VSS sky130_fd_pr__nfet_g5v0d10v5 w=1 l=0.5
XRz_30_20 BLZ20 dz_30_20 sky130_fd_pr_reram__reram_cell area_ox=0.0676
XMn_30_20 dn_30_20 WL30 SL20 VSS sky130_fd_pr__nfet_g5v0d10v5 w=1 l=0.5
XRn_30_20 BLN20 dn_30_20 sky130_fd_pr_reram__reram_cell area_ox=0.0676
XMp_30_21 dp_30_21 WL30 SL21 VSS sky130_fd_pr__nfet_g5v0d10v5 w=1 l=0.5
XRp_30_21 BLP21 dp_30_21 sky130_fd_pr_reram__reram_cell area_ox=0.0676
XMz_30_21 dz_30_21 WL30 SL21 VSS sky130_fd_pr__nfet_g5v0d10v5 w=1 l=0.5
XRz_30_21 BLZ21 dz_30_21 sky130_fd_pr_reram__reram_cell area_ox=0.0676
XMn_30_21 dn_30_21 WL30 SL21 VSS sky130_fd_pr__nfet_g5v0d10v5 w=1 l=0.5
XRn_30_21 BLN21 dn_30_21 sky130_fd_pr_reram__reram_cell area_ox=0.0676
XMp_30_22 dp_30_22 WL30 SL22 VSS sky130_fd_pr__nfet_g5v0d10v5 w=1 l=0.5
XRp_30_22 BLP22 dp_30_22 sky130_fd_pr_reram__reram_cell area_ox=0.0676
XMz_30_22 dz_30_22 WL30 SL22 VSS sky130_fd_pr__nfet_g5v0d10v5 w=1 l=0.5
XRz_30_22 BLZ22 dz_30_22 sky130_fd_pr_reram__reram_cell area_ox=0.0676
XMn_30_22 dn_30_22 WL30 SL22 VSS sky130_fd_pr__nfet_g5v0d10v5 w=1 l=0.5
XRn_30_22 BLN22 dn_30_22 sky130_fd_pr_reram__reram_cell area_ox=0.0676
XMp_30_23 dp_30_23 WL30 SL23 VSS sky130_fd_pr__nfet_g5v0d10v5 w=1 l=0.5
XRp_30_23 BLP23 dp_30_23 sky130_fd_pr_reram__reram_cell area_ox=0.0676
XMz_30_23 dz_30_23 WL30 SL23 VSS sky130_fd_pr__nfet_g5v0d10v5 w=1 l=0.5
XRz_30_23 BLZ23 dz_30_23 sky130_fd_pr_reram__reram_cell area_ox=0.0676
XMn_30_23 dn_30_23 WL30 SL23 VSS sky130_fd_pr__nfet_g5v0d10v5 w=1 l=0.5
XRn_30_23 BLN23 dn_30_23 sky130_fd_pr_reram__reram_cell area_ox=0.0676
XMp_31_0 dp_31_0 WL31 SL0 VSS sky130_fd_pr__nfet_g5v0d10v5 w=1 l=0.5
XRp_31_0 BLP0 dp_31_0 sky130_fd_pr_reram__reram_cell area_ox=0.0676
XMz_31_0 dz_31_0 WL31 SL0 VSS sky130_fd_pr__nfet_g5v0d10v5 w=1 l=0.5
XRz_31_0 BLZ0 dz_31_0 sky130_fd_pr_reram__reram_cell area_ox=0.0676
XMn_31_0 dn_31_0 WL31 SL0 VSS sky130_fd_pr__nfet_g5v0d10v5 w=1 l=0.5
XRn_31_0 BLN0 dn_31_0 sky130_fd_pr_reram__reram_cell area_ox=0.0676
XMp_31_1 dp_31_1 WL31 SL1 VSS sky130_fd_pr__nfet_g5v0d10v5 w=1 l=0.5
XRp_31_1 BLP1 dp_31_1 sky130_fd_pr_reram__reram_cell area_ox=0.0676
XMz_31_1 dz_31_1 WL31 SL1 VSS sky130_fd_pr__nfet_g5v0d10v5 w=1 l=0.5
XRz_31_1 BLZ1 dz_31_1 sky130_fd_pr_reram__reram_cell area_ox=0.0676
XMn_31_1 dn_31_1 WL31 SL1 VSS sky130_fd_pr__nfet_g5v0d10v5 w=1 l=0.5
XRn_31_1 BLN1 dn_31_1 sky130_fd_pr_reram__reram_cell area_ox=0.0676
XMp_31_2 dp_31_2 WL31 SL2 VSS sky130_fd_pr__nfet_g5v0d10v5 w=1 l=0.5
XRp_31_2 BLP2 dp_31_2 sky130_fd_pr_reram__reram_cell area_ox=0.0676
XMz_31_2 dz_31_2 WL31 SL2 VSS sky130_fd_pr__nfet_g5v0d10v5 w=1 l=0.5
XRz_31_2 BLZ2 dz_31_2 sky130_fd_pr_reram__reram_cell area_ox=0.0676
XMn_31_2 dn_31_2 WL31 SL2 VSS sky130_fd_pr__nfet_g5v0d10v5 w=1 l=0.5
XRn_31_2 BLN2 dn_31_2 sky130_fd_pr_reram__reram_cell area_ox=0.0676
XMp_31_3 dp_31_3 WL31 SL3 VSS sky130_fd_pr__nfet_g5v0d10v5 w=1 l=0.5
XRp_31_3 BLP3 dp_31_3 sky130_fd_pr_reram__reram_cell area_ox=0.0676
XMz_31_3 dz_31_3 WL31 SL3 VSS sky130_fd_pr__nfet_g5v0d10v5 w=1 l=0.5
XRz_31_3 BLZ3 dz_31_3 sky130_fd_pr_reram__reram_cell area_ox=0.0676
XMn_31_3 dn_31_3 WL31 SL3 VSS sky130_fd_pr__nfet_g5v0d10v5 w=1 l=0.5
XRn_31_3 BLN3 dn_31_3 sky130_fd_pr_reram__reram_cell area_ox=0.0676
XMp_31_4 dp_31_4 WL31 SL4 VSS sky130_fd_pr__nfet_g5v0d10v5 w=1 l=0.5
XRp_31_4 BLP4 dp_31_4 sky130_fd_pr_reram__reram_cell area_ox=0.0676
XMz_31_4 dz_31_4 WL31 SL4 VSS sky130_fd_pr__nfet_g5v0d10v5 w=1 l=0.5
XRz_31_4 BLZ4 dz_31_4 sky130_fd_pr_reram__reram_cell area_ox=0.0676
XMn_31_4 dn_31_4 WL31 SL4 VSS sky130_fd_pr__nfet_g5v0d10v5 w=1 l=0.5
XRn_31_4 BLN4 dn_31_4 sky130_fd_pr_reram__reram_cell area_ox=0.0676
XMp_31_5 dp_31_5 WL31 SL5 VSS sky130_fd_pr__nfet_g5v0d10v5 w=1 l=0.5
XRp_31_5 BLP5 dp_31_5 sky130_fd_pr_reram__reram_cell area_ox=0.0676
XMz_31_5 dz_31_5 WL31 SL5 VSS sky130_fd_pr__nfet_g5v0d10v5 w=1 l=0.5
XRz_31_5 BLZ5 dz_31_5 sky130_fd_pr_reram__reram_cell area_ox=0.0676
XMn_31_5 dn_31_5 WL31 SL5 VSS sky130_fd_pr__nfet_g5v0d10v5 w=1 l=0.5
XRn_31_5 BLN5 dn_31_5 sky130_fd_pr_reram__reram_cell area_ox=0.0676
XMp_31_6 dp_31_6 WL31 SL6 VSS sky130_fd_pr__nfet_g5v0d10v5 w=1 l=0.5
XRp_31_6 BLP6 dp_31_6 sky130_fd_pr_reram__reram_cell area_ox=0.0676
XMz_31_6 dz_31_6 WL31 SL6 VSS sky130_fd_pr__nfet_g5v0d10v5 w=1 l=0.5
XRz_31_6 BLZ6 dz_31_6 sky130_fd_pr_reram__reram_cell area_ox=0.0676
XMn_31_6 dn_31_6 WL31 SL6 VSS sky130_fd_pr__nfet_g5v0d10v5 w=1 l=0.5
XRn_31_6 BLN6 dn_31_6 sky130_fd_pr_reram__reram_cell area_ox=0.0676
XMp_31_7 dp_31_7 WL31 SL7 VSS sky130_fd_pr__nfet_g5v0d10v5 w=1 l=0.5
XRp_31_7 BLP7 dp_31_7 sky130_fd_pr_reram__reram_cell area_ox=0.0676
XMz_31_7 dz_31_7 WL31 SL7 VSS sky130_fd_pr__nfet_g5v0d10v5 w=1 l=0.5
XRz_31_7 BLZ7 dz_31_7 sky130_fd_pr_reram__reram_cell area_ox=0.0676
XMn_31_7 dn_31_7 WL31 SL7 VSS sky130_fd_pr__nfet_g5v0d10v5 w=1 l=0.5
XRn_31_7 BLN7 dn_31_7 sky130_fd_pr_reram__reram_cell area_ox=0.0676
XMp_31_8 dp_31_8 WL31 SL8 VSS sky130_fd_pr__nfet_g5v0d10v5 w=1 l=0.5
XRp_31_8 BLP8 dp_31_8 sky130_fd_pr_reram__reram_cell area_ox=0.0676
XMz_31_8 dz_31_8 WL31 SL8 VSS sky130_fd_pr__nfet_g5v0d10v5 w=1 l=0.5
XRz_31_8 BLZ8 dz_31_8 sky130_fd_pr_reram__reram_cell area_ox=0.0676
XMn_31_8 dn_31_8 WL31 SL8 VSS sky130_fd_pr__nfet_g5v0d10v5 w=1 l=0.5
XRn_31_8 BLN8 dn_31_8 sky130_fd_pr_reram__reram_cell area_ox=0.0676
XMp_31_9 dp_31_9 WL31 SL9 VSS sky130_fd_pr__nfet_g5v0d10v5 w=1 l=0.5
XRp_31_9 BLP9 dp_31_9 sky130_fd_pr_reram__reram_cell area_ox=0.0676
XMz_31_9 dz_31_9 WL31 SL9 VSS sky130_fd_pr__nfet_g5v0d10v5 w=1 l=0.5
XRz_31_9 BLZ9 dz_31_9 sky130_fd_pr_reram__reram_cell area_ox=0.0676
XMn_31_9 dn_31_9 WL31 SL9 VSS sky130_fd_pr__nfet_g5v0d10v5 w=1 l=0.5
XRn_31_9 BLN9 dn_31_9 sky130_fd_pr_reram__reram_cell area_ox=0.0676
XMp_31_10 dp_31_10 WL31 SL10 VSS sky130_fd_pr__nfet_g5v0d10v5 w=1 l=0.5
XRp_31_10 BLP10 dp_31_10 sky130_fd_pr_reram__reram_cell area_ox=0.0676
XMz_31_10 dz_31_10 WL31 SL10 VSS sky130_fd_pr__nfet_g5v0d10v5 w=1 l=0.5
XRz_31_10 BLZ10 dz_31_10 sky130_fd_pr_reram__reram_cell area_ox=0.0676
XMn_31_10 dn_31_10 WL31 SL10 VSS sky130_fd_pr__nfet_g5v0d10v5 w=1 l=0.5
XRn_31_10 BLN10 dn_31_10 sky130_fd_pr_reram__reram_cell area_ox=0.0676
XMp_31_11 dp_31_11 WL31 SL11 VSS sky130_fd_pr__nfet_g5v0d10v5 w=1 l=0.5
XRp_31_11 BLP11 dp_31_11 sky130_fd_pr_reram__reram_cell area_ox=0.0676
XMz_31_11 dz_31_11 WL31 SL11 VSS sky130_fd_pr__nfet_g5v0d10v5 w=1 l=0.5
XRz_31_11 BLZ11 dz_31_11 sky130_fd_pr_reram__reram_cell area_ox=0.0676
XMn_31_11 dn_31_11 WL31 SL11 VSS sky130_fd_pr__nfet_g5v0d10v5 w=1 l=0.5
XRn_31_11 BLN11 dn_31_11 sky130_fd_pr_reram__reram_cell area_ox=0.0676
XMp_31_12 dp_31_12 WL31 SL12 VSS sky130_fd_pr__nfet_g5v0d10v5 w=1 l=0.5
XRp_31_12 BLP12 dp_31_12 sky130_fd_pr_reram__reram_cell area_ox=0.0676
XMz_31_12 dz_31_12 WL31 SL12 VSS sky130_fd_pr__nfet_g5v0d10v5 w=1 l=0.5
XRz_31_12 BLZ12 dz_31_12 sky130_fd_pr_reram__reram_cell area_ox=0.0676
XMn_31_12 dn_31_12 WL31 SL12 VSS sky130_fd_pr__nfet_g5v0d10v5 w=1 l=0.5
XRn_31_12 BLN12 dn_31_12 sky130_fd_pr_reram__reram_cell area_ox=0.0676
XMp_31_13 dp_31_13 WL31 SL13 VSS sky130_fd_pr__nfet_g5v0d10v5 w=1 l=0.5
XRp_31_13 BLP13 dp_31_13 sky130_fd_pr_reram__reram_cell area_ox=0.0676
XMz_31_13 dz_31_13 WL31 SL13 VSS sky130_fd_pr__nfet_g5v0d10v5 w=1 l=0.5
XRz_31_13 BLZ13 dz_31_13 sky130_fd_pr_reram__reram_cell area_ox=0.0676
XMn_31_13 dn_31_13 WL31 SL13 VSS sky130_fd_pr__nfet_g5v0d10v5 w=1 l=0.5
XRn_31_13 BLN13 dn_31_13 sky130_fd_pr_reram__reram_cell area_ox=0.0676
XMp_31_14 dp_31_14 WL31 SL14 VSS sky130_fd_pr__nfet_g5v0d10v5 w=1 l=0.5
XRp_31_14 BLP14 dp_31_14 sky130_fd_pr_reram__reram_cell area_ox=0.0676
XMz_31_14 dz_31_14 WL31 SL14 VSS sky130_fd_pr__nfet_g5v0d10v5 w=1 l=0.5
XRz_31_14 BLZ14 dz_31_14 sky130_fd_pr_reram__reram_cell area_ox=0.0676
XMn_31_14 dn_31_14 WL31 SL14 VSS sky130_fd_pr__nfet_g5v0d10v5 w=1 l=0.5
XRn_31_14 BLN14 dn_31_14 sky130_fd_pr_reram__reram_cell area_ox=0.0676
XMp_31_15 dp_31_15 WL31 SL15 VSS sky130_fd_pr__nfet_g5v0d10v5 w=1 l=0.5
XRp_31_15 BLP15 dp_31_15 sky130_fd_pr_reram__reram_cell area_ox=0.0676
XMz_31_15 dz_31_15 WL31 SL15 VSS sky130_fd_pr__nfet_g5v0d10v5 w=1 l=0.5
XRz_31_15 BLZ15 dz_31_15 sky130_fd_pr_reram__reram_cell area_ox=0.0676
XMn_31_15 dn_31_15 WL31 SL15 VSS sky130_fd_pr__nfet_g5v0d10v5 w=1 l=0.5
XRn_31_15 BLN15 dn_31_15 sky130_fd_pr_reram__reram_cell area_ox=0.0676
XMp_31_16 dp_31_16 WL31 SL16 VSS sky130_fd_pr__nfet_g5v0d10v5 w=1 l=0.5
XRp_31_16 BLP16 dp_31_16 sky130_fd_pr_reram__reram_cell area_ox=0.0676
XMz_31_16 dz_31_16 WL31 SL16 VSS sky130_fd_pr__nfet_g5v0d10v5 w=1 l=0.5
XRz_31_16 BLZ16 dz_31_16 sky130_fd_pr_reram__reram_cell area_ox=0.0676
XMn_31_16 dn_31_16 WL31 SL16 VSS sky130_fd_pr__nfet_g5v0d10v5 w=1 l=0.5
XRn_31_16 BLN16 dn_31_16 sky130_fd_pr_reram__reram_cell area_ox=0.0676
XMp_31_17 dp_31_17 WL31 SL17 VSS sky130_fd_pr__nfet_g5v0d10v5 w=1 l=0.5
XRp_31_17 BLP17 dp_31_17 sky130_fd_pr_reram__reram_cell area_ox=0.0676
XMz_31_17 dz_31_17 WL31 SL17 VSS sky130_fd_pr__nfet_g5v0d10v5 w=1 l=0.5
XRz_31_17 BLZ17 dz_31_17 sky130_fd_pr_reram__reram_cell area_ox=0.0676
XMn_31_17 dn_31_17 WL31 SL17 VSS sky130_fd_pr__nfet_g5v0d10v5 w=1 l=0.5
XRn_31_17 BLN17 dn_31_17 sky130_fd_pr_reram__reram_cell area_ox=0.0676
XMp_31_18 dp_31_18 WL31 SL18 VSS sky130_fd_pr__nfet_g5v0d10v5 w=1 l=0.5
XRp_31_18 BLP18 dp_31_18 sky130_fd_pr_reram__reram_cell area_ox=0.0676
XMz_31_18 dz_31_18 WL31 SL18 VSS sky130_fd_pr__nfet_g5v0d10v5 w=1 l=0.5
XRz_31_18 BLZ18 dz_31_18 sky130_fd_pr_reram__reram_cell area_ox=0.0676
XMn_31_18 dn_31_18 WL31 SL18 VSS sky130_fd_pr__nfet_g5v0d10v5 w=1 l=0.5
XRn_31_18 BLN18 dn_31_18 sky130_fd_pr_reram__reram_cell area_ox=0.0676
XMp_31_19 dp_31_19 WL31 SL19 VSS sky130_fd_pr__nfet_g5v0d10v5 w=1 l=0.5
XRp_31_19 BLP19 dp_31_19 sky130_fd_pr_reram__reram_cell area_ox=0.0676
XMz_31_19 dz_31_19 WL31 SL19 VSS sky130_fd_pr__nfet_g5v0d10v5 w=1 l=0.5
XRz_31_19 BLZ19 dz_31_19 sky130_fd_pr_reram__reram_cell area_ox=0.0676
XMn_31_19 dn_31_19 WL31 SL19 VSS sky130_fd_pr__nfet_g5v0d10v5 w=1 l=0.5
XRn_31_19 BLN19 dn_31_19 sky130_fd_pr_reram__reram_cell area_ox=0.0676
XMp_31_20 dp_31_20 WL31 SL20 VSS sky130_fd_pr__nfet_g5v0d10v5 w=1 l=0.5
XRp_31_20 BLP20 dp_31_20 sky130_fd_pr_reram__reram_cell area_ox=0.0676
XMz_31_20 dz_31_20 WL31 SL20 VSS sky130_fd_pr__nfet_g5v0d10v5 w=1 l=0.5
XRz_31_20 BLZ20 dz_31_20 sky130_fd_pr_reram__reram_cell area_ox=0.0676
XMn_31_20 dn_31_20 WL31 SL20 VSS sky130_fd_pr__nfet_g5v0d10v5 w=1 l=0.5
XRn_31_20 BLN20 dn_31_20 sky130_fd_pr_reram__reram_cell area_ox=0.0676
XMp_31_21 dp_31_21 WL31 SL21 VSS sky130_fd_pr__nfet_g5v0d10v5 w=1 l=0.5
XRp_31_21 BLP21 dp_31_21 sky130_fd_pr_reram__reram_cell area_ox=0.0676
XMz_31_21 dz_31_21 WL31 SL21 VSS sky130_fd_pr__nfet_g5v0d10v5 w=1 l=0.5
XRz_31_21 BLZ21 dz_31_21 sky130_fd_pr_reram__reram_cell area_ox=0.0676
XMn_31_21 dn_31_21 WL31 SL21 VSS sky130_fd_pr__nfet_g5v0d10v5 w=1 l=0.5
XRn_31_21 BLN21 dn_31_21 sky130_fd_pr_reram__reram_cell area_ox=0.0676
XMp_31_22 dp_31_22 WL31 SL22 VSS sky130_fd_pr__nfet_g5v0d10v5 w=1 l=0.5
XRp_31_22 BLP22 dp_31_22 sky130_fd_pr_reram__reram_cell area_ox=0.0676
XMz_31_22 dz_31_22 WL31 SL22 VSS sky130_fd_pr__nfet_g5v0d10v5 w=1 l=0.5
XRz_31_22 BLZ22 dz_31_22 sky130_fd_pr_reram__reram_cell area_ox=0.0676
XMn_31_22 dn_31_22 WL31 SL22 VSS sky130_fd_pr__nfet_g5v0d10v5 w=1 l=0.5
XRn_31_22 BLN22 dn_31_22 sky130_fd_pr_reram__reram_cell area_ox=0.0676
XMp_31_23 dp_31_23 WL31 SL23 VSS sky130_fd_pr__nfet_g5v0d10v5 w=1 l=0.5
XRp_31_23 BLP23 dp_31_23 sky130_fd_pr_reram__reram_cell area_ox=0.0676
XMz_31_23 dz_31_23 WL31 SL23 VSS sky130_fd_pr__nfet_g5v0d10v5 w=1 l=0.5
XRz_31_23 BLZ23 dz_31_23 sky130_fd_pr_reram__reram_cell area_ox=0.0676
XMn_31_23 dn_31_23 WL31 SL23 VSS sky130_fd_pr__nfet_g5v0d10v5 w=1 l=0.5
XRn_31_23 BLN23 dn_31_23 sky130_fd_pr_reram__reram_cell area_ox=0.0676
XMp_32_0 dp_32_0 WL32 SL0 VSS sky130_fd_pr__nfet_g5v0d10v5 w=1 l=0.5
XRp_32_0 BLP0 dp_32_0 sky130_fd_pr_reram__reram_cell area_ox=0.0676
XMz_32_0 dz_32_0 WL32 SL0 VSS sky130_fd_pr__nfet_g5v0d10v5 w=1 l=0.5
XRz_32_0 BLZ0 dz_32_0 sky130_fd_pr_reram__reram_cell area_ox=0.0676
XMn_32_0 dn_32_0 WL32 SL0 VSS sky130_fd_pr__nfet_g5v0d10v5 w=1 l=0.5
XRn_32_0 BLN0 dn_32_0 sky130_fd_pr_reram__reram_cell area_ox=0.0676
XMp_32_1 dp_32_1 WL32 SL1 VSS sky130_fd_pr__nfet_g5v0d10v5 w=1 l=0.5
XRp_32_1 BLP1 dp_32_1 sky130_fd_pr_reram__reram_cell area_ox=0.0676
XMz_32_1 dz_32_1 WL32 SL1 VSS sky130_fd_pr__nfet_g5v0d10v5 w=1 l=0.5
XRz_32_1 BLZ1 dz_32_1 sky130_fd_pr_reram__reram_cell area_ox=0.0676
XMn_32_1 dn_32_1 WL32 SL1 VSS sky130_fd_pr__nfet_g5v0d10v5 w=1 l=0.5
XRn_32_1 BLN1 dn_32_1 sky130_fd_pr_reram__reram_cell area_ox=0.0676
XMp_32_2 dp_32_2 WL32 SL2 VSS sky130_fd_pr__nfet_g5v0d10v5 w=1 l=0.5
XRp_32_2 BLP2 dp_32_2 sky130_fd_pr_reram__reram_cell area_ox=0.0676
XMz_32_2 dz_32_2 WL32 SL2 VSS sky130_fd_pr__nfet_g5v0d10v5 w=1 l=0.5
XRz_32_2 BLZ2 dz_32_2 sky130_fd_pr_reram__reram_cell area_ox=0.0676
XMn_32_2 dn_32_2 WL32 SL2 VSS sky130_fd_pr__nfet_g5v0d10v5 w=1 l=0.5
XRn_32_2 BLN2 dn_32_2 sky130_fd_pr_reram__reram_cell area_ox=0.0676
XMp_32_3 dp_32_3 WL32 SL3 VSS sky130_fd_pr__nfet_g5v0d10v5 w=1 l=0.5
XRp_32_3 BLP3 dp_32_3 sky130_fd_pr_reram__reram_cell area_ox=0.0676
XMz_32_3 dz_32_3 WL32 SL3 VSS sky130_fd_pr__nfet_g5v0d10v5 w=1 l=0.5
XRz_32_3 BLZ3 dz_32_3 sky130_fd_pr_reram__reram_cell area_ox=0.0676
XMn_32_3 dn_32_3 WL32 SL3 VSS sky130_fd_pr__nfet_g5v0d10v5 w=1 l=0.5
XRn_32_3 BLN3 dn_32_3 sky130_fd_pr_reram__reram_cell area_ox=0.0676
XMp_32_4 dp_32_4 WL32 SL4 VSS sky130_fd_pr__nfet_g5v0d10v5 w=1 l=0.5
XRp_32_4 BLP4 dp_32_4 sky130_fd_pr_reram__reram_cell area_ox=0.0676
XMz_32_4 dz_32_4 WL32 SL4 VSS sky130_fd_pr__nfet_g5v0d10v5 w=1 l=0.5
XRz_32_4 BLZ4 dz_32_4 sky130_fd_pr_reram__reram_cell area_ox=0.0676
XMn_32_4 dn_32_4 WL32 SL4 VSS sky130_fd_pr__nfet_g5v0d10v5 w=1 l=0.5
XRn_32_4 BLN4 dn_32_4 sky130_fd_pr_reram__reram_cell area_ox=0.0676
XMp_32_5 dp_32_5 WL32 SL5 VSS sky130_fd_pr__nfet_g5v0d10v5 w=1 l=0.5
XRp_32_5 BLP5 dp_32_5 sky130_fd_pr_reram__reram_cell area_ox=0.0676
XMz_32_5 dz_32_5 WL32 SL5 VSS sky130_fd_pr__nfet_g5v0d10v5 w=1 l=0.5
XRz_32_5 BLZ5 dz_32_5 sky130_fd_pr_reram__reram_cell area_ox=0.0676
XMn_32_5 dn_32_5 WL32 SL5 VSS sky130_fd_pr__nfet_g5v0d10v5 w=1 l=0.5
XRn_32_5 BLN5 dn_32_5 sky130_fd_pr_reram__reram_cell area_ox=0.0676
XMp_32_6 dp_32_6 WL32 SL6 VSS sky130_fd_pr__nfet_g5v0d10v5 w=1 l=0.5
XRp_32_6 BLP6 dp_32_6 sky130_fd_pr_reram__reram_cell area_ox=0.0676
XMz_32_6 dz_32_6 WL32 SL6 VSS sky130_fd_pr__nfet_g5v0d10v5 w=1 l=0.5
XRz_32_6 BLZ6 dz_32_6 sky130_fd_pr_reram__reram_cell area_ox=0.0676
XMn_32_6 dn_32_6 WL32 SL6 VSS sky130_fd_pr__nfet_g5v0d10v5 w=1 l=0.5
XRn_32_6 BLN6 dn_32_6 sky130_fd_pr_reram__reram_cell area_ox=0.0676
XMp_32_7 dp_32_7 WL32 SL7 VSS sky130_fd_pr__nfet_g5v0d10v5 w=1 l=0.5
XRp_32_7 BLP7 dp_32_7 sky130_fd_pr_reram__reram_cell area_ox=0.0676
XMz_32_7 dz_32_7 WL32 SL7 VSS sky130_fd_pr__nfet_g5v0d10v5 w=1 l=0.5
XRz_32_7 BLZ7 dz_32_7 sky130_fd_pr_reram__reram_cell area_ox=0.0676
XMn_32_7 dn_32_7 WL32 SL7 VSS sky130_fd_pr__nfet_g5v0d10v5 w=1 l=0.5
XRn_32_7 BLN7 dn_32_7 sky130_fd_pr_reram__reram_cell area_ox=0.0676
XMp_32_8 dp_32_8 WL32 SL8 VSS sky130_fd_pr__nfet_g5v0d10v5 w=1 l=0.5
XRp_32_8 BLP8 dp_32_8 sky130_fd_pr_reram__reram_cell area_ox=0.0676
XMz_32_8 dz_32_8 WL32 SL8 VSS sky130_fd_pr__nfet_g5v0d10v5 w=1 l=0.5
XRz_32_8 BLZ8 dz_32_8 sky130_fd_pr_reram__reram_cell area_ox=0.0676
XMn_32_8 dn_32_8 WL32 SL8 VSS sky130_fd_pr__nfet_g5v0d10v5 w=1 l=0.5
XRn_32_8 BLN8 dn_32_8 sky130_fd_pr_reram__reram_cell area_ox=0.0676
XMp_32_9 dp_32_9 WL32 SL9 VSS sky130_fd_pr__nfet_g5v0d10v5 w=1 l=0.5
XRp_32_9 BLP9 dp_32_9 sky130_fd_pr_reram__reram_cell area_ox=0.0676
XMz_32_9 dz_32_9 WL32 SL9 VSS sky130_fd_pr__nfet_g5v0d10v5 w=1 l=0.5
XRz_32_9 BLZ9 dz_32_9 sky130_fd_pr_reram__reram_cell area_ox=0.0676
XMn_32_9 dn_32_9 WL32 SL9 VSS sky130_fd_pr__nfet_g5v0d10v5 w=1 l=0.5
XRn_32_9 BLN9 dn_32_9 sky130_fd_pr_reram__reram_cell area_ox=0.0676
XMp_32_10 dp_32_10 WL32 SL10 VSS sky130_fd_pr__nfet_g5v0d10v5 w=1 l=0.5
XRp_32_10 BLP10 dp_32_10 sky130_fd_pr_reram__reram_cell area_ox=0.0676
XMz_32_10 dz_32_10 WL32 SL10 VSS sky130_fd_pr__nfet_g5v0d10v5 w=1 l=0.5
XRz_32_10 BLZ10 dz_32_10 sky130_fd_pr_reram__reram_cell area_ox=0.0676
XMn_32_10 dn_32_10 WL32 SL10 VSS sky130_fd_pr__nfet_g5v0d10v5 w=1 l=0.5
XRn_32_10 BLN10 dn_32_10 sky130_fd_pr_reram__reram_cell area_ox=0.0676
XMp_32_11 dp_32_11 WL32 SL11 VSS sky130_fd_pr__nfet_g5v0d10v5 w=1 l=0.5
XRp_32_11 BLP11 dp_32_11 sky130_fd_pr_reram__reram_cell area_ox=0.0676
XMz_32_11 dz_32_11 WL32 SL11 VSS sky130_fd_pr__nfet_g5v0d10v5 w=1 l=0.5
XRz_32_11 BLZ11 dz_32_11 sky130_fd_pr_reram__reram_cell area_ox=0.0676
XMn_32_11 dn_32_11 WL32 SL11 VSS sky130_fd_pr__nfet_g5v0d10v5 w=1 l=0.5
XRn_32_11 BLN11 dn_32_11 sky130_fd_pr_reram__reram_cell area_ox=0.0676
XMp_32_12 dp_32_12 WL32 SL12 VSS sky130_fd_pr__nfet_g5v0d10v5 w=1 l=0.5
XRp_32_12 BLP12 dp_32_12 sky130_fd_pr_reram__reram_cell area_ox=0.0676
XMz_32_12 dz_32_12 WL32 SL12 VSS sky130_fd_pr__nfet_g5v0d10v5 w=1 l=0.5
XRz_32_12 BLZ12 dz_32_12 sky130_fd_pr_reram__reram_cell area_ox=0.0676
XMn_32_12 dn_32_12 WL32 SL12 VSS sky130_fd_pr__nfet_g5v0d10v5 w=1 l=0.5
XRn_32_12 BLN12 dn_32_12 sky130_fd_pr_reram__reram_cell area_ox=0.0676
XMp_32_13 dp_32_13 WL32 SL13 VSS sky130_fd_pr__nfet_g5v0d10v5 w=1 l=0.5
XRp_32_13 BLP13 dp_32_13 sky130_fd_pr_reram__reram_cell area_ox=0.0676
XMz_32_13 dz_32_13 WL32 SL13 VSS sky130_fd_pr__nfet_g5v0d10v5 w=1 l=0.5
XRz_32_13 BLZ13 dz_32_13 sky130_fd_pr_reram__reram_cell area_ox=0.0676
XMn_32_13 dn_32_13 WL32 SL13 VSS sky130_fd_pr__nfet_g5v0d10v5 w=1 l=0.5
XRn_32_13 BLN13 dn_32_13 sky130_fd_pr_reram__reram_cell area_ox=0.0676
XMp_32_14 dp_32_14 WL32 SL14 VSS sky130_fd_pr__nfet_g5v0d10v5 w=1 l=0.5
XRp_32_14 BLP14 dp_32_14 sky130_fd_pr_reram__reram_cell area_ox=0.0676
XMz_32_14 dz_32_14 WL32 SL14 VSS sky130_fd_pr__nfet_g5v0d10v5 w=1 l=0.5
XRz_32_14 BLZ14 dz_32_14 sky130_fd_pr_reram__reram_cell area_ox=0.0676
XMn_32_14 dn_32_14 WL32 SL14 VSS sky130_fd_pr__nfet_g5v0d10v5 w=1 l=0.5
XRn_32_14 BLN14 dn_32_14 sky130_fd_pr_reram__reram_cell area_ox=0.0676
XMp_32_15 dp_32_15 WL32 SL15 VSS sky130_fd_pr__nfet_g5v0d10v5 w=1 l=0.5
XRp_32_15 BLP15 dp_32_15 sky130_fd_pr_reram__reram_cell area_ox=0.0676
XMz_32_15 dz_32_15 WL32 SL15 VSS sky130_fd_pr__nfet_g5v0d10v5 w=1 l=0.5
XRz_32_15 BLZ15 dz_32_15 sky130_fd_pr_reram__reram_cell area_ox=0.0676
XMn_32_15 dn_32_15 WL32 SL15 VSS sky130_fd_pr__nfet_g5v0d10v5 w=1 l=0.5
XRn_32_15 BLN15 dn_32_15 sky130_fd_pr_reram__reram_cell area_ox=0.0676
XMp_32_16 dp_32_16 WL32 SL16 VSS sky130_fd_pr__nfet_g5v0d10v5 w=1 l=0.5
XRp_32_16 BLP16 dp_32_16 sky130_fd_pr_reram__reram_cell area_ox=0.0676
XMz_32_16 dz_32_16 WL32 SL16 VSS sky130_fd_pr__nfet_g5v0d10v5 w=1 l=0.5
XRz_32_16 BLZ16 dz_32_16 sky130_fd_pr_reram__reram_cell area_ox=0.0676
XMn_32_16 dn_32_16 WL32 SL16 VSS sky130_fd_pr__nfet_g5v0d10v5 w=1 l=0.5
XRn_32_16 BLN16 dn_32_16 sky130_fd_pr_reram__reram_cell area_ox=0.0676
XMp_32_17 dp_32_17 WL32 SL17 VSS sky130_fd_pr__nfet_g5v0d10v5 w=1 l=0.5
XRp_32_17 BLP17 dp_32_17 sky130_fd_pr_reram__reram_cell area_ox=0.0676
XMz_32_17 dz_32_17 WL32 SL17 VSS sky130_fd_pr__nfet_g5v0d10v5 w=1 l=0.5
XRz_32_17 BLZ17 dz_32_17 sky130_fd_pr_reram__reram_cell area_ox=0.0676
XMn_32_17 dn_32_17 WL32 SL17 VSS sky130_fd_pr__nfet_g5v0d10v5 w=1 l=0.5
XRn_32_17 BLN17 dn_32_17 sky130_fd_pr_reram__reram_cell area_ox=0.0676
XMp_32_18 dp_32_18 WL32 SL18 VSS sky130_fd_pr__nfet_g5v0d10v5 w=1 l=0.5
XRp_32_18 BLP18 dp_32_18 sky130_fd_pr_reram__reram_cell area_ox=0.0676
XMz_32_18 dz_32_18 WL32 SL18 VSS sky130_fd_pr__nfet_g5v0d10v5 w=1 l=0.5
XRz_32_18 BLZ18 dz_32_18 sky130_fd_pr_reram__reram_cell area_ox=0.0676
XMn_32_18 dn_32_18 WL32 SL18 VSS sky130_fd_pr__nfet_g5v0d10v5 w=1 l=0.5
XRn_32_18 BLN18 dn_32_18 sky130_fd_pr_reram__reram_cell area_ox=0.0676
XMp_32_19 dp_32_19 WL32 SL19 VSS sky130_fd_pr__nfet_g5v0d10v5 w=1 l=0.5
XRp_32_19 BLP19 dp_32_19 sky130_fd_pr_reram__reram_cell area_ox=0.0676
XMz_32_19 dz_32_19 WL32 SL19 VSS sky130_fd_pr__nfet_g5v0d10v5 w=1 l=0.5
XRz_32_19 BLZ19 dz_32_19 sky130_fd_pr_reram__reram_cell area_ox=0.0676
XMn_32_19 dn_32_19 WL32 SL19 VSS sky130_fd_pr__nfet_g5v0d10v5 w=1 l=0.5
XRn_32_19 BLN19 dn_32_19 sky130_fd_pr_reram__reram_cell area_ox=0.0676
XMp_32_20 dp_32_20 WL32 SL20 VSS sky130_fd_pr__nfet_g5v0d10v5 w=1 l=0.5
XRp_32_20 BLP20 dp_32_20 sky130_fd_pr_reram__reram_cell area_ox=0.0676
XMz_32_20 dz_32_20 WL32 SL20 VSS sky130_fd_pr__nfet_g5v0d10v5 w=1 l=0.5
XRz_32_20 BLZ20 dz_32_20 sky130_fd_pr_reram__reram_cell area_ox=0.0676
XMn_32_20 dn_32_20 WL32 SL20 VSS sky130_fd_pr__nfet_g5v0d10v5 w=1 l=0.5
XRn_32_20 BLN20 dn_32_20 sky130_fd_pr_reram__reram_cell area_ox=0.0676
XMp_32_21 dp_32_21 WL32 SL21 VSS sky130_fd_pr__nfet_g5v0d10v5 w=1 l=0.5
XRp_32_21 BLP21 dp_32_21 sky130_fd_pr_reram__reram_cell area_ox=0.0676
XMz_32_21 dz_32_21 WL32 SL21 VSS sky130_fd_pr__nfet_g5v0d10v5 w=1 l=0.5
XRz_32_21 BLZ21 dz_32_21 sky130_fd_pr_reram__reram_cell area_ox=0.0676
XMn_32_21 dn_32_21 WL32 SL21 VSS sky130_fd_pr__nfet_g5v0d10v5 w=1 l=0.5
XRn_32_21 BLN21 dn_32_21 sky130_fd_pr_reram__reram_cell area_ox=0.0676
XMp_32_22 dp_32_22 WL32 SL22 VSS sky130_fd_pr__nfet_g5v0d10v5 w=1 l=0.5
XRp_32_22 BLP22 dp_32_22 sky130_fd_pr_reram__reram_cell area_ox=0.0676
XMz_32_22 dz_32_22 WL32 SL22 VSS sky130_fd_pr__nfet_g5v0d10v5 w=1 l=0.5
XRz_32_22 BLZ22 dz_32_22 sky130_fd_pr_reram__reram_cell area_ox=0.0676
XMn_32_22 dn_32_22 WL32 SL22 VSS sky130_fd_pr__nfet_g5v0d10v5 w=1 l=0.5
XRn_32_22 BLN22 dn_32_22 sky130_fd_pr_reram__reram_cell area_ox=0.0676
XMp_32_23 dp_32_23 WL32 SL23 VSS sky130_fd_pr__nfet_g5v0d10v5 w=1 l=0.5
XRp_32_23 BLP23 dp_32_23 sky130_fd_pr_reram__reram_cell area_ox=0.0676
XMz_32_23 dz_32_23 WL32 SL23 VSS sky130_fd_pr__nfet_g5v0d10v5 w=1 l=0.5
XRz_32_23 BLZ23 dz_32_23 sky130_fd_pr_reram__reram_cell area_ox=0.0676
XMn_32_23 dn_32_23 WL32 SL23 VSS sky130_fd_pr__nfet_g5v0d10v5 w=1 l=0.5
XRn_32_23 BLN23 dn_32_23 sky130_fd_pr_reram__reram_cell area_ox=0.0676
XMp_33_0 dp_33_0 WL33 SL0 VSS sky130_fd_pr__nfet_g5v0d10v5 w=1 l=0.5
XRp_33_0 BLP0 dp_33_0 sky130_fd_pr_reram__reram_cell area_ox=0.0676
XMz_33_0 dz_33_0 WL33 SL0 VSS sky130_fd_pr__nfet_g5v0d10v5 w=1 l=0.5
XRz_33_0 BLZ0 dz_33_0 sky130_fd_pr_reram__reram_cell area_ox=0.0676
XMn_33_0 dn_33_0 WL33 SL0 VSS sky130_fd_pr__nfet_g5v0d10v5 w=1 l=0.5
XRn_33_0 BLN0 dn_33_0 sky130_fd_pr_reram__reram_cell area_ox=0.0676
XMp_33_1 dp_33_1 WL33 SL1 VSS sky130_fd_pr__nfet_g5v0d10v5 w=1 l=0.5
XRp_33_1 BLP1 dp_33_1 sky130_fd_pr_reram__reram_cell area_ox=0.0676
XMz_33_1 dz_33_1 WL33 SL1 VSS sky130_fd_pr__nfet_g5v0d10v5 w=1 l=0.5
XRz_33_1 BLZ1 dz_33_1 sky130_fd_pr_reram__reram_cell area_ox=0.0676
XMn_33_1 dn_33_1 WL33 SL1 VSS sky130_fd_pr__nfet_g5v0d10v5 w=1 l=0.5
XRn_33_1 BLN1 dn_33_1 sky130_fd_pr_reram__reram_cell area_ox=0.0676
XMp_33_2 dp_33_2 WL33 SL2 VSS sky130_fd_pr__nfet_g5v0d10v5 w=1 l=0.5
XRp_33_2 BLP2 dp_33_2 sky130_fd_pr_reram__reram_cell area_ox=0.0676
XMz_33_2 dz_33_2 WL33 SL2 VSS sky130_fd_pr__nfet_g5v0d10v5 w=1 l=0.5
XRz_33_2 BLZ2 dz_33_2 sky130_fd_pr_reram__reram_cell area_ox=0.0676
XMn_33_2 dn_33_2 WL33 SL2 VSS sky130_fd_pr__nfet_g5v0d10v5 w=1 l=0.5
XRn_33_2 BLN2 dn_33_2 sky130_fd_pr_reram__reram_cell area_ox=0.0676
XMp_33_3 dp_33_3 WL33 SL3 VSS sky130_fd_pr__nfet_g5v0d10v5 w=1 l=0.5
XRp_33_3 BLP3 dp_33_3 sky130_fd_pr_reram__reram_cell area_ox=0.0676
XMz_33_3 dz_33_3 WL33 SL3 VSS sky130_fd_pr__nfet_g5v0d10v5 w=1 l=0.5
XRz_33_3 BLZ3 dz_33_3 sky130_fd_pr_reram__reram_cell area_ox=0.0676
XMn_33_3 dn_33_3 WL33 SL3 VSS sky130_fd_pr__nfet_g5v0d10v5 w=1 l=0.5
XRn_33_3 BLN3 dn_33_3 sky130_fd_pr_reram__reram_cell area_ox=0.0676
XMp_33_4 dp_33_4 WL33 SL4 VSS sky130_fd_pr__nfet_g5v0d10v5 w=1 l=0.5
XRp_33_4 BLP4 dp_33_4 sky130_fd_pr_reram__reram_cell area_ox=0.0676
XMz_33_4 dz_33_4 WL33 SL4 VSS sky130_fd_pr__nfet_g5v0d10v5 w=1 l=0.5
XRz_33_4 BLZ4 dz_33_4 sky130_fd_pr_reram__reram_cell area_ox=0.0676
XMn_33_4 dn_33_4 WL33 SL4 VSS sky130_fd_pr__nfet_g5v0d10v5 w=1 l=0.5
XRn_33_4 BLN4 dn_33_4 sky130_fd_pr_reram__reram_cell area_ox=0.0676
XMp_33_5 dp_33_5 WL33 SL5 VSS sky130_fd_pr__nfet_g5v0d10v5 w=1 l=0.5
XRp_33_5 BLP5 dp_33_5 sky130_fd_pr_reram__reram_cell area_ox=0.0676
XMz_33_5 dz_33_5 WL33 SL5 VSS sky130_fd_pr__nfet_g5v0d10v5 w=1 l=0.5
XRz_33_5 BLZ5 dz_33_5 sky130_fd_pr_reram__reram_cell area_ox=0.0676
XMn_33_5 dn_33_5 WL33 SL5 VSS sky130_fd_pr__nfet_g5v0d10v5 w=1 l=0.5
XRn_33_5 BLN5 dn_33_5 sky130_fd_pr_reram__reram_cell area_ox=0.0676
XMp_33_6 dp_33_6 WL33 SL6 VSS sky130_fd_pr__nfet_g5v0d10v5 w=1 l=0.5
XRp_33_6 BLP6 dp_33_6 sky130_fd_pr_reram__reram_cell area_ox=0.0676
XMz_33_6 dz_33_6 WL33 SL6 VSS sky130_fd_pr__nfet_g5v0d10v5 w=1 l=0.5
XRz_33_6 BLZ6 dz_33_6 sky130_fd_pr_reram__reram_cell area_ox=0.0676
XMn_33_6 dn_33_6 WL33 SL6 VSS sky130_fd_pr__nfet_g5v0d10v5 w=1 l=0.5
XRn_33_6 BLN6 dn_33_6 sky130_fd_pr_reram__reram_cell area_ox=0.0676
XMp_33_7 dp_33_7 WL33 SL7 VSS sky130_fd_pr__nfet_g5v0d10v5 w=1 l=0.5
XRp_33_7 BLP7 dp_33_7 sky130_fd_pr_reram__reram_cell area_ox=0.0676
XMz_33_7 dz_33_7 WL33 SL7 VSS sky130_fd_pr__nfet_g5v0d10v5 w=1 l=0.5
XRz_33_7 BLZ7 dz_33_7 sky130_fd_pr_reram__reram_cell area_ox=0.0676
XMn_33_7 dn_33_7 WL33 SL7 VSS sky130_fd_pr__nfet_g5v0d10v5 w=1 l=0.5
XRn_33_7 BLN7 dn_33_7 sky130_fd_pr_reram__reram_cell area_ox=0.0676
XMp_33_8 dp_33_8 WL33 SL8 VSS sky130_fd_pr__nfet_g5v0d10v5 w=1 l=0.5
XRp_33_8 BLP8 dp_33_8 sky130_fd_pr_reram__reram_cell area_ox=0.0676
XMz_33_8 dz_33_8 WL33 SL8 VSS sky130_fd_pr__nfet_g5v0d10v5 w=1 l=0.5
XRz_33_8 BLZ8 dz_33_8 sky130_fd_pr_reram__reram_cell area_ox=0.0676
XMn_33_8 dn_33_8 WL33 SL8 VSS sky130_fd_pr__nfet_g5v0d10v5 w=1 l=0.5
XRn_33_8 BLN8 dn_33_8 sky130_fd_pr_reram__reram_cell area_ox=0.0676
XMp_33_9 dp_33_9 WL33 SL9 VSS sky130_fd_pr__nfet_g5v0d10v5 w=1 l=0.5
XRp_33_9 BLP9 dp_33_9 sky130_fd_pr_reram__reram_cell area_ox=0.0676
XMz_33_9 dz_33_9 WL33 SL9 VSS sky130_fd_pr__nfet_g5v0d10v5 w=1 l=0.5
XRz_33_9 BLZ9 dz_33_9 sky130_fd_pr_reram__reram_cell area_ox=0.0676
XMn_33_9 dn_33_9 WL33 SL9 VSS sky130_fd_pr__nfet_g5v0d10v5 w=1 l=0.5
XRn_33_9 BLN9 dn_33_9 sky130_fd_pr_reram__reram_cell area_ox=0.0676
XMp_33_10 dp_33_10 WL33 SL10 VSS sky130_fd_pr__nfet_g5v0d10v5 w=1 l=0.5
XRp_33_10 BLP10 dp_33_10 sky130_fd_pr_reram__reram_cell area_ox=0.0676
XMz_33_10 dz_33_10 WL33 SL10 VSS sky130_fd_pr__nfet_g5v0d10v5 w=1 l=0.5
XRz_33_10 BLZ10 dz_33_10 sky130_fd_pr_reram__reram_cell area_ox=0.0676
XMn_33_10 dn_33_10 WL33 SL10 VSS sky130_fd_pr__nfet_g5v0d10v5 w=1 l=0.5
XRn_33_10 BLN10 dn_33_10 sky130_fd_pr_reram__reram_cell area_ox=0.0676
XMp_33_11 dp_33_11 WL33 SL11 VSS sky130_fd_pr__nfet_g5v0d10v5 w=1 l=0.5
XRp_33_11 BLP11 dp_33_11 sky130_fd_pr_reram__reram_cell area_ox=0.0676
XMz_33_11 dz_33_11 WL33 SL11 VSS sky130_fd_pr__nfet_g5v0d10v5 w=1 l=0.5
XRz_33_11 BLZ11 dz_33_11 sky130_fd_pr_reram__reram_cell area_ox=0.0676
XMn_33_11 dn_33_11 WL33 SL11 VSS sky130_fd_pr__nfet_g5v0d10v5 w=1 l=0.5
XRn_33_11 BLN11 dn_33_11 sky130_fd_pr_reram__reram_cell area_ox=0.0676
XMp_33_12 dp_33_12 WL33 SL12 VSS sky130_fd_pr__nfet_g5v0d10v5 w=1 l=0.5
XRp_33_12 BLP12 dp_33_12 sky130_fd_pr_reram__reram_cell area_ox=0.0676
XMz_33_12 dz_33_12 WL33 SL12 VSS sky130_fd_pr__nfet_g5v0d10v5 w=1 l=0.5
XRz_33_12 BLZ12 dz_33_12 sky130_fd_pr_reram__reram_cell area_ox=0.0676
XMn_33_12 dn_33_12 WL33 SL12 VSS sky130_fd_pr__nfet_g5v0d10v5 w=1 l=0.5
XRn_33_12 BLN12 dn_33_12 sky130_fd_pr_reram__reram_cell area_ox=0.0676
XMp_33_13 dp_33_13 WL33 SL13 VSS sky130_fd_pr__nfet_g5v0d10v5 w=1 l=0.5
XRp_33_13 BLP13 dp_33_13 sky130_fd_pr_reram__reram_cell area_ox=0.0676
XMz_33_13 dz_33_13 WL33 SL13 VSS sky130_fd_pr__nfet_g5v0d10v5 w=1 l=0.5
XRz_33_13 BLZ13 dz_33_13 sky130_fd_pr_reram__reram_cell area_ox=0.0676
XMn_33_13 dn_33_13 WL33 SL13 VSS sky130_fd_pr__nfet_g5v0d10v5 w=1 l=0.5
XRn_33_13 BLN13 dn_33_13 sky130_fd_pr_reram__reram_cell area_ox=0.0676
XMp_33_14 dp_33_14 WL33 SL14 VSS sky130_fd_pr__nfet_g5v0d10v5 w=1 l=0.5
XRp_33_14 BLP14 dp_33_14 sky130_fd_pr_reram__reram_cell area_ox=0.0676
XMz_33_14 dz_33_14 WL33 SL14 VSS sky130_fd_pr__nfet_g5v0d10v5 w=1 l=0.5
XRz_33_14 BLZ14 dz_33_14 sky130_fd_pr_reram__reram_cell area_ox=0.0676
XMn_33_14 dn_33_14 WL33 SL14 VSS sky130_fd_pr__nfet_g5v0d10v5 w=1 l=0.5
XRn_33_14 BLN14 dn_33_14 sky130_fd_pr_reram__reram_cell area_ox=0.0676
XMp_33_15 dp_33_15 WL33 SL15 VSS sky130_fd_pr__nfet_g5v0d10v5 w=1 l=0.5
XRp_33_15 BLP15 dp_33_15 sky130_fd_pr_reram__reram_cell area_ox=0.0676
XMz_33_15 dz_33_15 WL33 SL15 VSS sky130_fd_pr__nfet_g5v0d10v5 w=1 l=0.5
XRz_33_15 BLZ15 dz_33_15 sky130_fd_pr_reram__reram_cell area_ox=0.0676
XMn_33_15 dn_33_15 WL33 SL15 VSS sky130_fd_pr__nfet_g5v0d10v5 w=1 l=0.5
XRn_33_15 BLN15 dn_33_15 sky130_fd_pr_reram__reram_cell area_ox=0.0676
XMp_33_16 dp_33_16 WL33 SL16 VSS sky130_fd_pr__nfet_g5v0d10v5 w=1 l=0.5
XRp_33_16 BLP16 dp_33_16 sky130_fd_pr_reram__reram_cell area_ox=0.0676
XMz_33_16 dz_33_16 WL33 SL16 VSS sky130_fd_pr__nfet_g5v0d10v5 w=1 l=0.5
XRz_33_16 BLZ16 dz_33_16 sky130_fd_pr_reram__reram_cell area_ox=0.0676
XMn_33_16 dn_33_16 WL33 SL16 VSS sky130_fd_pr__nfet_g5v0d10v5 w=1 l=0.5
XRn_33_16 BLN16 dn_33_16 sky130_fd_pr_reram__reram_cell area_ox=0.0676
XMp_33_17 dp_33_17 WL33 SL17 VSS sky130_fd_pr__nfet_g5v0d10v5 w=1 l=0.5
XRp_33_17 BLP17 dp_33_17 sky130_fd_pr_reram__reram_cell area_ox=0.0676
XMz_33_17 dz_33_17 WL33 SL17 VSS sky130_fd_pr__nfet_g5v0d10v5 w=1 l=0.5
XRz_33_17 BLZ17 dz_33_17 sky130_fd_pr_reram__reram_cell area_ox=0.0676
XMn_33_17 dn_33_17 WL33 SL17 VSS sky130_fd_pr__nfet_g5v0d10v5 w=1 l=0.5
XRn_33_17 BLN17 dn_33_17 sky130_fd_pr_reram__reram_cell area_ox=0.0676
XMp_33_18 dp_33_18 WL33 SL18 VSS sky130_fd_pr__nfet_g5v0d10v5 w=1 l=0.5
XRp_33_18 BLP18 dp_33_18 sky130_fd_pr_reram__reram_cell area_ox=0.0676
XMz_33_18 dz_33_18 WL33 SL18 VSS sky130_fd_pr__nfet_g5v0d10v5 w=1 l=0.5
XRz_33_18 BLZ18 dz_33_18 sky130_fd_pr_reram__reram_cell area_ox=0.0676
XMn_33_18 dn_33_18 WL33 SL18 VSS sky130_fd_pr__nfet_g5v0d10v5 w=1 l=0.5
XRn_33_18 BLN18 dn_33_18 sky130_fd_pr_reram__reram_cell area_ox=0.0676
XMp_33_19 dp_33_19 WL33 SL19 VSS sky130_fd_pr__nfet_g5v0d10v5 w=1 l=0.5
XRp_33_19 BLP19 dp_33_19 sky130_fd_pr_reram__reram_cell area_ox=0.0676
XMz_33_19 dz_33_19 WL33 SL19 VSS sky130_fd_pr__nfet_g5v0d10v5 w=1 l=0.5
XRz_33_19 BLZ19 dz_33_19 sky130_fd_pr_reram__reram_cell area_ox=0.0676
XMn_33_19 dn_33_19 WL33 SL19 VSS sky130_fd_pr__nfet_g5v0d10v5 w=1 l=0.5
XRn_33_19 BLN19 dn_33_19 sky130_fd_pr_reram__reram_cell area_ox=0.0676
XMp_33_20 dp_33_20 WL33 SL20 VSS sky130_fd_pr__nfet_g5v0d10v5 w=1 l=0.5
XRp_33_20 BLP20 dp_33_20 sky130_fd_pr_reram__reram_cell area_ox=0.0676
XMz_33_20 dz_33_20 WL33 SL20 VSS sky130_fd_pr__nfet_g5v0d10v5 w=1 l=0.5
XRz_33_20 BLZ20 dz_33_20 sky130_fd_pr_reram__reram_cell area_ox=0.0676
XMn_33_20 dn_33_20 WL33 SL20 VSS sky130_fd_pr__nfet_g5v0d10v5 w=1 l=0.5
XRn_33_20 BLN20 dn_33_20 sky130_fd_pr_reram__reram_cell area_ox=0.0676
XMp_33_21 dp_33_21 WL33 SL21 VSS sky130_fd_pr__nfet_g5v0d10v5 w=1 l=0.5
XRp_33_21 BLP21 dp_33_21 sky130_fd_pr_reram__reram_cell area_ox=0.0676
XMz_33_21 dz_33_21 WL33 SL21 VSS sky130_fd_pr__nfet_g5v0d10v5 w=1 l=0.5
XRz_33_21 BLZ21 dz_33_21 sky130_fd_pr_reram__reram_cell area_ox=0.0676
XMn_33_21 dn_33_21 WL33 SL21 VSS sky130_fd_pr__nfet_g5v0d10v5 w=1 l=0.5
XRn_33_21 BLN21 dn_33_21 sky130_fd_pr_reram__reram_cell area_ox=0.0676
XMp_33_22 dp_33_22 WL33 SL22 VSS sky130_fd_pr__nfet_g5v0d10v5 w=1 l=0.5
XRp_33_22 BLP22 dp_33_22 sky130_fd_pr_reram__reram_cell area_ox=0.0676
XMz_33_22 dz_33_22 WL33 SL22 VSS sky130_fd_pr__nfet_g5v0d10v5 w=1 l=0.5
XRz_33_22 BLZ22 dz_33_22 sky130_fd_pr_reram__reram_cell area_ox=0.0676
XMn_33_22 dn_33_22 WL33 SL22 VSS sky130_fd_pr__nfet_g5v0d10v5 w=1 l=0.5
XRn_33_22 BLN22 dn_33_22 sky130_fd_pr_reram__reram_cell area_ox=0.0676
XMp_33_23 dp_33_23 WL33 SL23 VSS sky130_fd_pr__nfet_g5v0d10v5 w=1 l=0.5
XRp_33_23 BLP23 dp_33_23 sky130_fd_pr_reram__reram_cell area_ox=0.0676
XMz_33_23 dz_33_23 WL33 SL23 VSS sky130_fd_pr__nfet_g5v0d10v5 w=1 l=0.5
XRz_33_23 BLZ23 dz_33_23 sky130_fd_pr_reram__reram_cell area_ox=0.0676
XMn_33_23 dn_33_23 WL33 SL23 VSS sky130_fd_pr__nfet_g5v0d10v5 w=1 l=0.5
XRn_33_23 BLN23 dn_33_23 sky130_fd_pr_reram__reram_cell area_ox=0.0676
XMp_34_0 dp_34_0 WL34 SL0 VSS sky130_fd_pr__nfet_g5v0d10v5 w=1 l=0.5
XRp_34_0 BLP0 dp_34_0 sky130_fd_pr_reram__reram_cell area_ox=0.0676
XMz_34_0 dz_34_0 WL34 SL0 VSS sky130_fd_pr__nfet_g5v0d10v5 w=1 l=0.5
XRz_34_0 BLZ0 dz_34_0 sky130_fd_pr_reram__reram_cell area_ox=0.0676
XMn_34_0 dn_34_0 WL34 SL0 VSS sky130_fd_pr__nfet_g5v0d10v5 w=1 l=0.5
XRn_34_0 BLN0 dn_34_0 sky130_fd_pr_reram__reram_cell area_ox=0.0676
XMp_34_1 dp_34_1 WL34 SL1 VSS sky130_fd_pr__nfet_g5v0d10v5 w=1 l=0.5
XRp_34_1 BLP1 dp_34_1 sky130_fd_pr_reram__reram_cell area_ox=0.0676
XMz_34_1 dz_34_1 WL34 SL1 VSS sky130_fd_pr__nfet_g5v0d10v5 w=1 l=0.5
XRz_34_1 BLZ1 dz_34_1 sky130_fd_pr_reram__reram_cell area_ox=0.0676
XMn_34_1 dn_34_1 WL34 SL1 VSS sky130_fd_pr__nfet_g5v0d10v5 w=1 l=0.5
XRn_34_1 BLN1 dn_34_1 sky130_fd_pr_reram__reram_cell area_ox=0.0676
XMp_34_2 dp_34_2 WL34 SL2 VSS sky130_fd_pr__nfet_g5v0d10v5 w=1 l=0.5
XRp_34_2 BLP2 dp_34_2 sky130_fd_pr_reram__reram_cell area_ox=0.0676
XMz_34_2 dz_34_2 WL34 SL2 VSS sky130_fd_pr__nfet_g5v0d10v5 w=1 l=0.5
XRz_34_2 BLZ2 dz_34_2 sky130_fd_pr_reram__reram_cell area_ox=0.0676
XMn_34_2 dn_34_2 WL34 SL2 VSS sky130_fd_pr__nfet_g5v0d10v5 w=1 l=0.5
XRn_34_2 BLN2 dn_34_2 sky130_fd_pr_reram__reram_cell area_ox=0.0676
XMp_34_3 dp_34_3 WL34 SL3 VSS sky130_fd_pr__nfet_g5v0d10v5 w=1 l=0.5
XRp_34_3 BLP3 dp_34_3 sky130_fd_pr_reram__reram_cell area_ox=0.0676
XMz_34_3 dz_34_3 WL34 SL3 VSS sky130_fd_pr__nfet_g5v0d10v5 w=1 l=0.5
XRz_34_3 BLZ3 dz_34_3 sky130_fd_pr_reram__reram_cell area_ox=0.0676
XMn_34_3 dn_34_3 WL34 SL3 VSS sky130_fd_pr__nfet_g5v0d10v5 w=1 l=0.5
XRn_34_3 BLN3 dn_34_3 sky130_fd_pr_reram__reram_cell area_ox=0.0676
XMp_34_4 dp_34_4 WL34 SL4 VSS sky130_fd_pr__nfet_g5v0d10v5 w=1 l=0.5
XRp_34_4 BLP4 dp_34_4 sky130_fd_pr_reram__reram_cell area_ox=0.0676
XMz_34_4 dz_34_4 WL34 SL4 VSS sky130_fd_pr__nfet_g5v0d10v5 w=1 l=0.5
XRz_34_4 BLZ4 dz_34_4 sky130_fd_pr_reram__reram_cell area_ox=0.0676
XMn_34_4 dn_34_4 WL34 SL4 VSS sky130_fd_pr__nfet_g5v0d10v5 w=1 l=0.5
XRn_34_4 BLN4 dn_34_4 sky130_fd_pr_reram__reram_cell area_ox=0.0676
XMp_34_5 dp_34_5 WL34 SL5 VSS sky130_fd_pr__nfet_g5v0d10v5 w=1 l=0.5
XRp_34_5 BLP5 dp_34_5 sky130_fd_pr_reram__reram_cell area_ox=0.0676
XMz_34_5 dz_34_5 WL34 SL5 VSS sky130_fd_pr__nfet_g5v0d10v5 w=1 l=0.5
XRz_34_5 BLZ5 dz_34_5 sky130_fd_pr_reram__reram_cell area_ox=0.0676
XMn_34_5 dn_34_5 WL34 SL5 VSS sky130_fd_pr__nfet_g5v0d10v5 w=1 l=0.5
XRn_34_5 BLN5 dn_34_5 sky130_fd_pr_reram__reram_cell area_ox=0.0676
XMp_34_6 dp_34_6 WL34 SL6 VSS sky130_fd_pr__nfet_g5v0d10v5 w=1 l=0.5
XRp_34_6 BLP6 dp_34_6 sky130_fd_pr_reram__reram_cell area_ox=0.0676
XMz_34_6 dz_34_6 WL34 SL6 VSS sky130_fd_pr__nfet_g5v0d10v5 w=1 l=0.5
XRz_34_6 BLZ6 dz_34_6 sky130_fd_pr_reram__reram_cell area_ox=0.0676
XMn_34_6 dn_34_6 WL34 SL6 VSS sky130_fd_pr__nfet_g5v0d10v5 w=1 l=0.5
XRn_34_6 BLN6 dn_34_6 sky130_fd_pr_reram__reram_cell area_ox=0.0676
XMp_34_7 dp_34_7 WL34 SL7 VSS sky130_fd_pr__nfet_g5v0d10v5 w=1 l=0.5
XRp_34_7 BLP7 dp_34_7 sky130_fd_pr_reram__reram_cell area_ox=0.0676
XMz_34_7 dz_34_7 WL34 SL7 VSS sky130_fd_pr__nfet_g5v0d10v5 w=1 l=0.5
XRz_34_7 BLZ7 dz_34_7 sky130_fd_pr_reram__reram_cell area_ox=0.0676
XMn_34_7 dn_34_7 WL34 SL7 VSS sky130_fd_pr__nfet_g5v0d10v5 w=1 l=0.5
XRn_34_7 BLN7 dn_34_7 sky130_fd_pr_reram__reram_cell area_ox=0.0676
XMp_34_8 dp_34_8 WL34 SL8 VSS sky130_fd_pr__nfet_g5v0d10v5 w=1 l=0.5
XRp_34_8 BLP8 dp_34_8 sky130_fd_pr_reram__reram_cell area_ox=0.0676
XMz_34_8 dz_34_8 WL34 SL8 VSS sky130_fd_pr__nfet_g5v0d10v5 w=1 l=0.5
XRz_34_8 BLZ8 dz_34_8 sky130_fd_pr_reram__reram_cell area_ox=0.0676
XMn_34_8 dn_34_8 WL34 SL8 VSS sky130_fd_pr__nfet_g5v0d10v5 w=1 l=0.5
XRn_34_8 BLN8 dn_34_8 sky130_fd_pr_reram__reram_cell area_ox=0.0676
XMp_34_9 dp_34_9 WL34 SL9 VSS sky130_fd_pr__nfet_g5v0d10v5 w=1 l=0.5
XRp_34_9 BLP9 dp_34_9 sky130_fd_pr_reram__reram_cell area_ox=0.0676
XMz_34_9 dz_34_9 WL34 SL9 VSS sky130_fd_pr__nfet_g5v0d10v5 w=1 l=0.5
XRz_34_9 BLZ9 dz_34_9 sky130_fd_pr_reram__reram_cell area_ox=0.0676
XMn_34_9 dn_34_9 WL34 SL9 VSS sky130_fd_pr__nfet_g5v0d10v5 w=1 l=0.5
XRn_34_9 BLN9 dn_34_9 sky130_fd_pr_reram__reram_cell area_ox=0.0676
XMp_34_10 dp_34_10 WL34 SL10 VSS sky130_fd_pr__nfet_g5v0d10v5 w=1 l=0.5
XRp_34_10 BLP10 dp_34_10 sky130_fd_pr_reram__reram_cell area_ox=0.0676
XMz_34_10 dz_34_10 WL34 SL10 VSS sky130_fd_pr__nfet_g5v0d10v5 w=1 l=0.5
XRz_34_10 BLZ10 dz_34_10 sky130_fd_pr_reram__reram_cell area_ox=0.0676
XMn_34_10 dn_34_10 WL34 SL10 VSS sky130_fd_pr__nfet_g5v0d10v5 w=1 l=0.5
XRn_34_10 BLN10 dn_34_10 sky130_fd_pr_reram__reram_cell area_ox=0.0676
XMp_34_11 dp_34_11 WL34 SL11 VSS sky130_fd_pr__nfet_g5v0d10v5 w=1 l=0.5
XRp_34_11 BLP11 dp_34_11 sky130_fd_pr_reram__reram_cell area_ox=0.0676
XMz_34_11 dz_34_11 WL34 SL11 VSS sky130_fd_pr__nfet_g5v0d10v5 w=1 l=0.5
XRz_34_11 BLZ11 dz_34_11 sky130_fd_pr_reram__reram_cell area_ox=0.0676
XMn_34_11 dn_34_11 WL34 SL11 VSS sky130_fd_pr__nfet_g5v0d10v5 w=1 l=0.5
XRn_34_11 BLN11 dn_34_11 sky130_fd_pr_reram__reram_cell area_ox=0.0676
XMp_34_12 dp_34_12 WL34 SL12 VSS sky130_fd_pr__nfet_g5v0d10v5 w=1 l=0.5
XRp_34_12 BLP12 dp_34_12 sky130_fd_pr_reram__reram_cell area_ox=0.0676
XMz_34_12 dz_34_12 WL34 SL12 VSS sky130_fd_pr__nfet_g5v0d10v5 w=1 l=0.5
XRz_34_12 BLZ12 dz_34_12 sky130_fd_pr_reram__reram_cell area_ox=0.0676
XMn_34_12 dn_34_12 WL34 SL12 VSS sky130_fd_pr__nfet_g5v0d10v5 w=1 l=0.5
XRn_34_12 BLN12 dn_34_12 sky130_fd_pr_reram__reram_cell area_ox=0.0676
XMp_34_13 dp_34_13 WL34 SL13 VSS sky130_fd_pr__nfet_g5v0d10v5 w=1 l=0.5
XRp_34_13 BLP13 dp_34_13 sky130_fd_pr_reram__reram_cell area_ox=0.0676
XMz_34_13 dz_34_13 WL34 SL13 VSS sky130_fd_pr__nfet_g5v0d10v5 w=1 l=0.5
XRz_34_13 BLZ13 dz_34_13 sky130_fd_pr_reram__reram_cell area_ox=0.0676
XMn_34_13 dn_34_13 WL34 SL13 VSS sky130_fd_pr__nfet_g5v0d10v5 w=1 l=0.5
XRn_34_13 BLN13 dn_34_13 sky130_fd_pr_reram__reram_cell area_ox=0.0676
XMp_34_14 dp_34_14 WL34 SL14 VSS sky130_fd_pr__nfet_g5v0d10v5 w=1 l=0.5
XRp_34_14 BLP14 dp_34_14 sky130_fd_pr_reram__reram_cell area_ox=0.0676
XMz_34_14 dz_34_14 WL34 SL14 VSS sky130_fd_pr__nfet_g5v0d10v5 w=1 l=0.5
XRz_34_14 BLZ14 dz_34_14 sky130_fd_pr_reram__reram_cell area_ox=0.0676
XMn_34_14 dn_34_14 WL34 SL14 VSS sky130_fd_pr__nfet_g5v0d10v5 w=1 l=0.5
XRn_34_14 BLN14 dn_34_14 sky130_fd_pr_reram__reram_cell area_ox=0.0676
XMp_34_15 dp_34_15 WL34 SL15 VSS sky130_fd_pr__nfet_g5v0d10v5 w=1 l=0.5
XRp_34_15 BLP15 dp_34_15 sky130_fd_pr_reram__reram_cell area_ox=0.0676
XMz_34_15 dz_34_15 WL34 SL15 VSS sky130_fd_pr__nfet_g5v0d10v5 w=1 l=0.5
XRz_34_15 BLZ15 dz_34_15 sky130_fd_pr_reram__reram_cell area_ox=0.0676
XMn_34_15 dn_34_15 WL34 SL15 VSS sky130_fd_pr__nfet_g5v0d10v5 w=1 l=0.5
XRn_34_15 BLN15 dn_34_15 sky130_fd_pr_reram__reram_cell area_ox=0.0676
XMp_34_16 dp_34_16 WL34 SL16 VSS sky130_fd_pr__nfet_g5v0d10v5 w=1 l=0.5
XRp_34_16 BLP16 dp_34_16 sky130_fd_pr_reram__reram_cell area_ox=0.0676
XMz_34_16 dz_34_16 WL34 SL16 VSS sky130_fd_pr__nfet_g5v0d10v5 w=1 l=0.5
XRz_34_16 BLZ16 dz_34_16 sky130_fd_pr_reram__reram_cell area_ox=0.0676
XMn_34_16 dn_34_16 WL34 SL16 VSS sky130_fd_pr__nfet_g5v0d10v5 w=1 l=0.5
XRn_34_16 BLN16 dn_34_16 sky130_fd_pr_reram__reram_cell area_ox=0.0676
XMp_34_17 dp_34_17 WL34 SL17 VSS sky130_fd_pr__nfet_g5v0d10v5 w=1 l=0.5
XRp_34_17 BLP17 dp_34_17 sky130_fd_pr_reram__reram_cell area_ox=0.0676
XMz_34_17 dz_34_17 WL34 SL17 VSS sky130_fd_pr__nfet_g5v0d10v5 w=1 l=0.5
XRz_34_17 BLZ17 dz_34_17 sky130_fd_pr_reram__reram_cell area_ox=0.0676
XMn_34_17 dn_34_17 WL34 SL17 VSS sky130_fd_pr__nfet_g5v0d10v5 w=1 l=0.5
XRn_34_17 BLN17 dn_34_17 sky130_fd_pr_reram__reram_cell area_ox=0.0676
XMp_34_18 dp_34_18 WL34 SL18 VSS sky130_fd_pr__nfet_g5v0d10v5 w=1 l=0.5
XRp_34_18 BLP18 dp_34_18 sky130_fd_pr_reram__reram_cell area_ox=0.0676
XMz_34_18 dz_34_18 WL34 SL18 VSS sky130_fd_pr__nfet_g5v0d10v5 w=1 l=0.5
XRz_34_18 BLZ18 dz_34_18 sky130_fd_pr_reram__reram_cell area_ox=0.0676
XMn_34_18 dn_34_18 WL34 SL18 VSS sky130_fd_pr__nfet_g5v0d10v5 w=1 l=0.5
XRn_34_18 BLN18 dn_34_18 sky130_fd_pr_reram__reram_cell area_ox=0.0676
XMp_34_19 dp_34_19 WL34 SL19 VSS sky130_fd_pr__nfet_g5v0d10v5 w=1 l=0.5
XRp_34_19 BLP19 dp_34_19 sky130_fd_pr_reram__reram_cell area_ox=0.0676
XMz_34_19 dz_34_19 WL34 SL19 VSS sky130_fd_pr__nfet_g5v0d10v5 w=1 l=0.5
XRz_34_19 BLZ19 dz_34_19 sky130_fd_pr_reram__reram_cell area_ox=0.0676
XMn_34_19 dn_34_19 WL34 SL19 VSS sky130_fd_pr__nfet_g5v0d10v5 w=1 l=0.5
XRn_34_19 BLN19 dn_34_19 sky130_fd_pr_reram__reram_cell area_ox=0.0676
XMp_34_20 dp_34_20 WL34 SL20 VSS sky130_fd_pr__nfet_g5v0d10v5 w=1 l=0.5
XRp_34_20 BLP20 dp_34_20 sky130_fd_pr_reram__reram_cell area_ox=0.0676
XMz_34_20 dz_34_20 WL34 SL20 VSS sky130_fd_pr__nfet_g5v0d10v5 w=1 l=0.5
XRz_34_20 BLZ20 dz_34_20 sky130_fd_pr_reram__reram_cell area_ox=0.0676
XMn_34_20 dn_34_20 WL34 SL20 VSS sky130_fd_pr__nfet_g5v0d10v5 w=1 l=0.5
XRn_34_20 BLN20 dn_34_20 sky130_fd_pr_reram__reram_cell area_ox=0.0676
XMp_34_21 dp_34_21 WL34 SL21 VSS sky130_fd_pr__nfet_g5v0d10v5 w=1 l=0.5
XRp_34_21 BLP21 dp_34_21 sky130_fd_pr_reram__reram_cell area_ox=0.0676
XMz_34_21 dz_34_21 WL34 SL21 VSS sky130_fd_pr__nfet_g5v0d10v5 w=1 l=0.5
XRz_34_21 BLZ21 dz_34_21 sky130_fd_pr_reram__reram_cell area_ox=0.0676
XMn_34_21 dn_34_21 WL34 SL21 VSS sky130_fd_pr__nfet_g5v0d10v5 w=1 l=0.5
XRn_34_21 BLN21 dn_34_21 sky130_fd_pr_reram__reram_cell area_ox=0.0676
XMp_34_22 dp_34_22 WL34 SL22 VSS sky130_fd_pr__nfet_g5v0d10v5 w=1 l=0.5
XRp_34_22 BLP22 dp_34_22 sky130_fd_pr_reram__reram_cell area_ox=0.0676
XMz_34_22 dz_34_22 WL34 SL22 VSS sky130_fd_pr__nfet_g5v0d10v5 w=1 l=0.5
XRz_34_22 BLZ22 dz_34_22 sky130_fd_pr_reram__reram_cell area_ox=0.0676
XMn_34_22 dn_34_22 WL34 SL22 VSS sky130_fd_pr__nfet_g5v0d10v5 w=1 l=0.5
XRn_34_22 BLN22 dn_34_22 sky130_fd_pr_reram__reram_cell area_ox=0.0676
XMp_34_23 dp_34_23 WL34 SL23 VSS sky130_fd_pr__nfet_g5v0d10v5 w=1 l=0.5
XRp_34_23 BLP23 dp_34_23 sky130_fd_pr_reram__reram_cell area_ox=0.0676
XMz_34_23 dz_34_23 WL34 SL23 VSS sky130_fd_pr__nfet_g5v0d10v5 w=1 l=0.5
XRz_34_23 BLZ23 dz_34_23 sky130_fd_pr_reram__reram_cell area_ox=0.0676
XMn_34_23 dn_34_23 WL34 SL23 VSS sky130_fd_pr__nfet_g5v0d10v5 w=1 l=0.5
XRn_34_23 BLN23 dn_34_23 sky130_fd_pr_reram__reram_cell area_ox=0.0676
XMp_35_0 dp_35_0 WL35 SL0 VSS sky130_fd_pr__nfet_g5v0d10v5 w=1 l=0.5
XRp_35_0 BLP0 dp_35_0 sky130_fd_pr_reram__reram_cell area_ox=0.0676
XMz_35_0 dz_35_0 WL35 SL0 VSS sky130_fd_pr__nfet_g5v0d10v5 w=1 l=0.5
XRz_35_0 BLZ0 dz_35_0 sky130_fd_pr_reram__reram_cell area_ox=0.0676
XMn_35_0 dn_35_0 WL35 SL0 VSS sky130_fd_pr__nfet_g5v0d10v5 w=1 l=0.5
XRn_35_0 BLN0 dn_35_0 sky130_fd_pr_reram__reram_cell area_ox=0.0676
XMp_35_1 dp_35_1 WL35 SL1 VSS sky130_fd_pr__nfet_g5v0d10v5 w=1 l=0.5
XRp_35_1 BLP1 dp_35_1 sky130_fd_pr_reram__reram_cell area_ox=0.0676
XMz_35_1 dz_35_1 WL35 SL1 VSS sky130_fd_pr__nfet_g5v0d10v5 w=1 l=0.5
XRz_35_1 BLZ1 dz_35_1 sky130_fd_pr_reram__reram_cell area_ox=0.0676
XMn_35_1 dn_35_1 WL35 SL1 VSS sky130_fd_pr__nfet_g5v0d10v5 w=1 l=0.5
XRn_35_1 BLN1 dn_35_1 sky130_fd_pr_reram__reram_cell area_ox=0.0676
XMp_35_2 dp_35_2 WL35 SL2 VSS sky130_fd_pr__nfet_g5v0d10v5 w=1 l=0.5
XRp_35_2 BLP2 dp_35_2 sky130_fd_pr_reram__reram_cell area_ox=0.0676
XMz_35_2 dz_35_2 WL35 SL2 VSS sky130_fd_pr__nfet_g5v0d10v5 w=1 l=0.5
XRz_35_2 BLZ2 dz_35_2 sky130_fd_pr_reram__reram_cell area_ox=0.0676
XMn_35_2 dn_35_2 WL35 SL2 VSS sky130_fd_pr__nfet_g5v0d10v5 w=1 l=0.5
XRn_35_2 BLN2 dn_35_2 sky130_fd_pr_reram__reram_cell area_ox=0.0676
XMp_35_3 dp_35_3 WL35 SL3 VSS sky130_fd_pr__nfet_g5v0d10v5 w=1 l=0.5
XRp_35_3 BLP3 dp_35_3 sky130_fd_pr_reram__reram_cell area_ox=0.0676
XMz_35_3 dz_35_3 WL35 SL3 VSS sky130_fd_pr__nfet_g5v0d10v5 w=1 l=0.5
XRz_35_3 BLZ3 dz_35_3 sky130_fd_pr_reram__reram_cell area_ox=0.0676
XMn_35_3 dn_35_3 WL35 SL3 VSS sky130_fd_pr__nfet_g5v0d10v5 w=1 l=0.5
XRn_35_3 BLN3 dn_35_3 sky130_fd_pr_reram__reram_cell area_ox=0.0676
XMp_35_4 dp_35_4 WL35 SL4 VSS sky130_fd_pr__nfet_g5v0d10v5 w=1 l=0.5
XRp_35_4 BLP4 dp_35_4 sky130_fd_pr_reram__reram_cell area_ox=0.0676
XMz_35_4 dz_35_4 WL35 SL4 VSS sky130_fd_pr__nfet_g5v0d10v5 w=1 l=0.5
XRz_35_4 BLZ4 dz_35_4 sky130_fd_pr_reram__reram_cell area_ox=0.0676
XMn_35_4 dn_35_4 WL35 SL4 VSS sky130_fd_pr__nfet_g5v0d10v5 w=1 l=0.5
XRn_35_4 BLN4 dn_35_4 sky130_fd_pr_reram__reram_cell area_ox=0.0676
XMp_35_5 dp_35_5 WL35 SL5 VSS sky130_fd_pr__nfet_g5v0d10v5 w=1 l=0.5
XRp_35_5 BLP5 dp_35_5 sky130_fd_pr_reram__reram_cell area_ox=0.0676
XMz_35_5 dz_35_5 WL35 SL5 VSS sky130_fd_pr__nfet_g5v0d10v5 w=1 l=0.5
XRz_35_5 BLZ5 dz_35_5 sky130_fd_pr_reram__reram_cell area_ox=0.0676
XMn_35_5 dn_35_5 WL35 SL5 VSS sky130_fd_pr__nfet_g5v0d10v5 w=1 l=0.5
XRn_35_5 BLN5 dn_35_5 sky130_fd_pr_reram__reram_cell area_ox=0.0676
XMp_35_6 dp_35_6 WL35 SL6 VSS sky130_fd_pr__nfet_g5v0d10v5 w=1 l=0.5
XRp_35_6 BLP6 dp_35_6 sky130_fd_pr_reram__reram_cell area_ox=0.0676
XMz_35_6 dz_35_6 WL35 SL6 VSS sky130_fd_pr__nfet_g5v0d10v5 w=1 l=0.5
XRz_35_6 BLZ6 dz_35_6 sky130_fd_pr_reram__reram_cell area_ox=0.0676
XMn_35_6 dn_35_6 WL35 SL6 VSS sky130_fd_pr__nfet_g5v0d10v5 w=1 l=0.5
XRn_35_6 BLN6 dn_35_6 sky130_fd_pr_reram__reram_cell area_ox=0.0676
XMp_35_7 dp_35_7 WL35 SL7 VSS sky130_fd_pr__nfet_g5v0d10v5 w=1 l=0.5
XRp_35_7 BLP7 dp_35_7 sky130_fd_pr_reram__reram_cell area_ox=0.0676
XMz_35_7 dz_35_7 WL35 SL7 VSS sky130_fd_pr__nfet_g5v0d10v5 w=1 l=0.5
XRz_35_7 BLZ7 dz_35_7 sky130_fd_pr_reram__reram_cell area_ox=0.0676
XMn_35_7 dn_35_7 WL35 SL7 VSS sky130_fd_pr__nfet_g5v0d10v5 w=1 l=0.5
XRn_35_7 BLN7 dn_35_7 sky130_fd_pr_reram__reram_cell area_ox=0.0676
XMp_35_8 dp_35_8 WL35 SL8 VSS sky130_fd_pr__nfet_g5v0d10v5 w=1 l=0.5
XRp_35_8 BLP8 dp_35_8 sky130_fd_pr_reram__reram_cell area_ox=0.0676
XMz_35_8 dz_35_8 WL35 SL8 VSS sky130_fd_pr__nfet_g5v0d10v5 w=1 l=0.5
XRz_35_8 BLZ8 dz_35_8 sky130_fd_pr_reram__reram_cell area_ox=0.0676
XMn_35_8 dn_35_8 WL35 SL8 VSS sky130_fd_pr__nfet_g5v0d10v5 w=1 l=0.5
XRn_35_8 BLN8 dn_35_8 sky130_fd_pr_reram__reram_cell area_ox=0.0676
XMp_35_9 dp_35_9 WL35 SL9 VSS sky130_fd_pr__nfet_g5v0d10v5 w=1 l=0.5
XRp_35_9 BLP9 dp_35_9 sky130_fd_pr_reram__reram_cell area_ox=0.0676
XMz_35_9 dz_35_9 WL35 SL9 VSS sky130_fd_pr__nfet_g5v0d10v5 w=1 l=0.5
XRz_35_9 BLZ9 dz_35_9 sky130_fd_pr_reram__reram_cell area_ox=0.0676
XMn_35_9 dn_35_9 WL35 SL9 VSS sky130_fd_pr__nfet_g5v0d10v5 w=1 l=0.5
XRn_35_9 BLN9 dn_35_9 sky130_fd_pr_reram__reram_cell area_ox=0.0676
XMp_35_10 dp_35_10 WL35 SL10 VSS sky130_fd_pr__nfet_g5v0d10v5 w=1 l=0.5
XRp_35_10 BLP10 dp_35_10 sky130_fd_pr_reram__reram_cell area_ox=0.0676
XMz_35_10 dz_35_10 WL35 SL10 VSS sky130_fd_pr__nfet_g5v0d10v5 w=1 l=0.5
XRz_35_10 BLZ10 dz_35_10 sky130_fd_pr_reram__reram_cell area_ox=0.0676
XMn_35_10 dn_35_10 WL35 SL10 VSS sky130_fd_pr__nfet_g5v0d10v5 w=1 l=0.5
XRn_35_10 BLN10 dn_35_10 sky130_fd_pr_reram__reram_cell area_ox=0.0676
XMp_35_11 dp_35_11 WL35 SL11 VSS sky130_fd_pr__nfet_g5v0d10v5 w=1 l=0.5
XRp_35_11 BLP11 dp_35_11 sky130_fd_pr_reram__reram_cell area_ox=0.0676
XMz_35_11 dz_35_11 WL35 SL11 VSS sky130_fd_pr__nfet_g5v0d10v5 w=1 l=0.5
XRz_35_11 BLZ11 dz_35_11 sky130_fd_pr_reram__reram_cell area_ox=0.0676
XMn_35_11 dn_35_11 WL35 SL11 VSS sky130_fd_pr__nfet_g5v0d10v5 w=1 l=0.5
XRn_35_11 BLN11 dn_35_11 sky130_fd_pr_reram__reram_cell area_ox=0.0676
XMp_35_12 dp_35_12 WL35 SL12 VSS sky130_fd_pr__nfet_g5v0d10v5 w=1 l=0.5
XRp_35_12 BLP12 dp_35_12 sky130_fd_pr_reram__reram_cell area_ox=0.0676
XMz_35_12 dz_35_12 WL35 SL12 VSS sky130_fd_pr__nfet_g5v0d10v5 w=1 l=0.5
XRz_35_12 BLZ12 dz_35_12 sky130_fd_pr_reram__reram_cell area_ox=0.0676
XMn_35_12 dn_35_12 WL35 SL12 VSS sky130_fd_pr__nfet_g5v0d10v5 w=1 l=0.5
XRn_35_12 BLN12 dn_35_12 sky130_fd_pr_reram__reram_cell area_ox=0.0676
XMp_35_13 dp_35_13 WL35 SL13 VSS sky130_fd_pr__nfet_g5v0d10v5 w=1 l=0.5
XRp_35_13 BLP13 dp_35_13 sky130_fd_pr_reram__reram_cell area_ox=0.0676
XMz_35_13 dz_35_13 WL35 SL13 VSS sky130_fd_pr__nfet_g5v0d10v5 w=1 l=0.5
XRz_35_13 BLZ13 dz_35_13 sky130_fd_pr_reram__reram_cell area_ox=0.0676
XMn_35_13 dn_35_13 WL35 SL13 VSS sky130_fd_pr__nfet_g5v0d10v5 w=1 l=0.5
XRn_35_13 BLN13 dn_35_13 sky130_fd_pr_reram__reram_cell area_ox=0.0676
XMp_35_14 dp_35_14 WL35 SL14 VSS sky130_fd_pr__nfet_g5v0d10v5 w=1 l=0.5
XRp_35_14 BLP14 dp_35_14 sky130_fd_pr_reram__reram_cell area_ox=0.0676
XMz_35_14 dz_35_14 WL35 SL14 VSS sky130_fd_pr__nfet_g5v0d10v5 w=1 l=0.5
XRz_35_14 BLZ14 dz_35_14 sky130_fd_pr_reram__reram_cell area_ox=0.0676
XMn_35_14 dn_35_14 WL35 SL14 VSS sky130_fd_pr__nfet_g5v0d10v5 w=1 l=0.5
XRn_35_14 BLN14 dn_35_14 sky130_fd_pr_reram__reram_cell area_ox=0.0676
XMp_35_15 dp_35_15 WL35 SL15 VSS sky130_fd_pr__nfet_g5v0d10v5 w=1 l=0.5
XRp_35_15 BLP15 dp_35_15 sky130_fd_pr_reram__reram_cell area_ox=0.0676
XMz_35_15 dz_35_15 WL35 SL15 VSS sky130_fd_pr__nfet_g5v0d10v5 w=1 l=0.5
XRz_35_15 BLZ15 dz_35_15 sky130_fd_pr_reram__reram_cell area_ox=0.0676
XMn_35_15 dn_35_15 WL35 SL15 VSS sky130_fd_pr__nfet_g5v0d10v5 w=1 l=0.5
XRn_35_15 BLN15 dn_35_15 sky130_fd_pr_reram__reram_cell area_ox=0.0676
XMp_35_16 dp_35_16 WL35 SL16 VSS sky130_fd_pr__nfet_g5v0d10v5 w=1 l=0.5
XRp_35_16 BLP16 dp_35_16 sky130_fd_pr_reram__reram_cell area_ox=0.0676
XMz_35_16 dz_35_16 WL35 SL16 VSS sky130_fd_pr__nfet_g5v0d10v5 w=1 l=0.5
XRz_35_16 BLZ16 dz_35_16 sky130_fd_pr_reram__reram_cell area_ox=0.0676
XMn_35_16 dn_35_16 WL35 SL16 VSS sky130_fd_pr__nfet_g5v0d10v5 w=1 l=0.5
XRn_35_16 BLN16 dn_35_16 sky130_fd_pr_reram__reram_cell area_ox=0.0676
XMp_35_17 dp_35_17 WL35 SL17 VSS sky130_fd_pr__nfet_g5v0d10v5 w=1 l=0.5
XRp_35_17 BLP17 dp_35_17 sky130_fd_pr_reram__reram_cell area_ox=0.0676
XMz_35_17 dz_35_17 WL35 SL17 VSS sky130_fd_pr__nfet_g5v0d10v5 w=1 l=0.5
XRz_35_17 BLZ17 dz_35_17 sky130_fd_pr_reram__reram_cell area_ox=0.0676
XMn_35_17 dn_35_17 WL35 SL17 VSS sky130_fd_pr__nfet_g5v0d10v5 w=1 l=0.5
XRn_35_17 BLN17 dn_35_17 sky130_fd_pr_reram__reram_cell area_ox=0.0676
XMp_35_18 dp_35_18 WL35 SL18 VSS sky130_fd_pr__nfet_g5v0d10v5 w=1 l=0.5
XRp_35_18 BLP18 dp_35_18 sky130_fd_pr_reram__reram_cell area_ox=0.0676
XMz_35_18 dz_35_18 WL35 SL18 VSS sky130_fd_pr__nfet_g5v0d10v5 w=1 l=0.5
XRz_35_18 BLZ18 dz_35_18 sky130_fd_pr_reram__reram_cell area_ox=0.0676
XMn_35_18 dn_35_18 WL35 SL18 VSS sky130_fd_pr__nfet_g5v0d10v5 w=1 l=0.5
XRn_35_18 BLN18 dn_35_18 sky130_fd_pr_reram__reram_cell area_ox=0.0676
XMp_35_19 dp_35_19 WL35 SL19 VSS sky130_fd_pr__nfet_g5v0d10v5 w=1 l=0.5
XRp_35_19 BLP19 dp_35_19 sky130_fd_pr_reram__reram_cell area_ox=0.0676
XMz_35_19 dz_35_19 WL35 SL19 VSS sky130_fd_pr__nfet_g5v0d10v5 w=1 l=0.5
XRz_35_19 BLZ19 dz_35_19 sky130_fd_pr_reram__reram_cell area_ox=0.0676
XMn_35_19 dn_35_19 WL35 SL19 VSS sky130_fd_pr__nfet_g5v0d10v5 w=1 l=0.5
XRn_35_19 BLN19 dn_35_19 sky130_fd_pr_reram__reram_cell area_ox=0.0676
XMp_35_20 dp_35_20 WL35 SL20 VSS sky130_fd_pr__nfet_g5v0d10v5 w=1 l=0.5
XRp_35_20 BLP20 dp_35_20 sky130_fd_pr_reram__reram_cell area_ox=0.0676
XMz_35_20 dz_35_20 WL35 SL20 VSS sky130_fd_pr__nfet_g5v0d10v5 w=1 l=0.5
XRz_35_20 BLZ20 dz_35_20 sky130_fd_pr_reram__reram_cell area_ox=0.0676
XMn_35_20 dn_35_20 WL35 SL20 VSS sky130_fd_pr__nfet_g5v0d10v5 w=1 l=0.5
XRn_35_20 BLN20 dn_35_20 sky130_fd_pr_reram__reram_cell area_ox=0.0676
XMp_35_21 dp_35_21 WL35 SL21 VSS sky130_fd_pr__nfet_g5v0d10v5 w=1 l=0.5
XRp_35_21 BLP21 dp_35_21 sky130_fd_pr_reram__reram_cell area_ox=0.0676
XMz_35_21 dz_35_21 WL35 SL21 VSS sky130_fd_pr__nfet_g5v0d10v5 w=1 l=0.5
XRz_35_21 BLZ21 dz_35_21 sky130_fd_pr_reram__reram_cell area_ox=0.0676
XMn_35_21 dn_35_21 WL35 SL21 VSS sky130_fd_pr__nfet_g5v0d10v5 w=1 l=0.5
XRn_35_21 BLN21 dn_35_21 sky130_fd_pr_reram__reram_cell area_ox=0.0676
XMp_35_22 dp_35_22 WL35 SL22 VSS sky130_fd_pr__nfet_g5v0d10v5 w=1 l=0.5
XRp_35_22 BLP22 dp_35_22 sky130_fd_pr_reram__reram_cell area_ox=0.0676
XMz_35_22 dz_35_22 WL35 SL22 VSS sky130_fd_pr__nfet_g5v0d10v5 w=1 l=0.5
XRz_35_22 BLZ22 dz_35_22 sky130_fd_pr_reram__reram_cell area_ox=0.0676
XMn_35_22 dn_35_22 WL35 SL22 VSS sky130_fd_pr__nfet_g5v0d10v5 w=1 l=0.5
XRn_35_22 BLN22 dn_35_22 sky130_fd_pr_reram__reram_cell area_ox=0.0676
XMp_35_23 dp_35_23 WL35 SL23 VSS sky130_fd_pr__nfet_g5v0d10v5 w=1 l=0.5
XRp_35_23 BLP23 dp_35_23 sky130_fd_pr_reram__reram_cell area_ox=0.0676
XMz_35_23 dz_35_23 WL35 SL23 VSS sky130_fd_pr__nfet_g5v0d10v5 w=1 l=0.5
XRz_35_23 BLZ23 dz_35_23 sky130_fd_pr_reram__reram_cell area_ox=0.0676
XMn_35_23 dn_35_23 WL35 SL23 VSS sky130_fd_pr__nfet_g5v0d10v5 w=1 l=0.5
XRn_35_23 BLN23 dn_35_23 sky130_fd_pr_reram__reram_cell area_ox=0.0676
XMp_36_0 dp_36_0 WL36 SL0 VSS sky130_fd_pr__nfet_g5v0d10v5 w=1 l=0.5
XRp_36_0 BLP0 dp_36_0 sky130_fd_pr_reram__reram_cell area_ox=0.0676
XMz_36_0 dz_36_0 WL36 SL0 VSS sky130_fd_pr__nfet_g5v0d10v5 w=1 l=0.5
XRz_36_0 BLZ0 dz_36_0 sky130_fd_pr_reram__reram_cell area_ox=0.0676
XMn_36_0 dn_36_0 WL36 SL0 VSS sky130_fd_pr__nfet_g5v0d10v5 w=1 l=0.5
XRn_36_0 BLN0 dn_36_0 sky130_fd_pr_reram__reram_cell area_ox=0.0676
XMp_36_1 dp_36_1 WL36 SL1 VSS sky130_fd_pr__nfet_g5v0d10v5 w=1 l=0.5
XRp_36_1 BLP1 dp_36_1 sky130_fd_pr_reram__reram_cell area_ox=0.0676
XMz_36_1 dz_36_1 WL36 SL1 VSS sky130_fd_pr__nfet_g5v0d10v5 w=1 l=0.5
XRz_36_1 BLZ1 dz_36_1 sky130_fd_pr_reram__reram_cell area_ox=0.0676
XMn_36_1 dn_36_1 WL36 SL1 VSS sky130_fd_pr__nfet_g5v0d10v5 w=1 l=0.5
XRn_36_1 BLN1 dn_36_1 sky130_fd_pr_reram__reram_cell area_ox=0.0676
XMp_36_2 dp_36_2 WL36 SL2 VSS sky130_fd_pr__nfet_g5v0d10v5 w=1 l=0.5
XRp_36_2 BLP2 dp_36_2 sky130_fd_pr_reram__reram_cell area_ox=0.0676
XMz_36_2 dz_36_2 WL36 SL2 VSS sky130_fd_pr__nfet_g5v0d10v5 w=1 l=0.5
XRz_36_2 BLZ2 dz_36_2 sky130_fd_pr_reram__reram_cell area_ox=0.0676
XMn_36_2 dn_36_2 WL36 SL2 VSS sky130_fd_pr__nfet_g5v0d10v5 w=1 l=0.5
XRn_36_2 BLN2 dn_36_2 sky130_fd_pr_reram__reram_cell area_ox=0.0676
XMp_36_3 dp_36_3 WL36 SL3 VSS sky130_fd_pr__nfet_g5v0d10v5 w=1 l=0.5
XRp_36_3 BLP3 dp_36_3 sky130_fd_pr_reram__reram_cell area_ox=0.0676
XMz_36_3 dz_36_3 WL36 SL3 VSS sky130_fd_pr__nfet_g5v0d10v5 w=1 l=0.5
XRz_36_3 BLZ3 dz_36_3 sky130_fd_pr_reram__reram_cell area_ox=0.0676
XMn_36_3 dn_36_3 WL36 SL3 VSS sky130_fd_pr__nfet_g5v0d10v5 w=1 l=0.5
XRn_36_3 BLN3 dn_36_3 sky130_fd_pr_reram__reram_cell area_ox=0.0676
XMp_36_4 dp_36_4 WL36 SL4 VSS sky130_fd_pr__nfet_g5v0d10v5 w=1 l=0.5
XRp_36_4 BLP4 dp_36_4 sky130_fd_pr_reram__reram_cell area_ox=0.0676
XMz_36_4 dz_36_4 WL36 SL4 VSS sky130_fd_pr__nfet_g5v0d10v5 w=1 l=0.5
XRz_36_4 BLZ4 dz_36_4 sky130_fd_pr_reram__reram_cell area_ox=0.0676
XMn_36_4 dn_36_4 WL36 SL4 VSS sky130_fd_pr__nfet_g5v0d10v5 w=1 l=0.5
XRn_36_4 BLN4 dn_36_4 sky130_fd_pr_reram__reram_cell area_ox=0.0676
XMp_36_5 dp_36_5 WL36 SL5 VSS sky130_fd_pr__nfet_g5v0d10v5 w=1 l=0.5
XRp_36_5 BLP5 dp_36_5 sky130_fd_pr_reram__reram_cell area_ox=0.0676
XMz_36_5 dz_36_5 WL36 SL5 VSS sky130_fd_pr__nfet_g5v0d10v5 w=1 l=0.5
XRz_36_5 BLZ5 dz_36_5 sky130_fd_pr_reram__reram_cell area_ox=0.0676
XMn_36_5 dn_36_5 WL36 SL5 VSS sky130_fd_pr__nfet_g5v0d10v5 w=1 l=0.5
XRn_36_5 BLN5 dn_36_5 sky130_fd_pr_reram__reram_cell area_ox=0.0676
XMp_36_6 dp_36_6 WL36 SL6 VSS sky130_fd_pr__nfet_g5v0d10v5 w=1 l=0.5
XRp_36_6 BLP6 dp_36_6 sky130_fd_pr_reram__reram_cell area_ox=0.0676
XMz_36_6 dz_36_6 WL36 SL6 VSS sky130_fd_pr__nfet_g5v0d10v5 w=1 l=0.5
XRz_36_6 BLZ6 dz_36_6 sky130_fd_pr_reram__reram_cell area_ox=0.0676
XMn_36_6 dn_36_6 WL36 SL6 VSS sky130_fd_pr__nfet_g5v0d10v5 w=1 l=0.5
XRn_36_6 BLN6 dn_36_6 sky130_fd_pr_reram__reram_cell area_ox=0.0676
XMp_36_7 dp_36_7 WL36 SL7 VSS sky130_fd_pr__nfet_g5v0d10v5 w=1 l=0.5
XRp_36_7 BLP7 dp_36_7 sky130_fd_pr_reram__reram_cell area_ox=0.0676
XMz_36_7 dz_36_7 WL36 SL7 VSS sky130_fd_pr__nfet_g5v0d10v5 w=1 l=0.5
XRz_36_7 BLZ7 dz_36_7 sky130_fd_pr_reram__reram_cell area_ox=0.0676
XMn_36_7 dn_36_7 WL36 SL7 VSS sky130_fd_pr__nfet_g5v0d10v5 w=1 l=0.5
XRn_36_7 BLN7 dn_36_7 sky130_fd_pr_reram__reram_cell area_ox=0.0676
XMp_36_8 dp_36_8 WL36 SL8 VSS sky130_fd_pr__nfet_g5v0d10v5 w=1 l=0.5
XRp_36_8 BLP8 dp_36_8 sky130_fd_pr_reram__reram_cell area_ox=0.0676
XMz_36_8 dz_36_8 WL36 SL8 VSS sky130_fd_pr__nfet_g5v0d10v5 w=1 l=0.5
XRz_36_8 BLZ8 dz_36_8 sky130_fd_pr_reram__reram_cell area_ox=0.0676
XMn_36_8 dn_36_8 WL36 SL8 VSS sky130_fd_pr__nfet_g5v0d10v5 w=1 l=0.5
XRn_36_8 BLN8 dn_36_8 sky130_fd_pr_reram__reram_cell area_ox=0.0676
XMp_36_9 dp_36_9 WL36 SL9 VSS sky130_fd_pr__nfet_g5v0d10v5 w=1 l=0.5
XRp_36_9 BLP9 dp_36_9 sky130_fd_pr_reram__reram_cell area_ox=0.0676
XMz_36_9 dz_36_9 WL36 SL9 VSS sky130_fd_pr__nfet_g5v0d10v5 w=1 l=0.5
XRz_36_9 BLZ9 dz_36_9 sky130_fd_pr_reram__reram_cell area_ox=0.0676
XMn_36_9 dn_36_9 WL36 SL9 VSS sky130_fd_pr__nfet_g5v0d10v5 w=1 l=0.5
XRn_36_9 BLN9 dn_36_9 sky130_fd_pr_reram__reram_cell area_ox=0.0676
XMp_36_10 dp_36_10 WL36 SL10 VSS sky130_fd_pr__nfet_g5v0d10v5 w=1 l=0.5
XRp_36_10 BLP10 dp_36_10 sky130_fd_pr_reram__reram_cell area_ox=0.0676
XMz_36_10 dz_36_10 WL36 SL10 VSS sky130_fd_pr__nfet_g5v0d10v5 w=1 l=0.5
XRz_36_10 BLZ10 dz_36_10 sky130_fd_pr_reram__reram_cell area_ox=0.0676
XMn_36_10 dn_36_10 WL36 SL10 VSS sky130_fd_pr__nfet_g5v0d10v5 w=1 l=0.5
XRn_36_10 BLN10 dn_36_10 sky130_fd_pr_reram__reram_cell area_ox=0.0676
XMp_36_11 dp_36_11 WL36 SL11 VSS sky130_fd_pr__nfet_g5v0d10v5 w=1 l=0.5
XRp_36_11 BLP11 dp_36_11 sky130_fd_pr_reram__reram_cell area_ox=0.0676
XMz_36_11 dz_36_11 WL36 SL11 VSS sky130_fd_pr__nfet_g5v0d10v5 w=1 l=0.5
XRz_36_11 BLZ11 dz_36_11 sky130_fd_pr_reram__reram_cell area_ox=0.0676
XMn_36_11 dn_36_11 WL36 SL11 VSS sky130_fd_pr__nfet_g5v0d10v5 w=1 l=0.5
XRn_36_11 BLN11 dn_36_11 sky130_fd_pr_reram__reram_cell area_ox=0.0676
XMp_36_12 dp_36_12 WL36 SL12 VSS sky130_fd_pr__nfet_g5v0d10v5 w=1 l=0.5
XRp_36_12 BLP12 dp_36_12 sky130_fd_pr_reram__reram_cell area_ox=0.0676
XMz_36_12 dz_36_12 WL36 SL12 VSS sky130_fd_pr__nfet_g5v0d10v5 w=1 l=0.5
XRz_36_12 BLZ12 dz_36_12 sky130_fd_pr_reram__reram_cell area_ox=0.0676
XMn_36_12 dn_36_12 WL36 SL12 VSS sky130_fd_pr__nfet_g5v0d10v5 w=1 l=0.5
XRn_36_12 BLN12 dn_36_12 sky130_fd_pr_reram__reram_cell area_ox=0.0676
XMp_36_13 dp_36_13 WL36 SL13 VSS sky130_fd_pr__nfet_g5v0d10v5 w=1 l=0.5
XRp_36_13 BLP13 dp_36_13 sky130_fd_pr_reram__reram_cell area_ox=0.0676
XMz_36_13 dz_36_13 WL36 SL13 VSS sky130_fd_pr__nfet_g5v0d10v5 w=1 l=0.5
XRz_36_13 BLZ13 dz_36_13 sky130_fd_pr_reram__reram_cell area_ox=0.0676
XMn_36_13 dn_36_13 WL36 SL13 VSS sky130_fd_pr__nfet_g5v0d10v5 w=1 l=0.5
XRn_36_13 BLN13 dn_36_13 sky130_fd_pr_reram__reram_cell area_ox=0.0676
XMp_36_14 dp_36_14 WL36 SL14 VSS sky130_fd_pr__nfet_g5v0d10v5 w=1 l=0.5
XRp_36_14 BLP14 dp_36_14 sky130_fd_pr_reram__reram_cell area_ox=0.0676
XMz_36_14 dz_36_14 WL36 SL14 VSS sky130_fd_pr__nfet_g5v0d10v5 w=1 l=0.5
XRz_36_14 BLZ14 dz_36_14 sky130_fd_pr_reram__reram_cell area_ox=0.0676
XMn_36_14 dn_36_14 WL36 SL14 VSS sky130_fd_pr__nfet_g5v0d10v5 w=1 l=0.5
XRn_36_14 BLN14 dn_36_14 sky130_fd_pr_reram__reram_cell area_ox=0.0676
XMp_36_15 dp_36_15 WL36 SL15 VSS sky130_fd_pr__nfet_g5v0d10v5 w=1 l=0.5
XRp_36_15 BLP15 dp_36_15 sky130_fd_pr_reram__reram_cell area_ox=0.0676
XMz_36_15 dz_36_15 WL36 SL15 VSS sky130_fd_pr__nfet_g5v0d10v5 w=1 l=0.5
XRz_36_15 BLZ15 dz_36_15 sky130_fd_pr_reram__reram_cell area_ox=0.0676
XMn_36_15 dn_36_15 WL36 SL15 VSS sky130_fd_pr__nfet_g5v0d10v5 w=1 l=0.5
XRn_36_15 BLN15 dn_36_15 sky130_fd_pr_reram__reram_cell area_ox=0.0676
XMp_36_16 dp_36_16 WL36 SL16 VSS sky130_fd_pr__nfet_g5v0d10v5 w=1 l=0.5
XRp_36_16 BLP16 dp_36_16 sky130_fd_pr_reram__reram_cell area_ox=0.0676
XMz_36_16 dz_36_16 WL36 SL16 VSS sky130_fd_pr__nfet_g5v0d10v5 w=1 l=0.5
XRz_36_16 BLZ16 dz_36_16 sky130_fd_pr_reram__reram_cell area_ox=0.0676
XMn_36_16 dn_36_16 WL36 SL16 VSS sky130_fd_pr__nfet_g5v0d10v5 w=1 l=0.5
XRn_36_16 BLN16 dn_36_16 sky130_fd_pr_reram__reram_cell area_ox=0.0676
XMp_36_17 dp_36_17 WL36 SL17 VSS sky130_fd_pr__nfet_g5v0d10v5 w=1 l=0.5
XRp_36_17 BLP17 dp_36_17 sky130_fd_pr_reram__reram_cell area_ox=0.0676
XMz_36_17 dz_36_17 WL36 SL17 VSS sky130_fd_pr__nfet_g5v0d10v5 w=1 l=0.5
XRz_36_17 BLZ17 dz_36_17 sky130_fd_pr_reram__reram_cell area_ox=0.0676
XMn_36_17 dn_36_17 WL36 SL17 VSS sky130_fd_pr__nfet_g5v0d10v5 w=1 l=0.5
XRn_36_17 BLN17 dn_36_17 sky130_fd_pr_reram__reram_cell area_ox=0.0676
XMp_36_18 dp_36_18 WL36 SL18 VSS sky130_fd_pr__nfet_g5v0d10v5 w=1 l=0.5
XRp_36_18 BLP18 dp_36_18 sky130_fd_pr_reram__reram_cell area_ox=0.0676
XMz_36_18 dz_36_18 WL36 SL18 VSS sky130_fd_pr__nfet_g5v0d10v5 w=1 l=0.5
XRz_36_18 BLZ18 dz_36_18 sky130_fd_pr_reram__reram_cell area_ox=0.0676
XMn_36_18 dn_36_18 WL36 SL18 VSS sky130_fd_pr__nfet_g5v0d10v5 w=1 l=0.5
XRn_36_18 BLN18 dn_36_18 sky130_fd_pr_reram__reram_cell area_ox=0.0676
XMp_36_19 dp_36_19 WL36 SL19 VSS sky130_fd_pr__nfet_g5v0d10v5 w=1 l=0.5
XRp_36_19 BLP19 dp_36_19 sky130_fd_pr_reram__reram_cell area_ox=0.0676
XMz_36_19 dz_36_19 WL36 SL19 VSS sky130_fd_pr__nfet_g5v0d10v5 w=1 l=0.5
XRz_36_19 BLZ19 dz_36_19 sky130_fd_pr_reram__reram_cell area_ox=0.0676
XMn_36_19 dn_36_19 WL36 SL19 VSS sky130_fd_pr__nfet_g5v0d10v5 w=1 l=0.5
XRn_36_19 BLN19 dn_36_19 sky130_fd_pr_reram__reram_cell area_ox=0.0676
XMp_36_20 dp_36_20 WL36 SL20 VSS sky130_fd_pr__nfet_g5v0d10v5 w=1 l=0.5
XRp_36_20 BLP20 dp_36_20 sky130_fd_pr_reram__reram_cell area_ox=0.0676
XMz_36_20 dz_36_20 WL36 SL20 VSS sky130_fd_pr__nfet_g5v0d10v5 w=1 l=0.5
XRz_36_20 BLZ20 dz_36_20 sky130_fd_pr_reram__reram_cell area_ox=0.0676
XMn_36_20 dn_36_20 WL36 SL20 VSS sky130_fd_pr__nfet_g5v0d10v5 w=1 l=0.5
XRn_36_20 BLN20 dn_36_20 sky130_fd_pr_reram__reram_cell area_ox=0.0676
XMp_36_21 dp_36_21 WL36 SL21 VSS sky130_fd_pr__nfet_g5v0d10v5 w=1 l=0.5
XRp_36_21 BLP21 dp_36_21 sky130_fd_pr_reram__reram_cell area_ox=0.0676
XMz_36_21 dz_36_21 WL36 SL21 VSS sky130_fd_pr__nfet_g5v0d10v5 w=1 l=0.5
XRz_36_21 BLZ21 dz_36_21 sky130_fd_pr_reram__reram_cell area_ox=0.0676
XMn_36_21 dn_36_21 WL36 SL21 VSS sky130_fd_pr__nfet_g5v0d10v5 w=1 l=0.5
XRn_36_21 BLN21 dn_36_21 sky130_fd_pr_reram__reram_cell area_ox=0.0676
XMp_36_22 dp_36_22 WL36 SL22 VSS sky130_fd_pr__nfet_g5v0d10v5 w=1 l=0.5
XRp_36_22 BLP22 dp_36_22 sky130_fd_pr_reram__reram_cell area_ox=0.0676
XMz_36_22 dz_36_22 WL36 SL22 VSS sky130_fd_pr__nfet_g5v0d10v5 w=1 l=0.5
XRz_36_22 BLZ22 dz_36_22 sky130_fd_pr_reram__reram_cell area_ox=0.0676
XMn_36_22 dn_36_22 WL36 SL22 VSS sky130_fd_pr__nfet_g5v0d10v5 w=1 l=0.5
XRn_36_22 BLN22 dn_36_22 sky130_fd_pr_reram__reram_cell area_ox=0.0676
XMp_36_23 dp_36_23 WL36 SL23 VSS sky130_fd_pr__nfet_g5v0d10v5 w=1 l=0.5
XRp_36_23 BLP23 dp_36_23 sky130_fd_pr_reram__reram_cell area_ox=0.0676
XMz_36_23 dz_36_23 WL36 SL23 VSS sky130_fd_pr__nfet_g5v0d10v5 w=1 l=0.5
XRz_36_23 BLZ23 dz_36_23 sky130_fd_pr_reram__reram_cell area_ox=0.0676
XMn_36_23 dn_36_23 WL36 SL23 VSS sky130_fd_pr__nfet_g5v0d10v5 w=1 l=0.5
XRn_36_23 BLN23 dn_36_23 sky130_fd_pr_reram__reram_cell area_ox=0.0676
XMp_37_0 dp_37_0 WL37 SL0 VSS sky130_fd_pr__nfet_g5v0d10v5 w=1 l=0.5
XRp_37_0 BLP0 dp_37_0 sky130_fd_pr_reram__reram_cell area_ox=0.0676
XMz_37_0 dz_37_0 WL37 SL0 VSS sky130_fd_pr__nfet_g5v0d10v5 w=1 l=0.5
XRz_37_0 BLZ0 dz_37_0 sky130_fd_pr_reram__reram_cell area_ox=0.0676
XMn_37_0 dn_37_0 WL37 SL0 VSS sky130_fd_pr__nfet_g5v0d10v5 w=1 l=0.5
XRn_37_0 BLN0 dn_37_0 sky130_fd_pr_reram__reram_cell area_ox=0.0676
XMp_37_1 dp_37_1 WL37 SL1 VSS sky130_fd_pr__nfet_g5v0d10v5 w=1 l=0.5
XRp_37_1 BLP1 dp_37_1 sky130_fd_pr_reram__reram_cell area_ox=0.0676
XMz_37_1 dz_37_1 WL37 SL1 VSS sky130_fd_pr__nfet_g5v0d10v5 w=1 l=0.5
XRz_37_1 BLZ1 dz_37_1 sky130_fd_pr_reram__reram_cell area_ox=0.0676
XMn_37_1 dn_37_1 WL37 SL1 VSS sky130_fd_pr__nfet_g5v0d10v5 w=1 l=0.5
XRn_37_1 BLN1 dn_37_1 sky130_fd_pr_reram__reram_cell area_ox=0.0676
XMp_37_2 dp_37_2 WL37 SL2 VSS sky130_fd_pr__nfet_g5v0d10v5 w=1 l=0.5
XRp_37_2 BLP2 dp_37_2 sky130_fd_pr_reram__reram_cell area_ox=0.0676
XMz_37_2 dz_37_2 WL37 SL2 VSS sky130_fd_pr__nfet_g5v0d10v5 w=1 l=0.5
XRz_37_2 BLZ2 dz_37_2 sky130_fd_pr_reram__reram_cell area_ox=0.0676
XMn_37_2 dn_37_2 WL37 SL2 VSS sky130_fd_pr__nfet_g5v0d10v5 w=1 l=0.5
XRn_37_2 BLN2 dn_37_2 sky130_fd_pr_reram__reram_cell area_ox=0.0676
XMp_37_3 dp_37_3 WL37 SL3 VSS sky130_fd_pr__nfet_g5v0d10v5 w=1 l=0.5
XRp_37_3 BLP3 dp_37_3 sky130_fd_pr_reram__reram_cell area_ox=0.0676
XMz_37_3 dz_37_3 WL37 SL3 VSS sky130_fd_pr__nfet_g5v0d10v5 w=1 l=0.5
XRz_37_3 BLZ3 dz_37_3 sky130_fd_pr_reram__reram_cell area_ox=0.0676
XMn_37_3 dn_37_3 WL37 SL3 VSS sky130_fd_pr__nfet_g5v0d10v5 w=1 l=0.5
XRn_37_3 BLN3 dn_37_3 sky130_fd_pr_reram__reram_cell area_ox=0.0676
XMp_37_4 dp_37_4 WL37 SL4 VSS sky130_fd_pr__nfet_g5v0d10v5 w=1 l=0.5
XRp_37_4 BLP4 dp_37_4 sky130_fd_pr_reram__reram_cell area_ox=0.0676
XMz_37_4 dz_37_4 WL37 SL4 VSS sky130_fd_pr__nfet_g5v0d10v5 w=1 l=0.5
XRz_37_4 BLZ4 dz_37_4 sky130_fd_pr_reram__reram_cell area_ox=0.0676
XMn_37_4 dn_37_4 WL37 SL4 VSS sky130_fd_pr__nfet_g5v0d10v5 w=1 l=0.5
XRn_37_4 BLN4 dn_37_4 sky130_fd_pr_reram__reram_cell area_ox=0.0676
XMp_37_5 dp_37_5 WL37 SL5 VSS sky130_fd_pr__nfet_g5v0d10v5 w=1 l=0.5
XRp_37_5 BLP5 dp_37_5 sky130_fd_pr_reram__reram_cell area_ox=0.0676
XMz_37_5 dz_37_5 WL37 SL5 VSS sky130_fd_pr__nfet_g5v0d10v5 w=1 l=0.5
XRz_37_5 BLN5 dz_37_5 sky130_fd_pr_reram__reram_cell area_ox=0.0676
XMn_37_5 dn_37_5 WL37 SL5 VSS sky130_fd_pr__nfet_g5v0d10v5 w=1 l=0.5
XRn_37_5 BLN5 dn_37_5 sky130_fd_pr_reram__reram_cell area_ox=0.0676
XMp_37_6 dp_37_6 WL37 SL6 VSS sky130_fd_pr__nfet_g5v0d10v5 w=1 l=0.5
XRp_37_6 BLP6 dp_37_6 sky130_fd_pr_reram__reram_cell area_ox=0.0676
XMz_37_6 dz_37_6 WL37 SL6 VSS sky130_fd_pr__nfet_g5v0d10v5 w=1 l=0.5
XRz_37_6 BLZ6 dz_37_6 sky130_fd_pr_reram__reram_cell area_ox=0.0676
XMn_37_6 dn_37_6 WL37 SL6 VSS sky130_fd_pr__nfet_g5v0d10v5 w=1 l=0.5
XRn_37_6 BLN6 dn_37_6 sky130_fd_pr_reram__reram_cell area_ox=0.0676
XMp_37_7 dp_37_7 WL37 SL7 VSS sky130_fd_pr__nfet_g5v0d10v5 w=1 l=0.5
XRp_37_7 BLP7 dp_37_7 sky130_fd_pr_reram__reram_cell area_ox=0.0676
XMz_37_7 dz_37_7 WL37 SL7 VSS sky130_fd_pr__nfet_g5v0d10v5 w=1 l=0.5
XRz_37_7 BLZ7 dz_37_7 sky130_fd_pr_reram__reram_cell area_ox=0.0676
XMn_37_7 dn_37_7 WL37 SL7 VSS sky130_fd_pr__nfet_g5v0d10v5 w=1 l=0.5
XRn_37_7 BLN7 dn_37_7 sky130_fd_pr_reram__reram_cell area_ox=0.0676
XMp_37_8 dp_37_8 WL37 SL8 VSS sky130_fd_pr__nfet_g5v0d10v5 w=1 l=0.5
XRp_37_8 BLP8 dp_37_8 sky130_fd_pr_reram__reram_cell area_ox=0.0676
XMz_37_8 dz_37_8 WL37 SL8 VSS sky130_fd_pr__nfet_g5v0d10v5 w=1 l=0.5
XRz_37_8 BLZ8 dz_37_8 sky130_fd_pr_reram__reram_cell area_ox=0.0676
XMn_37_8 dn_37_8 WL37 SL8 VSS sky130_fd_pr__nfet_g5v0d10v5 w=1 l=0.5
XRn_37_8 BLN8 dn_37_8 sky130_fd_pr_reram__reram_cell area_ox=0.0676
XMp_37_9 dp_37_9 WL37 SL9 VSS sky130_fd_pr__nfet_g5v0d10v5 w=1 l=0.5
XRp_37_9 BLP9 dp_37_9 sky130_fd_pr_reram__reram_cell area_ox=0.0676
XMz_37_9 dz_37_9 WL37 SL9 VSS sky130_fd_pr__nfet_g5v0d10v5 w=1 l=0.5
XRz_37_9 BLZ9 dz_37_9 sky130_fd_pr_reram__reram_cell area_ox=0.0676
XMn_37_9 dn_37_9 WL37 SL9 VSS sky130_fd_pr__nfet_g5v0d10v5 w=1 l=0.5
XRn_37_9 BLN9 dn_37_9 sky130_fd_pr_reram__reram_cell area_ox=0.0676
XMp_37_10 dp_37_10 WL37 SL10 VSS sky130_fd_pr__nfet_g5v0d10v5 w=1 l=0.5
XRp_37_10 BLP10 dp_37_10 sky130_fd_pr_reram__reram_cell area_ox=0.0676
XMz_37_10 dz_37_10 WL37 SL10 VSS sky130_fd_pr__nfet_g5v0d10v5 w=1 l=0.5
XRz_37_10 BLZ10 dz_37_10 sky130_fd_pr_reram__reram_cell area_ox=0.0676
XMn_37_10 dn_37_10 WL37 SL10 VSS sky130_fd_pr__nfet_g5v0d10v5 w=1 l=0.5
XRn_37_10 BLN10 dn_37_10 sky130_fd_pr_reram__reram_cell area_ox=0.0676
XMp_37_11 dp_37_11 WL37 SL11 VSS sky130_fd_pr__nfet_g5v0d10v5 w=1 l=0.5
XRp_37_11 BLP11 dp_37_11 sky130_fd_pr_reram__reram_cell area_ox=0.0676
XMz_37_11 dz_37_11 WL37 SL11 VSS sky130_fd_pr__nfet_g5v0d10v5 w=1 l=0.5
XRz_37_11 BLZ11 dz_37_11 sky130_fd_pr_reram__reram_cell area_ox=0.0676
XMn_37_11 dn_37_11 WL37 SL11 VSS sky130_fd_pr__nfet_g5v0d10v5 w=1 l=0.5
XRn_37_11 BLN11 dn_37_11 sky130_fd_pr_reram__reram_cell area_ox=0.0676
XMp_37_12 dp_37_12 WL37 SL12 VSS sky130_fd_pr__nfet_g5v0d10v5 w=1 l=0.5
XRp_37_12 BLP12 dp_37_12 sky130_fd_pr_reram__reram_cell area_ox=0.0676
XMz_37_12 dz_37_12 WL37 SL12 VSS sky130_fd_pr__nfet_g5v0d10v5 w=1 l=0.5
XRz_37_12 BLZ12 dz_37_12 sky130_fd_pr_reram__reram_cell area_ox=0.0676
XMn_37_12 dn_37_12 WL37 SL12 VSS sky130_fd_pr__nfet_g5v0d10v5 w=1 l=0.5
XRn_37_12 BLN12 dn_37_12 sky130_fd_pr_reram__reram_cell area_ox=0.0676
XMp_37_13 dp_37_13 WL37 SL13 VSS sky130_fd_pr__nfet_g5v0d10v5 w=1 l=0.5
XRp_37_13 BLP13 dp_37_13 sky130_fd_pr_reram__reram_cell area_ox=0.0676
XMz_37_13 dz_37_13 WL37 SL13 VSS sky130_fd_pr__nfet_g5v0d10v5 w=1 l=0.5
XRz_37_13 BLZ13 dz_37_13 sky130_fd_pr_reram__reram_cell area_ox=0.0676
XMn_37_13 dn_37_13 WL37 SL13 VSS sky130_fd_pr__nfet_g5v0d10v5 w=1 l=0.5
XRn_37_13 BLN13 dn_37_13 sky130_fd_pr_reram__reram_cell area_ox=0.0676
XMp_37_14 dp_37_14 WL37 SL14 VSS sky130_fd_pr__nfet_g5v0d10v5 w=1 l=0.5
XRp_37_14 BLP14 dp_37_14 sky130_fd_pr_reram__reram_cell area_ox=0.0676
XMz_37_14 dz_37_14 WL37 SL14 VSS sky130_fd_pr__nfet_g5v0d10v5 w=1 l=0.5
XRz_37_14 BLZ14 dz_37_14 sky130_fd_pr_reram__reram_cell area_ox=0.0676
XMn_37_14 dn_37_14 WL37 SL14 VSS sky130_fd_pr__nfet_g5v0d10v5 w=1 l=0.5
XRn_37_14 BLN14 dn_37_14 sky130_fd_pr_reram__reram_cell area_ox=0.0676
XMp_37_15 dp_37_15 WL37 SL15 VSS sky130_fd_pr__nfet_g5v0d10v5 w=1 l=0.5
XRp_37_15 BLP15 dp_37_15 sky130_fd_pr_reram__reram_cell area_ox=0.0676
XMz_37_15 dz_37_15 WL37 SL15 VSS sky130_fd_pr__nfet_g5v0d10v5 w=1 l=0.5
XRz_37_15 BLZ15 dz_37_15 sky130_fd_pr_reram__reram_cell area_ox=0.0676
XMn_37_15 dn_37_15 WL37 SL15 VSS sky130_fd_pr__nfet_g5v0d10v5 w=1 l=0.5
XRn_37_15 BLN15 dn_37_15 sky130_fd_pr_reram__reram_cell area_ox=0.0676
XMp_37_16 dp_37_16 WL37 SL16 VSS sky130_fd_pr__nfet_g5v0d10v5 w=1 l=0.5
XRp_37_16 BLP16 dp_37_16 sky130_fd_pr_reram__reram_cell area_ox=0.0676
XMz_37_16 dz_37_16 WL37 SL16 VSS sky130_fd_pr__nfet_g5v0d10v5 w=1 l=0.5
XRz_37_16 BLZ16 dz_37_16 sky130_fd_pr_reram__reram_cell area_ox=0.0676
XMn_37_16 dn_37_16 WL37 SL16 VSS sky130_fd_pr__nfet_g5v0d10v5 w=1 l=0.5
XRn_37_16 BLN16 dn_37_16 sky130_fd_pr_reram__reram_cell area_ox=0.0676
XMp_37_17 dp_37_17 WL37 SL17 VSS sky130_fd_pr__nfet_g5v0d10v5 w=1 l=0.5
XRp_37_17 BLP17 dp_37_17 sky130_fd_pr_reram__reram_cell area_ox=0.0676
XMz_37_17 dz_37_17 WL37 SL17 VSS sky130_fd_pr__nfet_g5v0d10v5 w=1 l=0.5
XRz_37_17 BLZ17 dz_37_17 sky130_fd_pr_reram__reram_cell area_ox=0.0676
XMn_37_17 dn_37_17 WL37 SL17 VSS sky130_fd_pr__nfet_g5v0d10v5 w=1 l=0.5
XRn_37_17 BLN17 dn_37_17 sky130_fd_pr_reram__reram_cell area_ox=0.0676
XMp_37_18 dp_37_18 WL37 SL18 VSS sky130_fd_pr__nfet_g5v0d10v5 w=1 l=0.5
XRp_37_18 BLP18 dp_37_18 sky130_fd_pr_reram__reram_cell area_ox=0.0676
XMz_37_18 dz_37_18 WL37 SL18 VSS sky130_fd_pr__nfet_g5v0d10v5 w=1 l=0.5
XRz_37_18 BLZ18 dz_37_18 sky130_fd_pr_reram__reram_cell area_ox=0.0676
XMn_37_18 dn_37_18 WL37 SL18 VSS sky130_fd_pr__nfet_g5v0d10v5 w=1 l=0.5
XRn_37_18 BLN18 dn_37_18 sky130_fd_pr_reram__reram_cell area_ox=0.0676
XMp_37_19 dp_37_19 WL37 SL19 VSS sky130_fd_pr__nfet_g5v0d10v5 w=1 l=0.5
XRp_37_19 BLP19 dp_37_19 sky130_fd_pr_reram__reram_cell area_ox=0.0676
XMz_37_19 dz_37_19 WL37 SL19 VSS sky130_fd_pr__nfet_g5v0d10v5 w=1 l=0.5
XRz_37_19 BLZ19 dz_37_19 sky130_fd_pr_reram__reram_cell area_ox=0.0676
XMn_37_19 dn_37_19 WL37 SL19 VSS sky130_fd_pr__nfet_g5v0d10v5 w=1 l=0.5
XRn_37_19 BLN19 dn_37_19 sky130_fd_pr_reram__reram_cell area_ox=0.0676
XMp_37_20 dp_37_20 WL37 SL20 VSS sky130_fd_pr__nfet_g5v0d10v5 w=1 l=0.5
XRp_37_20 BLP20 dp_37_20 sky130_fd_pr_reram__reram_cell area_ox=0.0676
XMz_37_20 dz_37_20 WL37 SL20 VSS sky130_fd_pr__nfet_g5v0d10v5 w=1 l=0.5
XRz_37_20 BLZ20 dz_37_20 sky130_fd_pr_reram__reram_cell area_ox=0.0676
XMn_37_20 dn_37_20 WL37 SL20 VSS sky130_fd_pr__nfet_g5v0d10v5 w=1 l=0.5
XRn_37_20 BLN20 dn_37_20 sky130_fd_pr_reram__reram_cell area_ox=0.0676
XMp_37_21 dp_37_21 WL37 SL21 VSS sky130_fd_pr__nfet_g5v0d10v5 w=1 l=0.5
XRp_37_21 BLP21 dp_37_21 sky130_fd_pr_reram__reram_cell area_ox=0.0676
XMz_37_21 dz_37_21 WL37 SL21 VSS sky130_fd_pr__nfet_g5v0d10v5 w=1 l=0.5
XRz_37_21 BLZ21 dz_37_21 sky130_fd_pr_reram__reram_cell area_ox=0.0676
XMn_37_21 dn_37_21 WL37 SL21 VSS sky130_fd_pr__nfet_g5v0d10v5 w=1 l=0.5
XRn_37_21 BLN21 dn_37_21 sky130_fd_pr_reram__reram_cell area_ox=0.0676
XMp_37_22 dp_37_22 WL37 SL22 VSS sky130_fd_pr__nfet_g5v0d10v5 w=1 l=0.5
XRp_37_22 BLP22 dp_37_22 sky130_fd_pr_reram__reram_cell area_ox=0.0676
XMz_37_22 dz_37_22 WL37 SL22 VSS sky130_fd_pr__nfet_g5v0d10v5 w=1 l=0.5
XRz_37_22 BLZ22 dz_37_22 sky130_fd_pr_reram__reram_cell area_ox=0.0676
XMn_37_22 dn_37_22 WL37 SL22 VSS sky130_fd_pr__nfet_g5v0d10v5 w=1 l=0.5
XRn_37_22 BLN22 dn_37_22 sky130_fd_pr_reram__reram_cell area_ox=0.0676
XMp_37_23 dp_37_23 WL37 SL23 VSS sky130_fd_pr__nfet_g5v0d10v5 w=1 l=0.5
XRp_37_23 BLP23 dp_37_23 sky130_fd_pr_reram__reram_cell area_ox=0.0676
XMz_37_23 dz_37_23 WL37 SL23 VSS sky130_fd_pr__nfet_g5v0d10v5 w=1 l=0.5
XRz_37_23 BLZ23 dz_37_23 sky130_fd_pr_reram__reram_cell area_ox=0.0676
XMn_37_23 dn_37_23 WL37 SL23 VSS sky130_fd_pr__nfet_g5v0d10v5 w=1 l=0.5
XRn_37_23 BLN23 dn_37_23 sky130_fd_pr_reram__reram_cell area_ox=0.0676
XMp_38_0 dp_38_0 WL38 SL0 VSS sky130_fd_pr__nfet_g5v0d10v5 w=1 l=0.5
XRp_38_0 BLP0 dp_38_0 sky130_fd_pr_reram__reram_cell area_ox=0.0676
XMz_38_0 dz_38_0 WL38 SL0 VSS sky130_fd_pr__nfet_g5v0d10v5 w=1 l=0.5
XRz_38_0 BLZ0 dz_38_0 sky130_fd_pr_reram__reram_cell area_ox=0.0676
XMn_38_0 dn_38_0 WL38 SL0 VSS sky130_fd_pr__nfet_g5v0d10v5 w=1 l=0.5
XRn_38_0 BLN0 dn_38_0 sky130_fd_pr_reram__reram_cell area_ox=0.0676
XMp_38_1 dp_38_1 WL38 SL1 VSS sky130_fd_pr__nfet_g5v0d10v5 w=1 l=0.5
XRp_38_1 BLP1 dp_38_1 sky130_fd_pr_reram__reram_cell area_ox=0.0676
XMz_38_1 dz_38_1 WL38 SL1 VSS sky130_fd_pr__nfet_g5v0d10v5 w=1 l=0.5
XRz_38_1 BLZ1 dz_38_1 sky130_fd_pr_reram__reram_cell area_ox=0.0676
XMn_38_1 dn_38_1 WL38 SL1 VSS sky130_fd_pr__nfet_g5v0d10v5 w=1 l=0.5
XRn_38_1 BLN1 dn_38_1 sky130_fd_pr_reram__reram_cell area_ox=0.0676
XMp_38_2 dp_38_2 WL38 SL2 VSS sky130_fd_pr__nfet_g5v0d10v5 w=1 l=0.5
XRp_38_2 BLP2 dp_38_2 sky130_fd_pr_reram__reram_cell area_ox=0.0676
XMz_38_2 dz_38_2 WL38 SL2 VSS sky130_fd_pr__nfet_g5v0d10v5 w=1 l=0.5
XRz_38_2 BLZ2 dz_38_2 sky130_fd_pr_reram__reram_cell area_ox=0.0676
XMn_38_2 dn_38_2 WL38 SL2 VSS sky130_fd_pr__nfet_g5v0d10v5 w=1 l=0.5
XRn_38_2 BLN2 dn_38_2 sky130_fd_pr_reram__reram_cell area_ox=0.0676
XMp_38_3 dp_38_3 WL38 SL3 VSS sky130_fd_pr__nfet_g5v0d10v5 w=1 l=0.5
XRp_38_3 BLP3 dp_38_3 sky130_fd_pr_reram__reram_cell area_ox=0.0676
XMz_38_3 dz_38_3 WL38 SL3 VSS sky130_fd_pr__nfet_g5v0d10v5 w=1 l=0.5
XRz_38_3 BLZ3 dz_38_3 sky130_fd_pr_reram__reram_cell area_ox=0.0676
XMn_38_3 dn_38_3 WL38 SL3 VSS sky130_fd_pr__nfet_g5v0d10v5 w=1 l=0.5
XRn_38_3 BLN3 dn_38_3 sky130_fd_pr_reram__reram_cell area_ox=0.0676
XMp_38_4 dp_38_4 WL38 SL4 VSS sky130_fd_pr__nfet_g5v0d10v5 w=1 l=0.5
XRp_38_4 BLP4 dp_38_4 sky130_fd_pr_reram__reram_cell area_ox=0.0676
XMz_38_4 dz_38_4 WL38 SL4 VSS sky130_fd_pr__nfet_g5v0d10v5 w=1 l=0.5
XRz_38_4 BLZ4 dz_38_4 sky130_fd_pr_reram__reram_cell area_ox=0.0676
XMn_38_4 dn_38_4 WL38 SL4 VSS sky130_fd_pr__nfet_g5v0d10v5 w=1 l=0.5
XRn_38_4 BLN4 dn_38_4 sky130_fd_pr_reram__reram_cell area_ox=0.0676
XMp_38_5 dp_38_5 WL38 SL5 VSS sky130_fd_pr__nfet_g5v0d10v5 w=1 l=0.5
XRp_38_5 BLP5 dp_38_5 sky130_fd_pr_reram__reram_cell area_ox=0.0676
XMz_38_5 dz_38_5 WL38 SL5 VSS sky130_fd_pr__nfet_g5v0d10v5 w=1 l=0.5
XRz_38_5 BLZ5 dz_38_5 sky130_fd_pr_reram__reram_cell area_ox=0.0676
XMn_38_5 dn_38_5 WL38 SL5 VSS sky130_fd_pr__nfet_g5v0d10v5 w=1 l=0.5
XRn_38_5 BLN5 dn_38_5 sky130_fd_pr_reram__reram_cell area_ox=0.0676
XMp_38_6 dp_38_6 WL38 SL6 VSS sky130_fd_pr__nfet_g5v0d10v5 w=1 l=0.5
XRp_38_6 BLP6 dp_38_6 sky130_fd_pr_reram__reram_cell area_ox=0.0676
XMz_38_6 dz_38_6 WL38 SL6 VSS sky130_fd_pr__nfet_g5v0d10v5 w=1 l=0.5
XRz_38_6 BLZ6 dz_38_6 sky130_fd_pr_reram__reram_cell area_ox=0.0676
XMn_38_6 dn_38_6 WL38 SL6 VSS sky130_fd_pr__nfet_g5v0d10v5 w=1 l=0.5
XRn_38_6 BLN6 dn_38_6 sky130_fd_pr_reram__reram_cell area_ox=0.0676
XMp_38_7 dp_38_7 WL38 SL7 VSS sky130_fd_pr__nfet_g5v0d10v5 w=1 l=0.5
XRp_38_7 BLP7 dp_38_7 sky130_fd_pr_reram__reram_cell area_ox=0.0676
XMz_38_7 dz_38_7 WL38 SL7 VSS sky130_fd_pr__nfet_g5v0d10v5 w=1 l=0.5
XRz_38_7 BLZ7 dz_38_7 sky130_fd_pr_reram__reram_cell area_ox=0.0676
XMn_38_7 dn_38_7 WL38 SL7 VSS sky130_fd_pr__nfet_g5v0d10v5 w=1 l=0.5
XRn_38_7 BLN7 dn_38_7 sky130_fd_pr_reram__reram_cell area_ox=0.0676
XMp_38_8 dp_38_8 WL38 SL8 VSS sky130_fd_pr__nfet_g5v0d10v5 w=1 l=0.5
XRp_38_8 BLP8 dp_38_8 sky130_fd_pr_reram__reram_cell area_ox=0.0676
XMz_38_8 dz_38_8 WL38 SL8 VSS sky130_fd_pr__nfet_g5v0d10v5 w=1 l=0.5
XRz_38_8 BLZ8 dz_38_8 sky130_fd_pr_reram__reram_cell area_ox=0.0676
XMn_38_8 dn_38_8 WL38 SL8 VSS sky130_fd_pr__nfet_g5v0d10v5 w=1 l=0.5
XRn_38_8 BLN8 dn_38_8 sky130_fd_pr_reram__reram_cell area_ox=0.0676
XMp_38_9 dp_38_9 WL38 SL9 VSS sky130_fd_pr__nfet_g5v0d10v5 w=1 l=0.5
XRp_38_9 BLP9 dp_38_9 sky130_fd_pr_reram__reram_cell area_ox=0.0676
XMz_38_9 dz_38_9 WL38 SL9 VSS sky130_fd_pr__nfet_g5v0d10v5 w=1 l=0.5
XRz_38_9 BLZ9 dz_38_9 sky130_fd_pr_reram__reram_cell area_ox=0.0676
XMn_38_9 dn_38_9 WL38 SL9 VSS sky130_fd_pr__nfet_g5v0d10v5 w=1 l=0.5
XRn_38_9 BLN9 dn_38_9 sky130_fd_pr_reram__reram_cell area_ox=0.0676
XMp_38_10 dp_38_10 WL38 SL10 VSS sky130_fd_pr__nfet_g5v0d10v5 w=1 l=0.5
XRp_38_10 BLP10 dp_38_10 sky130_fd_pr_reram__reram_cell area_ox=0.0676
XMz_38_10 dz_38_10 WL38 SL10 VSS sky130_fd_pr__nfet_g5v0d10v5 w=1 l=0.5
XRz_38_10 BLZ10 dz_38_10 sky130_fd_pr_reram__reram_cell area_ox=0.0676
XMn_38_10 dn_38_10 WL38 SL10 VSS sky130_fd_pr__nfet_g5v0d10v5 w=1 l=0.5
XRn_38_10 BLN10 dn_38_10 sky130_fd_pr_reram__reram_cell area_ox=0.0676
XMp_38_11 dp_38_11 WL38 SL11 VSS sky130_fd_pr__nfet_g5v0d10v5 w=1 l=0.5
XRp_38_11 BLP11 dp_38_11 sky130_fd_pr_reram__reram_cell area_ox=0.0676
XMz_38_11 dz_38_11 WL38 SL11 VSS sky130_fd_pr__nfet_g5v0d10v5 w=1 l=0.5
XRz_38_11 BLZ11 dz_38_11 sky130_fd_pr_reram__reram_cell area_ox=0.0676
XMn_38_11 dn_38_11 WL38 SL11 VSS sky130_fd_pr__nfet_g5v0d10v5 w=1 l=0.5
XRn_38_11 BLN11 dn_38_11 sky130_fd_pr_reram__reram_cell area_ox=0.0676
XMp_38_12 dp_38_12 WL38 SL12 VSS sky130_fd_pr__nfet_g5v0d10v5 w=1 l=0.5
XRp_38_12 BLP12 dp_38_12 sky130_fd_pr_reram__reram_cell area_ox=0.0676
XMz_38_12 dz_38_12 WL38 SL12 VSS sky130_fd_pr__nfet_g5v0d10v5 w=1 l=0.5
XRz_38_12 BLZ12 dz_38_12 sky130_fd_pr_reram__reram_cell area_ox=0.0676
XMn_38_12 dn_38_12 WL38 SL12 VSS sky130_fd_pr__nfet_g5v0d10v5 w=1 l=0.5
XRn_38_12 BLN12 dn_38_12 sky130_fd_pr_reram__reram_cell area_ox=0.0676
XMp_38_13 dp_38_13 WL38 SL13 VSS sky130_fd_pr__nfet_g5v0d10v5 w=1 l=0.5
XRp_38_13 BLP13 dp_38_13 sky130_fd_pr_reram__reram_cell area_ox=0.0676
XMz_38_13 dz_38_13 WL38 SL13 VSS sky130_fd_pr__nfet_g5v0d10v5 w=1 l=0.5
XRz_38_13 BLZ13 dz_38_13 sky130_fd_pr_reram__reram_cell area_ox=0.0676
XMn_38_13 dn_38_13 WL38 SL13 VSS sky130_fd_pr__nfet_g5v0d10v5 w=1 l=0.5
XRn_38_13 BLN13 dn_38_13 sky130_fd_pr_reram__reram_cell area_ox=0.0676
XMp_38_14 dp_38_14 WL38 SL14 VSS sky130_fd_pr__nfet_g5v0d10v5 w=1 l=0.5
XRp_38_14 BLP14 dp_38_14 sky130_fd_pr_reram__reram_cell area_ox=0.0676
XMz_38_14 dz_38_14 WL38 SL14 VSS sky130_fd_pr__nfet_g5v0d10v5 w=1 l=0.5
XRz_38_14 BLZ14 dz_38_14 sky130_fd_pr_reram__reram_cell area_ox=0.0676
XMn_38_14 dn_38_14 WL38 SL14 VSS sky130_fd_pr__nfet_g5v0d10v5 w=1 l=0.5
XRn_38_14 BLN14 dn_38_14 sky130_fd_pr_reram__reram_cell area_ox=0.0676
XMp_38_15 dp_38_15 WL38 SL15 VSS sky130_fd_pr__nfet_g5v0d10v5 w=1 l=0.5
XRp_38_15 BLP15 dp_38_15 sky130_fd_pr_reram__reram_cell area_ox=0.0676
XMz_38_15 dz_38_15 WL38 SL15 VSS sky130_fd_pr__nfet_g5v0d10v5 w=1 l=0.5
XRz_38_15 BLZ15 dz_38_15 sky130_fd_pr_reram__reram_cell area_ox=0.0676
XMn_38_15 dn_38_15 WL38 SL15 VSS sky130_fd_pr__nfet_g5v0d10v5 w=1 l=0.5
XRn_38_15 BLN15 dn_38_15 sky130_fd_pr_reram__reram_cell area_ox=0.0676
XMp_38_16 dp_38_16 WL38 SL16 VSS sky130_fd_pr__nfet_g5v0d10v5 w=1 l=0.5
XRp_38_16 BLP16 dp_38_16 sky130_fd_pr_reram__reram_cell area_ox=0.0676
XMz_38_16 dz_38_16 WL38 SL16 VSS sky130_fd_pr__nfet_g5v0d10v5 w=1 l=0.5
XRz_38_16 BLZ16 dz_38_16 sky130_fd_pr_reram__reram_cell area_ox=0.0676
XMn_38_16 dn_38_16 WL38 SL16 VSS sky130_fd_pr__nfet_g5v0d10v5 w=1 l=0.5
XRn_38_16 BLN16 dn_38_16 sky130_fd_pr_reram__reram_cell area_ox=0.0676
XMp_38_17 dp_38_17 WL38 SL17 VSS sky130_fd_pr__nfet_g5v0d10v5 w=1 l=0.5
XRp_38_17 BLP17 dp_38_17 sky130_fd_pr_reram__reram_cell area_ox=0.0676
XMz_38_17 dz_38_17 WL38 SL17 VSS sky130_fd_pr__nfet_g5v0d10v5 w=1 l=0.5
XRz_38_17 BLZ17 dz_38_17 sky130_fd_pr_reram__reram_cell area_ox=0.0676
XMn_38_17 dn_38_17 WL38 SL17 VSS sky130_fd_pr__nfet_g5v0d10v5 w=1 l=0.5
XRn_38_17 BLN17 dn_38_17 sky130_fd_pr_reram__reram_cell area_ox=0.0676
XMp_38_18 dp_38_18 WL38 SL18 VSS sky130_fd_pr__nfet_g5v0d10v5 w=1 l=0.5
XRp_38_18 BLP18 dp_38_18 sky130_fd_pr_reram__reram_cell area_ox=0.0676
XMz_38_18 dz_38_18 WL38 SL18 VSS sky130_fd_pr__nfet_g5v0d10v5 w=1 l=0.5
XRz_38_18 BLZ18 dz_38_18 sky130_fd_pr_reram__reram_cell area_ox=0.0676
XMn_38_18 dn_38_18 WL38 SL18 VSS sky130_fd_pr__nfet_g5v0d10v5 w=1 l=0.5
XRn_38_18 BLN18 dn_38_18 sky130_fd_pr_reram__reram_cell area_ox=0.0676
XMp_38_19 dp_38_19 WL38 SL19 VSS sky130_fd_pr__nfet_g5v0d10v5 w=1 l=0.5
XRp_38_19 BLP19 dp_38_19 sky130_fd_pr_reram__reram_cell area_ox=0.0676
XMz_38_19 dz_38_19 WL38 SL19 VSS sky130_fd_pr__nfet_g5v0d10v5 w=1 l=0.5
XRz_38_19 BLZ19 dz_38_19 sky130_fd_pr_reram__reram_cell area_ox=0.0676
XMn_38_19 dn_38_19 WL38 SL19 VSS sky130_fd_pr__nfet_g5v0d10v5 w=1 l=0.5
XRn_38_19 BLN19 dn_38_19 sky130_fd_pr_reram__reram_cell area_ox=0.0676
XMp_38_20 dp_38_20 WL38 SL20 VSS sky130_fd_pr__nfet_g5v0d10v5 w=1 l=0.5
XRp_38_20 BLP20 dp_38_20 sky130_fd_pr_reram__reram_cell area_ox=0.0676
XMz_38_20 dz_38_20 WL38 SL20 VSS sky130_fd_pr__nfet_g5v0d10v5 w=1 l=0.5
XRz_38_20 BLZ20 dz_38_20 sky130_fd_pr_reram__reram_cell area_ox=0.0676
XMn_38_20 dn_38_20 WL38 SL20 VSS sky130_fd_pr__nfet_g5v0d10v5 w=1 l=0.5
XRn_38_20 BLN20 dn_38_20 sky130_fd_pr_reram__reram_cell area_ox=0.0676
XMp_38_21 dp_38_21 WL38 SL21 VSS sky130_fd_pr__nfet_g5v0d10v5 w=1 l=0.5
XRp_38_21 BLP21 dp_38_21 sky130_fd_pr_reram__reram_cell area_ox=0.0676
XMz_38_21 dz_38_21 WL38 SL21 VSS sky130_fd_pr__nfet_g5v0d10v5 w=1 l=0.5
XRz_38_21 BLZ21 dz_38_21 sky130_fd_pr_reram__reram_cell area_ox=0.0676
XMn_38_21 dn_38_21 WL38 SL21 VSS sky130_fd_pr__nfet_g5v0d10v5 w=1 l=0.5
XRn_38_21 BLN21 dn_38_21 sky130_fd_pr_reram__reram_cell area_ox=0.0676
XMp_38_22 dp_38_22 WL38 SL22 VSS sky130_fd_pr__nfet_g5v0d10v5 w=1 l=0.5
XRp_38_22 BLP22 dp_38_22 sky130_fd_pr_reram__reram_cell area_ox=0.0676
XMz_38_22 dz_38_22 WL38 SL22 VSS sky130_fd_pr__nfet_g5v0d10v5 w=1 l=0.5
XRz_38_22 BLZ22 dz_38_22 sky130_fd_pr_reram__reram_cell area_ox=0.0676
XMn_38_22 dn_38_22 WL38 SL22 VSS sky130_fd_pr__nfet_g5v0d10v5 w=1 l=0.5
XRn_38_22 BLN22 dn_38_22 sky130_fd_pr_reram__reram_cell area_ox=0.0676
XMp_38_23 dp_38_23 WL38 SL23 VSS sky130_fd_pr__nfet_g5v0d10v5 w=1 l=0.5
XRp_38_23 BLP23 dp_38_23 sky130_fd_pr_reram__reram_cell area_ox=0.0676
XMz_38_23 dz_38_23 WL38 SL23 VSS sky130_fd_pr__nfet_g5v0d10v5 w=1 l=0.5
XRz_38_23 BLZ23 dz_38_23 sky130_fd_pr_reram__reram_cell area_ox=0.0676
XMn_38_23 dn_38_23 WL38 SL23 VSS sky130_fd_pr__nfet_g5v0d10v5 w=1 l=0.5
XRn_38_23 BLN23 dn_38_23 sky130_fd_pr_reram__reram_cell area_ox=0.0676
XMp_39_0 dp_39_0 WL39 SL0 VSS sky130_fd_pr__nfet_g5v0d10v5 w=1 l=0.5
XRp_39_0 BLP0 dp_39_0 sky130_fd_pr_reram__reram_cell area_ox=0.0676
XMz_39_0 dz_39_0 WL39 SL0 VSS sky130_fd_pr__nfet_g5v0d10v5 w=1 l=0.5
XRz_39_0 BLZ0 dz_39_0 sky130_fd_pr_reram__reram_cell area_ox=0.0676
XMn_39_0 dn_39_0 WL39 SL0 VSS sky130_fd_pr__nfet_g5v0d10v5 w=1 l=0.5
XRn_39_0 BLN0 dn_39_0 sky130_fd_pr_reram__reram_cell area_ox=0.0676
XMp_39_1 dp_39_1 WL39 SL1 VSS sky130_fd_pr__nfet_g5v0d10v5 w=1 l=0.5
XRp_39_1 BLP1 dp_39_1 sky130_fd_pr_reram__reram_cell area_ox=0.0676
XMz_39_1 dz_39_1 WL39 SL1 VSS sky130_fd_pr__nfet_g5v0d10v5 w=1 l=0.5
XRz_39_1 BLZ1 dz_39_1 sky130_fd_pr_reram__reram_cell area_ox=0.0676
XMn_39_1 dn_39_1 WL39 SL1 VSS sky130_fd_pr__nfet_g5v0d10v5 w=1 l=0.5
XRn_39_1 BLN1 dn_39_1 sky130_fd_pr_reram__reram_cell area_ox=0.0676
XMp_39_2 dp_39_2 WL39 SL2 VSS sky130_fd_pr__nfet_g5v0d10v5 w=1 l=0.5
XRp_39_2 BLP2 dp_39_2 sky130_fd_pr_reram__reram_cell area_ox=0.0676
XMz_39_2 dz_39_2 WL39 SL2 VSS sky130_fd_pr__nfet_g5v0d10v5 w=1 l=0.5
XRz_39_2 BLZ2 dz_39_2 sky130_fd_pr_reram__reram_cell area_ox=0.0676
XMn_39_2 dn_39_2 WL39 SL2 VSS sky130_fd_pr__nfet_g5v0d10v5 w=1 l=0.5
XRn_39_2 BLN2 dn_39_2 sky130_fd_pr_reram__reram_cell area_ox=0.0676
XMp_39_3 dp_39_3 WL39 SL3 VSS sky130_fd_pr__nfet_g5v0d10v5 w=1 l=0.5
XRp_39_3 BLP3 dp_39_3 sky130_fd_pr_reram__reram_cell area_ox=0.0676
XMz_39_3 dz_39_3 WL39 SL3 VSS sky130_fd_pr__nfet_g5v0d10v5 w=1 l=0.5
XRz_39_3 BLZ3 dz_39_3 sky130_fd_pr_reram__reram_cell area_ox=0.0676
XMn_39_3 dn_39_3 WL39 SL3 VSS sky130_fd_pr__nfet_g5v0d10v5 w=1 l=0.5
XRn_39_3 BLN3 dn_39_3 sky130_fd_pr_reram__reram_cell area_ox=0.0676
XMp_39_4 dp_39_4 WL39 SL4 VSS sky130_fd_pr__nfet_g5v0d10v5 w=1 l=0.5
XRp_39_4 BLP4 dp_39_4 sky130_fd_pr_reram__reram_cell area_ox=0.0676
XMz_39_4 dz_39_4 WL39 SL4 VSS sky130_fd_pr__nfet_g5v0d10v5 w=1 l=0.5
XRz_39_4 BLZ4 dz_39_4 sky130_fd_pr_reram__reram_cell area_ox=0.0676
XMn_39_4 dn_39_4 WL39 SL4 VSS sky130_fd_pr__nfet_g5v0d10v5 w=1 l=0.5
XRn_39_4 BLN4 dn_39_4 sky130_fd_pr_reram__reram_cell area_ox=0.0676
XMp_39_5 dp_39_5 WL39 SL5 VSS sky130_fd_pr__nfet_g5v0d10v5 w=1 l=0.5
XRp_39_5 BLP5 dp_39_5 sky130_fd_pr_reram__reram_cell area_ox=0.0676
XMz_39_5 dz_39_5 WL39 SL5 VSS sky130_fd_pr__nfet_g5v0d10v5 w=1 l=0.5
XRz_39_5 BLZ5 dz_39_5 sky130_fd_pr_reram__reram_cell area_ox=0.0676
XMn_39_5 dn_39_5 WL39 SL5 VSS sky130_fd_pr__nfet_g5v0d10v5 w=1 l=0.5
XRn_39_5 BLN5 dn_39_5 sky130_fd_pr_reram__reram_cell area_ox=0.0676
XMp_39_6 dp_39_6 WL39 SL6 VSS sky130_fd_pr__nfet_g5v0d10v5 w=1 l=0.5
XRp_39_6 BLP6 dp_39_6 sky130_fd_pr_reram__reram_cell area_ox=0.0676
XMz_39_6 dz_39_6 WL39 SL6 VSS sky130_fd_pr__nfet_g5v0d10v5 w=1 l=0.5
XRz_39_6 BLZ6 dz_39_6 sky130_fd_pr_reram__reram_cell area_ox=0.0676
XMn_39_6 dn_39_6 WL39 SL6 VSS sky130_fd_pr__nfet_g5v0d10v5 w=1 l=0.5
XRn_39_6 BLN6 dn_39_6 sky130_fd_pr_reram__reram_cell area_ox=0.0676
XMp_39_7 dp_39_7 WL39 SL7 VSS sky130_fd_pr__nfet_g5v0d10v5 w=1 l=0.5
XRp_39_7 BLP7 dp_39_7 sky130_fd_pr_reram__reram_cell area_ox=0.0676
XMz_39_7 dz_39_7 WL39 SL7 VSS sky130_fd_pr__nfet_g5v0d10v5 w=1 l=0.5
XRz_39_7 BLZ7 dz_39_7 sky130_fd_pr_reram__reram_cell area_ox=0.0676
XMn_39_7 dn_39_7 WL39 SL7 VSS sky130_fd_pr__nfet_g5v0d10v5 w=1 l=0.5
XRn_39_7 BLN7 dn_39_7 sky130_fd_pr_reram__reram_cell area_ox=0.0676
XMp_39_8 dp_39_8 WL39 SL8 VSS sky130_fd_pr__nfet_g5v0d10v5 w=1 l=0.5
XRp_39_8 BLP8 dp_39_8 sky130_fd_pr_reram__reram_cell area_ox=0.0676
XMz_39_8 dz_39_8 WL39 SL8 VSS sky130_fd_pr__nfet_g5v0d10v5 w=1 l=0.5
XRz_39_8 BLZ8 dz_39_8 sky130_fd_pr_reram__reram_cell area_ox=0.0676
XMn_39_8 dn_39_8 WL39 SL8 VSS sky130_fd_pr__nfet_g5v0d10v5 w=1 l=0.5
XRn_39_8 BLN8 dn_39_8 sky130_fd_pr_reram__reram_cell area_ox=0.0676
XMp_39_9 dp_39_9 WL39 SL9 VSS sky130_fd_pr__nfet_g5v0d10v5 w=1 l=0.5
XRp_39_9 BLP9 dp_39_9 sky130_fd_pr_reram__reram_cell area_ox=0.0676
XMz_39_9 dz_39_9 WL39 SL9 VSS sky130_fd_pr__nfet_g5v0d10v5 w=1 l=0.5
XRz_39_9 BLZ9 dz_39_9 sky130_fd_pr_reram__reram_cell area_ox=0.0676
XMn_39_9 dn_39_9 WL39 SL9 VSS sky130_fd_pr__nfet_g5v0d10v5 w=1 l=0.5
XRn_39_9 BLN9 dn_39_9 sky130_fd_pr_reram__reram_cell area_ox=0.0676
XMp_39_10 dp_39_10 WL39 SL10 VSS sky130_fd_pr__nfet_g5v0d10v5 w=1 l=0.5
XRp_39_10 BLP10 dp_39_10 sky130_fd_pr_reram__reram_cell area_ox=0.0676
XMz_39_10 dz_39_10 WL39 SL10 VSS sky130_fd_pr__nfet_g5v0d10v5 w=1 l=0.5
XRz_39_10 BLZ10 dz_39_10 sky130_fd_pr_reram__reram_cell area_ox=0.0676
XMn_39_10 dn_39_10 WL39 SL10 VSS sky130_fd_pr__nfet_g5v0d10v5 w=1 l=0.5
XRn_39_10 BLN10 dn_39_10 sky130_fd_pr_reram__reram_cell area_ox=0.0676
XMp_39_11 dp_39_11 WL39 SL11 VSS sky130_fd_pr__nfet_g5v0d10v5 w=1 l=0.5
XRp_39_11 BLP11 dp_39_11 sky130_fd_pr_reram__reram_cell area_ox=0.0676
XMz_39_11 dz_39_11 WL39 SL11 VSS sky130_fd_pr__nfet_g5v0d10v5 w=1 l=0.5
XRz_39_11 BLZ11 dz_39_11 sky130_fd_pr_reram__reram_cell area_ox=0.0676
XMn_39_11 dn_39_11 WL39 SL11 VSS sky130_fd_pr__nfet_g5v0d10v5 w=1 l=0.5
XRn_39_11 BLN11 dn_39_11 sky130_fd_pr_reram__reram_cell area_ox=0.0676
XMp_39_12 dp_39_12 WL39 SL12 VSS sky130_fd_pr__nfet_g5v0d10v5 w=1 l=0.5
XRp_39_12 BLP12 dp_39_12 sky130_fd_pr_reram__reram_cell area_ox=0.0676
XMz_39_12 dz_39_12 WL39 SL12 VSS sky130_fd_pr__nfet_g5v0d10v5 w=1 l=0.5
XRz_39_12 BLZ12 dz_39_12 sky130_fd_pr_reram__reram_cell area_ox=0.0676
XMn_39_12 dn_39_12 WL39 SL12 VSS sky130_fd_pr__nfet_g5v0d10v5 w=1 l=0.5
XRn_39_12 BLN12 dn_39_12 sky130_fd_pr_reram__reram_cell area_ox=0.0676
XMp_39_13 dp_39_13 WL39 SL13 VSS sky130_fd_pr__nfet_g5v0d10v5 w=1 l=0.5
XRp_39_13 BLP13 dp_39_13 sky130_fd_pr_reram__reram_cell area_ox=0.0676
XMz_39_13 dz_39_13 WL39 SL13 VSS sky130_fd_pr__nfet_g5v0d10v5 w=1 l=0.5
XRz_39_13 BLZ13 dz_39_13 sky130_fd_pr_reram__reram_cell area_ox=0.0676
XMn_39_13 dn_39_13 WL39 SL13 VSS sky130_fd_pr__nfet_g5v0d10v5 w=1 l=0.5
XRn_39_13 BLN13 dn_39_13 sky130_fd_pr_reram__reram_cell area_ox=0.0676
XMp_39_14 dp_39_14 WL39 SL14 VSS sky130_fd_pr__nfet_g5v0d10v5 w=1 l=0.5
XRp_39_14 BLP14 dp_39_14 sky130_fd_pr_reram__reram_cell area_ox=0.0676
XMz_39_14 dz_39_14 WL39 SL14 VSS sky130_fd_pr__nfet_g5v0d10v5 w=1 l=0.5
XRz_39_14 BLZ14 dz_39_14 sky130_fd_pr_reram__reram_cell area_ox=0.0676
XMn_39_14 dn_39_14 WL39 SL14 VSS sky130_fd_pr__nfet_g5v0d10v5 w=1 l=0.5
XRn_39_14 BLN14 dn_39_14 sky130_fd_pr_reram__reram_cell area_ox=0.0676
XMp_39_15 dp_39_15 WL39 SL15 VSS sky130_fd_pr__nfet_g5v0d10v5 w=1 l=0.5
XRp_39_15 BLP15 dp_39_15 sky130_fd_pr_reram__reram_cell area_ox=0.0676
XMz_39_15 dz_39_15 WL39 SL15 VSS sky130_fd_pr__nfet_g5v0d10v5 w=1 l=0.5
XRz_39_15 BLZ15 dz_39_15 sky130_fd_pr_reram__reram_cell area_ox=0.0676
XMn_39_15 dn_39_15 WL39 SL15 VSS sky130_fd_pr__nfet_g5v0d10v5 w=1 l=0.5
XRn_39_15 BLN15 dn_39_15 sky130_fd_pr_reram__reram_cell area_ox=0.0676
XMp_39_16 dp_39_16 WL39 SL16 VSS sky130_fd_pr__nfet_g5v0d10v5 w=1 l=0.5
XRp_39_16 BLP16 dp_39_16 sky130_fd_pr_reram__reram_cell area_ox=0.0676
XMz_39_16 dz_39_16 WL39 SL16 VSS sky130_fd_pr__nfet_g5v0d10v5 w=1 l=0.5
XRz_39_16 BLZ16 dz_39_16 sky130_fd_pr_reram__reram_cell area_ox=0.0676
XMn_39_16 dn_39_16 WL39 SL16 VSS sky130_fd_pr__nfet_g5v0d10v5 w=1 l=0.5
XRn_39_16 BLN16 dn_39_16 sky130_fd_pr_reram__reram_cell area_ox=0.0676
XMp_39_17 dp_39_17 WL39 SL17 VSS sky130_fd_pr__nfet_g5v0d10v5 w=1 l=0.5
XRp_39_17 BLP17 dp_39_17 sky130_fd_pr_reram__reram_cell area_ox=0.0676
XMz_39_17 dz_39_17 WL39 SL17 VSS sky130_fd_pr__nfet_g5v0d10v5 w=1 l=0.5
XRz_39_17 BLZ17 dz_39_17 sky130_fd_pr_reram__reram_cell area_ox=0.0676
XMn_39_17 dn_39_17 WL39 SL17 VSS sky130_fd_pr__nfet_g5v0d10v5 w=1 l=0.5
XRn_39_17 BLN17 dn_39_17 sky130_fd_pr_reram__reram_cell area_ox=0.0676
XMp_39_18 dp_39_18 WL39 SL18 VSS sky130_fd_pr__nfet_g5v0d10v5 w=1 l=0.5
XRp_39_18 BLP18 dp_39_18 sky130_fd_pr_reram__reram_cell area_ox=0.0676
XMz_39_18 dz_39_18 WL39 SL18 VSS sky130_fd_pr__nfet_g5v0d10v5 w=1 l=0.5
XRz_39_18 BLZ18 dz_39_18 sky130_fd_pr_reram__reram_cell area_ox=0.0676
XMn_39_18 dn_39_18 WL39 SL18 VSS sky130_fd_pr__nfet_g5v0d10v5 w=1 l=0.5
XRn_39_18 BLN18 dn_39_18 sky130_fd_pr_reram__reram_cell area_ox=0.0676
XMp_39_19 dp_39_19 WL39 SL19 VSS sky130_fd_pr__nfet_g5v0d10v5 w=1 l=0.5
XRp_39_19 BLP19 dp_39_19 sky130_fd_pr_reram__reram_cell area_ox=0.0676
XMz_39_19 dz_39_19 WL39 SL19 VSS sky130_fd_pr__nfet_g5v0d10v5 w=1 l=0.5
XRz_39_19 BLZ19 dz_39_19 sky130_fd_pr_reram__reram_cell area_ox=0.0676
XMn_39_19 dn_39_19 WL39 SL19 VSS sky130_fd_pr__nfet_g5v0d10v5 w=1 l=0.5
XRn_39_19 BLN19 dn_39_19 sky130_fd_pr_reram__reram_cell area_ox=0.0676
XMp_39_20 dp_39_20 WL39 SL20 VSS sky130_fd_pr__nfet_g5v0d10v5 w=1 l=0.5
XRp_39_20 BLP20 dp_39_20 sky130_fd_pr_reram__reram_cell area_ox=0.0676
XMz_39_20 dz_39_20 WL39 SL20 VSS sky130_fd_pr__nfet_g5v0d10v5 w=1 l=0.5
XRz_39_20 BLZ20 dz_39_20 sky130_fd_pr_reram__reram_cell area_ox=0.0676
XMn_39_20 dn_39_20 WL39 SL20 VSS sky130_fd_pr__nfet_g5v0d10v5 w=1 l=0.5
XRn_39_20 BLN20 dn_39_20 sky130_fd_pr_reram__reram_cell area_ox=0.0676
XMp_39_21 dp_39_21 WL39 SL21 VSS sky130_fd_pr__nfet_g5v0d10v5 w=1 l=0.5
XRp_39_21 BLP21 dp_39_21 sky130_fd_pr_reram__reram_cell area_ox=0.0676
XMz_39_21 dz_39_21 WL39 SL21 VSS sky130_fd_pr__nfet_g5v0d10v5 w=1 l=0.5
XRz_39_21 BLZ21 dz_39_21 sky130_fd_pr_reram__reram_cell area_ox=0.0676
XMn_39_21 dn_39_21 WL39 SL21 VSS sky130_fd_pr__nfet_g5v0d10v5 w=1 l=0.5
XRn_39_21 BLN21 dn_39_21 sky130_fd_pr_reram__reram_cell area_ox=0.0676
XMp_39_22 dp_39_22 WL39 SL22 VSS sky130_fd_pr__nfet_g5v0d10v5 w=1 l=0.5
XRp_39_22 BLP22 dp_39_22 sky130_fd_pr_reram__reram_cell area_ox=0.0676
XMz_39_22 dz_39_22 WL39 SL22 VSS sky130_fd_pr__nfet_g5v0d10v5 w=1 l=0.5
XRz_39_22 BLZ22 dz_39_22 sky130_fd_pr_reram__reram_cell area_ox=0.0676
XMn_39_22 dn_39_22 WL39 SL22 VSS sky130_fd_pr__nfet_g5v0d10v5 w=1 l=0.5
XRn_39_22 BLN22 dn_39_22 sky130_fd_pr_reram__reram_cell area_ox=0.0676
XMp_39_23 dp_39_23 WL39 SL23 VSS sky130_fd_pr__nfet_g5v0d10v5 w=1 l=0.5
XRp_39_23 BLP23 dp_39_23 sky130_fd_pr_reram__reram_cell area_ox=0.0676
XMz_39_23 dz_39_23 WL39 SL23 VSS sky130_fd_pr__nfet_g5v0d10v5 w=1 l=0.5
XRz_39_23 BLZ23 dz_39_23 sky130_fd_pr_reram__reram_cell area_ox=0.0676
XMn_39_23 dn_39_23 WL39 SL23 VSS sky130_fd_pr__nfet_g5v0d10v5 w=1 l=0.5
XRn_39_23 BLN23 dn_39_23 sky130_fd_pr_reram__reram_cell area_ox=0.0676
XMp_40_0 dp_40_0 WL40 SL0 VSS sky130_fd_pr__nfet_g5v0d10v5 w=1 l=0.5
XRp_40_0 BLP0 dp_40_0 sky130_fd_pr_reram__reram_cell area_ox=0.0676
XMz_40_0 dz_40_0 WL40 SL0 VSS sky130_fd_pr__nfet_g5v0d10v5 w=1 l=0.5
XRz_40_0 BLZ0 dz_40_0 sky130_fd_pr_reram__reram_cell area_ox=0.0676
XMn_40_0 dn_40_0 WL40 SL0 VSS sky130_fd_pr__nfet_g5v0d10v5 w=1 l=0.5
XRn_40_0 BLN0 dn_40_0 sky130_fd_pr_reram__reram_cell area_ox=0.0676
XMp_40_1 dp_40_1 WL40 SL1 VSS sky130_fd_pr__nfet_g5v0d10v5 w=1 l=0.5
XRp_40_1 BLP1 dp_40_1 sky130_fd_pr_reram__reram_cell area_ox=0.0676
XMz_40_1 dz_40_1 WL40 SL1 VSS sky130_fd_pr__nfet_g5v0d10v5 w=1 l=0.5
XRz_40_1 BLZ1 dz_40_1 sky130_fd_pr_reram__reram_cell area_ox=0.0676
XMn_40_1 dn_40_1 WL40 SL1 VSS sky130_fd_pr__nfet_g5v0d10v5 w=1 l=0.5
XRn_40_1 BLN1 dn_40_1 sky130_fd_pr_reram__reram_cell area_ox=0.0676
XMp_40_2 dp_40_2 WL40 SL2 VSS sky130_fd_pr__nfet_g5v0d10v5 w=1 l=0.5
XRp_40_2 BLP2 dp_40_2 sky130_fd_pr_reram__reram_cell area_ox=0.0676
XMz_40_2 dz_40_2 WL40 SL2 VSS sky130_fd_pr__nfet_g5v0d10v5 w=1 l=0.5
XRz_40_2 BLZ2 dz_40_2 sky130_fd_pr_reram__reram_cell area_ox=0.0676
XMn_40_2 dn_40_2 WL40 SL2 VSS sky130_fd_pr__nfet_g5v0d10v5 w=1 l=0.5
XRn_40_2 BLN2 dn_40_2 sky130_fd_pr_reram__reram_cell area_ox=0.0676
XMp_40_3 dp_40_3 WL40 SL3 VSS sky130_fd_pr__nfet_g5v0d10v5 w=1 l=0.5
XRp_40_3 BLP3 dp_40_3 sky130_fd_pr_reram__reram_cell area_ox=0.0676
XMz_40_3 dz_40_3 WL40 SL3 VSS sky130_fd_pr__nfet_g5v0d10v5 w=1 l=0.5
XRz_40_3 BLZ3 dz_40_3 sky130_fd_pr_reram__reram_cell area_ox=0.0676
XMn_40_3 dn_40_3 WL40 SL3 VSS sky130_fd_pr__nfet_g5v0d10v5 w=1 l=0.5
XRn_40_3 BLN3 dn_40_3 sky130_fd_pr_reram__reram_cell area_ox=0.0676
XMp_40_4 dp_40_4 WL40 SL4 VSS sky130_fd_pr__nfet_g5v0d10v5 w=1 l=0.5
XRp_40_4 BLP4 dp_40_4 sky130_fd_pr_reram__reram_cell area_ox=0.0676
XMz_40_4 dz_40_4 WL40 SL4 VSS sky130_fd_pr__nfet_g5v0d10v5 w=1 l=0.5
XRz_40_4 BLZ4 dz_40_4 sky130_fd_pr_reram__reram_cell area_ox=0.0676
XMn_40_4 dn_40_4 WL40 SL4 VSS sky130_fd_pr__nfet_g5v0d10v5 w=1 l=0.5
XRn_40_4 BLN4 dn_40_4 sky130_fd_pr_reram__reram_cell area_ox=0.0676
XMp_40_5 dp_40_5 WL40 SL5 VSS sky130_fd_pr__nfet_g5v0d10v5 w=1 l=0.5
XRp_40_5 BLP5 dp_40_5 sky130_fd_pr_reram__reram_cell area_ox=0.0676
XMz_40_5 dz_40_5 WL40 SL5 VSS sky130_fd_pr__nfet_g5v0d10v5 w=1 l=0.5
XRz_40_5 BLZ5 dz_40_5 sky130_fd_pr_reram__reram_cell area_ox=0.0676
XMn_40_5 dn_40_5 WL40 SL5 VSS sky130_fd_pr__nfet_g5v0d10v5 w=1 l=0.5
XRn_40_5 BLN5 dn_40_5 sky130_fd_pr_reram__reram_cell area_ox=0.0676
XMp_40_6 dp_40_6 WL40 SL6 VSS sky130_fd_pr__nfet_g5v0d10v5 w=1 l=0.5
XRp_40_6 BLP6 dp_40_6 sky130_fd_pr_reram__reram_cell area_ox=0.0676
XMz_40_6 dz_40_6 WL40 SL6 VSS sky130_fd_pr__nfet_g5v0d10v5 w=1 l=0.5
XRz_40_6 BLZ6 dz_40_6 sky130_fd_pr_reram__reram_cell area_ox=0.0676
XMn_40_6 dn_40_6 WL40 SL6 VSS sky130_fd_pr__nfet_g5v0d10v5 w=1 l=0.5
XRn_40_6 BLN6 dn_40_6 sky130_fd_pr_reram__reram_cell area_ox=0.0676
XMp_40_7 dp_40_7 WL40 SL7 VSS sky130_fd_pr__nfet_g5v0d10v5 w=1 l=0.5
XRp_40_7 BLP7 dp_40_7 sky130_fd_pr_reram__reram_cell area_ox=0.0676
XMz_40_7 dz_40_7 WL40 SL7 VSS sky130_fd_pr__nfet_g5v0d10v5 w=1 l=0.5
XRz_40_7 BLZ7 dz_40_7 sky130_fd_pr_reram__reram_cell area_ox=0.0676
XMn_40_7 dn_40_7 WL40 SL7 VSS sky130_fd_pr__nfet_g5v0d10v5 w=1 l=0.5
XRn_40_7 BLN7 dn_40_7 sky130_fd_pr_reram__reram_cell area_ox=0.0676
XMp_40_8 dp_40_8 WL40 SL8 VSS sky130_fd_pr__nfet_g5v0d10v5 w=1 l=0.5
XRp_40_8 BLP8 dp_40_8 sky130_fd_pr_reram__reram_cell area_ox=0.0676
XMz_40_8 dz_40_8 WL40 SL8 VSS sky130_fd_pr__nfet_g5v0d10v5 w=1 l=0.5
XRz_40_8 BLZ8 dz_40_8 sky130_fd_pr_reram__reram_cell area_ox=0.0676
XMn_40_8 dn_40_8 WL40 SL8 VSS sky130_fd_pr__nfet_g5v0d10v5 w=1 l=0.5
XRn_40_8 BLN8 dn_40_8 sky130_fd_pr_reram__reram_cell area_ox=0.0676
XMp_40_9 dp_40_9 WL40 SL9 VSS sky130_fd_pr__nfet_g5v0d10v5 w=1 l=0.5
XRp_40_9 BLP9 dp_40_9 sky130_fd_pr_reram__reram_cell area_ox=0.0676
XMz_40_9 dz_40_9 WL40 SL9 VSS sky130_fd_pr__nfet_g5v0d10v5 w=1 l=0.5
XRz_40_9 BLZ9 dz_40_9 sky130_fd_pr_reram__reram_cell area_ox=0.0676
XMn_40_9 dn_40_9 WL40 SL9 VSS sky130_fd_pr__nfet_g5v0d10v5 w=1 l=0.5
XRn_40_9 BLN9 dn_40_9 sky130_fd_pr_reram__reram_cell area_ox=0.0676
XMp_40_10 dp_40_10 WL40 SL10 VSS sky130_fd_pr__nfet_g5v0d10v5 w=1 l=0.5
XRp_40_10 BLP10 dp_40_10 sky130_fd_pr_reram__reram_cell area_ox=0.0676
XMz_40_10 dz_40_10 WL40 SL10 VSS sky130_fd_pr__nfet_g5v0d10v5 w=1 l=0.5
XRz_40_10 BLZ10 dz_40_10 sky130_fd_pr_reram__reram_cell area_ox=0.0676
XMn_40_10 dn_40_10 WL40 SL10 VSS sky130_fd_pr__nfet_g5v0d10v5 w=1 l=0.5
XRn_40_10 BLN10 dn_40_10 sky130_fd_pr_reram__reram_cell area_ox=0.0676
XMp_40_11 dp_40_11 WL40 SL11 VSS sky130_fd_pr__nfet_g5v0d10v5 w=1 l=0.5
XRp_40_11 BLP11 dp_40_11 sky130_fd_pr_reram__reram_cell area_ox=0.0676
XMz_40_11 dz_40_11 WL40 SL11 VSS sky130_fd_pr__nfet_g5v0d10v5 w=1 l=0.5
XRz_40_11 BLZ11 dz_40_11 sky130_fd_pr_reram__reram_cell area_ox=0.0676
XMn_40_11 dn_40_11 WL40 SL11 VSS sky130_fd_pr__nfet_g5v0d10v5 w=1 l=0.5
XRn_40_11 BLN11 dn_40_11 sky130_fd_pr_reram__reram_cell area_ox=0.0676
XMp_40_12 dp_40_12 WL40 SL12 VSS sky130_fd_pr__nfet_g5v0d10v5 w=1 l=0.5
XRp_40_12 BLP12 dp_40_12 sky130_fd_pr_reram__reram_cell area_ox=0.0676
XMz_40_12 dz_40_12 WL40 SL12 VSS sky130_fd_pr__nfet_g5v0d10v5 w=1 l=0.5
XRz_40_12 BLZ12 dz_40_12 sky130_fd_pr_reram__reram_cell area_ox=0.0676
XMn_40_12 dn_40_12 WL40 SL12 VSS sky130_fd_pr__nfet_g5v0d10v5 w=1 l=0.5
XRn_40_12 BLN12 dn_40_12 sky130_fd_pr_reram__reram_cell area_ox=0.0676
XMp_40_13 dp_40_13 WL40 SL13 VSS sky130_fd_pr__nfet_g5v0d10v5 w=1 l=0.5
XRp_40_13 BLP13 dp_40_13 sky130_fd_pr_reram__reram_cell area_ox=0.0676
XMz_40_13 dz_40_13 WL40 SL13 VSS sky130_fd_pr__nfet_g5v0d10v5 w=1 l=0.5
XRz_40_13 BLZ13 dz_40_13 sky130_fd_pr_reram__reram_cell area_ox=0.0676
XMn_40_13 dn_40_13 WL40 SL13 VSS sky130_fd_pr__nfet_g5v0d10v5 w=1 l=0.5
XRn_40_13 BLN13 dn_40_13 sky130_fd_pr_reram__reram_cell area_ox=0.0676
XMp_40_14 dp_40_14 WL40 SL14 VSS sky130_fd_pr__nfet_g5v0d10v5 w=1 l=0.5
XRp_40_14 BLP14 dp_40_14 sky130_fd_pr_reram__reram_cell area_ox=0.0676
XMz_40_14 dz_40_14 WL40 SL14 VSS sky130_fd_pr__nfet_g5v0d10v5 w=1 l=0.5
XRz_40_14 BLZ14 dz_40_14 sky130_fd_pr_reram__reram_cell area_ox=0.0676
XMn_40_14 dn_40_14 WL40 SL14 VSS sky130_fd_pr__nfet_g5v0d10v5 w=1 l=0.5
XRn_40_14 BLN14 dn_40_14 sky130_fd_pr_reram__reram_cell area_ox=0.0676
XMp_40_15 dp_40_15 WL40 SL15 VSS sky130_fd_pr__nfet_g5v0d10v5 w=1 l=0.5
XRp_40_15 BLP15 dp_40_15 sky130_fd_pr_reram__reram_cell area_ox=0.0676
XMz_40_15 dz_40_15 WL40 SL15 VSS sky130_fd_pr__nfet_g5v0d10v5 w=1 l=0.5
XRz_40_15 BLZ15 dz_40_15 sky130_fd_pr_reram__reram_cell area_ox=0.0676
XMn_40_15 dn_40_15 WL40 SL15 VSS sky130_fd_pr__nfet_g5v0d10v5 w=1 l=0.5
XRn_40_15 BLN15 dn_40_15 sky130_fd_pr_reram__reram_cell area_ox=0.0676
XMp_40_16 dp_40_16 WL40 SL16 VSS sky130_fd_pr__nfet_g5v0d10v5 w=1 l=0.5
XRp_40_16 BLP16 dp_40_16 sky130_fd_pr_reram__reram_cell area_ox=0.0676
XMz_40_16 dz_40_16 WL40 SL16 VSS sky130_fd_pr__nfet_g5v0d10v5 w=1 l=0.5
XRz_40_16 BLZ16 dz_40_16 sky130_fd_pr_reram__reram_cell area_ox=0.0676
XMn_40_16 dn_40_16 WL40 SL16 VSS sky130_fd_pr__nfet_g5v0d10v5 w=1 l=0.5
XRn_40_16 BLN16 dn_40_16 sky130_fd_pr_reram__reram_cell area_ox=0.0676
XMp_40_17 dp_40_17 WL40 SL17 VSS sky130_fd_pr__nfet_g5v0d10v5 w=1 l=0.5
XRp_40_17 BLP17 dp_40_17 sky130_fd_pr_reram__reram_cell area_ox=0.0676
XMz_40_17 dz_40_17 WL40 SL17 VSS sky130_fd_pr__nfet_g5v0d10v5 w=1 l=0.5
XRz_40_17 BLZ17 dz_40_17 sky130_fd_pr_reram__reram_cell area_ox=0.0676
XMn_40_17 dn_40_17 WL40 SL17 VSS sky130_fd_pr__nfet_g5v0d10v5 w=1 l=0.5
XRn_40_17 BLN17 dn_40_17 sky130_fd_pr_reram__reram_cell area_ox=0.0676
XMp_40_18 dp_40_18 WL40 SL18 VSS sky130_fd_pr__nfet_g5v0d10v5 w=1 l=0.5
XRp_40_18 BLP18 dp_40_18 sky130_fd_pr_reram__reram_cell area_ox=0.0676
XMz_40_18 dz_40_18 WL40 SL18 VSS sky130_fd_pr__nfet_g5v0d10v5 w=1 l=0.5
XRz_40_18 BLZ18 dz_40_18 sky130_fd_pr_reram__reram_cell area_ox=0.0676
XMn_40_18 dn_40_18 WL40 SL18 VSS sky130_fd_pr__nfet_g5v0d10v5 w=1 l=0.5
XRn_40_18 BLN18 dn_40_18 sky130_fd_pr_reram__reram_cell area_ox=0.0676
XMp_40_19 dp_40_19 WL40 SL19 VSS sky130_fd_pr__nfet_g5v0d10v5 w=1 l=0.5
XRp_40_19 BLP19 dp_40_19 sky130_fd_pr_reram__reram_cell area_ox=0.0676
XMz_40_19 dz_40_19 WL40 SL19 VSS sky130_fd_pr__nfet_g5v0d10v5 w=1 l=0.5
XRz_40_19 BLZ19 dz_40_19 sky130_fd_pr_reram__reram_cell area_ox=0.0676
XMn_40_19 dn_40_19 WL40 SL19 VSS sky130_fd_pr__nfet_g5v0d10v5 w=1 l=0.5
XRn_40_19 BLN19 dn_40_19 sky130_fd_pr_reram__reram_cell area_ox=0.0676
XMp_40_20 dp_40_20 WL40 SL20 VSS sky130_fd_pr__nfet_g5v0d10v5 w=1 l=0.5
XRp_40_20 BLP20 dp_40_20 sky130_fd_pr_reram__reram_cell area_ox=0.0676
XMz_40_20 dz_40_20 WL40 SL20 VSS sky130_fd_pr__nfet_g5v0d10v5 w=1 l=0.5
XRz_40_20 BLZ20 dz_40_20 sky130_fd_pr_reram__reram_cell area_ox=0.0676
XMn_40_20 dn_40_20 WL40 SL20 VSS sky130_fd_pr__nfet_g5v0d10v5 w=1 l=0.5
XRn_40_20 BLN20 dn_40_20 sky130_fd_pr_reram__reram_cell area_ox=0.0676
XMp_40_21 dp_40_21 WL40 SL21 VSS sky130_fd_pr__nfet_g5v0d10v5 w=1 l=0.5
XRp_40_21 BLP21 dp_40_21 sky130_fd_pr_reram__reram_cell area_ox=0.0676
XMz_40_21 dz_40_21 WL40 SL21 VSS sky130_fd_pr__nfet_g5v0d10v5 w=1 l=0.5
XRz_40_21 BLZ21 dz_40_21 sky130_fd_pr_reram__reram_cell area_ox=0.0676
XMn_40_21 dn_40_21 WL40 SL21 VSS sky130_fd_pr__nfet_g5v0d10v5 w=1 l=0.5
XRn_40_21 BLN21 dn_40_21 sky130_fd_pr_reram__reram_cell area_ox=0.0676
XMp_40_22 dp_40_22 WL40 SL22 VSS sky130_fd_pr__nfet_g5v0d10v5 w=1 l=0.5
XRp_40_22 BLP22 dp_40_22 sky130_fd_pr_reram__reram_cell area_ox=0.0676
XMz_40_22 dz_40_22 WL40 SL22 VSS sky130_fd_pr__nfet_g5v0d10v5 w=1 l=0.5
XRz_40_22 BLZ22 dz_40_22 sky130_fd_pr_reram__reram_cell area_ox=0.0676
XMn_40_22 dn_40_22 WL40 SL22 VSS sky130_fd_pr__nfet_g5v0d10v5 w=1 l=0.5
XRn_40_22 BLN22 dn_40_22 sky130_fd_pr_reram__reram_cell area_ox=0.0676
XMp_40_23 dp_40_23 WL40 SL23 VSS sky130_fd_pr__nfet_g5v0d10v5 w=1 l=0.5
XRp_40_23 BLP23 dp_40_23 sky130_fd_pr_reram__reram_cell area_ox=0.0676
XMz_40_23 dz_40_23 WL40 SL23 VSS sky130_fd_pr__nfet_g5v0d10v5 w=1 l=0.5
XRz_40_23 BLZ23 dz_40_23 sky130_fd_pr_reram__reram_cell area_ox=0.0676
XMn_40_23 dn_40_23 WL40 SL23 VSS sky130_fd_pr__nfet_g5v0d10v5 w=1 l=0.5
XRn_40_23 BLN23 dn_40_23 sky130_fd_pr_reram__reram_cell area_ox=0.0676
XMp_41_0 dp_41_0 WL41 SL0 VSS sky130_fd_pr__nfet_g5v0d10v5 w=1 l=0.5
XRp_41_0 BLP0 dp_41_0 sky130_fd_pr_reram__reram_cell area_ox=0.0676
XMz_41_0 dz_41_0 WL41 SL0 VSS sky130_fd_pr__nfet_g5v0d10v5 w=1 l=0.5
XRz_41_0 BLZ0 dz_41_0 sky130_fd_pr_reram__reram_cell area_ox=0.0676
XMn_41_0 dn_41_0 WL41 SL0 VSS sky130_fd_pr__nfet_g5v0d10v5 w=1 l=0.5
XRn_41_0 BLN0 dn_41_0 sky130_fd_pr_reram__reram_cell area_ox=0.0676
XMp_41_1 dp_41_1 WL41 SL1 VSS sky130_fd_pr__nfet_g5v0d10v5 w=1 l=0.5
XRp_41_1 BLP1 dp_41_1 sky130_fd_pr_reram__reram_cell area_ox=0.0676
XMz_41_1 dz_41_1 WL41 SL1 VSS sky130_fd_pr__nfet_g5v0d10v5 w=1 l=0.5
XRz_41_1 BLZ1 dz_41_1 sky130_fd_pr_reram__reram_cell area_ox=0.0676
XMn_41_1 dn_41_1 WL41 SL1 VSS sky130_fd_pr__nfet_g5v0d10v5 w=1 l=0.5
XRn_41_1 BLN1 dn_41_1 sky130_fd_pr_reram__reram_cell area_ox=0.0676
XMp_41_2 dp_41_2 WL41 SL2 VSS sky130_fd_pr__nfet_g5v0d10v5 w=1 l=0.5
XRp_41_2 BLP2 dp_41_2 sky130_fd_pr_reram__reram_cell area_ox=0.0676
XMz_41_2 dz_41_2 WL41 SL2 VSS sky130_fd_pr__nfet_g5v0d10v5 w=1 l=0.5
XRz_41_2 BLZ2 dz_41_2 sky130_fd_pr_reram__reram_cell area_ox=0.0676
XMn_41_2 dn_41_2 WL41 SL2 VSS sky130_fd_pr__nfet_g5v0d10v5 w=1 l=0.5
XRn_41_2 BLN2 dn_41_2 sky130_fd_pr_reram__reram_cell area_ox=0.0676
XMp_41_3 dp_41_3 WL41 SL3 VSS sky130_fd_pr__nfet_g5v0d10v5 w=1 l=0.5
XRp_41_3 BLP3 dp_41_3 sky130_fd_pr_reram__reram_cell area_ox=0.0676
XMz_41_3 dz_41_3 WL41 SL3 VSS sky130_fd_pr__nfet_g5v0d10v5 w=1 l=0.5
XRz_41_3 BLZ3 dz_41_3 sky130_fd_pr_reram__reram_cell area_ox=0.0676
XMn_41_3 dn_41_3 WL41 SL3 VSS sky130_fd_pr__nfet_g5v0d10v5 w=1 l=0.5
XRn_41_3 BLN3 dn_41_3 sky130_fd_pr_reram__reram_cell area_ox=0.0676
XMp_41_4 dp_41_4 WL41 SL4 VSS sky130_fd_pr__nfet_g5v0d10v5 w=1 l=0.5
XRp_41_4 BLP4 dp_41_4 sky130_fd_pr_reram__reram_cell area_ox=0.0676
XMz_41_4 dz_41_4 WL41 SL4 VSS sky130_fd_pr__nfet_g5v0d10v5 w=1 l=0.5
XRz_41_4 BLZ4 dz_41_4 sky130_fd_pr_reram__reram_cell area_ox=0.0676
XMn_41_4 dn_41_4 WL41 SL4 VSS sky130_fd_pr__nfet_g5v0d10v5 w=1 l=0.5
XRn_41_4 BLN4 dn_41_4 sky130_fd_pr_reram__reram_cell area_ox=0.0676
XMp_41_5 dp_41_5 WL41 SL5 VSS sky130_fd_pr__nfet_g5v0d10v5 w=1 l=0.5
XRp_41_5 BLP5 dp_41_5 sky130_fd_pr_reram__reram_cell area_ox=0.0676
XMz_41_5 dz_41_5 WL41 SL5 VSS sky130_fd_pr__nfet_g5v0d10v5 w=1 l=0.5
XRz_41_5 BLZ5 dz_41_5 sky130_fd_pr_reram__reram_cell area_ox=0.0676
XMn_41_5 dn_41_5 WL41 SL5 VSS sky130_fd_pr__nfet_g5v0d10v5 w=1 l=0.5
XRn_41_5 BLN5 dn_41_5 sky130_fd_pr_reram__reram_cell area_ox=0.0676
XMp_41_6 dp_41_6 WL41 SL6 VSS sky130_fd_pr__nfet_g5v0d10v5 w=1 l=0.5
XRp_41_6 BLP6 dp_41_6 sky130_fd_pr_reram__reram_cell area_ox=0.0676
XMz_41_6 dz_41_6 WL41 SL6 VSS sky130_fd_pr__nfet_g5v0d10v5 w=1 l=0.5
XRz_41_6 BLZ6 dz_41_6 sky130_fd_pr_reram__reram_cell area_ox=0.0676
XMn_41_6 dn_41_6 WL41 SL6 VSS sky130_fd_pr__nfet_g5v0d10v5 w=1 l=0.5
XRn_41_6 BLN6 dn_41_6 sky130_fd_pr_reram__reram_cell area_ox=0.0676
XMp_41_7 dp_41_7 WL41 SL7 VSS sky130_fd_pr__nfet_g5v0d10v5 w=1 l=0.5
XRp_41_7 BLP7 dp_41_7 sky130_fd_pr_reram__reram_cell area_ox=0.0676
XMz_41_7 dz_41_7 WL41 SL7 VSS sky130_fd_pr__nfet_g5v0d10v5 w=1 l=0.5
XRz_41_7 BLZ7 dz_41_7 sky130_fd_pr_reram__reram_cell area_ox=0.0676
XMn_41_7 dn_41_7 WL41 SL7 VSS sky130_fd_pr__nfet_g5v0d10v5 w=1 l=0.5
XRn_41_7 BLN7 dn_41_7 sky130_fd_pr_reram__reram_cell area_ox=0.0676
XMp_41_8 dp_41_8 WL41 SL8 VSS sky130_fd_pr__nfet_g5v0d10v5 w=1 l=0.5
XRp_41_8 BLP8 dp_41_8 sky130_fd_pr_reram__reram_cell area_ox=0.0676
XMz_41_8 dz_41_8 WL41 SL8 VSS sky130_fd_pr__nfet_g5v0d10v5 w=1 l=0.5
XRz_41_8 BLZ8 dz_41_8 sky130_fd_pr_reram__reram_cell area_ox=0.0676
XMn_41_8 dn_41_8 WL41 SL8 VSS sky130_fd_pr__nfet_g5v0d10v5 w=1 l=0.5
XRn_41_8 BLN8 dn_41_8 sky130_fd_pr_reram__reram_cell area_ox=0.0676
XMp_41_9 dp_41_9 WL41 SL9 VSS sky130_fd_pr__nfet_g5v0d10v5 w=1 l=0.5
XRp_41_9 BLP9 dp_41_9 sky130_fd_pr_reram__reram_cell area_ox=0.0676
XMz_41_9 dz_41_9 WL41 SL9 VSS sky130_fd_pr__nfet_g5v0d10v5 w=1 l=0.5
XRz_41_9 BLZ9 dz_41_9 sky130_fd_pr_reram__reram_cell area_ox=0.0676
XMn_41_9 dn_41_9 WL41 SL9 VSS sky130_fd_pr__nfet_g5v0d10v5 w=1 l=0.5
XRn_41_9 BLN9 dn_41_9 sky130_fd_pr_reram__reram_cell area_ox=0.0676
XMp_41_10 dp_41_10 WL41 SL10 VSS sky130_fd_pr__nfet_g5v0d10v5 w=1 l=0.5
XRp_41_10 BLP10 dp_41_10 sky130_fd_pr_reram__reram_cell area_ox=0.0676
XMz_41_10 dz_41_10 WL41 SL10 VSS sky130_fd_pr__nfet_g5v0d10v5 w=1 l=0.5
XRz_41_10 BLZ10 dz_41_10 sky130_fd_pr_reram__reram_cell area_ox=0.0676
XMn_41_10 dn_41_10 WL41 SL10 VSS sky130_fd_pr__nfet_g5v0d10v5 w=1 l=0.5
XRn_41_10 BLN10 dn_41_10 sky130_fd_pr_reram__reram_cell area_ox=0.0676
XMp_41_11 dp_41_11 WL41 SL11 VSS sky130_fd_pr__nfet_g5v0d10v5 w=1 l=0.5
XRp_41_11 BLP11 dp_41_11 sky130_fd_pr_reram__reram_cell area_ox=0.0676
XMz_41_11 dz_41_11 WL41 SL11 VSS sky130_fd_pr__nfet_g5v0d10v5 w=1 l=0.5
XRz_41_11 BLZ11 dz_41_11 sky130_fd_pr_reram__reram_cell area_ox=0.0676
XMn_41_11 dn_41_11 WL41 SL11 VSS sky130_fd_pr__nfet_g5v0d10v5 w=1 l=0.5
XRn_41_11 BLN11 dn_41_11 sky130_fd_pr_reram__reram_cell area_ox=0.0676
XMp_41_12 dp_41_12 WL41 SL12 VSS sky130_fd_pr__nfet_g5v0d10v5 w=1 l=0.5
XRp_41_12 BLP12 dp_41_12 sky130_fd_pr_reram__reram_cell area_ox=0.0676
XMz_41_12 dz_41_12 WL41 SL12 VSS sky130_fd_pr__nfet_g5v0d10v5 w=1 l=0.5
XRz_41_12 BLZ12 dz_41_12 sky130_fd_pr_reram__reram_cell area_ox=0.0676
XMn_41_12 dn_41_12 WL41 SL12 VSS sky130_fd_pr__nfet_g5v0d10v5 w=1 l=0.5
XRn_41_12 BLN12 dn_41_12 sky130_fd_pr_reram__reram_cell area_ox=0.0676
XMp_41_13 dp_41_13 WL41 SL13 VSS sky130_fd_pr__nfet_g5v0d10v5 w=1 l=0.5
XRp_41_13 BLP13 dp_41_13 sky130_fd_pr_reram__reram_cell area_ox=0.0676
XMz_41_13 dz_41_13 WL41 SL13 VSS sky130_fd_pr__nfet_g5v0d10v5 w=1 l=0.5
XRz_41_13 BLZ13 dz_41_13 sky130_fd_pr_reram__reram_cell area_ox=0.0676
XMn_41_13 dn_41_13 WL41 SL13 VSS sky130_fd_pr__nfet_g5v0d10v5 w=1 l=0.5
XRn_41_13 BLN13 dn_41_13 sky130_fd_pr_reram__reram_cell area_ox=0.0676
XMp_41_14 dp_41_14 WL41 SL14 VSS sky130_fd_pr__nfet_g5v0d10v5 w=1 l=0.5
XRp_41_14 BLP14 dp_41_14 sky130_fd_pr_reram__reram_cell area_ox=0.0676
XMz_41_14 dz_41_14 WL41 SL14 VSS sky130_fd_pr__nfet_g5v0d10v5 w=1 l=0.5
XRz_41_14 BLZ14 dz_41_14 sky130_fd_pr_reram__reram_cell area_ox=0.0676
XMn_41_14 dn_41_14 WL41 SL14 VSS sky130_fd_pr__nfet_g5v0d10v5 w=1 l=0.5
XRn_41_14 BLN14 dn_41_14 sky130_fd_pr_reram__reram_cell area_ox=0.0676
XMp_41_15 dp_41_15 WL41 SL15 VSS sky130_fd_pr__nfet_g5v0d10v5 w=1 l=0.5
XRp_41_15 BLP15 dp_41_15 sky130_fd_pr_reram__reram_cell area_ox=0.0676
XMz_41_15 dz_41_15 WL41 SL15 VSS sky130_fd_pr__nfet_g5v0d10v5 w=1 l=0.5
XRz_41_15 BLZ15 dz_41_15 sky130_fd_pr_reram__reram_cell area_ox=0.0676
XMn_41_15 dn_41_15 WL41 SL15 VSS sky130_fd_pr__nfet_g5v0d10v5 w=1 l=0.5
XRn_41_15 BLN15 dn_41_15 sky130_fd_pr_reram__reram_cell area_ox=0.0676
XMp_41_16 dp_41_16 WL41 SL16 VSS sky130_fd_pr__nfet_g5v0d10v5 w=1 l=0.5
XRp_41_16 BLP16 dp_41_16 sky130_fd_pr_reram__reram_cell area_ox=0.0676
XMz_41_16 dz_41_16 WL41 SL16 VSS sky130_fd_pr__nfet_g5v0d10v5 w=1 l=0.5
XRz_41_16 BLZ16 dz_41_16 sky130_fd_pr_reram__reram_cell area_ox=0.0676
XMn_41_16 dn_41_16 WL41 SL16 VSS sky130_fd_pr__nfet_g5v0d10v5 w=1 l=0.5
XRn_41_16 BLN16 dn_41_16 sky130_fd_pr_reram__reram_cell area_ox=0.0676
XMp_41_17 dp_41_17 WL41 SL17 VSS sky130_fd_pr__nfet_g5v0d10v5 w=1 l=0.5
XRp_41_17 BLP17 dp_41_17 sky130_fd_pr_reram__reram_cell area_ox=0.0676
XMz_41_17 dz_41_17 WL41 SL17 VSS sky130_fd_pr__nfet_g5v0d10v5 w=1 l=0.5
XRz_41_17 BLZ17 dz_41_17 sky130_fd_pr_reram__reram_cell area_ox=0.0676
XMn_41_17 dn_41_17 WL41 SL17 VSS sky130_fd_pr__nfet_g5v0d10v5 w=1 l=0.5
XRn_41_17 BLN17 dn_41_17 sky130_fd_pr_reram__reram_cell area_ox=0.0676
XMp_41_18 dp_41_18 WL41 SL18 VSS sky130_fd_pr__nfet_g5v0d10v5 w=1 l=0.5
XRp_41_18 BLP18 dp_41_18 sky130_fd_pr_reram__reram_cell area_ox=0.0676
XMz_41_18 dz_41_18 WL41 SL18 VSS sky130_fd_pr__nfet_g5v0d10v5 w=1 l=0.5
XRz_41_18 BLZ18 dz_41_18 sky130_fd_pr_reram__reram_cell area_ox=0.0676
XMn_41_18 dn_41_18 WL41 SL18 VSS sky130_fd_pr__nfet_g5v0d10v5 w=1 l=0.5
XRn_41_18 BLN18 dn_41_18 sky130_fd_pr_reram__reram_cell area_ox=0.0676
XMp_41_19 dp_41_19 WL41 SL19 VSS sky130_fd_pr__nfet_g5v0d10v5 w=1 l=0.5
XRp_41_19 BLP19 dp_41_19 sky130_fd_pr_reram__reram_cell area_ox=0.0676
XMz_41_19 dz_41_19 WL41 SL19 VSS sky130_fd_pr__nfet_g5v0d10v5 w=1 l=0.5
XRz_41_19 BLZ19 dz_41_19 sky130_fd_pr_reram__reram_cell area_ox=0.0676
XMn_41_19 dn_41_19 WL41 SL19 VSS sky130_fd_pr__nfet_g5v0d10v5 w=1 l=0.5
XRn_41_19 BLN19 dn_41_19 sky130_fd_pr_reram__reram_cell area_ox=0.0676
XMp_41_20 dp_41_20 WL41 SL20 VSS sky130_fd_pr__nfet_g5v0d10v5 w=1 l=0.5
XRp_41_20 BLP20 dp_41_20 sky130_fd_pr_reram__reram_cell area_ox=0.0676
XMz_41_20 dz_41_20 WL41 SL20 VSS sky130_fd_pr__nfet_g5v0d10v5 w=1 l=0.5
XRz_41_20 BLZ20 dz_41_20 sky130_fd_pr_reram__reram_cell area_ox=0.0676
XMn_41_20 dn_41_20 WL41 SL20 VSS sky130_fd_pr__nfet_g5v0d10v5 w=1 l=0.5
XRn_41_20 BLN20 dn_41_20 sky130_fd_pr_reram__reram_cell area_ox=0.0676
XMp_41_21 dp_41_21 WL41 SL21 VSS sky130_fd_pr__nfet_g5v0d10v5 w=1 l=0.5
XRp_41_21 BLP21 dp_41_21 sky130_fd_pr_reram__reram_cell area_ox=0.0676
XMz_41_21 dz_41_21 WL41 SL21 VSS sky130_fd_pr__nfet_g5v0d10v5 w=1 l=0.5
XRz_41_21 BLZ21 dz_41_21 sky130_fd_pr_reram__reram_cell area_ox=0.0676
XMn_41_21 dn_41_21 WL41 SL21 VSS sky130_fd_pr__nfet_g5v0d10v5 w=1 l=0.5
XRn_41_21 BLN21 dn_41_21 sky130_fd_pr_reram__reram_cell area_ox=0.0676
XMp_41_22 dp_41_22 WL41 SL22 VSS sky130_fd_pr__nfet_g5v0d10v5 w=1 l=0.5
XRp_41_22 BLP22 dp_41_22 sky130_fd_pr_reram__reram_cell area_ox=0.0676
XMz_41_22 dz_41_22 WL41 SL22 VSS sky130_fd_pr__nfet_g5v0d10v5 w=1 l=0.5
XRz_41_22 BLZ22 dz_41_22 sky130_fd_pr_reram__reram_cell area_ox=0.0676
XMn_41_22 dn_41_22 WL41 SL22 VSS sky130_fd_pr__nfet_g5v0d10v5 w=1 l=0.5
XRn_41_22 BLN22 dn_41_22 sky130_fd_pr_reram__reram_cell area_ox=0.0676
XMp_41_23 dp_41_23 WL41 SL23 VSS sky130_fd_pr__nfet_g5v0d10v5 w=1 l=0.5
XRp_41_23 BLP23 dp_41_23 sky130_fd_pr_reram__reram_cell area_ox=0.0676
XMz_41_23 dz_41_23 WL41 SL23 VSS sky130_fd_pr__nfet_g5v0d10v5 w=1 l=0.5
XRz_41_23 BLZ23 dz_41_23 sky130_fd_pr_reram__reram_cell area_ox=0.0676
XMn_41_23 dn_41_23 WL41 SL23 VSS sky130_fd_pr__nfet_g5v0d10v5 w=1 l=0.5
XRn_41_23 BLN23 dn_41_23 sky130_fd_pr_reram__reram_cell area_ox=0.0676
XMp_42_0 dp_42_0 WL42 SL0 VSS sky130_fd_pr__nfet_g5v0d10v5 w=1 l=0.5
XRp_42_0 BLP0 dp_42_0 sky130_fd_pr_reram__reram_cell area_ox=0.0676
XMz_42_0 dz_42_0 WL42 SL0 VSS sky130_fd_pr__nfet_g5v0d10v5 w=1 l=0.5
XRz_42_0 BLZ0 dz_42_0 sky130_fd_pr_reram__reram_cell area_ox=0.0676
XMn_42_0 dn_42_0 WL42 SL0 VSS sky130_fd_pr__nfet_g5v0d10v5 w=1 l=0.5
XRn_42_0 BLN0 dn_42_0 sky130_fd_pr_reram__reram_cell area_ox=0.0676
XMp_42_1 dp_42_1 WL42 SL1 VSS sky130_fd_pr__nfet_g5v0d10v5 w=1 l=0.5
XRp_42_1 BLP1 dp_42_1 sky130_fd_pr_reram__reram_cell area_ox=0.0676
XMz_42_1 dz_42_1 WL42 SL1 VSS sky130_fd_pr__nfet_g5v0d10v5 w=1 l=0.5
XRz_42_1 BLZ1 dz_42_1 sky130_fd_pr_reram__reram_cell area_ox=0.0676
XMn_42_1 dn_42_1 WL42 SL1 VSS sky130_fd_pr__nfet_g5v0d10v5 w=1 l=0.5
XRn_42_1 BLN1 dn_42_1 sky130_fd_pr_reram__reram_cell area_ox=0.0676
XMp_42_2 dp_42_2 WL42 SL2 VSS sky130_fd_pr__nfet_g5v0d10v5 w=1 l=0.5
XRp_42_2 BLP2 dp_42_2 sky130_fd_pr_reram__reram_cell area_ox=0.0676
XMz_42_2 dz_42_2 WL42 SL2 VSS sky130_fd_pr__nfet_g5v0d10v5 w=1 l=0.5
XRz_42_2 BLZ2 dz_42_2 sky130_fd_pr_reram__reram_cell area_ox=0.0676
XMn_42_2 dn_42_2 WL42 SL2 VSS sky130_fd_pr__nfet_g5v0d10v5 w=1 l=0.5
XRn_42_2 BLN2 dn_42_2 sky130_fd_pr_reram__reram_cell area_ox=0.0676
XMp_42_3 dp_42_3 WL42 SL3 VSS sky130_fd_pr__nfet_g5v0d10v5 w=1 l=0.5
XRp_42_3 BLP3 dp_42_3 sky130_fd_pr_reram__reram_cell area_ox=0.0676
XMz_42_3 dz_42_3 WL42 SL3 VSS sky130_fd_pr__nfet_g5v0d10v5 w=1 l=0.5
XRz_42_3 BLZ3 dz_42_3 sky130_fd_pr_reram__reram_cell area_ox=0.0676
XMn_42_3 dn_42_3 WL42 SL3 VSS sky130_fd_pr__nfet_g5v0d10v5 w=1 l=0.5
XRn_42_3 BLN3 dn_42_3 sky130_fd_pr_reram__reram_cell area_ox=0.0676
XMp_42_4 dp_42_4 WL42 SL4 VSS sky130_fd_pr__nfet_g5v0d10v5 w=1 l=0.5
XRp_42_4 BLP4 dp_42_4 sky130_fd_pr_reram__reram_cell area_ox=0.0676
XMz_42_4 dz_42_4 WL42 SL4 VSS sky130_fd_pr__nfet_g5v0d10v5 w=1 l=0.5
XRz_42_4 BLZ4 dz_42_4 sky130_fd_pr_reram__reram_cell area_ox=0.0676
XMn_42_4 dn_42_4 WL42 SL4 VSS sky130_fd_pr__nfet_g5v0d10v5 w=1 l=0.5
XRn_42_4 BLN4 dn_42_4 sky130_fd_pr_reram__reram_cell area_ox=0.0676
XMp_42_5 dp_42_5 WL42 SL5 VSS sky130_fd_pr__nfet_g5v0d10v5 w=1 l=0.5
XRp_42_5 BLP5 dp_42_5 sky130_fd_pr_reram__reram_cell area_ox=0.0676
XMz_42_5 dz_42_5 WL42 SL5 VSS sky130_fd_pr__nfet_g5v0d10v5 w=1 l=0.5
XRz_42_5 BLZ5 dz_42_5 sky130_fd_pr_reram__reram_cell area_ox=0.0676
XMn_42_5 dn_42_5 WL42 SL5 VSS sky130_fd_pr__nfet_g5v0d10v5 w=1 l=0.5
XRn_42_5 BLN5 dn_42_5 sky130_fd_pr_reram__reram_cell area_ox=0.0676
XMp_42_6 dp_42_6 WL42 SL6 VSS sky130_fd_pr__nfet_g5v0d10v5 w=1 l=0.5
XRp_42_6 BLP6 dp_42_6 sky130_fd_pr_reram__reram_cell area_ox=0.0676
XMz_42_6 dz_42_6 WL42 SL6 VSS sky130_fd_pr__nfet_g5v0d10v5 w=1 l=0.5
XRz_42_6 BLZ6 dz_42_6 sky130_fd_pr_reram__reram_cell area_ox=0.0676
XMn_42_6 dn_42_6 WL42 SL6 VSS sky130_fd_pr__nfet_g5v0d10v5 w=1 l=0.5
XRn_42_6 BLN6 dn_42_6 sky130_fd_pr_reram__reram_cell area_ox=0.0676
XMp_42_7 dp_42_7 WL42 SL7 VSS sky130_fd_pr__nfet_g5v0d10v5 w=1 l=0.5
XRp_42_7 BLP7 dp_42_7 sky130_fd_pr_reram__reram_cell area_ox=0.0676
XMz_42_7 dz_42_7 WL42 SL7 VSS sky130_fd_pr__nfet_g5v0d10v5 w=1 l=0.5
XRz_42_7 BLZ7 dz_42_7 sky130_fd_pr_reram__reram_cell area_ox=0.0676
XMn_42_7 dn_42_7 WL42 SL7 VSS sky130_fd_pr__nfet_g5v0d10v5 w=1 l=0.5
XRn_42_7 BLN7 dn_42_7 sky130_fd_pr_reram__reram_cell area_ox=0.0676
XMp_42_8 dp_42_8 WL42 SL8 VSS sky130_fd_pr__nfet_g5v0d10v5 w=1 l=0.5
XRp_42_8 BLP8 dp_42_8 sky130_fd_pr_reram__reram_cell area_ox=0.0676
XMz_42_8 dz_42_8 WL42 SL8 VSS sky130_fd_pr__nfet_g5v0d10v5 w=1 l=0.5
XRz_42_8 BLZ8 dz_42_8 sky130_fd_pr_reram__reram_cell area_ox=0.0676
XMn_42_8 dn_42_8 WL42 SL8 VSS sky130_fd_pr__nfet_g5v0d10v5 w=1 l=0.5
XRn_42_8 BLN8 dn_42_8 sky130_fd_pr_reram__reram_cell area_ox=0.0676
XMp_42_9 dp_42_9 WL42 SL9 VSS sky130_fd_pr__nfet_g5v0d10v5 w=1 l=0.5
XRp_42_9 BLP9 dp_42_9 sky130_fd_pr_reram__reram_cell area_ox=0.0676
XMz_42_9 dz_42_9 WL42 SL9 VSS sky130_fd_pr__nfet_g5v0d10v5 w=1 l=0.5
XRz_42_9 BLZ9 dz_42_9 sky130_fd_pr_reram__reram_cell area_ox=0.0676
XMn_42_9 dn_42_9 WL42 SL9 VSS sky130_fd_pr__nfet_g5v0d10v5 w=1 l=0.5
XRn_42_9 BLN9 dn_42_9 sky130_fd_pr_reram__reram_cell area_ox=0.0676
XMp_42_10 dp_42_10 WL42 SL10 VSS sky130_fd_pr__nfet_g5v0d10v5 w=1 l=0.5
XRp_42_10 BLP10 dp_42_10 sky130_fd_pr_reram__reram_cell area_ox=0.0676
XMz_42_10 dz_42_10 WL42 SL10 VSS sky130_fd_pr__nfet_g5v0d10v5 w=1 l=0.5
XRz_42_10 BLZ10 dz_42_10 sky130_fd_pr_reram__reram_cell area_ox=0.0676
XMn_42_10 dn_42_10 WL42 SL10 VSS sky130_fd_pr__nfet_g5v0d10v5 w=1 l=0.5
XRn_42_10 BLN10 dn_42_10 sky130_fd_pr_reram__reram_cell area_ox=0.0676
XMp_42_11 dp_42_11 WL42 SL11 VSS sky130_fd_pr__nfet_g5v0d10v5 w=1 l=0.5
XRp_42_11 BLP11 dp_42_11 sky130_fd_pr_reram__reram_cell area_ox=0.0676
XMz_42_11 dz_42_11 WL42 SL11 VSS sky130_fd_pr__nfet_g5v0d10v5 w=1 l=0.5
XRz_42_11 BLZ11 dz_42_11 sky130_fd_pr_reram__reram_cell area_ox=0.0676
XMn_42_11 dn_42_11 WL42 SL11 VSS sky130_fd_pr__nfet_g5v0d10v5 w=1 l=0.5
XRn_42_11 BLN11 dn_42_11 sky130_fd_pr_reram__reram_cell area_ox=0.0676
XMp_42_12 dp_42_12 WL42 SL12 VSS sky130_fd_pr__nfet_g5v0d10v5 w=1 l=0.5
XRp_42_12 BLP12 dp_42_12 sky130_fd_pr_reram__reram_cell area_ox=0.0676
XMz_42_12 dz_42_12 WL42 SL12 VSS sky130_fd_pr__nfet_g5v0d10v5 w=1 l=0.5
XRz_42_12 BLZ12 dz_42_12 sky130_fd_pr_reram__reram_cell area_ox=0.0676
XMn_42_12 dn_42_12 WL42 SL12 VSS sky130_fd_pr__nfet_g5v0d10v5 w=1 l=0.5
XRn_42_12 BLN12 dn_42_12 sky130_fd_pr_reram__reram_cell area_ox=0.0676
XMp_42_13 dp_42_13 WL42 SL13 VSS sky130_fd_pr__nfet_g5v0d10v5 w=1 l=0.5
XRp_42_13 BLP13 dp_42_13 sky130_fd_pr_reram__reram_cell area_ox=0.0676
XMz_42_13 dz_42_13 WL42 SL13 VSS sky130_fd_pr__nfet_g5v0d10v5 w=1 l=0.5
XRz_42_13 BLZ13 dz_42_13 sky130_fd_pr_reram__reram_cell area_ox=0.0676
XMn_42_13 dn_42_13 WL42 SL13 VSS sky130_fd_pr__nfet_g5v0d10v5 w=1 l=0.5
XRn_42_13 BLN13 dn_42_13 sky130_fd_pr_reram__reram_cell area_ox=0.0676
XMp_42_14 dp_42_14 WL42 SL14 VSS sky130_fd_pr__nfet_g5v0d10v5 w=1 l=0.5
XRp_42_14 BLP14 dp_42_14 sky130_fd_pr_reram__reram_cell area_ox=0.0676
XMz_42_14 dz_42_14 WL42 SL14 VSS sky130_fd_pr__nfet_g5v0d10v5 w=1 l=0.5
XRz_42_14 BLZ14 dz_42_14 sky130_fd_pr_reram__reram_cell area_ox=0.0676
XMn_42_14 dn_42_14 WL42 SL14 VSS sky130_fd_pr__nfet_g5v0d10v5 w=1 l=0.5
XRn_42_14 BLN14 dn_42_14 sky130_fd_pr_reram__reram_cell area_ox=0.0676
XMp_42_15 dp_42_15 WL42 SL15 VSS sky130_fd_pr__nfet_g5v0d10v5 w=1 l=0.5
XRp_42_15 BLP15 dp_42_15 sky130_fd_pr_reram__reram_cell area_ox=0.0676
XMz_42_15 dz_42_15 WL42 SL15 VSS sky130_fd_pr__nfet_g5v0d10v5 w=1 l=0.5
XRz_42_15 BLZ15 dz_42_15 sky130_fd_pr_reram__reram_cell area_ox=0.0676
XMn_42_15 dn_42_15 WL42 SL15 VSS sky130_fd_pr__nfet_g5v0d10v5 w=1 l=0.5
XRn_42_15 BLN15 dn_42_15 sky130_fd_pr_reram__reram_cell area_ox=0.0676
XMp_42_16 dp_42_16 WL42 SL16 VSS sky130_fd_pr__nfet_g5v0d10v5 w=1 l=0.5
XRp_42_16 BLP16 dp_42_16 sky130_fd_pr_reram__reram_cell area_ox=0.0676
XMz_42_16 dz_42_16 WL42 SL16 VSS sky130_fd_pr__nfet_g5v0d10v5 w=1 l=0.5
XRz_42_16 BLZ16 dz_42_16 sky130_fd_pr_reram__reram_cell area_ox=0.0676
XMn_42_16 dn_42_16 WL42 SL16 VSS sky130_fd_pr__nfet_g5v0d10v5 w=1 l=0.5
XRn_42_16 BLN16 dn_42_16 sky130_fd_pr_reram__reram_cell area_ox=0.0676
XMp_42_17 dp_42_17 WL42 SL17 VSS sky130_fd_pr__nfet_g5v0d10v5 w=1 l=0.5
XRp_42_17 BLP17 dp_42_17 sky130_fd_pr_reram__reram_cell area_ox=0.0676
XMz_42_17 dz_42_17 WL42 SL17 VSS sky130_fd_pr__nfet_g5v0d10v5 w=1 l=0.5
XRz_42_17 BLZ17 dz_42_17 sky130_fd_pr_reram__reram_cell area_ox=0.0676
XMn_42_17 dn_42_17 WL42 SL17 VSS sky130_fd_pr__nfet_g5v0d10v5 w=1 l=0.5
XRn_42_17 BLN17 dn_42_17 sky130_fd_pr_reram__reram_cell area_ox=0.0676
XMp_42_18 dp_42_18 WL42 SL18 VSS sky130_fd_pr__nfet_g5v0d10v5 w=1 l=0.5
XRp_42_18 BLP18 dp_42_18 sky130_fd_pr_reram__reram_cell area_ox=0.0676
XMz_42_18 dz_42_18 WL42 SL18 VSS sky130_fd_pr__nfet_g5v0d10v5 w=1 l=0.5
XRz_42_18 BLZ18 dz_42_18 sky130_fd_pr_reram__reram_cell area_ox=0.0676
XMn_42_18 dn_42_18 WL42 SL18 VSS sky130_fd_pr__nfet_g5v0d10v5 w=1 l=0.5
XRn_42_18 BLN18 dn_42_18 sky130_fd_pr_reram__reram_cell area_ox=0.0676
XMp_42_19 dp_42_19 WL42 SL19 VSS sky130_fd_pr__nfet_g5v0d10v5 w=1 l=0.5
XRp_42_19 BLP19 dp_42_19 sky130_fd_pr_reram__reram_cell area_ox=0.0676
XMz_42_19 dz_42_19 WL42 SL19 VSS sky130_fd_pr__nfet_g5v0d10v5 w=1 l=0.5
XRz_42_19 BLZ19 dz_42_19 sky130_fd_pr_reram__reram_cell area_ox=0.0676
XMn_42_19 dn_42_19 WL42 SL19 VSS sky130_fd_pr__nfet_g5v0d10v5 w=1 l=0.5
XRn_42_19 BLN19 dn_42_19 sky130_fd_pr_reram__reram_cell area_ox=0.0676
XMp_42_20 dp_42_20 WL42 SL20 VSS sky130_fd_pr__nfet_g5v0d10v5 w=1 l=0.5
XRp_42_20 BLP20 dp_42_20 sky130_fd_pr_reram__reram_cell area_ox=0.0676
XMz_42_20 dz_42_20 WL42 SL20 VSS sky130_fd_pr__nfet_g5v0d10v5 w=1 l=0.5
XRz_42_20 BLZ20 dz_42_20 sky130_fd_pr_reram__reram_cell area_ox=0.0676
XMn_42_20 dn_42_20 WL42 SL20 VSS sky130_fd_pr__nfet_g5v0d10v5 w=1 l=0.5
XRn_42_20 BLN20 dn_42_20 sky130_fd_pr_reram__reram_cell area_ox=0.0676
XMp_42_21 dp_42_21 WL42 SL21 VSS sky130_fd_pr__nfet_g5v0d10v5 w=1 l=0.5
XRp_42_21 BLP21 dp_42_21 sky130_fd_pr_reram__reram_cell area_ox=0.0676
XMz_42_21 dz_42_21 WL42 SL21 VSS sky130_fd_pr__nfet_g5v0d10v5 w=1 l=0.5
XRz_42_21 BLZ21 dz_42_21 sky130_fd_pr_reram__reram_cell area_ox=0.0676
XMn_42_21 dn_42_21 WL42 SL21 VSS sky130_fd_pr__nfet_g5v0d10v5 w=1 l=0.5
XRn_42_21 BLN21 dn_42_21 sky130_fd_pr_reram__reram_cell area_ox=0.0676
XMp_42_22 dp_42_22 WL42 SL22 VSS sky130_fd_pr__nfet_g5v0d10v5 w=1 l=0.5
XRp_42_22 BLP22 dp_42_22 sky130_fd_pr_reram__reram_cell area_ox=0.0676
XMz_42_22 dz_42_22 WL42 SL22 VSS sky130_fd_pr__nfet_g5v0d10v5 w=1 l=0.5
XRz_42_22 BLZ22 dz_42_22 sky130_fd_pr_reram__reram_cell area_ox=0.0676
XMn_42_22 dn_42_22 WL42 SL22 VSS sky130_fd_pr__nfet_g5v0d10v5 w=1 l=0.5
XRn_42_22 BLN22 dn_42_22 sky130_fd_pr_reram__reram_cell area_ox=0.0676
XMp_42_23 dp_42_23 WL42 SL23 VSS sky130_fd_pr__nfet_g5v0d10v5 w=1 l=0.5
XRp_42_23 BLP23 dp_42_23 sky130_fd_pr_reram__reram_cell area_ox=0.0676
XMz_42_23 dz_42_23 WL42 SL23 VSS sky130_fd_pr__nfet_g5v0d10v5 w=1 l=0.5
XRz_42_23 BLZ23 dz_42_23 sky130_fd_pr_reram__reram_cell area_ox=0.0676
XMn_42_23 dn_42_23 WL42 SL23 VSS sky130_fd_pr__nfet_g5v0d10v5 w=1 l=0.5
XRn_42_23 BLN23 dn_42_23 sky130_fd_pr_reram__reram_cell area_ox=0.0676
XMp_43_0 dp_43_0 WL43 SL0 VSS sky130_fd_pr__nfet_g5v0d10v5 w=1 l=0.5
XRp_43_0 BLP0 dp_43_0 sky130_fd_pr_reram__reram_cell area_ox=0.0676
XMz_43_0 dz_43_0 WL43 SL0 VSS sky130_fd_pr__nfet_g5v0d10v5 w=1 l=0.5
XRz_43_0 BLZ0 dz_43_0 sky130_fd_pr_reram__reram_cell area_ox=0.0676
XMn_43_0 dn_43_0 WL43 SL0 VSS sky130_fd_pr__nfet_g5v0d10v5 w=1 l=0.5
XRn_43_0 BLN0 dn_43_0 sky130_fd_pr_reram__reram_cell area_ox=0.0676
XMp_43_1 dp_43_1 WL43 SL1 VSS sky130_fd_pr__nfet_g5v0d10v5 w=1 l=0.5
XRp_43_1 BLP1 dp_43_1 sky130_fd_pr_reram__reram_cell area_ox=0.0676
XMz_43_1 dz_43_1 WL43 SL1 VSS sky130_fd_pr__nfet_g5v0d10v5 w=1 l=0.5
XRz_43_1 BLZ1 dz_43_1 sky130_fd_pr_reram__reram_cell area_ox=0.0676
XMn_43_1 dn_43_1 WL43 SL1 VSS sky130_fd_pr__nfet_g5v0d10v5 w=1 l=0.5
XRn_43_1 BLN1 dn_43_1 sky130_fd_pr_reram__reram_cell area_ox=0.0676
XMp_43_2 dp_43_2 WL43 SL2 VSS sky130_fd_pr__nfet_g5v0d10v5 w=1 l=0.5
XRp_43_2 BLP2 dp_43_2 sky130_fd_pr_reram__reram_cell area_ox=0.0676
XMz_43_2 dz_43_2 WL43 SL2 VSS sky130_fd_pr__nfet_g5v0d10v5 w=1 l=0.5
XRz_43_2 BLZ2 dz_43_2 sky130_fd_pr_reram__reram_cell area_ox=0.0676
XMn_43_2 dn_43_2 WL43 SL2 VSS sky130_fd_pr__nfet_g5v0d10v5 w=1 l=0.5
XRn_43_2 BLN2 dn_43_2 sky130_fd_pr_reram__reram_cell area_ox=0.0676
XMp_43_3 dp_43_3 WL43 SL3 VSS sky130_fd_pr__nfet_g5v0d10v5 w=1 l=0.5
XRp_43_3 BLP3 dp_43_3 sky130_fd_pr_reram__reram_cell area_ox=0.0676
XMz_43_3 dz_43_3 WL43 SL3 VSS sky130_fd_pr__nfet_g5v0d10v5 w=1 l=0.5
XRz_43_3 BLZ3 dz_43_3 sky130_fd_pr_reram__reram_cell area_ox=0.0676
XMn_43_3 dn_43_3 WL43 SL3 VSS sky130_fd_pr__nfet_g5v0d10v5 w=1 l=0.5
XRn_43_3 BLN3 dn_43_3 sky130_fd_pr_reram__reram_cell area_ox=0.0676
XMp_43_4 dp_43_4 WL43 SL4 VSS sky130_fd_pr__nfet_g5v0d10v5 w=1 l=0.5
XRp_43_4 BLP4 dp_43_4 sky130_fd_pr_reram__reram_cell area_ox=0.0676
XMz_43_4 dz_43_4 WL43 SL4 VSS sky130_fd_pr__nfet_g5v0d10v5 w=1 l=0.5
XRz_43_4 BLZ4 dz_43_4 sky130_fd_pr_reram__reram_cell area_ox=0.0676
XMn_43_4 dn_43_4 WL43 SL4 VSS sky130_fd_pr__nfet_g5v0d10v5 w=1 l=0.5
XRn_43_4 BLN4 dn_43_4 sky130_fd_pr_reram__reram_cell area_ox=0.0676
XMp_43_5 dp_43_5 WL43 SL5 VSS sky130_fd_pr__nfet_g5v0d10v5 w=1 l=0.5
XRp_43_5 BLP5 dp_43_5 sky130_fd_pr_reram__reram_cell area_ox=0.0676
XMz_43_5 dz_43_5 WL43 SL5 VSS sky130_fd_pr__nfet_g5v0d10v5 w=1 l=0.5
XRz_43_5 BLZ5 dz_43_5 sky130_fd_pr_reram__reram_cell area_ox=0.0676
XMn_43_5 dn_43_5 WL43 SL5 VSS sky130_fd_pr__nfet_g5v0d10v5 w=1 l=0.5
XRn_43_5 BLN5 dn_43_5 sky130_fd_pr_reram__reram_cell area_ox=0.0676
XMp_43_6 dp_43_6 WL43 SL6 VSS sky130_fd_pr__nfet_g5v0d10v5 w=1 l=0.5
XRp_43_6 BLP6 dp_43_6 sky130_fd_pr_reram__reram_cell area_ox=0.0676
XMz_43_6 dz_43_6 WL43 SL6 VSS sky130_fd_pr__nfet_g5v0d10v5 w=1 l=0.5
XRz_43_6 BLZ6 dz_43_6 sky130_fd_pr_reram__reram_cell area_ox=0.0676
XMn_43_6 dn_43_6 WL43 SL6 VSS sky130_fd_pr__nfet_g5v0d10v5 w=1 l=0.5
XRn_43_6 BLN6 dn_43_6 sky130_fd_pr_reram__reram_cell area_ox=0.0676
XMp_43_7 dp_43_7 WL43 SL7 VSS sky130_fd_pr__nfet_g5v0d10v5 w=1 l=0.5
XRp_43_7 BLP7 dp_43_7 sky130_fd_pr_reram__reram_cell area_ox=0.0676
XMz_43_7 dz_43_7 WL43 SL7 VSS sky130_fd_pr__nfet_g5v0d10v5 w=1 l=0.5
XRz_43_7 BLZ7 dz_43_7 sky130_fd_pr_reram__reram_cell area_ox=0.0676
XMn_43_7 dn_43_7 WL43 SL7 VSS sky130_fd_pr__nfet_g5v0d10v5 w=1 l=0.5
XRn_43_7 BLN7 dn_43_7 sky130_fd_pr_reram__reram_cell area_ox=0.0676
XMp_43_8 dp_43_8 WL43 SL8 VSS sky130_fd_pr__nfet_g5v0d10v5 w=1 l=0.5
XRp_43_8 BLP8 dp_43_8 sky130_fd_pr_reram__reram_cell area_ox=0.0676
XMz_43_8 dz_43_8 WL43 SL8 VSS sky130_fd_pr__nfet_g5v0d10v5 w=1 l=0.5
XRz_43_8 BLZ8 dz_43_8 sky130_fd_pr_reram__reram_cell area_ox=0.0676
XMn_43_8 dn_43_8 WL43 SL8 VSS sky130_fd_pr__nfet_g5v0d10v5 w=1 l=0.5
XRn_43_8 BLN8 dn_43_8 sky130_fd_pr_reram__reram_cell area_ox=0.0676
XMp_43_9 dp_43_9 WL43 SL9 VSS sky130_fd_pr__nfet_g5v0d10v5 w=1 l=0.5
XRp_43_9 BLP9 dp_43_9 sky130_fd_pr_reram__reram_cell area_ox=0.0676
XMz_43_9 dz_43_9 WL43 SL9 VSS sky130_fd_pr__nfet_g5v0d10v5 w=1 l=0.5
XRz_43_9 BLZ9 dz_43_9 sky130_fd_pr_reram__reram_cell area_ox=0.0676
XMn_43_9 dn_43_9 WL43 SL9 VSS sky130_fd_pr__nfet_g5v0d10v5 w=1 l=0.5
XRn_43_9 BLN9 dn_43_9 sky130_fd_pr_reram__reram_cell area_ox=0.0676
XMp_43_10 dp_43_10 WL43 SL10 VSS sky130_fd_pr__nfet_g5v0d10v5 w=1 l=0.5
XRp_43_10 BLP10 dp_43_10 sky130_fd_pr_reram__reram_cell area_ox=0.0676
XMz_43_10 dz_43_10 WL43 SL10 VSS sky130_fd_pr__nfet_g5v0d10v5 w=1 l=0.5
XRz_43_10 BLZ10 dz_43_10 sky130_fd_pr_reram__reram_cell area_ox=0.0676
XMn_43_10 dn_43_10 WL43 SL10 VSS sky130_fd_pr__nfet_g5v0d10v5 w=1 l=0.5
XRn_43_10 BLN10 dn_43_10 sky130_fd_pr_reram__reram_cell area_ox=0.0676
XMp_43_11 dp_43_11 WL43 SL11 VSS sky130_fd_pr__nfet_g5v0d10v5 w=1 l=0.5
XRp_43_11 BLP11 dp_43_11 sky130_fd_pr_reram__reram_cell area_ox=0.0676
XMz_43_11 dz_43_11 WL43 SL11 VSS sky130_fd_pr__nfet_g5v0d10v5 w=1 l=0.5
XRz_43_11 BLZ11 dz_43_11 sky130_fd_pr_reram__reram_cell area_ox=0.0676
XMn_43_11 dn_43_11 WL43 SL11 VSS sky130_fd_pr__nfet_g5v0d10v5 w=1 l=0.5
XRn_43_11 BLN11 dn_43_11 sky130_fd_pr_reram__reram_cell area_ox=0.0676
XMp_43_12 dp_43_12 WL43 SL12 VSS sky130_fd_pr__nfet_g5v0d10v5 w=1 l=0.5
XRp_43_12 BLP12 dp_43_12 sky130_fd_pr_reram__reram_cell area_ox=0.0676
XMz_43_12 dz_43_12 WL43 SL12 VSS sky130_fd_pr__nfet_g5v0d10v5 w=1 l=0.5
XRz_43_12 BLZ12 dz_43_12 sky130_fd_pr_reram__reram_cell area_ox=0.0676
XMn_43_12 dn_43_12 WL43 SL12 VSS sky130_fd_pr__nfet_g5v0d10v5 w=1 l=0.5
XRn_43_12 BLN12 dn_43_12 sky130_fd_pr_reram__reram_cell area_ox=0.0676
XMp_43_13 dp_43_13 WL43 SL13 VSS sky130_fd_pr__nfet_g5v0d10v5 w=1 l=0.5
XRp_43_13 BLP13 dp_43_13 sky130_fd_pr_reram__reram_cell area_ox=0.0676
XMz_43_13 dz_43_13 WL43 SL13 VSS sky130_fd_pr__nfet_g5v0d10v5 w=1 l=0.5
XRz_43_13 BLZ13 dz_43_13 sky130_fd_pr_reram__reram_cell area_ox=0.0676
XMn_43_13 dn_43_13 WL43 SL13 VSS sky130_fd_pr__nfet_g5v0d10v5 w=1 l=0.5
XRn_43_13 BLN13 dn_43_13 sky130_fd_pr_reram__reram_cell area_ox=0.0676
XMp_43_14 dp_43_14 WL43 SL14 VSS sky130_fd_pr__nfet_g5v0d10v5 w=1 l=0.5
XRp_43_14 BLP14 dp_43_14 sky130_fd_pr_reram__reram_cell area_ox=0.0676
XMz_43_14 dz_43_14 WL43 SL14 VSS sky130_fd_pr__nfet_g5v0d10v5 w=1 l=0.5
XRz_43_14 BLZ14 dz_43_14 sky130_fd_pr_reram__reram_cell area_ox=0.0676
XMn_43_14 dn_43_14 WL43 SL14 VSS sky130_fd_pr__nfet_g5v0d10v5 w=1 l=0.5
XRn_43_14 BLN14 dn_43_14 sky130_fd_pr_reram__reram_cell area_ox=0.0676
XMp_43_15 dp_43_15 WL43 SL15 VSS sky130_fd_pr__nfet_g5v0d10v5 w=1 l=0.5
XRp_43_15 BLP15 dp_43_15 sky130_fd_pr_reram__reram_cell area_ox=0.0676
XMz_43_15 dz_43_15 WL43 SL15 VSS sky130_fd_pr__nfet_g5v0d10v5 w=1 l=0.5
XRz_43_15 BLZ15 dz_43_15 sky130_fd_pr_reram__reram_cell area_ox=0.0676
XMn_43_15 dn_43_15 WL43 SL15 VSS sky130_fd_pr__nfet_g5v0d10v5 w=1 l=0.5
XRn_43_15 BLN15 dn_43_15 sky130_fd_pr_reram__reram_cell area_ox=0.0676
XMp_43_16 dp_43_16 WL43 SL16 VSS sky130_fd_pr__nfet_g5v0d10v5 w=1 l=0.5
XRp_43_16 BLP16 dp_43_16 sky130_fd_pr_reram__reram_cell area_ox=0.0676
XMz_43_16 dz_43_16 WL43 SL16 VSS sky130_fd_pr__nfet_g5v0d10v5 w=1 l=0.5
XRz_43_16 BLZ16 dz_43_16 sky130_fd_pr_reram__reram_cell area_ox=0.0676
XMn_43_16 dn_43_16 WL43 SL16 VSS sky130_fd_pr__nfet_g5v0d10v5 w=1 l=0.5
XRn_43_16 BLN16 dn_43_16 sky130_fd_pr_reram__reram_cell area_ox=0.0676
XMp_43_17 dp_43_17 WL43 SL17 VSS sky130_fd_pr__nfet_g5v0d10v5 w=1 l=0.5
XRp_43_17 BLP17 dp_43_17 sky130_fd_pr_reram__reram_cell area_ox=0.0676
XMz_43_17 dz_43_17 WL43 SL17 VSS sky130_fd_pr__nfet_g5v0d10v5 w=1 l=0.5
XRz_43_17 BLZ17 dz_43_17 sky130_fd_pr_reram__reram_cell area_ox=0.0676
XMn_43_17 dn_43_17 WL43 SL17 VSS sky130_fd_pr__nfet_g5v0d10v5 w=1 l=0.5
XRn_43_17 BLN17 dn_43_17 sky130_fd_pr_reram__reram_cell area_ox=0.0676
XMp_43_18 dp_43_18 WL43 SL18 VSS sky130_fd_pr__nfet_g5v0d10v5 w=1 l=0.5
XRp_43_18 BLP18 dp_43_18 sky130_fd_pr_reram__reram_cell area_ox=0.0676
XMz_43_18 dz_43_18 WL43 SL18 VSS sky130_fd_pr__nfet_g5v0d10v5 w=1 l=0.5
XRz_43_18 BLZ18 dz_43_18 sky130_fd_pr_reram__reram_cell area_ox=0.0676
XMn_43_18 dn_43_18 WL43 SL18 VSS sky130_fd_pr__nfet_g5v0d10v5 w=1 l=0.5
XRn_43_18 BLN18 dn_43_18 sky130_fd_pr_reram__reram_cell area_ox=0.0676
XMp_43_19 dp_43_19 WL43 SL19 VSS sky130_fd_pr__nfet_g5v0d10v5 w=1 l=0.5
XRp_43_19 BLP19 dp_43_19 sky130_fd_pr_reram__reram_cell area_ox=0.0676
XMz_43_19 dz_43_19 WL43 SL19 VSS sky130_fd_pr__nfet_g5v0d10v5 w=1 l=0.5
XRz_43_19 BLZ19 dz_43_19 sky130_fd_pr_reram__reram_cell area_ox=0.0676
XMn_43_19 dn_43_19 WL43 SL19 VSS sky130_fd_pr__nfet_g5v0d10v5 w=1 l=0.5
XRn_43_19 BLN19 dn_43_19 sky130_fd_pr_reram__reram_cell area_ox=0.0676
XMp_43_20 dp_43_20 WL43 SL20 VSS sky130_fd_pr__nfet_g5v0d10v5 w=1 l=0.5
XRp_43_20 BLP20 dp_43_20 sky130_fd_pr_reram__reram_cell area_ox=0.0676
XMz_43_20 dz_43_20 WL43 SL20 VSS sky130_fd_pr__nfet_g5v0d10v5 w=1 l=0.5
XRz_43_20 BLZ20 dz_43_20 sky130_fd_pr_reram__reram_cell area_ox=0.0676
XMn_43_20 dn_43_20 WL43 SL20 VSS sky130_fd_pr__nfet_g5v0d10v5 w=1 l=0.5
XRn_43_20 BLN20 dn_43_20 sky130_fd_pr_reram__reram_cell area_ox=0.0676
XMp_43_21 dp_43_21 WL43 SL21 VSS sky130_fd_pr__nfet_g5v0d10v5 w=1 l=0.5
XRp_43_21 BLP21 dp_43_21 sky130_fd_pr_reram__reram_cell area_ox=0.0676
XMz_43_21 dz_43_21 WL43 SL21 VSS sky130_fd_pr__nfet_g5v0d10v5 w=1 l=0.5
XRz_43_21 BLZ21 dz_43_21 sky130_fd_pr_reram__reram_cell area_ox=0.0676
XMn_43_21 dn_43_21 WL43 SL21 VSS sky130_fd_pr__nfet_g5v0d10v5 w=1 l=0.5
XRn_43_21 BLN21 dn_43_21 sky130_fd_pr_reram__reram_cell area_ox=0.0676
XMp_43_22 dp_43_22 WL43 SL22 VSS sky130_fd_pr__nfet_g5v0d10v5 w=1 l=0.5
XRp_43_22 BLP22 dp_43_22 sky130_fd_pr_reram__reram_cell area_ox=0.0676
XMz_43_22 dz_43_22 WL43 SL22 VSS sky130_fd_pr__nfet_g5v0d10v5 w=1 l=0.5
XRz_43_22 BLZ22 dz_43_22 sky130_fd_pr_reram__reram_cell area_ox=0.0676
XMn_43_22 dn_43_22 WL43 SL22 VSS sky130_fd_pr__nfet_g5v0d10v5 w=1 l=0.5
XRn_43_22 BLN22 dn_43_22 sky130_fd_pr_reram__reram_cell area_ox=0.0676
XMp_43_23 dp_43_23 WL43 SL23 VSS sky130_fd_pr__nfet_g5v0d10v5 w=1 l=0.5
XRp_43_23 BLP23 dp_43_23 sky130_fd_pr_reram__reram_cell area_ox=0.0676
XMz_43_23 dz_43_23 WL43 SL23 VSS sky130_fd_pr__nfet_g5v0d10v5 w=1 l=0.5
XRz_43_23 BLZ23 dz_43_23 sky130_fd_pr_reram__reram_cell area_ox=0.0676
XMn_43_23 dn_43_23 WL43 SL23 VSS sky130_fd_pr__nfet_g5v0d10v5 w=1 l=0.5
XRn_43_23 BLN23 dn_43_23 sky130_fd_pr_reram__reram_cell area_ox=0.0676
XMp_44_0 dp_44_0 WL44 SL0 VSS sky130_fd_pr__nfet_g5v0d10v5 w=1 l=0.5
XRp_44_0 BLP0 dp_44_0 sky130_fd_pr_reram__reram_cell area_ox=0.0676
XMz_44_0 dz_44_0 WL44 SL0 VSS sky130_fd_pr__nfet_g5v0d10v5 w=1 l=0.5
XRz_44_0 BLZ0 dz_44_0 sky130_fd_pr_reram__reram_cell area_ox=0.0676
XMn_44_0 dn_44_0 WL44 SL0 VSS sky130_fd_pr__nfet_g5v0d10v5 w=1 l=0.5
XRn_44_0 BLN0 dn_44_0 sky130_fd_pr_reram__reram_cell area_ox=0.0676
XMp_44_1 dp_44_1 WL44 SL1 VSS sky130_fd_pr__nfet_g5v0d10v5 w=1 l=0.5
XRp_44_1 BLP1 dp_44_1 sky130_fd_pr_reram__reram_cell area_ox=0.0676
XMz_44_1 dz_44_1 WL44 SL1 VSS sky130_fd_pr__nfet_g5v0d10v5 w=1 l=0.5
XRz_44_1 BLZ1 dz_44_1 sky130_fd_pr_reram__reram_cell area_ox=0.0676
XMn_44_1 dn_44_1 WL44 SL1 VSS sky130_fd_pr__nfet_g5v0d10v5 w=1 l=0.5
XRn_44_1 BLN1 dn_44_1 sky130_fd_pr_reram__reram_cell area_ox=0.0676
XMp_44_2 dp_44_2 WL44 SL2 VSS sky130_fd_pr__nfet_g5v0d10v5 w=1 l=0.5
XRp_44_2 BLP2 dp_44_2 sky130_fd_pr_reram__reram_cell area_ox=0.0676
XMz_44_2 dz_44_2 WL44 SL2 VSS sky130_fd_pr__nfet_g5v0d10v5 w=1 l=0.5
XRz_44_2 BLZ2 dz_44_2 sky130_fd_pr_reram__reram_cell area_ox=0.0676
XMn_44_2 dn_44_2 WL44 SL2 VSS sky130_fd_pr__nfet_g5v0d10v5 w=1 l=0.5
XRn_44_2 BLN2 dn_44_2 sky130_fd_pr_reram__reram_cell area_ox=0.0676
XMp_44_3 dp_44_3 WL44 SL3 VSS sky130_fd_pr__nfet_g5v0d10v5 w=1 l=0.5
XRp_44_3 BLP3 dp_44_3 sky130_fd_pr_reram__reram_cell area_ox=0.0676
XMz_44_3 dz_44_3 WL44 SL3 VSS sky130_fd_pr__nfet_g5v0d10v5 w=1 l=0.5
XRz_44_3 BLZ3 dz_44_3 sky130_fd_pr_reram__reram_cell area_ox=0.0676
XMn_44_3 dn_44_3 WL44 SL3 VSS sky130_fd_pr__nfet_g5v0d10v5 w=1 l=0.5
XRn_44_3 BLN3 dn_44_3 sky130_fd_pr_reram__reram_cell area_ox=0.0676
XMp_44_4 dp_44_4 WL44 SL4 VSS sky130_fd_pr__nfet_g5v0d10v5 w=1 l=0.5
XRp_44_4 BLP4 dp_44_4 sky130_fd_pr_reram__reram_cell area_ox=0.0676
XMz_44_4 dz_44_4 WL44 SL4 VSS sky130_fd_pr__nfet_g5v0d10v5 w=1 l=0.5
XRz_44_4 BLZ4 dz_44_4 sky130_fd_pr_reram__reram_cell area_ox=0.0676
XMn_44_4 dn_44_4 WL44 SL4 VSS sky130_fd_pr__nfet_g5v0d10v5 w=1 l=0.5
XRn_44_4 BLN4 dn_44_4 sky130_fd_pr_reram__reram_cell area_ox=0.0676
XMp_44_5 dp_44_5 WL44 SL5 VSS sky130_fd_pr__nfet_g5v0d10v5 w=1 l=0.5
XRp_44_5 BLP5 dp_44_5 sky130_fd_pr_reram__reram_cell area_ox=0.0676
XMz_44_5 dz_44_5 WL44 SL5 VSS sky130_fd_pr__nfet_g5v0d10v5 w=1 l=0.5
XRz_44_5 BLZ5 dz_44_5 sky130_fd_pr_reram__reram_cell area_ox=0.0676
XMn_44_5 dn_44_5 WL44 SL5 VSS sky130_fd_pr__nfet_g5v0d10v5 w=1 l=0.5
XRn_44_5 BLN5 dn_44_5 sky130_fd_pr_reram__reram_cell area_ox=0.0676
XMp_44_6 dp_44_6 WL44 SL6 VSS sky130_fd_pr__nfet_g5v0d10v5 w=1 l=0.5
XRp_44_6 BLP6 dp_44_6 sky130_fd_pr_reram__reram_cell area_ox=0.0676
XMz_44_6 dz_44_6 WL44 SL6 VSS sky130_fd_pr__nfet_g5v0d10v5 w=1 l=0.5
XRz_44_6 BLZ6 dz_44_6 sky130_fd_pr_reram__reram_cell area_ox=0.0676
XMn_44_6 dn_44_6 WL44 SL6 VSS sky130_fd_pr__nfet_g5v0d10v5 w=1 l=0.5
XRn_44_6 BLN6 dn_44_6 sky130_fd_pr_reram__reram_cell area_ox=0.0676
XMp_44_7 dp_44_7 WL44 SL7 VSS sky130_fd_pr__nfet_g5v0d10v5 w=1 l=0.5
XRp_44_7 BLP7 dp_44_7 sky130_fd_pr_reram__reram_cell area_ox=0.0676
XMz_44_7 dz_44_7 WL44 SL7 VSS sky130_fd_pr__nfet_g5v0d10v5 w=1 l=0.5
XRz_44_7 BLZ7 dz_44_7 sky130_fd_pr_reram__reram_cell area_ox=0.0676
XMn_44_7 dn_44_7 WL44 SL7 VSS sky130_fd_pr__nfet_g5v0d10v5 w=1 l=0.5
XRn_44_7 BLN7 dn_44_7 sky130_fd_pr_reram__reram_cell area_ox=0.0676
XMp_44_8 dp_44_8 WL44 SL8 VSS sky130_fd_pr__nfet_g5v0d10v5 w=1 l=0.5
XRp_44_8 BLP8 dp_44_8 sky130_fd_pr_reram__reram_cell area_ox=0.0676
XMz_44_8 dz_44_8 WL44 SL8 VSS sky130_fd_pr__nfet_g5v0d10v5 w=1 l=0.5
XRz_44_8 BLZ8 dz_44_8 sky130_fd_pr_reram__reram_cell area_ox=0.0676
XMn_44_8 dn_44_8 WL44 SL8 VSS sky130_fd_pr__nfet_g5v0d10v5 w=1 l=0.5
XRn_44_8 BLN8 dn_44_8 sky130_fd_pr_reram__reram_cell area_ox=0.0676
XMp_44_9 dp_44_9 WL44 SL9 VSS sky130_fd_pr__nfet_g5v0d10v5 w=1 l=0.5
XRp_44_9 BLP9 dp_44_9 sky130_fd_pr_reram__reram_cell area_ox=0.0676
XMz_44_9 dz_44_9 WL44 SL9 VSS sky130_fd_pr__nfet_g5v0d10v5 w=1 l=0.5
XRz_44_9 BLZ9 dz_44_9 sky130_fd_pr_reram__reram_cell area_ox=0.0676
XMn_44_9 dn_44_9 WL44 SL9 VSS sky130_fd_pr__nfet_g5v0d10v5 w=1 l=0.5
XRn_44_9 BLN9 dn_44_9 sky130_fd_pr_reram__reram_cell area_ox=0.0676
XMp_44_10 dp_44_10 WL44 SL10 VSS sky130_fd_pr__nfet_g5v0d10v5 w=1 l=0.5
XRp_44_10 BLP10 dp_44_10 sky130_fd_pr_reram__reram_cell area_ox=0.0676
XMz_44_10 dz_44_10 WL44 SL10 VSS sky130_fd_pr__nfet_g5v0d10v5 w=1 l=0.5
XRz_44_10 BLZ10 dz_44_10 sky130_fd_pr_reram__reram_cell area_ox=0.0676
XMn_44_10 dn_44_10 WL44 SL10 VSS sky130_fd_pr__nfet_g5v0d10v5 w=1 l=0.5
XRn_44_10 BLN10 dn_44_10 sky130_fd_pr_reram__reram_cell area_ox=0.0676
XMp_44_11 dp_44_11 WL44 SL11 VSS sky130_fd_pr__nfet_g5v0d10v5 w=1 l=0.5
XRp_44_11 BLP11 dp_44_11 sky130_fd_pr_reram__reram_cell area_ox=0.0676
XMz_44_11 dz_44_11 WL44 SL11 VSS sky130_fd_pr__nfet_g5v0d10v5 w=1 l=0.5
XRz_44_11 BLZ11 dz_44_11 sky130_fd_pr_reram__reram_cell area_ox=0.0676
XMn_44_11 dn_44_11 WL44 SL11 VSS sky130_fd_pr__nfet_g5v0d10v5 w=1 l=0.5
XRn_44_11 BLN11 dn_44_11 sky130_fd_pr_reram__reram_cell area_ox=0.0676
XMp_44_12 dp_44_12 WL44 SL12 VSS sky130_fd_pr__nfet_g5v0d10v5 w=1 l=0.5
XRp_44_12 BLP12 dp_44_12 sky130_fd_pr_reram__reram_cell area_ox=0.0676
XMz_44_12 dz_44_12 WL44 SL12 VSS sky130_fd_pr__nfet_g5v0d10v5 w=1 l=0.5
XRz_44_12 BLZ12 dz_44_12 sky130_fd_pr_reram__reram_cell area_ox=0.0676
XMn_44_12 dn_44_12 WL44 SL12 VSS sky130_fd_pr__nfet_g5v0d10v5 w=1 l=0.5
XRn_44_12 BLN12 dn_44_12 sky130_fd_pr_reram__reram_cell area_ox=0.0676
XMp_44_13 dp_44_13 WL44 SL13 VSS sky130_fd_pr__nfet_g5v0d10v5 w=1 l=0.5
XRp_44_13 BLP13 dp_44_13 sky130_fd_pr_reram__reram_cell area_ox=0.0676
XMz_44_13 dz_44_13 WL44 SL13 VSS sky130_fd_pr__nfet_g5v0d10v5 w=1 l=0.5
XRz_44_13 BLZ13 dz_44_13 sky130_fd_pr_reram__reram_cell area_ox=0.0676
XMn_44_13 dn_44_13 WL44 SL13 VSS sky130_fd_pr__nfet_g5v0d10v5 w=1 l=0.5
XRn_44_13 BLN13 dn_44_13 sky130_fd_pr_reram__reram_cell area_ox=0.0676
XMp_44_14 dp_44_14 WL44 SL14 VSS sky130_fd_pr__nfet_g5v0d10v5 w=1 l=0.5
XRp_44_14 BLP14 dp_44_14 sky130_fd_pr_reram__reram_cell area_ox=0.0676
XMz_44_14 dz_44_14 WL44 SL14 VSS sky130_fd_pr__nfet_g5v0d10v5 w=1 l=0.5
XRz_44_14 BLZ14 dz_44_14 sky130_fd_pr_reram__reram_cell area_ox=0.0676
XMn_44_14 dn_44_14 WL44 SL14 VSS sky130_fd_pr__nfet_g5v0d10v5 w=1 l=0.5
XRn_44_14 BLN14 dn_44_14 sky130_fd_pr_reram__reram_cell area_ox=0.0676
XMp_44_15 dp_44_15 WL44 SL15 VSS sky130_fd_pr__nfet_g5v0d10v5 w=1 l=0.5
XRp_44_15 BLP15 dp_44_15 sky130_fd_pr_reram__reram_cell area_ox=0.0676
XMz_44_15 dz_44_15 WL44 SL15 VSS sky130_fd_pr__nfet_g5v0d10v5 w=1 l=0.5
XRz_44_15 BLZ15 dz_44_15 sky130_fd_pr_reram__reram_cell area_ox=0.0676
XMn_44_15 dn_44_15 WL44 SL15 VSS sky130_fd_pr__nfet_g5v0d10v5 w=1 l=0.5
XRn_44_15 BLN15 dn_44_15 sky130_fd_pr_reram__reram_cell area_ox=0.0676
XMp_44_16 dp_44_16 WL44 SL16 VSS sky130_fd_pr__nfet_g5v0d10v5 w=1 l=0.5
XRp_44_16 BLP16 dp_44_16 sky130_fd_pr_reram__reram_cell area_ox=0.0676
XMz_44_16 dz_44_16 WL44 SL16 VSS sky130_fd_pr__nfet_g5v0d10v5 w=1 l=0.5
XRz_44_16 BLZ16 dz_44_16 sky130_fd_pr_reram__reram_cell area_ox=0.0676
XMn_44_16 dn_44_16 WL44 SL16 VSS sky130_fd_pr__nfet_g5v0d10v5 w=1 l=0.5
XRn_44_16 BLN16 dn_44_16 sky130_fd_pr_reram__reram_cell area_ox=0.0676
XMp_44_17 dp_44_17 WL44 SL17 VSS sky130_fd_pr__nfet_g5v0d10v5 w=1 l=0.5
XRp_44_17 BLP17 dp_44_17 sky130_fd_pr_reram__reram_cell area_ox=0.0676
XMz_44_17 dz_44_17 WL44 SL17 VSS sky130_fd_pr__nfet_g5v0d10v5 w=1 l=0.5
XRz_44_17 BLZ17 dz_44_17 sky130_fd_pr_reram__reram_cell area_ox=0.0676
XMn_44_17 dn_44_17 WL44 SL17 VSS sky130_fd_pr__nfet_g5v0d10v5 w=1 l=0.5
XRn_44_17 BLN17 dn_44_17 sky130_fd_pr_reram__reram_cell area_ox=0.0676
XMp_44_18 dp_44_18 WL44 SL18 VSS sky130_fd_pr__nfet_g5v0d10v5 w=1 l=0.5
XRp_44_18 BLP18 dp_44_18 sky130_fd_pr_reram__reram_cell area_ox=0.0676
XMz_44_18 dz_44_18 WL44 SL18 VSS sky130_fd_pr__nfet_g5v0d10v5 w=1 l=0.5
XRz_44_18 BLZ18 dz_44_18 sky130_fd_pr_reram__reram_cell area_ox=0.0676
XMn_44_18 dn_44_18 WL44 SL18 VSS sky130_fd_pr__nfet_g5v0d10v5 w=1 l=0.5
XRn_44_18 BLN18 dn_44_18 sky130_fd_pr_reram__reram_cell area_ox=0.0676
XMp_44_19 dp_44_19 WL44 SL19 VSS sky130_fd_pr__nfet_g5v0d10v5 w=1 l=0.5
XRp_44_19 BLP19 dp_44_19 sky130_fd_pr_reram__reram_cell area_ox=0.0676
XMz_44_19 dz_44_19 WL44 SL19 VSS sky130_fd_pr__nfet_g5v0d10v5 w=1 l=0.5
XRz_44_19 BLZ19 dz_44_19 sky130_fd_pr_reram__reram_cell area_ox=0.0676
XMn_44_19 dn_44_19 WL44 SL19 VSS sky130_fd_pr__nfet_g5v0d10v5 w=1 l=0.5
XRn_44_19 BLN19 dn_44_19 sky130_fd_pr_reram__reram_cell area_ox=0.0676
XMp_44_20 dp_44_20 WL44 SL20 VSS sky130_fd_pr__nfet_g5v0d10v5 w=1 l=0.5
XRp_44_20 BLP20 dp_44_20 sky130_fd_pr_reram__reram_cell area_ox=0.0676
XMz_44_20 dz_44_20 WL44 SL20 VSS sky130_fd_pr__nfet_g5v0d10v5 w=1 l=0.5
XRz_44_20 BLZ20 dz_44_20 sky130_fd_pr_reram__reram_cell area_ox=0.0676
XMn_44_20 dn_44_20 WL44 SL20 VSS sky130_fd_pr__nfet_g5v0d10v5 w=1 l=0.5
XRn_44_20 BLN20 dn_44_20 sky130_fd_pr_reram__reram_cell area_ox=0.0676
XMp_44_21 dp_44_21 WL44 SL21 VSS sky130_fd_pr__nfet_g5v0d10v5 w=1 l=0.5
XRp_44_21 BLP21 dp_44_21 sky130_fd_pr_reram__reram_cell area_ox=0.0676
XMz_44_21 dz_44_21 WL44 SL21 VSS sky130_fd_pr__nfet_g5v0d10v5 w=1 l=0.5
XRz_44_21 BLZ21 dz_44_21 sky130_fd_pr_reram__reram_cell area_ox=0.0676
XMn_44_21 dn_44_21 WL44 SL21 VSS sky130_fd_pr__nfet_g5v0d10v5 w=1 l=0.5
XRn_44_21 BLN21 dn_44_21 sky130_fd_pr_reram__reram_cell area_ox=0.0676
XMp_44_22 dp_44_22 WL44 SL22 VSS sky130_fd_pr__nfet_g5v0d10v5 w=1 l=0.5
XRp_44_22 BLP22 dp_44_22 sky130_fd_pr_reram__reram_cell area_ox=0.0676
XMz_44_22 dz_44_22 WL44 SL22 VSS sky130_fd_pr__nfet_g5v0d10v5 w=1 l=0.5
XRz_44_22 BLZ22 dz_44_22 sky130_fd_pr_reram__reram_cell area_ox=0.0676
XMn_44_22 dn_44_22 WL44 SL22 VSS sky130_fd_pr__nfet_g5v0d10v5 w=1 l=0.5
XRn_44_22 BLN22 dn_44_22 sky130_fd_pr_reram__reram_cell area_ox=0.0676
XMp_44_23 dp_44_23 WL44 SL23 VSS sky130_fd_pr__nfet_g5v0d10v5 w=1 l=0.5
XRp_44_23 BLP23 dp_44_23 sky130_fd_pr_reram__reram_cell area_ox=0.0676
XMz_44_23 dz_44_23 WL44 SL23 VSS sky130_fd_pr__nfet_g5v0d10v5 w=1 l=0.5
XRz_44_23 BLZ23 dz_44_23 sky130_fd_pr_reram__reram_cell area_ox=0.0676
XMn_44_23 dn_44_23 WL44 SL23 VSS sky130_fd_pr__nfet_g5v0d10v5 w=1 l=0.5
XRn_44_23 BLN23 dn_44_23 sky130_fd_pr_reram__reram_cell area_ox=0.0676
XMp_45_0 dp_45_0 WL45 SL0 VSS sky130_fd_pr__nfet_g5v0d10v5 w=1 l=0.5
XRp_45_0 BLP0 dp_45_0 sky130_fd_pr_reram__reram_cell area_ox=0.0676
XMz_45_0 dz_45_0 WL45 SL0 VSS sky130_fd_pr__nfet_g5v0d10v5 w=1 l=0.5
XRz_45_0 BLZ0 dz_45_0 sky130_fd_pr_reram__reram_cell area_ox=0.0676
XMn_45_0 dn_45_0 WL45 SL0 VSS sky130_fd_pr__nfet_g5v0d10v5 w=1 l=0.5
XRn_45_0 BLN0 dn_45_0 sky130_fd_pr_reram__reram_cell area_ox=0.0676
XMp_45_1 dp_45_1 WL45 SL1 VSS sky130_fd_pr__nfet_g5v0d10v5 w=1 l=0.5
XRp_45_1 BLP1 dp_45_1 sky130_fd_pr_reram__reram_cell area_ox=0.0676
XMz_45_1 dz_45_1 WL45 SL1 VSS sky130_fd_pr__nfet_g5v0d10v5 w=1 l=0.5
XRz_45_1 BLZ1 dz_45_1 sky130_fd_pr_reram__reram_cell area_ox=0.0676
XMn_45_1 dn_45_1 WL45 SL1 VSS sky130_fd_pr__nfet_g5v0d10v5 w=1 l=0.5
XRn_45_1 BLN1 dn_45_1 sky130_fd_pr_reram__reram_cell area_ox=0.0676
XMp_45_2 dp_45_2 WL45 SL2 VSS sky130_fd_pr__nfet_g5v0d10v5 w=1 l=0.5
XRp_45_2 BLP2 dp_45_2 sky130_fd_pr_reram__reram_cell area_ox=0.0676
XMz_45_2 dz_45_2 WL45 SL2 VSS sky130_fd_pr__nfet_g5v0d10v5 w=1 l=0.5
XRz_45_2 BLZ2 dz_45_2 sky130_fd_pr_reram__reram_cell area_ox=0.0676
XMn_45_2 dn_45_2 WL45 SL2 VSS sky130_fd_pr__nfet_g5v0d10v5 w=1 l=0.5
XRn_45_2 BLN2 dn_45_2 sky130_fd_pr_reram__reram_cell area_ox=0.0676
XMp_45_3 dp_45_3 WL45 SL3 VSS sky130_fd_pr__nfet_g5v0d10v5 w=1 l=0.5
XRp_45_3 BLP3 dp_45_3 sky130_fd_pr_reram__reram_cell area_ox=0.0676
XMz_45_3 dz_45_3 WL45 SL3 VSS sky130_fd_pr__nfet_g5v0d10v5 w=1 l=0.5
XRz_45_3 BLZ3 dz_45_3 sky130_fd_pr_reram__reram_cell area_ox=0.0676
XMn_45_3 dn_45_3 WL45 SL3 VSS sky130_fd_pr__nfet_g5v0d10v5 w=1 l=0.5
XRn_45_3 BLN3 dn_45_3 sky130_fd_pr_reram__reram_cell area_ox=0.0676
XMp_45_4 dp_45_4 WL45 SL4 VSS sky130_fd_pr__nfet_g5v0d10v5 w=1 l=0.5
XRp_45_4 BLP4 dp_45_4 sky130_fd_pr_reram__reram_cell area_ox=0.0676
XMz_45_4 dz_45_4 WL45 SL4 VSS sky130_fd_pr__nfet_g5v0d10v5 w=1 l=0.5
XRz_45_4 BLZ4 dz_45_4 sky130_fd_pr_reram__reram_cell area_ox=0.0676
XMn_45_4 dn_45_4 WL45 SL4 VSS sky130_fd_pr__nfet_g5v0d10v5 w=1 l=0.5
XRn_45_4 BLN4 dn_45_4 sky130_fd_pr_reram__reram_cell area_ox=0.0676
XMp_45_5 dp_45_5 WL45 SL5 VSS sky130_fd_pr__nfet_g5v0d10v5 w=1 l=0.5
XRp_45_5 BLP5 dp_45_5 sky130_fd_pr_reram__reram_cell area_ox=0.0676
XMz_45_5 dz_45_5 WL45 SL5 VSS sky130_fd_pr__nfet_g5v0d10v5 w=1 l=0.5
XRz_45_5 BLZ5 dz_45_5 sky130_fd_pr_reram__reram_cell area_ox=0.0676
XMn_45_5 dn_45_5 WL45 SL5 VSS sky130_fd_pr__nfet_g5v0d10v5 w=1 l=0.5
XRn_45_5 BLN5 dn_45_5 sky130_fd_pr_reram__reram_cell area_ox=0.0676
XMp_45_6 dp_45_6 WL45 SL6 VSS sky130_fd_pr__nfet_g5v0d10v5 w=1 l=0.5
XRp_45_6 BLP6 dp_45_6 sky130_fd_pr_reram__reram_cell area_ox=0.0676
XMz_45_6 dz_45_6 WL45 SL6 VSS sky130_fd_pr__nfet_g5v0d10v5 w=1 l=0.5
XRz_45_6 BLZ6 dz_45_6 sky130_fd_pr_reram__reram_cell area_ox=0.0676
XMn_45_6 dn_45_6 WL45 SL6 VSS sky130_fd_pr__nfet_g5v0d10v5 w=1 l=0.5
XRn_45_6 BLN6 dn_45_6 sky130_fd_pr_reram__reram_cell area_ox=0.0676
XMp_45_7 dp_45_7 WL45 SL7 VSS sky130_fd_pr__nfet_g5v0d10v5 w=1 l=0.5
XRp_45_7 BLP7 dp_45_7 sky130_fd_pr_reram__reram_cell area_ox=0.0676
XMz_45_7 dz_45_7 WL45 SL7 VSS sky130_fd_pr__nfet_g5v0d10v5 w=1 l=0.5
XRz_45_7 BLZ7 dz_45_7 sky130_fd_pr_reram__reram_cell area_ox=0.0676
XMn_45_7 dn_45_7 WL45 SL7 VSS sky130_fd_pr__nfet_g5v0d10v5 w=1 l=0.5
XRn_45_7 BLN7 dn_45_7 sky130_fd_pr_reram__reram_cell area_ox=0.0676
XMp_45_8 dp_45_8 WL45 SL8 VSS sky130_fd_pr__nfet_g5v0d10v5 w=1 l=0.5
XRp_45_8 BLP8 dp_45_8 sky130_fd_pr_reram__reram_cell area_ox=0.0676
XMz_45_8 dz_45_8 WL45 SL8 VSS sky130_fd_pr__nfet_g5v0d10v5 w=1 l=0.5
XRz_45_8 BLZ8 dz_45_8 sky130_fd_pr_reram__reram_cell area_ox=0.0676
XMn_45_8 dn_45_8 WL45 SL8 VSS sky130_fd_pr__nfet_g5v0d10v5 w=1 l=0.5
XRn_45_8 BLN8 dn_45_8 sky130_fd_pr_reram__reram_cell area_ox=0.0676
XMp_45_9 dp_45_9 WL45 SL9 VSS sky130_fd_pr__nfet_g5v0d10v5 w=1 l=0.5
XRp_45_9 BLP9 dp_45_9 sky130_fd_pr_reram__reram_cell area_ox=0.0676
XMz_45_9 dz_45_9 WL45 SL9 VSS sky130_fd_pr__nfet_g5v0d10v5 w=1 l=0.5
XRz_45_9 BLZ9 dz_45_9 sky130_fd_pr_reram__reram_cell area_ox=0.0676
XMn_45_9 dn_45_9 WL45 SL9 VSS sky130_fd_pr__nfet_g5v0d10v5 w=1 l=0.5
XRn_45_9 BLN9 dn_45_9 sky130_fd_pr_reram__reram_cell area_ox=0.0676
XMp_45_10 dp_45_10 WL45 SL10 VSS sky130_fd_pr__nfet_g5v0d10v5 w=1 l=0.5
XRp_45_10 BLP10 dp_45_10 sky130_fd_pr_reram__reram_cell area_ox=0.0676
XMz_45_10 dz_45_10 WL45 SL10 VSS sky130_fd_pr__nfet_g5v0d10v5 w=1 l=0.5
XRz_45_10 BLZ10 dz_45_10 sky130_fd_pr_reram__reram_cell area_ox=0.0676
XMn_45_10 dn_45_10 WL45 SL10 VSS sky130_fd_pr__nfet_g5v0d10v5 w=1 l=0.5
XRn_45_10 BLN10 dn_45_10 sky130_fd_pr_reram__reram_cell area_ox=0.0676
XMp_45_11 dp_45_11 WL45 SL11 VSS sky130_fd_pr__nfet_g5v0d10v5 w=1 l=0.5
XRp_45_11 BLP11 dp_45_11 sky130_fd_pr_reram__reram_cell area_ox=0.0676
XMz_45_11 dz_45_11 WL45 SL11 VSS sky130_fd_pr__nfet_g5v0d10v5 w=1 l=0.5
XRz_45_11 BLZ11 dz_45_11 sky130_fd_pr_reram__reram_cell area_ox=0.0676
XMn_45_11 dn_45_11 WL45 SL11 VSS sky130_fd_pr__nfet_g5v0d10v5 w=1 l=0.5
XRn_45_11 BLN11 dn_45_11 sky130_fd_pr_reram__reram_cell area_ox=0.0676
XMp_45_12 dp_45_12 WL45 SL12 VSS sky130_fd_pr__nfet_g5v0d10v5 w=1 l=0.5
XRp_45_12 BLP12 dp_45_12 sky130_fd_pr_reram__reram_cell area_ox=0.0676
XMz_45_12 dz_45_12 WL45 SL12 VSS sky130_fd_pr__nfet_g5v0d10v5 w=1 l=0.5
XRz_45_12 BLZ12 dz_45_12 sky130_fd_pr_reram__reram_cell area_ox=0.0676
XMn_45_12 dn_45_12 WL45 SL12 VSS sky130_fd_pr__nfet_g5v0d10v5 w=1 l=0.5
XRn_45_12 BLN12 dn_45_12 sky130_fd_pr_reram__reram_cell area_ox=0.0676
XMp_45_13 dp_45_13 WL45 SL13 VSS sky130_fd_pr__nfet_g5v0d10v5 w=1 l=0.5
XRp_45_13 BLP13 dp_45_13 sky130_fd_pr_reram__reram_cell area_ox=0.0676
XMz_45_13 dz_45_13 WL45 SL13 VSS sky130_fd_pr__nfet_g5v0d10v5 w=1 l=0.5
XRz_45_13 BLZ13 dz_45_13 sky130_fd_pr_reram__reram_cell area_ox=0.0676
XMn_45_13 dn_45_13 WL45 SL13 VSS sky130_fd_pr__nfet_g5v0d10v5 w=1 l=0.5
XRn_45_13 BLN13 dn_45_13 sky130_fd_pr_reram__reram_cell area_ox=0.0676
XMp_45_14 dp_45_14 WL45 SL14 VSS sky130_fd_pr__nfet_g5v0d10v5 w=1 l=0.5
XRp_45_14 BLP14 dp_45_14 sky130_fd_pr_reram__reram_cell area_ox=0.0676
XMz_45_14 dz_45_14 WL45 SL14 VSS sky130_fd_pr__nfet_g5v0d10v5 w=1 l=0.5
XRz_45_14 BLZ14 dz_45_14 sky130_fd_pr_reram__reram_cell area_ox=0.0676
XMn_45_14 dn_45_14 WL45 SL14 VSS sky130_fd_pr__nfet_g5v0d10v5 w=1 l=0.5
XRn_45_14 BLN14 dn_45_14 sky130_fd_pr_reram__reram_cell area_ox=0.0676
XMp_45_15 dp_45_15 WL45 SL15 VSS sky130_fd_pr__nfet_g5v0d10v5 w=1 l=0.5
XRp_45_15 BLP15 dp_45_15 sky130_fd_pr_reram__reram_cell area_ox=0.0676
XMz_45_15 dz_45_15 WL45 SL15 VSS sky130_fd_pr__nfet_g5v0d10v5 w=1 l=0.5
XRz_45_15 BLZ15 dz_45_15 sky130_fd_pr_reram__reram_cell area_ox=0.0676
XMn_45_15 dn_45_15 WL45 SL15 VSS sky130_fd_pr__nfet_g5v0d10v5 w=1 l=0.5
XRn_45_15 BLN15 dn_45_15 sky130_fd_pr_reram__reram_cell area_ox=0.0676
XMp_45_16 dp_45_16 WL45 SL16 VSS sky130_fd_pr__nfet_g5v0d10v5 w=1 l=0.5
XRp_45_16 BLP16 dp_45_16 sky130_fd_pr_reram__reram_cell area_ox=0.0676
XMz_45_16 dz_45_16 WL45 SL16 VSS sky130_fd_pr__nfet_g5v0d10v5 w=1 l=0.5
XRz_45_16 BLZ16 dz_45_16 sky130_fd_pr_reram__reram_cell area_ox=0.0676
XMn_45_16 dn_45_16 WL45 SL16 VSS sky130_fd_pr__nfet_g5v0d10v5 w=1 l=0.5
XRn_45_16 BLN16 dn_45_16 sky130_fd_pr_reram__reram_cell area_ox=0.0676
XMp_45_17 dp_45_17 WL45 SL17 VSS sky130_fd_pr__nfet_g5v0d10v5 w=1 l=0.5
XRp_45_17 BLP17 dp_45_17 sky130_fd_pr_reram__reram_cell area_ox=0.0676
XMz_45_17 dz_45_17 WL45 SL17 VSS sky130_fd_pr__nfet_g5v0d10v5 w=1 l=0.5
XRz_45_17 BLZ17 dz_45_17 sky130_fd_pr_reram__reram_cell area_ox=0.0676
XMn_45_17 dn_45_17 WL45 SL17 VSS sky130_fd_pr__nfet_g5v0d10v5 w=1 l=0.5
XRn_45_17 BLN17 dn_45_17 sky130_fd_pr_reram__reram_cell area_ox=0.0676
XMp_45_18 dp_45_18 WL45 SL18 VSS sky130_fd_pr__nfet_g5v0d10v5 w=1 l=0.5
XRp_45_18 BLP18 dp_45_18 sky130_fd_pr_reram__reram_cell area_ox=0.0676
XMz_45_18 dz_45_18 WL45 SL18 VSS sky130_fd_pr__nfet_g5v0d10v5 w=1 l=0.5
XRz_45_18 BLZ18 dz_45_18 sky130_fd_pr_reram__reram_cell area_ox=0.0676
XMn_45_18 dn_45_18 WL45 SL18 VSS sky130_fd_pr__nfet_g5v0d10v5 w=1 l=0.5
XRn_45_18 BLN18 dn_45_18 sky130_fd_pr_reram__reram_cell area_ox=0.0676
XMp_45_19 dp_45_19 WL45 SL19 VSS sky130_fd_pr__nfet_g5v0d10v5 w=1 l=0.5
XRp_45_19 BLP19 dp_45_19 sky130_fd_pr_reram__reram_cell area_ox=0.0676
XMz_45_19 dz_45_19 WL45 SL19 VSS sky130_fd_pr__nfet_g5v0d10v5 w=1 l=0.5
XRz_45_19 BLZ19 dz_45_19 sky130_fd_pr_reram__reram_cell area_ox=0.0676
XMn_45_19 dn_45_19 WL45 SL19 VSS sky130_fd_pr__nfet_g5v0d10v5 w=1 l=0.5
XRn_45_19 BLN19 dn_45_19 sky130_fd_pr_reram__reram_cell area_ox=0.0676
XMp_45_20 dp_45_20 WL45 SL20 VSS sky130_fd_pr__nfet_g5v0d10v5 w=1 l=0.5
XRp_45_20 BLP20 dp_45_20 sky130_fd_pr_reram__reram_cell area_ox=0.0676
XMz_45_20 dz_45_20 WL45 SL20 VSS sky130_fd_pr__nfet_g5v0d10v5 w=1 l=0.5
XRz_45_20 BLZ20 dz_45_20 sky130_fd_pr_reram__reram_cell area_ox=0.0676
XMn_45_20 dn_45_20 WL45 SL20 VSS sky130_fd_pr__nfet_g5v0d10v5 w=1 l=0.5
XRn_45_20 BLN20 dn_45_20 sky130_fd_pr_reram__reram_cell area_ox=0.0676
XMp_45_21 dp_45_21 WL45 SL21 VSS sky130_fd_pr__nfet_g5v0d10v5 w=1 l=0.5
XRp_45_21 BLP21 dp_45_21 sky130_fd_pr_reram__reram_cell area_ox=0.0676
XMz_45_21 dz_45_21 WL45 SL21 VSS sky130_fd_pr__nfet_g5v0d10v5 w=1 l=0.5
XRz_45_21 BLZ21 dz_45_21 sky130_fd_pr_reram__reram_cell area_ox=0.0676
XMn_45_21 dn_45_21 WL45 SL21 VSS sky130_fd_pr__nfet_g5v0d10v5 w=1 l=0.5
XRn_45_21 BLN21 dn_45_21 sky130_fd_pr_reram__reram_cell area_ox=0.0676
XMp_45_22 dp_45_22 WL45 SL22 VSS sky130_fd_pr__nfet_g5v0d10v5 w=1 l=0.5
XRp_45_22 BLP22 dp_45_22 sky130_fd_pr_reram__reram_cell area_ox=0.0676
XMz_45_22 dz_45_22 WL45 SL22 VSS sky130_fd_pr__nfet_g5v0d10v5 w=1 l=0.5
XRz_45_22 BLZ22 dz_45_22 sky130_fd_pr_reram__reram_cell area_ox=0.0676
XMn_45_22 dn_45_22 WL45 SL22 VSS sky130_fd_pr__nfet_g5v0d10v5 w=1 l=0.5
XRn_45_22 BLN22 dn_45_22 sky130_fd_pr_reram__reram_cell area_ox=0.0676
XMp_45_23 dp_45_23 WL45 SL23 VSS sky130_fd_pr__nfet_g5v0d10v5 w=1 l=0.5
XRp_45_23 BLP23 dp_45_23 sky130_fd_pr_reram__reram_cell area_ox=0.0676
XMz_45_23 dz_45_23 WL45 SL23 VSS sky130_fd_pr__nfet_g5v0d10v5 w=1 l=0.5
XRz_45_23 BLZ23 dz_45_23 sky130_fd_pr_reram__reram_cell area_ox=0.0676
XMn_45_23 dn_45_23 WL45 SL23 VSS sky130_fd_pr__nfet_g5v0d10v5 w=1 l=0.5
XRn_45_23 BLN23 dn_45_23 sky130_fd_pr_reram__reram_cell area_ox=0.0676
XMp_46_0 dp_46_0 WL46 SL0 VSS sky130_fd_pr__nfet_g5v0d10v5 w=1 l=0.5
XRp_46_0 BLP0 dp_46_0 sky130_fd_pr_reram__reram_cell area_ox=0.0676
XMz_46_0 dz_46_0 WL46 SL0 VSS sky130_fd_pr__nfet_g5v0d10v5 w=1 l=0.5
XRz_46_0 BLZ0 dz_46_0 sky130_fd_pr_reram__reram_cell area_ox=0.0676
XMn_46_0 dn_46_0 WL46 SL0 VSS sky130_fd_pr__nfet_g5v0d10v5 w=1 l=0.5
XRn_46_0 BLN0 dn_46_0 sky130_fd_pr_reram__reram_cell area_ox=0.0676
XMp_46_1 dp_46_1 WL46 SL1 VSS sky130_fd_pr__nfet_g5v0d10v5 w=1 l=0.5
XRp_46_1 BLP1 dp_46_1 sky130_fd_pr_reram__reram_cell area_ox=0.0676
XMz_46_1 dz_46_1 WL46 SL1 VSS sky130_fd_pr__nfet_g5v0d10v5 w=1 l=0.5
XRz_46_1 BLZ1 dz_46_1 sky130_fd_pr_reram__reram_cell area_ox=0.0676
XMn_46_1 dn_46_1 WL46 SL1 VSS sky130_fd_pr__nfet_g5v0d10v5 w=1 l=0.5
XRn_46_1 BLN1 dn_46_1 sky130_fd_pr_reram__reram_cell area_ox=0.0676
XMp_46_2 dp_46_2 WL46 SL2 VSS sky130_fd_pr__nfet_g5v0d10v5 w=1 l=0.5
XRp_46_2 BLP2 dp_46_2 sky130_fd_pr_reram__reram_cell area_ox=0.0676
XMz_46_2 dz_46_2 WL46 SL2 VSS sky130_fd_pr__nfet_g5v0d10v5 w=1 l=0.5
XRz_46_2 BLZ2 dz_46_2 sky130_fd_pr_reram__reram_cell area_ox=0.0676
XMn_46_2 dn_46_2 WL46 SL2 VSS sky130_fd_pr__nfet_g5v0d10v5 w=1 l=0.5
XRn_46_2 BLN2 dn_46_2 sky130_fd_pr_reram__reram_cell area_ox=0.0676
XMp_46_3 dp_46_3 WL46 SL3 VSS sky130_fd_pr__nfet_g5v0d10v5 w=1 l=0.5
XRp_46_3 BLP3 dp_46_3 sky130_fd_pr_reram__reram_cell area_ox=0.0676
XMz_46_3 dz_46_3 WL46 SL3 VSS sky130_fd_pr__nfet_g5v0d10v5 w=1 l=0.5
XRz_46_3 BLZ3 dz_46_3 sky130_fd_pr_reram__reram_cell area_ox=0.0676
XMn_46_3 dn_46_3 WL46 SL3 VSS sky130_fd_pr__nfet_g5v0d10v5 w=1 l=0.5
XRn_46_3 BLN3 dn_46_3 sky130_fd_pr_reram__reram_cell area_ox=0.0676
XMp_46_4 dp_46_4 WL46 SL4 VSS sky130_fd_pr__nfet_g5v0d10v5 w=1 l=0.5
XRp_46_4 BLP4 dp_46_4 sky130_fd_pr_reram__reram_cell area_ox=0.0676
XMz_46_4 dz_46_4 WL46 SL4 VSS sky130_fd_pr__nfet_g5v0d10v5 w=1 l=0.5
XRz_46_4 BLZ4 dz_46_4 sky130_fd_pr_reram__reram_cell area_ox=0.0676
XMn_46_4 dn_46_4 WL46 SL4 VSS sky130_fd_pr__nfet_g5v0d10v5 w=1 l=0.5
XRn_46_4 BLN4 dn_46_4 sky130_fd_pr_reram__reram_cell area_ox=0.0676
XMp_46_5 dp_46_5 WL46 SL5 VSS sky130_fd_pr__nfet_g5v0d10v5 w=1 l=0.5
XRp_46_5 BLP5 dp_46_5 sky130_fd_pr_reram__reram_cell area_ox=0.0676
XMz_46_5 dz_46_5 WL46 SL5 VSS sky130_fd_pr__nfet_g5v0d10v5 w=1 l=0.5
XRz_46_5 BLZ5 dz_46_5 sky130_fd_pr_reram__reram_cell area_ox=0.0676
XMn_46_5 dn_46_5 WL46 SL5 VSS sky130_fd_pr__nfet_g5v0d10v5 w=1 l=0.5
XRn_46_5 BLN5 dn_46_5 sky130_fd_pr_reram__reram_cell area_ox=0.0676
XMp_46_6 dp_46_6 WL46 SL6 VSS sky130_fd_pr__nfet_g5v0d10v5 w=1 l=0.5
XRp_46_6 BLP6 dp_46_6 sky130_fd_pr_reram__reram_cell area_ox=0.0676
XMz_46_6 dz_46_6 WL46 SL6 VSS sky130_fd_pr__nfet_g5v0d10v5 w=1 l=0.5
XRz_46_6 BLZ6 dz_46_6 sky130_fd_pr_reram__reram_cell area_ox=0.0676
XMn_46_6 dn_46_6 WL46 SL6 VSS sky130_fd_pr__nfet_g5v0d10v5 w=1 l=0.5
XRn_46_6 BLN6 dn_46_6 sky130_fd_pr_reram__reram_cell area_ox=0.0676
XMp_46_7 dp_46_7 WL46 SL7 VSS sky130_fd_pr__nfet_g5v0d10v5 w=1 l=0.5
XRp_46_7 BLP7 dp_46_7 sky130_fd_pr_reram__reram_cell area_ox=0.0676
XMz_46_7 dz_46_7 WL46 SL7 VSS sky130_fd_pr__nfet_g5v0d10v5 w=1 l=0.5
XRz_46_7 BLZ7 dz_46_7 sky130_fd_pr_reram__reram_cell area_ox=0.0676
XMn_46_7 dn_46_7 WL46 SL7 VSS sky130_fd_pr__nfet_g5v0d10v5 w=1 l=0.5
XRn_46_7 BLN7 dn_46_7 sky130_fd_pr_reram__reram_cell area_ox=0.0676
XMp_46_8 dp_46_8 WL46 SL8 VSS sky130_fd_pr__nfet_g5v0d10v5 w=1 l=0.5
XRp_46_8 BLP8 dp_46_8 sky130_fd_pr_reram__reram_cell area_ox=0.0676
XMz_46_8 dz_46_8 WL46 SL8 VSS sky130_fd_pr__nfet_g5v0d10v5 w=1 l=0.5
XRz_46_8 BLZ8 dz_46_8 sky130_fd_pr_reram__reram_cell area_ox=0.0676
XMn_46_8 dn_46_8 WL46 SL8 VSS sky130_fd_pr__nfet_g5v0d10v5 w=1 l=0.5
XRn_46_8 BLN8 dn_46_8 sky130_fd_pr_reram__reram_cell area_ox=0.0676
XMp_46_9 dp_46_9 WL46 SL9 VSS sky130_fd_pr__nfet_g5v0d10v5 w=1 l=0.5
XRp_46_9 BLP9 dp_46_9 sky130_fd_pr_reram__reram_cell area_ox=0.0676
XMz_46_9 dz_46_9 WL46 SL9 VSS sky130_fd_pr__nfet_g5v0d10v5 w=1 l=0.5
XRz_46_9 BLZ9 dz_46_9 sky130_fd_pr_reram__reram_cell area_ox=0.0676
XMn_46_9 dn_46_9 WL46 SL9 VSS sky130_fd_pr__nfet_g5v0d10v5 w=1 l=0.5
XRn_46_9 BLN9 dn_46_9 sky130_fd_pr_reram__reram_cell area_ox=0.0676
XMp_46_10 dp_46_10 WL46 SL10 VSS sky130_fd_pr__nfet_g5v0d10v5 w=1 l=0.5
XRp_46_10 BLP10 dp_46_10 sky130_fd_pr_reram__reram_cell area_ox=0.0676
XMz_46_10 dz_46_10 WL46 SL10 VSS sky130_fd_pr__nfet_g5v0d10v5 w=1 l=0.5
XRz_46_10 BLZ10 dz_46_10 sky130_fd_pr_reram__reram_cell area_ox=0.0676
XMn_46_10 dn_46_10 WL46 SL10 VSS sky130_fd_pr__nfet_g5v0d10v5 w=1 l=0.5
XRn_46_10 BLN10 dn_46_10 sky130_fd_pr_reram__reram_cell area_ox=0.0676
XMp_46_11 dp_46_11 WL46 SL11 VSS sky130_fd_pr__nfet_g5v0d10v5 w=1 l=0.5
XRp_46_11 BLP11 dp_46_11 sky130_fd_pr_reram__reram_cell area_ox=0.0676
XMz_46_11 dz_46_11 WL46 SL11 VSS sky130_fd_pr__nfet_g5v0d10v5 w=1 l=0.5
XRz_46_11 BLZ11 dz_46_11 sky130_fd_pr_reram__reram_cell area_ox=0.0676
XMn_46_11 dn_46_11 WL46 SL11 VSS sky130_fd_pr__nfet_g5v0d10v5 w=1 l=0.5
XRn_46_11 BLN11 dn_46_11 sky130_fd_pr_reram__reram_cell area_ox=0.0676
XMp_46_12 dp_46_12 WL46 SL12 VSS sky130_fd_pr__nfet_g5v0d10v5 w=1 l=0.5
XRp_46_12 BLP12 dp_46_12 sky130_fd_pr_reram__reram_cell area_ox=0.0676
XMz_46_12 dz_46_12 WL46 SL12 VSS sky130_fd_pr__nfet_g5v0d10v5 w=1 l=0.5
XRz_46_12 BLZ12 dz_46_12 sky130_fd_pr_reram__reram_cell area_ox=0.0676
XMn_46_12 dn_46_12 WL46 SL12 VSS sky130_fd_pr__nfet_g5v0d10v5 w=1 l=0.5
XRn_46_12 BLN12 dn_46_12 sky130_fd_pr_reram__reram_cell area_ox=0.0676
XMp_46_13 dp_46_13 WL46 SL13 VSS sky130_fd_pr__nfet_g5v0d10v5 w=1 l=0.5
XRp_46_13 BLP13 dp_46_13 sky130_fd_pr_reram__reram_cell area_ox=0.0676
XMz_46_13 dz_46_13 WL46 SL13 VSS sky130_fd_pr__nfet_g5v0d10v5 w=1 l=0.5
XRz_46_13 BLZ13 dz_46_13 sky130_fd_pr_reram__reram_cell area_ox=0.0676
XMn_46_13 dn_46_13 WL46 SL13 VSS sky130_fd_pr__nfet_g5v0d10v5 w=1 l=0.5
XRn_46_13 BLN13 dn_46_13 sky130_fd_pr_reram__reram_cell area_ox=0.0676
XMp_46_14 dp_46_14 WL46 SL14 VSS sky130_fd_pr__nfet_g5v0d10v5 w=1 l=0.5
XRp_46_14 BLP14 dp_46_14 sky130_fd_pr_reram__reram_cell area_ox=0.0676
XMz_46_14 dz_46_14 WL46 SL14 VSS sky130_fd_pr__nfet_g5v0d10v5 w=1 l=0.5
XRz_46_14 BLZ14 dz_46_14 sky130_fd_pr_reram__reram_cell area_ox=0.0676
XMn_46_14 dn_46_14 WL46 SL14 VSS sky130_fd_pr__nfet_g5v0d10v5 w=1 l=0.5
XRn_46_14 BLN14 dn_46_14 sky130_fd_pr_reram__reram_cell area_ox=0.0676
XMp_46_15 dp_46_15 WL46 SL15 VSS sky130_fd_pr__nfet_g5v0d10v5 w=1 l=0.5
XRp_46_15 BLP15 dp_46_15 sky130_fd_pr_reram__reram_cell area_ox=0.0676
XMz_46_15 dz_46_15 WL46 SL15 VSS sky130_fd_pr__nfet_g5v0d10v5 w=1 l=0.5
XRz_46_15 BLZ15 dz_46_15 sky130_fd_pr_reram__reram_cell area_ox=0.0676
XMn_46_15 dn_46_15 WL46 SL15 VSS sky130_fd_pr__nfet_g5v0d10v5 w=1 l=0.5
XRn_46_15 BLN15 dn_46_15 sky130_fd_pr_reram__reram_cell area_ox=0.0676
XMp_46_16 dp_46_16 WL46 SL16 VSS sky130_fd_pr__nfet_g5v0d10v5 w=1 l=0.5
XRp_46_16 BLP16 dp_46_16 sky130_fd_pr_reram__reram_cell area_ox=0.0676
XMz_46_16 dz_46_16 WL46 SL16 VSS sky130_fd_pr__nfet_g5v0d10v5 w=1 l=0.5
XRz_46_16 BLZ16 dz_46_16 sky130_fd_pr_reram__reram_cell area_ox=0.0676
XMn_46_16 dn_46_16 WL46 SL16 VSS sky130_fd_pr__nfet_g5v0d10v5 w=1 l=0.5
XRn_46_16 BLN16 dn_46_16 sky130_fd_pr_reram__reram_cell area_ox=0.0676
XMp_46_17 dp_46_17 WL46 SL17 VSS sky130_fd_pr__nfet_g5v0d10v5 w=1 l=0.5
XRp_46_17 BLP17 dp_46_17 sky130_fd_pr_reram__reram_cell area_ox=0.0676
XMz_46_17 dz_46_17 WL46 SL17 VSS sky130_fd_pr__nfet_g5v0d10v5 w=1 l=0.5
XRz_46_17 BLZ17 dz_46_17 sky130_fd_pr_reram__reram_cell area_ox=0.0676
XMn_46_17 dn_46_17 WL46 SL17 VSS sky130_fd_pr__nfet_g5v0d10v5 w=1 l=0.5
XRn_46_17 BLN17 dn_46_17 sky130_fd_pr_reram__reram_cell area_ox=0.0676
XMp_46_18 dp_46_18 WL46 SL18 VSS sky130_fd_pr__nfet_g5v0d10v5 w=1 l=0.5
XRp_46_18 BLP18 dp_46_18 sky130_fd_pr_reram__reram_cell area_ox=0.0676
XMz_46_18 dz_46_18 WL46 SL18 VSS sky130_fd_pr__nfet_g5v0d10v5 w=1 l=0.5
XRz_46_18 BLZ18 dz_46_18 sky130_fd_pr_reram__reram_cell area_ox=0.0676
XMn_46_18 dn_46_18 WL46 SL18 VSS sky130_fd_pr__nfet_g5v0d10v5 w=1 l=0.5
XRn_46_18 BLN18 dn_46_18 sky130_fd_pr_reram__reram_cell area_ox=0.0676
XMp_46_19 dp_46_19 WL46 SL19 VSS sky130_fd_pr__nfet_g5v0d10v5 w=1 l=0.5
XRp_46_19 BLP19 dp_46_19 sky130_fd_pr_reram__reram_cell area_ox=0.0676
XMz_46_19 dz_46_19 WL46 SL19 VSS sky130_fd_pr__nfet_g5v0d10v5 w=1 l=0.5
XRz_46_19 BLZ19 dz_46_19 sky130_fd_pr_reram__reram_cell area_ox=0.0676
XMn_46_19 dn_46_19 WL46 SL19 VSS sky130_fd_pr__nfet_g5v0d10v5 w=1 l=0.5
XRn_46_19 BLN19 dn_46_19 sky130_fd_pr_reram__reram_cell area_ox=0.0676
XMp_46_20 dp_46_20 WL46 SL20 VSS sky130_fd_pr__nfet_g5v0d10v5 w=1 l=0.5
XRp_46_20 BLP20 dp_46_20 sky130_fd_pr_reram__reram_cell area_ox=0.0676
XMz_46_20 dz_46_20 WL46 SL20 VSS sky130_fd_pr__nfet_g5v0d10v5 w=1 l=0.5
XRz_46_20 BLZ20 dz_46_20 sky130_fd_pr_reram__reram_cell area_ox=0.0676
XMn_46_20 dn_46_20 WL46 SL20 VSS sky130_fd_pr__nfet_g5v0d10v5 w=1 l=0.5
XRn_46_20 BLN20 dn_46_20 sky130_fd_pr_reram__reram_cell area_ox=0.0676
XMp_46_21 dp_46_21 WL46 SL21 VSS sky130_fd_pr__nfet_g5v0d10v5 w=1 l=0.5
XRp_46_21 BLP21 dp_46_21 sky130_fd_pr_reram__reram_cell area_ox=0.0676
XMz_46_21 dz_46_21 WL46 SL21 VSS sky130_fd_pr__nfet_g5v0d10v5 w=1 l=0.5
XRz_46_21 BLZ21 dz_46_21 sky130_fd_pr_reram__reram_cell area_ox=0.0676
XMn_46_21 dn_46_21 WL46 SL21 VSS sky130_fd_pr__nfet_g5v0d10v5 w=1 l=0.5
XRn_46_21 BLN21 dn_46_21 sky130_fd_pr_reram__reram_cell area_ox=0.0676
XMp_46_22 dp_46_22 WL46 SL22 VSS sky130_fd_pr__nfet_g5v0d10v5 w=1 l=0.5
XRp_46_22 BLP22 dp_46_22 sky130_fd_pr_reram__reram_cell area_ox=0.0676
XMz_46_22 dz_46_22 WL46 SL22 VSS sky130_fd_pr__nfet_g5v0d10v5 w=1 l=0.5
XRz_46_22 BLZ22 dz_46_22 sky130_fd_pr_reram__reram_cell area_ox=0.0676
XMn_46_22 dn_46_22 WL46 SL22 VSS sky130_fd_pr__nfet_g5v0d10v5 w=1 l=0.5
XRn_46_22 BLN22 dn_46_22 sky130_fd_pr_reram__reram_cell area_ox=0.0676
XMp_46_23 dp_46_23 WL46 SL23 VSS sky130_fd_pr__nfet_g5v0d10v5 w=1 l=0.5
XRp_46_23 BLP23 dp_46_23 sky130_fd_pr_reram__reram_cell area_ox=0.0676
XMz_46_23 dz_46_23 WL46 SL23 VSS sky130_fd_pr__nfet_g5v0d10v5 w=1 l=0.5
XRz_46_23 BLZ23 dz_46_23 sky130_fd_pr_reram__reram_cell area_ox=0.0676
XMn_46_23 dn_46_23 WL46 SL23 VSS sky130_fd_pr__nfet_g5v0d10v5 w=1 l=0.5
XRn_46_23 BLN23 dn_46_23 sky130_fd_pr_reram__reram_cell area_ox=0.0676
XMp_47_0 dp_47_0 WL47 SL0 VSS sky130_fd_pr__nfet_g5v0d10v5 w=1 l=0.5
XRp_47_0 BLP0 dp_47_0 sky130_fd_pr_reram__reram_cell area_ox=0.0676
XMz_47_0 dz_47_0 WL47 SL0 VSS sky130_fd_pr__nfet_g5v0d10v5 w=1 l=0.5
XRz_47_0 BLZ0 dz_47_0 sky130_fd_pr_reram__reram_cell area_ox=0.0676
XMn_47_0 dn_47_0 WL47 SL0 VSS sky130_fd_pr__nfet_g5v0d10v5 w=1 l=0.5
XRn_47_0 BLN0 dn_47_0 sky130_fd_pr_reram__reram_cell area_ox=0.0676
XMp_47_1 dp_47_1 WL47 SL1 VSS sky130_fd_pr__nfet_g5v0d10v5 w=1 l=0.5
XRp_47_1 BLP1 dp_47_1 sky130_fd_pr_reram__reram_cell area_ox=0.0676
XMz_47_1 dz_47_1 WL47 SL1 VSS sky130_fd_pr__nfet_g5v0d10v5 w=1 l=0.5
XRz_47_1 BLZ1 dz_47_1 sky130_fd_pr_reram__reram_cell area_ox=0.0676
XMn_47_1 dn_47_1 WL47 SL1 VSS sky130_fd_pr__nfet_g5v0d10v5 w=1 l=0.5
XRn_47_1 BLN1 dn_47_1 sky130_fd_pr_reram__reram_cell area_ox=0.0676
XMp_47_2 dp_47_2 WL47 SL2 VSS sky130_fd_pr__nfet_g5v0d10v5 w=1 l=0.5
XRp_47_2 BLP2 dp_47_2 sky130_fd_pr_reram__reram_cell area_ox=0.0676
XMz_47_2 dz_47_2 WL47 SL2 VSS sky130_fd_pr__nfet_g5v0d10v5 w=1 l=0.5
XRz_47_2 BLZ2 dz_47_2 sky130_fd_pr_reram__reram_cell area_ox=0.0676
XMn_47_2 dn_47_2 WL47 SL2 VSS sky130_fd_pr__nfet_g5v0d10v5 w=1 l=0.5
XRn_47_2 BLN2 dn_47_2 sky130_fd_pr_reram__reram_cell area_ox=0.0676
XMp_47_3 dp_47_3 WL47 SL3 VSS sky130_fd_pr__nfet_g5v0d10v5 w=1 l=0.5
XRp_47_3 BLP3 dp_47_3 sky130_fd_pr_reram__reram_cell area_ox=0.0676
XMz_47_3 dz_47_3 WL47 SL3 VSS sky130_fd_pr__nfet_g5v0d10v5 w=1 l=0.5
XRz_47_3 BLZ3 dz_47_3 sky130_fd_pr_reram__reram_cell area_ox=0.0676
XMn_47_3 dn_47_3 WL47 SL3 VSS sky130_fd_pr__nfet_g5v0d10v5 w=1 l=0.5
XRn_47_3 BLN3 dn_47_3 sky130_fd_pr_reram__reram_cell area_ox=0.0676
XMp_47_4 dp_47_4 WL47 SL4 VSS sky130_fd_pr__nfet_g5v0d10v5 w=1 l=0.5
XRp_47_4 BLP4 dp_47_4 sky130_fd_pr_reram__reram_cell area_ox=0.0676
XMz_47_4 dz_47_4 WL47 SL4 VSS sky130_fd_pr__nfet_g5v0d10v5 w=1 l=0.5
XRz_47_4 BLZ4 dz_47_4 sky130_fd_pr_reram__reram_cell area_ox=0.0676
XMn_47_4 dn_47_4 WL47 SL4 VSS sky130_fd_pr__nfet_g5v0d10v5 w=1 l=0.5
XRn_47_4 BLN4 dn_47_4 sky130_fd_pr_reram__reram_cell area_ox=0.0676
XMp_47_5 dp_47_5 WL47 SL5 VSS sky130_fd_pr__nfet_g5v0d10v5 w=1 l=0.5
XRp_47_5 BLP5 dp_47_5 sky130_fd_pr_reram__reram_cell area_ox=0.0676
XMz_47_5 dz_47_5 WL47 SL5 VSS sky130_fd_pr__nfet_g5v0d10v5 w=1 l=0.5
XRz_47_5 BLZ5 dz_47_5 sky130_fd_pr_reram__reram_cell area_ox=0.0676
XMn_47_5 dn_47_5 WL47 SL5 VSS sky130_fd_pr__nfet_g5v0d10v5 w=1 l=0.5
XRn_47_5 BLN5 dn_47_5 sky130_fd_pr_reram__reram_cell area_ox=0.0676
XMp_47_6 dp_47_6 WL47 SL6 VSS sky130_fd_pr__nfet_g5v0d10v5 w=1 l=0.5
XRp_47_6 BLP6 dp_47_6 sky130_fd_pr_reram__reram_cell area_ox=0.0676
XMz_47_6 dz_47_6 WL47 SL6 VSS sky130_fd_pr__nfet_g5v0d10v5 w=1 l=0.5
XRz_47_6 BLZ6 dz_47_6 sky130_fd_pr_reram__reram_cell area_ox=0.0676
XMn_47_6 dn_47_6 WL47 SL6 VSS sky130_fd_pr__nfet_g5v0d10v5 w=1 l=0.5
XRn_47_6 BLN6 dn_47_6 sky130_fd_pr_reram__reram_cell area_ox=0.0676
XMp_47_7 dp_47_7 WL47 SL7 VSS sky130_fd_pr__nfet_g5v0d10v5 w=1 l=0.5
XRp_47_7 BLP7 dp_47_7 sky130_fd_pr_reram__reram_cell area_ox=0.0676
XMz_47_7 dz_47_7 WL47 SL7 VSS sky130_fd_pr__nfet_g5v0d10v5 w=1 l=0.5
XRz_47_7 BLZ7 dz_47_7 sky130_fd_pr_reram__reram_cell area_ox=0.0676
XMn_47_7 dn_47_7 WL47 SL7 VSS sky130_fd_pr__nfet_g5v0d10v5 w=1 l=0.5
XRn_47_7 BLN7 dn_47_7 sky130_fd_pr_reram__reram_cell area_ox=0.0676
XMp_47_8 dp_47_8 WL47 SL8 VSS sky130_fd_pr__nfet_g5v0d10v5 w=1 l=0.5
XRp_47_8 BLP8 dp_47_8 sky130_fd_pr_reram__reram_cell area_ox=0.0676
XMz_47_8 dz_47_8 WL47 SL8 VSS sky130_fd_pr__nfet_g5v0d10v5 w=1 l=0.5
XRz_47_8 BLZ8 dz_47_8 sky130_fd_pr_reram__reram_cell area_ox=0.0676
XMn_47_8 dn_47_8 WL47 SL8 VSS sky130_fd_pr__nfet_g5v0d10v5 w=1 l=0.5
XRn_47_8 BLN8 dn_47_8 sky130_fd_pr_reram__reram_cell area_ox=0.0676
XMp_47_9 dp_47_9 WL47 SL9 VSS sky130_fd_pr__nfet_g5v0d10v5 w=1 l=0.5
XRp_47_9 BLP9 dp_47_9 sky130_fd_pr_reram__reram_cell area_ox=0.0676
XMz_47_9 dz_47_9 WL47 SL9 VSS sky130_fd_pr__nfet_g5v0d10v5 w=1 l=0.5
XRz_47_9 BLZ9 dz_47_9 sky130_fd_pr_reram__reram_cell area_ox=0.0676
XMn_47_9 dn_47_9 WL47 SL9 VSS sky130_fd_pr__nfet_g5v0d10v5 w=1 l=0.5
XRn_47_9 BLN9 dn_47_9 sky130_fd_pr_reram__reram_cell area_ox=0.0676
XMp_47_10 dp_47_10 WL47 SL10 VSS sky130_fd_pr__nfet_g5v0d10v5 w=1 l=0.5
XRp_47_10 BLP10 dp_47_10 sky130_fd_pr_reram__reram_cell area_ox=0.0676
XMz_47_10 dz_47_10 WL47 SL10 VSS sky130_fd_pr__nfet_g5v0d10v5 w=1 l=0.5
XRz_47_10 BLZ10 dz_47_10 sky130_fd_pr_reram__reram_cell area_ox=0.0676
XMn_47_10 dn_47_10 WL47 SL10 VSS sky130_fd_pr__nfet_g5v0d10v5 w=1 l=0.5
XRn_47_10 BLN10 dn_47_10 sky130_fd_pr_reram__reram_cell area_ox=0.0676
XMp_47_11 dp_47_11 WL47 SL11 VSS sky130_fd_pr__nfet_g5v0d10v5 w=1 l=0.5
XRp_47_11 BLP11 dp_47_11 sky130_fd_pr_reram__reram_cell area_ox=0.0676
XMz_47_11 dz_47_11 WL47 SL11 VSS sky130_fd_pr__nfet_g5v0d10v5 w=1 l=0.5
XRz_47_11 BLZ11 dz_47_11 sky130_fd_pr_reram__reram_cell area_ox=0.0676
XMn_47_11 dn_47_11 WL47 SL11 VSS sky130_fd_pr__nfet_g5v0d10v5 w=1 l=0.5
XRn_47_11 BLN11 dn_47_11 sky130_fd_pr_reram__reram_cell area_ox=0.0676
XMp_47_12 dp_47_12 WL47 SL12 VSS sky130_fd_pr__nfet_g5v0d10v5 w=1 l=0.5
XRp_47_12 BLP12 dp_47_12 sky130_fd_pr_reram__reram_cell area_ox=0.0676
XMz_47_12 dz_47_12 WL47 SL12 VSS sky130_fd_pr__nfet_g5v0d10v5 w=1 l=0.5
XRz_47_12 BLZ12 dz_47_12 sky130_fd_pr_reram__reram_cell area_ox=0.0676
XMn_47_12 dn_47_12 WL47 SL12 VSS sky130_fd_pr__nfet_g5v0d10v5 w=1 l=0.5
XRn_47_12 BLN12 dn_47_12 sky130_fd_pr_reram__reram_cell area_ox=0.0676
XMp_47_13 dp_47_13 WL47 SL13 VSS sky130_fd_pr__nfet_g5v0d10v5 w=1 l=0.5
XRp_47_13 BLP13 dp_47_13 sky130_fd_pr_reram__reram_cell area_ox=0.0676
XMz_47_13 dz_47_13 WL47 SL13 VSS sky130_fd_pr__nfet_g5v0d10v5 w=1 l=0.5
XRz_47_13 BLZ13 dz_47_13 sky130_fd_pr_reram__reram_cell area_ox=0.0676
XMn_47_13 dn_47_13 WL47 SL13 VSS sky130_fd_pr__nfet_g5v0d10v5 w=1 l=0.5
XRn_47_13 BLN13 dn_47_13 sky130_fd_pr_reram__reram_cell area_ox=0.0676
XMp_47_14 dp_47_14 WL47 SL14 VSS sky130_fd_pr__nfet_g5v0d10v5 w=1 l=0.5
XRp_47_14 BLP14 dp_47_14 sky130_fd_pr_reram__reram_cell area_ox=0.0676
XMz_47_14 dz_47_14 WL47 SL14 VSS sky130_fd_pr__nfet_g5v0d10v5 w=1 l=0.5
XRz_47_14 BLZ14 dz_47_14 sky130_fd_pr_reram__reram_cell area_ox=0.0676
XMn_47_14 dn_47_14 WL47 SL14 VSS sky130_fd_pr__nfet_g5v0d10v5 w=1 l=0.5
XRn_47_14 BLN14 dn_47_14 sky130_fd_pr_reram__reram_cell area_ox=0.0676
XMp_47_15 dp_47_15 WL47 SL15 VSS sky130_fd_pr__nfet_g5v0d10v5 w=1 l=0.5
XRp_47_15 BLP15 dp_47_15 sky130_fd_pr_reram__reram_cell area_ox=0.0676
XMz_47_15 dz_47_15 WL47 SL15 VSS sky130_fd_pr__nfet_g5v0d10v5 w=1 l=0.5
XRz_47_15 BLZ15 dz_47_15 sky130_fd_pr_reram__reram_cell area_ox=0.0676
XMn_47_15 dn_47_15 WL47 SL15 VSS sky130_fd_pr__nfet_g5v0d10v5 w=1 l=0.5
XRn_47_15 BLN15 dn_47_15 sky130_fd_pr_reram__reram_cell area_ox=0.0676
XMp_47_16 dp_47_16 WL47 SL16 VSS sky130_fd_pr__nfet_g5v0d10v5 w=1 l=0.5
XRp_47_16 BLP16 dp_47_16 sky130_fd_pr_reram__reram_cell area_ox=0.0676
XMz_47_16 dz_47_16 WL47 SL16 VSS sky130_fd_pr__nfet_g5v0d10v5 w=1 l=0.5
XRz_47_16 BLZ16 dz_47_16 sky130_fd_pr_reram__reram_cell area_ox=0.0676
XMn_47_16 dn_47_16 WL47 SL16 VSS sky130_fd_pr__nfet_g5v0d10v5 w=1 l=0.5
XRn_47_16 BLN16 dn_47_16 sky130_fd_pr_reram__reram_cell area_ox=0.0676
XMp_47_17 dp_47_17 WL47 SL17 VSS sky130_fd_pr__nfet_g5v0d10v5 w=1 l=0.5
XRp_47_17 BLP17 dp_47_17 sky130_fd_pr_reram__reram_cell area_ox=0.0676
XMz_47_17 dz_47_17 WL47 SL17 VSS sky130_fd_pr__nfet_g5v0d10v5 w=1 l=0.5
XRz_47_17 BLZ17 dz_47_17 sky130_fd_pr_reram__reram_cell area_ox=0.0676
XMn_47_17 dn_47_17 WL47 SL17 VSS sky130_fd_pr__nfet_g5v0d10v5 w=1 l=0.5
XRn_47_17 BLN17 dn_47_17 sky130_fd_pr_reram__reram_cell area_ox=0.0676
XMp_47_18 dp_47_18 WL47 SL18 VSS sky130_fd_pr__nfet_g5v0d10v5 w=1 l=0.5
XRp_47_18 BLP18 dp_47_18 sky130_fd_pr_reram__reram_cell area_ox=0.0676
XMz_47_18 dz_47_18 WL47 SL18 VSS sky130_fd_pr__nfet_g5v0d10v5 w=1 l=0.5
XRz_47_18 BLZ18 dz_47_18 sky130_fd_pr_reram__reram_cell area_ox=0.0676
XMn_47_18 dn_47_18 WL47 SL18 VSS sky130_fd_pr__nfet_g5v0d10v5 w=1 l=0.5
XRn_47_18 BLN18 dn_47_18 sky130_fd_pr_reram__reram_cell area_ox=0.0676
XMp_47_19 dp_47_19 WL47 SL19 VSS sky130_fd_pr__nfet_g5v0d10v5 w=1 l=0.5
XRp_47_19 BLP19 dp_47_19 sky130_fd_pr_reram__reram_cell area_ox=0.0676
XMz_47_19 dz_47_19 WL47 SL19 VSS sky130_fd_pr__nfet_g5v0d10v5 w=1 l=0.5
XRz_47_19 BLZ19 dz_47_19 sky130_fd_pr_reram__reram_cell area_ox=0.0676
XMn_47_19 dn_47_19 WL47 SL19 VSS sky130_fd_pr__nfet_g5v0d10v5 w=1 l=0.5
XRn_47_19 BLN19 dn_47_19 sky130_fd_pr_reram__reram_cell area_ox=0.0676
XMp_47_20 dp_47_20 WL47 SL20 VSS sky130_fd_pr__nfet_g5v0d10v5 w=1 l=0.5
XRp_47_20 BLP20 dp_47_20 sky130_fd_pr_reram__reram_cell area_ox=0.0676
XMz_47_20 dz_47_20 WL47 SL20 VSS sky130_fd_pr__nfet_g5v0d10v5 w=1 l=0.5
XRz_47_20 BLZ20 dz_47_20 sky130_fd_pr_reram__reram_cell area_ox=0.0676
XMn_47_20 dn_47_20 WL47 SL20 VSS sky130_fd_pr__nfet_g5v0d10v5 w=1 l=0.5
XRn_47_20 BLN20 dn_47_20 sky130_fd_pr_reram__reram_cell area_ox=0.0676
XMp_47_21 dp_47_21 WL47 SL21 VSS sky130_fd_pr__nfet_g5v0d10v5 w=1 l=0.5
XRp_47_21 BLP21 dp_47_21 sky130_fd_pr_reram__reram_cell area_ox=0.0676
XMz_47_21 dz_47_21 WL47 SL21 VSS sky130_fd_pr__nfet_g5v0d10v5 w=1 l=0.5
XRz_47_21 BLZ21 dz_47_21 sky130_fd_pr_reram__reram_cell area_ox=0.0676
XMn_47_21 dn_47_21 WL47 SL21 VSS sky130_fd_pr__nfet_g5v0d10v5 w=1 l=0.5
XRn_47_21 BLN21 dn_47_21 sky130_fd_pr_reram__reram_cell area_ox=0.0676
XMp_47_22 dp_47_22 WL47 SL22 VSS sky130_fd_pr__nfet_g5v0d10v5 w=1 l=0.5
XRp_47_22 BLP22 dp_47_22 sky130_fd_pr_reram__reram_cell area_ox=0.0676
XMz_47_22 dz_47_22 WL47 SL22 VSS sky130_fd_pr__nfet_g5v0d10v5 w=1 l=0.5
XRz_47_22 BLZ22 dz_47_22 sky130_fd_pr_reram__reram_cell area_ox=0.0676
XMn_47_22 dn_47_22 WL47 SL22 VSS sky130_fd_pr__nfet_g5v0d10v5 w=1 l=0.5
XRn_47_22 BLN22 dn_47_22 sky130_fd_pr_reram__reram_cell area_ox=0.0676
XMp_47_23 dp_47_23 WL47 SL23 VSS sky130_fd_pr__nfet_g5v0d10v5 w=1 l=0.5
XRp_47_23 BLP23 dp_47_23 sky130_fd_pr_reram__reram_cell area_ox=0.0676
XMz_47_23 dz_47_23 WL47 SL23 VSS sky130_fd_pr__nfet_g5v0d10v5 w=1 l=0.5
XRz_47_23 BLZ23 dz_47_23 sky130_fd_pr_reram__reram_cell area_ox=0.0676
XMn_47_23 dn_47_23 WL47 SL23 VSS sky130_fd_pr__nfet_g5v0d10v5 w=1 l=0.5
XRn_47_23 BLN23 dn_47_23 sky130_fd_pr_reram__reram_cell area_ox=0.0676
XMp_48_0 dp_48_0 WL48 SL0 VSS sky130_fd_pr__nfet_g5v0d10v5 w=1 l=0.5
XRp_48_0 BLP0 dp_48_0 sky130_fd_pr_reram__reram_cell area_ox=0.0676
XMz_48_0 dz_48_0 WL48 SL0 VSS sky130_fd_pr__nfet_g5v0d10v5 w=1 l=0.5
XRz_48_0 BLZ0 dz_48_0 sky130_fd_pr_reram__reram_cell area_ox=0.0676
XMn_48_0 dn_48_0 WL48 SL0 VSS sky130_fd_pr__nfet_g5v0d10v5 w=1 l=0.5
XRn_48_0 BLN0 dn_48_0 sky130_fd_pr_reram__reram_cell area_ox=0.0676
XMp_48_1 dp_48_1 WL48 SL1 VSS sky130_fd_pr__nfet_g5v0d10v5 w=1 l=0.5
XRp_48_1 BLP1 dp_48_1 sky130_fd_pr_reram__reram_cell area_ox=0.0676
XMz_48_1 dz_48_1 WL48 SL1 VSS sky130_fd_pr__nfet_g5v0d10v5 w=1 l=0.5
XRz_48_1 BLZ1 dz_48_1 sky130_fd_pr_reram__reram_cell area_ox=0.0676
XMn_48_1 dn_48_1 WL48 SL1 VSS sky130_fd_pr__nfet_g5v0d10v5 w=1 l=0.5
XRn_48_1 BLN1 dn_48_1 sky130_fd_pr_reram__reram_cell area_ox=0.0676
XMp_48_2 dp_48_2 WL48 SL2 VSS sky130_fd_pr__nfet_g5v0d10v5 w=1 l=0.5
XRp_48_2 BLP2 dp_48_2 sky130_fd_pr_reram__reram_cell area_ox=0.0676
XMz_48_2 dz_48_2 WL48 SL2 VSS sky130_fd_pr__nfet_g5v0d10v5 w=1 l=0.5
XRz_48_2 BLZ2 dz_48_2 sky130_fd_pr_reram__reram_cell area_ox=0.0676
XMn_48_2 dn_48_2 WL48 SL2 VSS sky130_fd_pr__nfet_g5v0d10v5 w=1 l=0.5
XRn_48_2 BLN2 dn_48_2 sky130_fd_pr_reram__reram_cell area_ox=0.0676
XMp_48_3 dp_48_3 WL48 SL3 VSS sky130_fd_pr__nfet_g5v0d10v5 w=1 l=0.5
XRp_48_3 BLP3 dp_48_3 sky130_fd_pr_reram__reram_cell area_ox=0.0676
XMz_48_3 dz_48_3 WL48 SL3 VSS sky130_fd_pr__nfet_g5v0d10v5 w=1 l=0.5
XRz_48_3 BLZ3 dz_48_3 sky130_fd_pr_reram__reram_cell area_ox=0.0676
XMn_48_3 dn_48_3 WL48 SL3 VSS sky130_fd_pr__nfet_g5v0d10v5 w=1 l=0.5
XRn_48_3 BLN3 dn_48_3 sky130_fd_pr_reram__reram_cell area_ox=0.0676
XMp_48_4 dp_48_4 WL48 SL4 VSS sky130_fd_pr__nfet_g5v0d10v5 w=1 l=0.5
XRp_48_4 BLP4 dp_48_4 sky130_fd_pr_reram__reram_cell area_ox=0.0676
XMz_48_4 dz_48_4 WL48 SL4 VSS sky130_fd_pr__nfet_g5v0d10v5 w=1 l=0.5
XRz_48_4 BLZ4 dz_48_4 sky130_fd_pr_reram__reram_cell area_ox=0.0676
XMn_48_4 dn_48_4 WL48 SL4 VSS sky130_fd_pr__nfet_g5v0d10v5 w=1 l=0.5
XRn_48_4 BLN4 dn_48_4 sky130_fd_pr_reram__reram_cell area_ox=0.0676
XMp_48_5 dp_48_5 WL48 SL5 VSS sky130_fd_pr__nfet_g5v0d10v5 w=1 l=0.5
XRp_48_5 BLP5 dp_48_5 sky130_fd_pr_reram__reram_cell area_ox=0.0676
XMz_48_5 dz_48_5 WL48 SL5 VSS sky130_fd_pr__nfet_g5v0d10v5 w=1 l=0.5
XRz_48_5 BLZ5 dz_48_5 sky130_fd_pr_reram__reram_cell area_ox=0.0676
XMn_48_5 dn_48_5 WL48 SL5 VSS sky130_fd_pr__nfet_g5v0d10v5 w=1 l=0.5
XRn_48_5 BLN5 dn_48_5 sky130_fd_pr_reram__reram_cell area_ox=0.0676
XMp_48_6 dp_48_6 WL48 SL6 VSS sky130_fd_pr__nfet_g5v0d10v5 w=1 l=0.5
XRp_48_6 BLP6 dp_48_6 sky130_fd_pr_reram__reram_cell area_ox=0.0676
XMz_48_6 dz_48_6 WL48 SL6 VSS sky130_fd_pr__nfet_g5v0d10v5 w=1 l=0.5
XRz_48_6 BLZ6 dz_48_6 sky130_fd_pr_reram__reram_cell area_ox=0.0676
XMn_48_6 dn_48_6 WL48 SL6 VSS sky130_fd_pr__nfet_g5v0d10v5 w=1 l=0.5
XRn_48_6 BLN6 dn_48_6 sky130_fd_pr_reram__reram_cell area_ox=0.0676
XMp_48_7 dp_48_7 WL48 SL7 VSS sky130_fd_pr__nfet_g5v0d10v5 w=1 l=0.5
XRp_48_7 BLP7 dp_48_7 sky130_fd_pr_reram__reram_cell area_ox=0.0676
XMz_48_7 dz_48_7 WL48 SL7 VSS sky130_fd_pr__nfet_g5v0d10v5 w=1 l=0.5
XRz_48_7 BLZ7 dz_48_7 sky130_fd_pr_reram__reram_cell area_ox=0.0676
XMn_48_7 dn_48_7 WL48 SL7 VSS sky130_fd_pr__nfet_g5v0d10v5 w=1 l=0.5
XRn_48_7 BLN7 dn_48_7 sky130_fd_pr_reram__reram_cell area_ox=0.0676
XMp_48_8 dp_48_8 WL48 SL8 VSS sky130_fd_pr__nfet_g5v0d10v5 w=1 l=0.5
XRp_48_8 BLP8 dp_48_8 sky130_fd_pr_reram__reram_cell area_ox=0.0676
XMz_48_8 dz_48_8 WL48 SL8 VSS sky130_fd_pr__nfet_g5v0d10v5 w=1 l=0.5
XRz_48_8 BLZ8 dz_48_8 sky130_fd_pr_reram__reram_cell area_ox=0.0676
XMn_48_8 dn_48_8 WL48 SL8 VSS sky130_fd_pr__nfet_g5v0d10v5 w=1 l=0.5
XRn_48_8 BLN8 dn_48_8 sky130_fd_pr_reram__reram_cell area_ox=0.0676
XMp_48_9 dp_48_9 WL48 SL9 VSS sky130_fd_pr__nfet_g5v0d10v5 w=1 l=0.5
XRp_48_9 BLP9 dp_48_9 sky130_fd_pr_reram__reram_cell area_ox=0.0676
XMz_48_9 dz_48_9 WL48 SL9 VSS sky130_fd_pr__nfet_g5v0d10v5 w=1 l=0.5
XRz_48_9 BLZ9 dz_48_9 sky130_fd_pr_reram__reram_cell area_ox=0.0676
XMn_48_9 dn_48_9 WL48 SL9 VSS sky130_fd_pr__nfet_g5v0d10v5 w=1 l=0.5
XRn_48_9 BLN9 dn_48_9 sky130_fd_pr_reram__reram_cell area_ox=0.0676
XMp_48_10 dp_48_10 WL48 SL10 VSS sky130_fd_pr__nfet_g5v0d10v5 w=1 l=0.5
XRp_48_10 BLP10 dp_48_10 sky130_fd_pr_reram__reram_cell area_ox=0.0676
XMz_48_10 dz_48_10 WL48 SL10 VSS sky130_fd_pr__nfet_g5v0d10v5 w=1 l=0.5
XRz_48_10 BLZ10 dz_48_10 sky130_fd_pr_reram__reram_cell area_ox=0.0676
XMn_48_10 dn_48_10 WL48 SL10 VSS sky130_fd_pr__nfet_g5v0d10v5 w=1 l=0.5
XRn_48_10 BLN10 dn_48_10 sky130_fd_pr_reram__reram_cell area_ox=0.0676
XMp_48_11 dp_48_11 WL48 SL11 VSS sky130_fd_pr__nfet_g5v0d10v5 w=1 l=0.5
XRp_48_11 BLP11 dp_48_11 sky130_fd_pr_reram__reram_cell area_ox=0.0676
XMz_48_11 dz_48_11 WL48 SL11 VSS sky130_fd_pr__nfet_g5v0d10v5 w=1 l=0.5
XRz_48_11 BLZ11 dz_48_11 sky130_fd_pr_reram__reram_cell area_ox=0.0676
XMn_48_11 dn_48_11 WL48 SL11 VSS sky130_fd_pr__nfet_g5v0d10v5 w=1 l=0.5
XRn_48_11 BLN11 dn_48_11 sky130_fd_pr_reram__reram_cell area_ox=0.0676
XMp_48_12 dp_48_12 WL48 SL12 VSS sky130_fd_pr__nfet_g5v0d10v5 w=1 l=0.5
XRp_48_12 BLP12 dp_48_12 sky130_fd_pr_reram__reram_cell area_ox=0.0676
XMz_48_12 dz_48_12 WL48 SL12 VSS sky130_fd_pr__nfet_g5v0d10v5 w=1 l=0.5
XRz_48_12 BLZ12 dz_48_12 sky130_fd_pr_reram__reram_cell area_ox=0.0676
XMn_48_12 dn_48_12 WL48 SL12 VSS sky130_fd_pr__nfet_g5v0d10v5 w=1 l=0.5
XRn_48_12 BLN12 dn_48_12 sky130_fd_pr_reram__reram_cell area_ox=0.0676
XMp_48_13 dp_48_13 WL48 SL13 VSS sky130_fd_pr__nfet_g5v0d10v5 w=1 l=0.5
XRp_48_13 BLP13 dp_48_13 sky130_fd_pr_reram__reram_cell area_ox=0.0676
XMz_48_13 dz_48_13 WL48 SL13 VSS sky130_fd_pr__nfet_g5v0d10v5 w=1 l=0.5
XRz_48_13 BLZ13 dz_48_13 sky130_fd_pr_reram__reram_cell area_ox=0.0676
XMn_48_13 dn_48_13 WL48 SL13 VSS sky130_fd_pr__nfet_g5v0d10v5 w=1 l=0.5
XRn_48_13 BLN13 dn_48_13 sky130_fd_pr_reram__reram_cell area_ox=0.0676
XMp_48_14 dp_48_14 WL48 SL14 VSS sky130_fd_pr__nfet_g5v0d10v5 w=1 l=0.5
XRp_48_14 BLP14 dp_48_14 sky130_fd_pr_reram__reram_cell area_ox=0.0676
XMz_48_14 dz_48_14 WL48 SL14 VSS sky130_fd_pr__nfet_g5v0d10v5 w=1 l=0.5
XRz_48_14 BLZ14 dz_48_14 sky130_fd_pr_reram__reram_cell area_ox=0.0676
XMn_48_14 dn_48_14 WL48 SL14 VSS sky130_fd_pr__nfet_g5v0d10v5 w=1 l=0.5
XRn_48_14 BLN14 dn_48_14 sky130_fd_pr_reram__reram_cell area_ox=0.0676
XMp_48_15 dp_48_15 WL48 SL15 VSS sky130_fd_pr__nfet_g5v0d10v5 w=1 l=0.5
XRp_48_15 BLP15 dp_48_15 sky130_fd_pr_reram__reram_cell area_ox=0.0676
XMz_48_15 dz_48_15 WL48 SL15 VSS sky130_fd_pr__nfet_g5v0d10v5 w=1 l=0.5
XRz_48_15 BLZ15 dz_48_15 sky130_fd_pr_reram__reram_cell area_ox=0.0676
XMn_48_15 dn_48_15 WL48 SL15 VSS sky130_fd_pr__nfet_g5v0d10v5 w=1 l=0.5
XRn_48_15 BLN15 dn_48_15 sky130_fd_pr_reram__reram_cell area_ox=0.0676
XMp_48_16 dp_48_16 WL48 SL16 VSS sky130_fd_pr__nfet_g5v0d10v5 w=1 l=0.5
XRp_48_16 BLP16 dp_48_16 sky130_fd_pr_reram__reram_cell area_ox=0.0676
XMz_48_16 dz_48_16 WL48 SL16 VSS sky130_fd_pr__nfet_g5v0d10v5 w=1 l=0.5
XRz_48_16 BLZ16 dz_48_16 sky130_fd_pr_reram__reram_cell area_ox=0.0676
XMn_48_16 dn_48_16 WL48 SL16 VSS sky130_fd_pr__nfet_g5v0d10v5 w=1 l=0.5
XRn_48_16 BLN16 dn_48_16 sky130_fd_pr_reram__reram_cell area_ox=0.0676
XMp_48_17 dp_48_17 WL48 SL17 VSS sky130_fd_pr__nfet_g5v0d10v5 w=1 l=0.5
XRp_48_17 BLP17 dp_48_17 sky130_fd_pr_reram__reram_cell area_ox=0.0676
XMz_48_17 dz_48_17 WL48 SL17 VSS sky130_fd_pr__nfet_g5v0d10v5 w=1 l=0.5
XRz_48_17 BLZ17 dz_48_17 sky130_fd_pr_reram__reram_cell area_ox=0.0676
XMn_48_17 dn_48_17 WL48 SL17 VSS sky130_fd_pr__nfet_g5v0d10v5 w=1 l=0.5
XRn_48_17 BLN17 dn_48_17 sky130_fd_pr_reram__reram_cell area_ox=0.0676
XMp_48_18 dp_48_18 WL48 SL18 VSS sky130_fd_pr__nfet_g5v0d10v5 w=1 l=0.5
XRp_48_18 BLP18 dp_48_18 sky130_fd_pr_reram__reram_cell area_ox=0.0676
XMz_48_18 dz_48_18 WL48 SL18 VSS sky130_fd_pr__nfet_g5v0d10v5 w=1 l=0.5
XRz_48_18 BLZ18 dz_48_18 sky130_fd_pr_reram__reram_cell area_ox=0.0676
XMn_48_18 dn_48_18 WL48 SL18 VSS sky130_fd_pr__nfet_g5v0d10v5 w=1 l=0.5
XRn_48_18 BLN18 dn_48_18 sky130_fd_pr_reram__reram_cell area_ox=0.0676
XMp_48_19 dp_48_19 WL48 SL19 VSS sky130_fd_pr__nfet_g5v0d10v5 w=1 l=0.5
XRp_48_19 BLP19 dp_48_19 sky130_fd_pr_reram__reram_cell area_ox=0.0676
XMz_48_19 dz_48_19 WL48 SL19 VSS sky130_fd_pr__nfet_g5v0d10v5 w=1 l=0.5
XRz_48_19 BLZ19 dz_48_19 sky130_fd_pr_reram__reram_cell area_ox=0.0676
XMn_48_19 dn_48_19 WL48 SL19 VSS sky130_fd_pr__nfet_g5v0d10v5 w=1 l=0.5
XRn_48_19 BLN19 dn_48_19 sky130_fd_pr_reram__reram_cell area_ox=0.0676
XMp_48_20 dp_48_20 WL48 SL20 VSS sky130_fd_pr__nfet_g5v0d10v5 w=1 l=0.5
XRp_48_20 BLP20 dp_48_20 sky130_fd_pr_reram__reram_cell area_ox=0.0676
XMz_48_20 dz_48_20 WL48 SL20 VSS sky130_fd_pr__nfet_g5v0d10v5 w=1 l=0.5
XRz_48_20 BLZ20 dz_48_20 sky130_fd_pr_reram__reram_cell area_ox=0.0676
XMn_48_20 dn_48_20 WL48 SL20 VSS sky130_fd_pr__nfet_g5v0d10v5 w=1 l=0.5
XRn_48_20 BLN20 dn_48_20 sky130_fd_pr_reram__reram_cell area_ox=0.0676
XMp_48_21 dp_48_21 WL48 SL21 VSS sky130_fd_pr__nfet_g5v0d10v5 w=1 l=0.5
XRp_48_21 BLP21 dp_48_21 sky130_fd_pr_reram__reram_cell area_ox=0.0676
XMz_48_21 dz_48_21 WL48 SL21 VSS sky130_fd_pr__nfet_g5v0d10v5 w=1 l=0.5
XRz_48_21 BLZ21 dz_48_21 sky130_fd_pr_reram__reram_cell area_ox=0.0676
XMn_48_21 dn_48_21 WL48 SL21 VSS sky130_fd_pr__nfet_g5v0d10v5 w=1 l=0.5
XRn_48_21 BLN21 dn_48_21 sky130_fd_pr_reram__reram_cell area_ox=0.0676
XMp_48_22 dp_48_22 WL48 SL22 VSS sky130_fd_pr__nfet_g5v0d10v5 w=1 l=0.5
XRp_48_22 BLP22 dp_48_22 sky130_fd_pr_reram__reram_cell area_ox=0.0676
XMz_48_22 dz_48_22 WL48 SL22 VSS sky130_fd_pr__nfet_g5v0d10v5 w=1 l=0.5
XRz_48_22 BLZ22 dz_48_22 sky130_fd_pr_reram__reram_cell area_ox=0.0676
XMn_48_22 dn_48_22 WL48 SL22 VSS sky130_fd_pr__nfet_g5v0d10v5 w=1 l=0.5
XRn_48_22 BLN22 dn_48_22 sky130_fd_pr_reram__reram_cell area_ox=0.0676
XMp_48_23 dp_48_23 WL48 SL23 VSS sky130_fd_pr__nfet_g5v0d10v5 w=1 l=0.5
XRp_48_23 BLP23 dp_48_23 sky130_fd_pr_reram__reram_cell area_ox=0.0676
XMz_48_23 dz_48_23 WL48 SL23 VSS sky130_fd_pr__nfet_g5v0d10v5 w=1 l=0.5
XRz_48_23 BLZ23 dz_48_23 sky130_fd_pr_reram__reram_cell area_ox=0.0676
XMn_48_23 dn_48_23 WL48 SL23 VSS sky130_fd_pr__nfet_g5v0d10v5 w=1 l=0.5
XRn_48_23 BLN23 dn_48_23 sky130_fd_pr_reram__reram_cell area_ox=0.0676
XMp_49_0 dp_49_0 WL49 SL0 VSS sky130_fd_pr__nfet_g5v0d10v5 w=1 l=0.5
XRp_49_0 BLP0 dp_49_0 sky130_fd_pr_reram__reram_cell area_ox=0.0676
XMz_49_0 dz_49_0 WL49 SL0 VSS sky130_fd_pr__nfet_g5v0d10v5 w=1 l=0.5
XRz_49_0 BLZ0 dz_49_0 sky130_fd_pr_reram__reram_cell area_ox=0.0676
XMn_49_0 dn_49_0 WL49 SL0 VSS sky130_fd_pr__nfet_g5v0d10v5 w=1 l=0.5
XRn_49_0 BLN0 dn_49_0 sky130_fd_pr_reram__reram_cell area_ox=0.0676
XMp_49_1 dp_49_1 WL49 SL1 VSS sky130_fd_pr__nfet_g5v0d10v5 w=1 l=0.5
XRp_49_1 BLP1 dp_49_1 sky130_fd_pr_reram__reram_cell area_ox=0.0676
XMz_49_1 dz_49_1 WL49 SL1 VSS sky130_fd_pr__nfet_g5v0d10v5 w=1 l=0.5
XRz_49_1 BLZ1 dz_49_1 sky130_fd_pr_reram__reram_cell area_ox=0.0676
XMn_49_1 dn_49_1 WL49 SL1 VSS sky130_fd_pr__nfet_g5v0d10v5 w=1 l=0.5
XRn_49_1 BLN1 dn_49_1 sky130_fd_pr_reram__reram_cell area_ox=0.0676
XMp_49_2 dp_49_2 WL49 SL2 VSS sky130_fd_pr__nfet_g5v0d10v5 w=1 l=0.5
XRp_49_2 BLP2 dp_49_2 sky130_fd_pr_reram__reram_cell area_ox=0.0676
XMz_49_2 dz_49_2 WL49 SL2 VSS sky130_fd_pr__nfet_g5v0d10v5 w=1 l=0.5
XRz_49_2 BLZ2 dz_49_2 sky130_fd_pr_reram__reram_cell area_ox=0.0676
XMn_49_2 dn_49_2 WL49 SL2 VSS sky130_fd_pr__nfet_g5v0d10v5 w=1 l=0.5
XRn_49_2 BLN2 dn_49_2 sky130_fd_pr_reram__reram_cell area_ox=0.0676
XMp_49_3 dp_49_3 WL49 SL3 VSS sky130_fd_pr__nfet_g5v0d10v5 w=1 l=0.5
XRp_49_3 BLP3 dp_49_3 sky130_fd_pr_reram__reram_cell area_ox=0.0676
XMz_49_3 dz_49_3 WL49 SL3 VSS sky130_fd_pr__nfet_g5v0d10v5 w=1 l=0.5
XRz_49_3 BLZ3 dz_49_3 sky130_fd_pr_reram__reram_cell area_ox=0.0676
XMn_49_3 dn_49_3 WL49 SL3 VSS sky130_fd_pr__nfet_g5v0d10v5 w=1 l=0.5
XRn_49_3 BLN3 dn_49_3 sky130_fd_pr_reram__reram_cell area_ox=0.0676
XMp_49_4 dp_49_4 WL49 SL4 VSS sky130_fd_pr__nfet_g5v0d10v5 w=1 l=0.5
XRp_49_4 BLP4 dp_49_4 sky130_fd_pr_reram__reram_cell area_ox=0.0676
XMz_49_4 dz_49_4 WL49 SL4 VSS sky130_fd_pr__nfet_g5v0d10v5 w=1 l=0.5
XRz_49_4 BLZ4 dz_49_4 sky130_fd_pr_reram__reram_cell area_ox=0.0676
XMn_49_4 dn_49_4 WL49 SL4 VSS sky130_fd_pr__nfet_g5v0d10v5 w=1 l=0.5
XRn_49_4 BLN4 dn_49_4 sky130_fd_pr_reram__reram_cell area_ox=0.0676
XMp_49_5 dp_49_5 WL49 SL5 VSS sky130_fd_pr__nfet_g5v0d10v5 w=1 l=0.5
XRp_49_5 BLP5 dp_49_5 sky130_fd_pr_reram__reram_cell area_ox=0.0676
XMz_49_5 dz_49_5 WL49 SL5 VSS sky130_fd_pr__nfet_g5v0d10v5 w=1 l=0.5
XRz_49_5 BLZ5 dz_49_5 sky130_fd_pr_reram__reram_cell area_ox=0.0676
XMn_49_5 dn_49_5 WL49 SL5 VSS sky130_fd_pr__nfet_g5v0d10v5 w=1 l=0.5
XRn_49_5 BLN5 dn_49_5 sky130_fd_pr_reram__reram_cell area_ox=0.0676
XMp_49_6 dp_49_6 WL49 SL6 VSS sky130_fd_pr__nfet_g5v0d10v5 w=1 l=0.5
XRp_49_6 BLP6 dp_49_6 sky130_fd_pr_reram__reram_cell area_ox=0.0676
XMz_49_6 dz_49_6 WL49 SL6 VSS sky130_fd_pr__nfet_g5v0d10v5 w=1 l=0.5
XRz_49_6 BLZ6 dz_49_6 sky130_fd_pr_reram__reram_cell area_ox=0.0676
XMn_49_6 dn_49_6 WL49 SL6 VSS sky130_fd_pr__nfet_g5v0d10v5 w=1 l=0.5
XRn_49_6 BLN6 dn_49_6 sky130_fd_pr_reram__reram_cell area_ox=0.0676
XMp_49_7 dp_49_7 WL49 SL7 VSS sky130_fd_pr__nfet_g5v0d10v5 w=1 l=0.5
XRp_49_7 BLP7 dp_49_7 sky130_fd_pr_reram__reram_cell area_ox=0.0676
XMz_49_7 dz_49_7 WL49 SL7 VSS sky130_fd_pr__nfet_g5v0d10v5 w=1 l=0.5
XRz_49_7 BLZ7 dz_49_7 sky130_fd_pr_reram__reram_cell area_ox=0.0676
XMn_49_7 dn_49_7 WL49 SL7 VSS sky130_fd_pr__nfet_g5v0d10v5 w=1 l=0.5
XRn_49_7 BLN7 dn_49_7 sky130_fd_pr_reram__reram_cell area_ox=0.0676
XMp_49_8 dp_49_8 WL49 SL8 VSS sky130_fd_pr__nfet_g5v0d10v5 w=1 l=0.5
XRp_49_8 BLP8 dp_49_8 sky130_fd_pr_reram__reram_cell area_ox=0.0676
XMz_49_8 dz_49_8 WL49 SL8 VSS sky130_fd_pr__nfet_g5v0d10v5 w=1 l=0.5
XRz_49_8 BLZ8 dz_49_8 sky130_fd_pr_reram__reram_cell area_ox=0.0676
XMn_49_8 dn_49_8 WL49 SL8 VSS sky130_fd_pr__nfet_g5v0d10v5 w=1 l=0.5
XRn_49_8 BLN8 dn_49_8 sky130_fd_pr_reram__reram_cell area_ox=0.0676
XMp_49_9 dp_49_9 WL49 SL9 VSS sky130_fd_pr__nfet_g5v0d10v5 w=1 l=0.5
XRp_49_9 BLP9 dp_49_9 sky130_fd_pr_reram__reram_cell area_ox=0.0676
XMz_49_9 dz_49_9 WL49 SL9 VSS sky130_fd_pr__nfet_g5v0d10v5 w=1 l=0.5
XRz_49_9 BLZ9 dz_49_9 sky130_fd_pr_reram__reram_cell area_ox=0.0676
XMn_49_9 dn_49_9 WL49 SL9 VSS sky130_fd_pr__nfet_g5v0d10v5 w=1 l=0.5
XRn_49_9 BLN9 dn_49_9 sky130_fd_pr_reram__reram_cell area_ox=0.0676
XMp_49_10 dp_49_10 WL49 SL10 VSS sky130_fd_pr__nfet_g5v0d10v5 w=1 l=0.5
XRp_49_10 BLP10 dp_49_10 sky130_fd_pr_reram__reram_cell area_ox=0.0676
XMz_49_10 dz_49_10 WL49 SL10 VSS sky130_fd_pr__nfet_g5v0d10v5 w=1 l=0.5
XRz_49_10 BLZ10 dz_49_10 sky130_fd_pr_reram__reram_cell area_ox=0.0676
XMn_49_10 dn_49_10 WL49 SL10 VSS sky130_fd_pr__nfet_g5v0d10v5 w=1 l=0.5
XRn_49_10 BLN10 dn_49_10 sky130_fd_pr_reram__reram_cell area_ox=0.0676
XMp_49_11 dp_49_11 WL49 SL11 VSS sky130_fd_pr__nfet_g5v0d10v5 w=1 l=0.5
XRp_49_11 BLP11 dp_49_11 sky130_fd_pr_reram__reram_cell area_ox=0.0676
XMz_49_11 dz_49_11 WL49 SL11 VSS sky130_fd_pr__nfet_g5v0d10v5 w=1 l=0.5
XRz_49_11 BLZ11 dz_49_11 sky130_fd_pr_reram__reram_cell area_ox=0.0676
XMn_49_11 dn_49_11 WL49 SL11 VSS sky130_fd_pr__nfet_g5v0d10v5 w=1 l=0.5
XRn_49_11 BLN11 dn_49_11 sky130_fd_pr_reram__reram_cell area_ox=0.0676
XMp_49_12 dp_49_12 WL49 SL12 VSS sky130_fd_pr__nfet_g5v0d10v5 w=1 l=0.5
XRp_49_12 BLP12 dp_49_12 sky130_fd_pr_reram__reram_cell area_ox=0.0676
XMz_49_12 dz_49_12 WL49 SL12 VSS sky130_fd_pr__nfet_g5v0d10v5 w=1 l=0.5
XRz_49_12 BLZ12 dz_49_12 sky130_fd_pr_reram__reram_cell area_ox=0.0676
XMn_49_12 dn_49_12 WL49 SL12 VSS sky130_fd_pr__nfet_g5v0d10v5 w=1 l=0.5
XRn_49_12 BLN12 dn_49_12 sky130_fd_pr_reram__reram_cell area_ox=0.0676
XMp_49_13 dp_49_13 WL49 SL13 VSS sky130_fd_pr__nfet_g5v0d10v5 w=1 l=0.5
XRp_49_13 BLP13 dp_49_13 sky130_fd_pr_reram__reram_cell area_ox=0.0676
XMz_49_13 dz_49_13 WL49 SL13 VSS sky130_fd_pr__nfet_g5v0d10v5 w=1 l=0.5
XRz_49_13 BLZ13 dz_49_13 sky130_fd_pr_reram__reram_cell area_ox=0.0676
XMn_49_13 dn_49_13 WL49 SL13 VSS sky130_fd_pr__nfet_g5v0d10v5 w=1 l=0.5
XRn_49_13 BLN13 dn_49_13 sky130_fd_pr_reram__reram_cell area_ox=0.0676
XMp_49_14 dp_49_14 WL49 SL14 VSS sky130_fd_pr__nfet_g5v0d10v5 w=1 l=0.5
XRp_49_14 BLP14 dp_49_14 sky130_fd_pr_reram__reram_cell area_ox=0.0676
XMz_49_14 dz_49_14 WL49 SL14 VSS sky130_fd_pr__nfet_g5v0d10v5 w=1 l=0.5
XRz_49_14 BLZ14 dz_49_14 sky130_fd_pr_reram__reram_cell area_ox=0.0676
XMn_49_14 dn_49_14 WL49 SL14 VSS sky130_fd_pr__nfet_g5v0d10v5 w=1 l=0.5
XRn_49_14 BLN14 dn_49_14 sky130_fd_pr_reram__reram_cell area_ox=0.0676
XMp_49_15 dp_49_15 WL49 SL15 VSS sky130_fd_pr__nfet_g5v0d10v5 w=1 l=0.5
XRp_49_15 BLP15 dp_49_15 sky130_fd_pr_reram__reram_cell area_ox=0.0676
XMz_49_15 dz_49_15 WL49 SL15 VSS sky130_fd_pr__nfet_g5v0d10v5 w=1 l=0.5
XRz_49_15 BLZ15 dz_49_15 sky130_fd_pr_reram__reram_cell area_ox=0.0676
XMn_49_15 dn_49_15 WL49 SL15 VSS sky130_fd_pr__nfet_g5v0d10v5 w=1 l=0.5
XRn_49_15 BLN15 dn_49_15 sky130_fd_pr_reram__reram_cell area_ox=0.0676
XMp_49_16 dp_49_16 WL49 SL16 VSS sky130_fd_pr__nfet_g5v0d10v5 w=1 l=0.5
XRp_49_16 BLP16 dp_49_16 sky130_fd_pr_reram__reram_cell area_ox=0.0676
XMz_49_16 dz_49_16 WL49 SL16 VSS sky130_fd_pr__nfet_g5v0d10v5 w=1 l=0.5
XRz_49_16 BLZ16 dz_49_16 sky130_fd_pr_reram__reram_cell area_ox=0.0676
XMn_49_16 dn_49_16 WL49 SL16 VSS sky130_fd_pr__nfet_g5v0d10v5 w=1 l=0.5
XRn_49_16 BLN16 dn_49_16 sky130_fd_pr_reram__reram_cell area_ox=0.0676
XMp_49_17 dp_49_17 WL49 SL17 VSS sky130_fd_pr__nfet_g5v0d10v5 w=1 l=0.5
XRp_49_17 BLP17 dp_49_17 sky130_fd_pr_reram__reram_cell area_ox=0.0676
XMz_49_17 dz_49_17 WL49 SL17 VSS sky130_fd_pr__nfet_g5v0d10v5 w=1 l=0.5
XRz_49_17 BLZ17 dz_49_17 sky130_fd_pr_reram__reram_cell area_ox=0.0676
XMn_49_17 dn_49_17 WL49 SL17 VSS sky130_fd_pr__nfet_g5v0d10v5 w=1 l=0.5
XRn_49_17 BLN17 dn_49_17 sky130_fd_pr_reram__reram_cell area_ox=0.0676
XMp_49_18 dp_49_18 WL49 SL18 VSS sky130_fd_pr__nfet_g5v0d10v5 w=1 l=0.5
XRp_49_18 BLP18 dp_49_18 sky130_fd_pr_reram__reram_cell area_ox=0.0676
XMz_49_18 dz_49_18 WL49 SL18 VSS sky130_fd_pr__nfet_g5v0d10v5 w=1 l=0.5
XRz_49_18 BLZ18 dz_49_18 sky130_fd_pr_reram__reram_cell area_ox=0.0676
XMn_49_18 dn_49_18 WL49 SL18 VSS sky130_fd_pr__nfet_g5v0d10v5 w=1 l=0.5
XRn_49_18 BLN18 dn_49_18 sky130_fd_pr_reram__reram_cell area_ox=0.0676
XMp_49_19 dp_49_19 WL49 SL19 VSS sky130_fd_pr__nfet_g5v0d10v5 w=1 l=0.5
XRp_49_19 BLP19 dp_49_19 sky130_fd_pr_reram__reram_cell area_ox=0.0676
XMz_49_19 dz_49_19 WL49 SL19 VSS sky130_fd_pr__nfet_g5v0d10v5 w=1 l=0.5
XRz_49_19 BLZ19 dz_49_19 sky130_fd_pr_reram__reram_cell area_ox=0.0676
XMn_49_19 dn_49_19 WL49 SL19 VSS sky130_fd_pr__nfet_g5v0d10v5 w=1 l=0.5
XRn_49_19 BLN19 dn_49_19 sky130_fd_pr_reram__reram_cell area_ox=0.0676
XMp_49_20 dp_49_20 WL49 SL20 VSS sky130_fd_pr__nfet_g5v0d10v5 w=1 l=0.5
XRp_49_20 BLP20 dp_49_20 sky130_fd_pr_reram__reram_cell area_ox=0.0676
XMz_49_20 dz_49_20 WL49 SL20 VSS sky130_fd_pr__nfet_g5v0d10v5 w=1 l=0.5
XRz_49_20 BLZ20 dz_49_20 sky130_fd_pr_reram__reram_cell area_ox=0.0676
XMn_49_20 dn_49_20 WL49 SL20 VSS sky130_fd_pr__nfet_g5v0d10v5 w=1 l=0.5
XRn_49_20 BLN20 dn_49_20 sky130_fd_pr_reram__reram_cell area_ox=0.0676
XMp_49_21 dp_49_21 WL49 SL21 VSS sky130_fd_pr__nfet_g5v0d10v5 w=1 l=0.5
XRp_49_21 BLP21 dp_49_21 sky130_fd_pr_reram__reram_cell area_ox=0.0676
XMz_49_21 dz_49_21 WL49 SL21 VSS sky130_fd_pr__nfet_g5v0d10v5 w=1 l=0.5
XRz_49_21 BLZ21 dz_49_21 sky130_fd_pr_reram__reram_cell area_ox=0.0676
XMn_49_21 dn_49_21 WL49 SL21 VSS sky130_fd_pr__nfet_g5v0d10v5 w=1 l=0.5
XRn_49_21 BLN21 dn_49_21 sky130_fd_pr_reram__reram_cell area_ox=0.0676
XMp_49_22 dp_49_22 WL49 SL22 VSS sky130_fd_pr__nfet_g5v0d10v5 w=1 l=0.5
XRp_49_22 BLP22 dp_49_22 sky130_fd_pr_reram__reram_cell area_ox=0.0676
XMz_49_22 dz_49_22 WL49 SL22 VSS sky130_fd_pr__nfet_g5v0d10v5 w=1 l=0.5
XRz_49_22 BLZ22 dz_49_22 sky130_fd_pr_reram__reram_cell area_ox=0.0676
XMn_49_22 dn_49_22 WL49 SL22 VSS sky130_fd_pr__nfet_g5v0d10v5 w=1 l=0.5
XRn_49_22 BLN22 dn_49_22 sky130_fd_pr_reram__reram_cell area_ox=0.0676
XMp_49_23 dp_49_23 WL49 SL23 VSS sky130_fd_pr__nfet_g5v0d10v5 w=1 l=0.5
XRp_49_23 BLP23 dp_49_23 sky130_fd_pr_reram__reram_cell area_ox=0.0676
XMz_49_23 dz_49_23 WL49 SL23 VSS sky130_fd_pr__nfet_g5v0d10v5 w=1 l=0.5
XRz_49_23 BLZ23 dz_49_23 sky130_fd_pr_reram__reram_cell area_ox=0.0676
XMn_49_23 dn_49_23 WL49 SL23 VSS sky130_fd_pr__nfet_g5v0d10v5 w=1 l=0.5
XRn_49_23 BLN23 dn_49_23 sky130_fd_pr_reram__reram_cell area_ox=0.0676
XMp_50_0 dp_50_0 WL50 SL0 VSS sky130_fd_pr__nfet_g5v0d10v5 w=1 l=0.5
XRp_50_0 BLP0 dp_50_0 sky130_fd_pr_reram__reram_cell area_ox=0.0676
XMz_50_0 dz_50_0 WL50 SL0 VSS sky130_fd_pr__nfet_g5v0d10v5 w=1 l=0.5
XRz_50_0 BLZ0 dz_50_0 sky130_fd_pr_reram__reram_cell area_ox=0.0676
XMn_50_0 dn_50_0 WL50 SL0 VSS sky130_fd_pr__nfet_g5v0d10v5 w=1 l=0.5
XRn_50_0 BLN0 dn_50_0 sky130_fd_pr_reram__reram_cell area_ox=0.0676
XMp_50_1 dp_50_1 WL50 SL1 VSS sky130_fd_pr__nfet_g5v0d10v5 w=1 l=0.5
XRp_50_1 BLP1 dp_50_1 sky130_fd_pr_reram__reram_cell area_ox=0.0676
XMz_50_1 dz_50_1 WL50 SL1 VSS sky130_fd_pr__nfet_g5v0d10v5 w=1 l=0.5
XRz_50_1 BLZ1 dz_50_1 sky130_fd_pr_reram__reram_cell area_ox=0.0676
XMn_50_1 dn_50_1 WL50 SL1 VSS sky130_fd_pr__nfet_g5v0d10v5 w=1 l=0.5
XRn_50_1 BLN1 dn_50_1 sky130_fd_pr_reram__reram_cell area_ox=0.0676
XMp_50_2 dp_50_2 WL50 SL2 VSS sky130_fd_pr__nfet_g5v0d10v5 w=1 l=0.5
XRp_50_2 BLP2 dp_50_2 sky130_fd_pr_reram__reram_cell area_ox=0.0676
XMz_50_2 dz_50_2 WL50 SL2 VSS sky130_fd_pr__nfet_g5v0d10v5 w=1 l=0.5
XRz_50_2 BLZ2 dz_50_2 sky130_fd_pr_reram__reram_cell area_ox=0.0676
XMn_50_2 dn_50_2 WL50 SL2 VSS sky130_fd_pr__nfet_g5v0d10v5 w=1 l=0.5
XRn_50_2 BLN2 dn_50_2 sky130_fd_pr_reram__reram_cell area_ox=0.0676
XMp_50_3 dp_50_3 WL50 SL3 VSS sky130_fd_pr__nfet_g5v0d10v5 w=1 l=0.5
XRp_50_3 BLP3 dp_50_3 sky130_fd_pr_reram__reram_cell area_ox=0.0676
XMz_50_3 dz_50_3 WL50 SL3 VSS sky130_fd_pr__nfet_g5v0d10v5 w=1 l=0.5
XRz_50_3 BLZ3 dz_50_3 sky130_fd_pr_reram__reram_cell area_ox=0.0676
XMn_50_3 dn_50_3 WL50 SL3 VSS sky130_fd_pr__nfet_g5v0d10v5 w=1 l=0.5
XRn_50_3 BLN3 dn_50_3 sky130_fd_pr_reram__reram_cell area_ox=0.0676
XMp_50_4 dp_50_4 WL50 SL4 VSS sky130_fd_pr__nfet_g5v0d10v5 w=1 l=0.5
XRp_50_4 BLP4 dp_50_4 sky130_fd_pr_reram__reram_cell area_ox=0.0676
XMz_50_4 dz_50_4 WL50 SL4 VSS sky130_fd_pr__nfet_g5v0d10v5 w=1 l=0.5
XRz_50_4 BLZ4 dz_50_4 sky130_fd_pr_reram__reram_cell area_ox=0.0676
XMn_50_4 dn_50_4 WL50 SL4 VSS sky130_fd_pr__nfet_g5v0d10v5 w=1 l=0.5
XRn_50_4 BLN4 dn_50_4 sky130_fd_pr_reram__reram_cell area_ox=0.0676
XMp_50_5 dp_50_5 WL50 SL5 VSS sky130_fd_pr__nfet_g5v0d10v5 w=1 l=0.5
XRp_50_5 BLP5 dp_50_5 sky130_fd_pr_reram__reram_cell area_ox=0.0676
XMz_50_5 dz_50_5 WL50 SL5 VSS sky130_fd_pr__nfet_g5v0d10v5 w=1 l=0.5
XRz_50_5 BLZ5 dz_50_5 sky130_fd_pr_reram__reram_cell area_ox=0.0676
XMn_50_5 dn_50_5 WL50 SL5 VSS sky130_fd_pr__nfet_g5v0d10v5 w=1 l=0.5
XRn_50_5 BLN5 dn_50_5 sky130_fd_pr_reram__reram_cell area_ox=0.0676
XMp_50_6 dp_50_6 WL50 SL6 VSS sky130_fd_pr__nfet_g5v0d10v5 w=1 l=0.5
XRp_50_6 BLP6 dp_50_6 sky130_fd_pr_reram__reram_cell area_ox=0.0676
XMz_50_6 dz_50_6 WL50 SL6 VSS sky130_fd_pr__nfet_g5v0d10v5 w=1 l=0.5
XRz_50_6 BLZ6 dz_50_6 sky130_fd_pr_reram__reram_cell area_ox=0.0676
XMn_50_6 dn_50_6 WL50 SL6 VSS sky130_fd_pr__nfet_g5v0d10v5 w=1 l=0.5
XRn_50_6 BLN6 dn_50_6 sky130_fd_pr_reram__reram_cell area_ox=0.0676
XMp_50_7 dp_50_7 WL50 SL7 VSS sky130_fd_pr__nfet_g5v0d10v5 w=1 l=0.5
XRp_50_7 BLP7 dp_50_7 sky130_fd_pr_reram__reram_cell area_ox=0.0676
XMz_50_7 dz_50_7 WL50 SL7 VSS sky130_fd_pr__nfet_g5v0d10v5 w=1 l=0.5
XRz_50_7 BLZ7 dz_50_7 sky130_fd_pr_reram__reram_cell area_ox=0.0676
XMn_50_7 dn_50_7 WL50 SL7 VSS sky130_fd_pr__nfet_g5v0d10v5 w=1 l=0.5
XRn_50_7 BLN7 dn_50_7 sky130_fd_pr_reram__reram_cell area_ox=0.0676
XMp_50_8 dp_50_8 WL50 SL8 VSS sky130_fd_pr__nfet_g5v0d10v5 w=1 l=0.5
XRp_50_8 BLP8 dp_50_8 sky130_fd_pr_reram__reram_cell area_ox=0.0676
XMz_50_8 dz_50_8 WL50 SL8 VSS sky130_fd_pr__nfet_g5v0d10v5 w=1 l=0.5
XRz_50_8 BLZ8 dz_50_8 sky130_fd_pr_reram__reram_cell area_ox=0.0676
XMn_50_8 dn_50_8 WL50 SL8 VSS sky130_fd_pr__nfet_g5v0d10v5 w=1 l=0.5
XRn_50_8 BLN8 dn_50_8 sky130_fd_pr_reram__reram_cell area_ox=0.0676
XMp_50_9 dp_50_9 WL50 SL9 VSS sky130_fd_pr__nfet_g5v0d10v5 w=1 l=0.5
XRp_50_9 BLP9 dp_50_9 sky130_fd_pr_reram__reram_cell area_ox=0.0676
XMz_50_9 dz_50_9 WL50 SL9 VSS sky130_fd_pr__nfet_g5v0d10v5 w=1 l=0.5
XRz_50_9 BLZ9 dz_50_9 sky130_fd_pr_reram__reram_cell area_ox=0.0676
XMn_50_9 dn_50_9 WL50 SL9 VSS sky130_fd_pr__nfet_g5v0d10v5 w=1 l=0.5
XRn_50_9 BLN9 dn_50_9 sky130_fd_pr_reram__reram_cell area_ox=0.0676
XMp_50_10 dp_50_10 WL50 SL10 VSS sky130_fd_pr__nfet_g5v0d10v5 w=1 l=0.5
XRp_50_10 BLP10 dp_50_10 sky130_fd_pr_reram__reram_cell area_ox=0.0676
XMz_50_10 dz_50_10 WL50 SL10 VSS sky130_fd_pr__nfet_g5v0d10v5 w=1 l=0.5
XRz_50_10 BLZ10 dz_50_10 sky130_fd_pr_reram__reram_cell area_ox=0.0676
XMn_50_10 dn_50_10 WL50 SL10 VSS sky130_fd_pr__nfet_g5v0d10v5 w=1 l=0.5
XRn_50_10 BLN10 dn_50_10 sky130_fd_pr_reram__reram_cell area_ox=0.0676
XMp_50_11 dp_50_11 WL50 SL11 VSS sky130_fd_pr__nfet_g5v0d10v5 w=1 l=0.5
XRp_50_11 BLP11 dp_50_11 sky130_fd_pr_reram__reram_cell area_ox=0.0676
XMz_50_11 dz_50_11 WL50 SL11 VSS sky130_fd_pr__nfet_g5v0d10v5 w=1 l=0.5
XRz_50_11 BLZ11 dz_50_11 sky130_fd_pr_reram__reram_cell area_ox=0.0676
XMn_50_11 dn_50_11 WL50 SL11 VSS sky130_fd_pr__nfet_g5v0d10v5 w=1 l=0.5
XRn_50_11 BLN11 dn_50_11 sky130_fd_pr_reram__reram_cell area_ox=0.0676
XMp_50_12 dp_50_12 WL50 SL12 VSS sky130_fd_pr__nfet_g5v0d10v5 w=1 l=0.5
XRp_50_12 BLP12 dp_50_12 sky130_fd_pr_reram__reram_cell area_ox=0.0676
XMz_50_12 dz_50_12 WL50 SL12 VSS sky130_fd_pr__nfet_g5v0d10v5 w=1 l=0.5
XRz_50_12 BLZ12 dz_50_12 sky130_fd_pr_reram__reram_cell area_ox=0.0676
XMn_50_12 dn_50_12 WL50 SL12 VSS sky130_fd_pr__nfet_g5v0d10v5 w=1 l=0.5
XRn_50_12 BLN12 dn_50_12 sky130_fd_pr_reram__reram_cell area_ox=0.0676
XMp_50_13 dp_50_13 WL50 SL13 VSS sky130_fd_pr__nfet_g5v0d10v5 w=1 l=0.5
XRp_50_13 BLP13 dp_50_13 sky130_fd_pr_reram__reram_cell area_ox=0.0676
XMz_50_13 dz_50_13 WL50 SL13 VSS sky130_fd_pr__nfet_g5v0d10v5 w=1 l=0.5
XRz_50_13 BLZ13 dz_50_13 sky130_fd_pr_reram__reram_cell area_ox=0.0676
XMn_50_13 dn_50_13 WL50 SL13 VSS sky130_fd_pr__nfet_g5v0d10v5 w=1 l=0.5
XRn_50_13 BLN13 dn_50_13 sky130_fd_pr_reram__reram_cell area_ox=0.0676
XMp_50_14 dp_50_14 WL50 SL14 VSS sky130_fd_pr__nfet_g5v0d10v5 w=1 l=0.5
XRp_50_14 BLP14 dp_50_14 sky130_fd_pr_reram__reram_cell area_ox=0.0676
XMz_50_14 dz_50_14 WL50 SL14 VSS sky130_fd_pr__nfet_g5v0d10v5 w=1 l=0.5
XRz_50_14 BLZ14 dz_50_14 sky130_fd_pr_reram__reram_cell area_ox=0.0676
XMn_50_14 dn_50_14 WL50 SL14 VSS sky130_fd_pr__nfet_g5v0d10v5 w=1 l=0.5
XRn_50_14 BLN14 dn_50_14 sky130_fd_pr_reram__reram_cell area_ox=0.0676
XMp_50_15 dp_50_15 WL50 SL15 VSS sky130_fd_pr__nfet_g5v0d10v5 w=1 l=0.5
XRp_50_15 BLP15 dp_50_15 sky130_fd_pr_reram__reram_cell area_ox=0.0676
XMz_50_15 dz_50_15 WL50 SL15 VSS sky130_fd_pr__nfet_g5v0d10v5 w=1 l=0.5
XRz_50_15 BLZ15 dz_50_15 sky130_fd_pr_reram__reram_cell area_ox=0.0676
XMn_50_15 dn_50_15 WL50 SL15 VSS sky130_fd_pr__nfet_g5v0d10v5 w=1 l=0.5
XRn_50_15 BLN15 dn_50_15 sky130_fd_pr_reram__reram_cell area_ox=0.0676
XMp_50_16 dp_50_16 WL50 SL16 VSS sky130_fd_pr__nfet_g5v0d10v5 w=1 l=0.5
XRp_50_16 BLP16 dp_50_16 sky130_fd_pr_reram__reram_cell area_ox=0.0676
XMz_50_16 dz_50_16 WL50 SL16 VSS sky130_fd_pr__nfet_g5v0d10v5 w=1 l=0.5
XRz_50_16 BLZ16 dz_50_16 sky130_fd_pr_reram__reram_cell area_ox=0.0676
XMn_50_16 dn_50_16 WL50 SL16 VSS sky130_fd_pr__nfet_g5v0d10v5 w=1 l=0.5
XRn_50_16 BLN16 dn_50_16 sky130_fd_pr_reram__reram_cell area_ox=0.0676
XMp_50_17 dp_50_17 WL50 SL17 VSS sky130_fd_pr__nfet_g5v0d10v5 w=1 l=0.5
XRp_50_17 BLP17 dp_50_17 sky130_fd_pr_reram__reram_cell area_ox=0.0676
XMz_50_17 dz_50_17 WL50 SL17 VSS sky130_fd_pr__nfet_g5v0d10v5 w=1 l=0.5
XRz_50_17 BLZ17 dz_50_17 sky130_fd_pr_reram__reram_cell area_ox=0.0676
XMn_50_17 dn_50_17 WL50 SL17 VSS sky130_fd_pr__nfet_g5v0d10v5 w=1 l=0.5
XRn_50_17 BLN17 dn_50_17 sky130_fd_pr_reram__reram_cell area_ox=0.0676
XMp_50_18 dp_50_18 WL50 SL18 VSS sky130_fd_pr__nfet_g5v0d10v5 w=1 l=0.5
XRp_50_18 BLP18 dp_50_18 sky130_fd_pr_reram__reram_cell area_ox=0.0676
XMz_50_18 dz_50_18 WL50 SL18 VSS sky130_fd_pr__nfet_g5v0d10v5 w=1 l=0.5
XRz_50_18 BLZ18 dz_50_18 sky130_fd_pr_reram__reram_cell area_ox=0.0676
XMn_50_18 dn_50_18 WL50 SL18 VSS sky130_fd_pr__nfet_g5v0d10v5 w=1 l=0.5
XRn_50_18 BLN18 dn_50_18 sky130_fd_pr_reram__reram_cell area_ox=0.0676
XMp_50_19 dp_50_19 WL50 SL19 VSS sky130_fd_pr__nfet_g5v0d10v5 w=1 l=0.5
XRp_50_19 BLP19 dp_50_19 sky130_fd_pr_reram__reram_cell area_ox=0.0676
XMz_50_19 dz_50_19 WL50 SL19 VSS sky130_fd_pr__nfet_g5v0d10v5 w=1 l=0.5
XRz_50_19 BLZ19 dz_50_19 sky130_fd_pr_reram__reram_cell area_ox=0.0676
XMn_50_19 dn_50_19 WL50 SL19 VSS sky130_fd_pr__nfet_g5v0d10v5 w=1 l=0.5
XRn_50_19 BLN19 dn_50_19 sky130_fd_pr_reram__reram_cell area_ox=0.0676
XMp_50_20 dp_50_20 WL50 SL20 VSS sky130_fd_pr__nfet_g5v0d10v5 w=1 l=0.5
XRp_50_20 BLP20 dp_50_20 sky130_fd_pr_reram__reram_cell area_ox=0.0676
XMz_50_20 dz_50_20 WL50 SL20 VSS sky130_fd_pr__nfet_g5v0d10v5 w=1 l=0.5
XRz_50_20 BLZ20 dz_50_20 sky130_fd_pr_reram__reram_cell area_ox=0.0676
XMn_50_20 dn_50_20 WL50 SL20 VSS sky130_fd_pr__nfet_g5v0d10v5 w=1 l=0.5
XRn_50_20 BLN20 dn_50_20 sky130_fd_pr_reram__reram_cell area_ox=0.0676
XMp_50_21 dp_50_21 WL50 SL21 VSS sky130_fd_pr__nfet_g5v0d10v5 w=1 l=0.5
XRp_50_21 BLP21 dp_50_21 sky130_fd_pr_reram__reram_cell area_ox=0.0676
XMz_50_21 dz_50_21 WL50 SL21 VSS sky130_fd_pr__nfet_g5v0d10v5 w=1 l=0.5
XRz_50_21 BLZ21 dz_50_21 sky130_fd_pr_reram__reram_cell area_ox=0.0676
XMn_50_21 dn_50_21 WL50 SL21 VSS sky130_fd_pr__nfet_g5v0d10v5 w=1 l=0.5
XRn_50_21 BLN21 dn_50_21 sky130_fd_pr_reram__reram_cell area_ox=0.0676
XMp_50_22 dp_50_22 WL50 SL22 VSS sky130_fd_pr__nfet_g5v0d10v5 w=1 l=0.5
XRp_50_22 BLP22 dp_50_22 sky130_fd_pr_reram__reram_cell area_ox=0.0676
XMz_50_22 dz_50_22 WL50 SL22 VSS sky130_fd_pr__nfet_g5v0d10v5 w=1 l=0.5
XRz_50_22 BLZ22 dz_50_22 sky130_fd_pr_reram__reram_cell area_ox=0.0676
XMn_50_22 dn_50_22 WL50 SL22 VSS sky130_fd_pr__nfet_g5v0d10v5 w=1 l=0.5
XRn_50_22 BLN22 dn_50_22 sky130_fd_pr_reram__reram_cell area_ox=0.0676
XMp_50_23 dp_50_23 WL50 SL23 VSS sky130_fd_pr__nfet_g5v0d10v5 w=1 l=0.5
XRp_50_23 BLP23 dp_50_23 sky130_fd_pr_reram__reram_cell area_ox=0.0676
XMz_50_23 dz_50_23 WL50 SL23 VSS sky130_fd_pr__nfet_g5v0d10v5 w=1 l=0.5
XRz_50_23 BLZ23 dz_50_23 sky130_fd_pr_reram__reram_cell area_ox=0.0676
XMn_50_23 dn_50_23 WL50 SL23 VSS sky130_fd_pr__nfet_g5v0d10v5 w=1 l=0.5
XRn_50_23 BLN23 dn_50_23 sky130_fd_pr_reram__reram_cell area_ox=0.0676
XMp_51_0 dp_51_0 WL51 SL0 VSS sky130_fd_pr__nfet_g5v0d10v5 w=1 l=0.5
XRp_51_0 BLP0 dp_51_0 sky130_fd_pr_reram__reram_cell area_ox=0.0676
XMz_51_0 dz_51_0 WL51 SL0 VSS sky130_fd_pr__nfet_g5v0d10v5 w=1 l=0.5
XRz_51_0 BLZ0 dz_51_0 sky130_fd_pr_reram__reram_cell area_ox=0.0676
XMn_51_0 dn_51_0 WL51 SL0 VSS sky130_fd_pr__nfet_g5v0d10v5 w=1 l=0.5
XRn_51_0 BLN0 dn_51_0 sky130_fd_pr_reram__reram_cell area_ox=0.0676
XMp_51_1 dp_51_1 WL51 SL1 VSS sky130_fd_pr__nfet_g5v0d10v5 w=1 l=0.5
XRp_51_1 BLP1 dp_51_1 sky130_fd_pr_reram__reram_cell area_ox=0.0676
XMz_51_1 dz_51_1 WL51 SL1 VSS sky130_fd_pr__nfet_g5v0d10v5 w=1 l=0.5
XRz_51_1 BLZ1 dz_51_1 sky130_fd_pr_reram__reram_cell area_ox=0.0676
XMn_51_1 dn_51_1 WL51 SL1 VSS sky130_fd_pr__nfet_g5v0d10v5 w=1 l=0.5
XRn_51_1 BLN1 dn_51_1 sky130_fd_pr_reram__reram_cell area_ox=0.0676
XMp_51_2 dp_51_2 WL51 SL2 VSS sky130_fd_pr__nfet_g5v0d10v5 w=1 l=0.5
XRp_51_2 BLP2 dp_51_2 sky130_fd_pr_reram__reram_cell area_ox=0.0676
XMz_51_2 dz_51_2 WL51 SL2 VSS sky130_fd_pr__nfet_g5v0d10v5 w=1 l=0.5
XRz_51_2 BLZ2 dz_51_2 sky130_fd_pr_reram__reram_cell area_ox=0.0676
XMn_51_2 dn_51_2 WL51 SL2 VSS sky130_fd_pr__nfet_g5v0d10v5 w=1 l=0.5
XRn_51_2 BLN2 dn_51_2 sky130_fd_pr_reram__reram_cell area_ox=0.0676
XMp_51_3 dp_51_3 WL51 SL3 VSS sky130_fd_pr__nfet_g5v0d10v5 w=1 l=0.5
XRp_51_3 BLP3 dp_51_3 sky130_fd_pr_reram__reram_cell area_ox=0.0676
XMz_51_3 dz_51_3 WL51 SL3 VSS sky130_fd_pr__nfet_g5v0d10v5 w=1 l=0.5
XRz_51_3 BLZ3 dz_51_3 sky130_fd_pr_reram__reram_cell area_ox=0.0676
XMn_51_3 dn_51_3 WL51 SL3 VSS sky130_fd_pr__nfet_g5v0d10v5 w=1 l=0.5
XRn_51_3 BLN3 dn_51_3 sky130_fd_pr_reram__reram_cell area_ox=0.0676
XMp_51_4 dp_51_4 WL51 SL4 VSS sky130_fd_pr__nfet_g5v0d10v5 w=1 l=0.5
XRp_51_4 BLP4 dp_51_4 sky130_fd_pr_reram__reram_cell area_ox=0.0676
XMz_51_4 dz_51_4 WL51 SL4 VSS sky130_fd_pr__nfet_g5v0d10v5 w=1 l=0.5
XRz_51_4 BLZ4 dz_51_4 sky130_fd_pr_reram__reram_cell area_ox=0.0676
XMn_51_4 dn_51_4 WL51 SL4 VSS sky130_fd_pr__nfet_g5v0d10v5 w=1 l=0.5
XRn_51_4 BLN4 dn_51_4 sky130_fd_pr_reram__reram_cell area_ox=0.0676
XMp_51_5 dp_51_5 WL51 SL5 VSS sky130_fd_pr__nfet_g5v0d10v5 w=1 l=0.5
XRp_51_5 BLP5 dp_51_5 sky130_fd_pr_reram__reram_cell area_ox=0.0676
XMz_51_5 dz_51_5 WL51 SL5 VSS sky130_fd_pr__nfet_g5v0d10v5 w=1 l=0.5
XRz_51_5 BLZ5 dz_51_5 sky130_fd_pr_reram__reram_cell area_ox=0.0676
XMn_51_5 dn_51_5 WL51 SL5 VSS sky130_fd_pr__nfet_g5v0d10v5 w=1 l=0.5
XRn_51_5 BLN5 dn_51_5 sky130_fd_pr_reram__reram_cell area_ox=0.0676
XMp_51_6 dp_51_6 WL51 SL6 VSS sky130_fd_pr__nfet_g5v0d10v5 w=1 l=0.5
XRp_51_6 BLP6 dp_51_6 sky130_fd_pr_reram__reram_cell area_ox=0.0676
XMz_51_6 dz_51_6 WL51 SL6 VSS sky130_fd_pr__nfet_g5v0d10v5 w=1 l=0.5
XRz_51_6 BLZ6 dz_51_6 sky130_fd_pr_reram__reram_cell area_ox=0.0676
XMn_51_6 dn_51_6 WL51 SL6 VSS sky130_fd_pr__nfet_g5v0d10v5 w=1 l=0.5
XRn_51_6 BLN6 dn_51_6 sky130_fd_pr_reram__reram_cell area_ox=0.0676
XMp_51_7 dp_51_7 WL51 SL7 VSS sky130_fd_pr__nfet_g5v0d10v5 w=1 l=0.5
XRp_51_7 BLP7 dp_51_7 sky130_fd_pr_reram__reram_cell area_ox=0.0676
XMz_51_7 dz_51_7 WL51 SL7 VSS sky130_fd_pr__nfet_g5v0d10v5 w=1 l=0.5
XRz_51_7 BLZ7 dz_51_7 sky130_fd_pr_reram__reram_cell area_ox=0.0676
XMn_51_7 dn_51_7 WL51 SL7 VSS sky130_fd_pr__nfet_g5v0d10v5 w=1 l=0.5
XRn_51_7 BLN7 dn_51_7 sky130_fd_pr_reram__reram_cell area_ox=0.0676
XMp_51_8 dp_51_8 WL51 SL8 VSS sky130_fd_pr__nfet_g5v0d10v5 w=1 l=0.5
XRp_51_8 BLP8 dp_51_8 sky130_fd_pr_reram__reram_cell area_ox=0.0676
XMz_51_8 dz_51_8 WL51 SL8 VSS sky130_fd_pr__nfet_g5v0d10v5 w=1 l=0.5
XRz_51_8 BLZ8 dz_51_8 sky130_fd_pr_reram__reram_cell area_ox=0.0676
XMn_51_8 dn_51_8 WL51 SL8 VSS sky130_fd_pr__nfet_g5v0d10v5 w=1 l=0.5
XRn_51_8 BLN8 dn_51_8 sky130_fd_pr_reram__reram_cell area_ox=0.0676
XMp_51_9 dp_51_9 WL51 SL9 VSS sky130_fd_pr__nfet_g5v0d10v5 w=1 l=0.5
XRp_51_9 BLP9 dp_51_9 sky130_fd_pr_reram__reram_cell area_ox=0.0676
XMz_51_9 dz_51_9 WL51 SL9 VSS sky130_fd_pr__nfet_g5v0d10v5 w=1 l=0.5
XRz_51_9 BLZ9 dz_51_9 sky130_fd_pr_reram__reram_cell area_ox=0.0676
XMn_51_9 dn_51_9 WL51 SL9 VSS sky130_fd_pr__nfet_g5v0d10v5 w=1 l=0.5
XRn_51_9 BLN9 dn_51_9 sky130_fd_pr_reram__reram_cell area_ox=0.0676
XMp_51_10 dp_51_10 WL51 SL10 VSS sky130_fd_pr__nfet_g5v0d10v5 w=1 l=0.5
XRp_51_10 BLP10 dp_51_10 sky130_fd_pr_reram__reram_cell area_ox=0.0676
XMz_51_10 dz_51_10 WL51 SL10 VSS sky130_fd_pr__nfet_g5v0d10v5 w=1 l=0.5
XRz_51_10 BLZ10 dz_51_10 sky130_fd_pr_reram__reram_cell area_ox=0.0676
XMn_51_10 dn_51_10 WL51 SL10 VSS sky130_fd_pr__nfet_g5v0d10v5 w=1 l=0.5
XRn_51_10 BLN10 dn_51_10 sky130_fd_pr_reram__reram_cell area_ox=0.0676
XMp_51_11 dp_51_11 WL51 SL11 VSS sky130_fd_pr__nfet_g5v0d10v5 w=1 l=0.5
XRp_51_11 BLP11 dp_51_11 sky130_fd_pr_reram__reram_cell area_ox=0.0676
XMz_51_11 dz_51_11 WL51 SL11 VSS sky130_fd_pr__nfet_g5v0d10v5 w=1 l=0.5
XRz_51_11 BLZ11 dz_51_11 sky130_fd_pr_reram__reram_cell area_ox=0.0676
XMn_51_11 dn_51_11 WL51 SL11 VSS sky130_fd_pr__nfet_g5v0d10v5 w=1 l=0.5
XRn_51_11 BLN11 dn_51_11 sky130_fd_pr_reram__reram_cell area_ox=0.0676
XMp_51_12 dp_51_12 WL51 SL12 VSS sky130_fd_pr__nfet_g5v0d10v5 w=1 l=0.5
XRp_51_12 BLP12 dp_51_12 sky130_fd_pr_reram__reram_cell area_ox=0.0676
XMz_51_12 dz_51_12 WL51 SL12 VSS sky130_fd_pr__nfet_g5v0d10v5 w=1 l=0.5
XRz_51_12 BLZ12 dz_51_12 sky130_fd_pr_reram__reram_cell area_ox=0.0676
XMn_51_12 dn_51_12 WL51 SL12 VSS sky130_fd_pr__nfet_g5v0d10v5 w=1 l=0.5
XRn_51_12 BLN12 dn_51_12 sky130_fd_pr_reram__reram_cell area_ox=0.0676
XMp_51_13 dp_51_13 WL51 SL13 VSS sky130_fd_pr__nfet_g5v0d10v5 w=1 l=0.5
XRp_51_13 BLP13 dp_51_13 sky130_fd_pr_reram__reram_cell area_ox=0.0676
XMz_51_13 dz_51_13 WL51 SL13 VSS sky130_fd_pr__nfet_g5v0d10v5 w=1 l=0.5
XRz_51_13 BLZ13 dz_51_13 sky130_fd_pr_reram__reram_cell area_ox=0.0676
XMn_51_13 dn_51_13 WL51 SL13 VSS sky130_fd_pr__nfet_g5v0d10v5 w=1 l=0.5
XRn_51_13 BLN13 dn_51_13 sky130_fd_pr_reram__reram_cell area_ox=0.0676
XMp_51_14 dp_51_14 WL51 SL14 VSS sky130_fd_pr__nfet_g5v0d10v5 w=1 l=0.5
XRp_51_14 BLP14 dp_51_14 sky130_fd_pr_reram__reram_cell area_ox=0.0676
XMz_51_14 dz_51_14 WL51 SL14 VSS sky130_fd_pr__nfet_g5v0d10v5 w=1 l=0.5
XRz_51_14 BLZ14 dz_51_14 sky130_fd_pr_reram__reram_cell area_ox=0.0676
XMn_51_14 dn_51_14 WL51 SL14 VSS sky130_fd_pr__nfet_g5v0d10v5 w=1 l=0.5
XRn_51_14 BLN14 dn_51_14 sky130_fd_pr_reram__reram_cell area_ox=0.0676
XMp_51_15 dp_51_15 WL51 SL15 VSS sky130_fd_pr__nfet_g5v0d10v5 w=1 l=0.5
XRp_51_15 BLP15 dp_51_15 sky130_fd_pr_reram__reram_cell area_ox=0.0676
XMz_51_15 dz_51_15 WL51 SL15 VSS sky130_fd_pr__nfet_g5v0d10v5 w=1 l=0.5
XRz_51_15 BLZ15 dz_51_15 sky130_fd_pr_reram__reram_cell area_ox=0.0676
XMn_51_15 dn_51_15 WL51 SL15 VSS sky130_fd_pr__nfet_g5v0d10v5 w=1 l=0.5
XRn_51_15 BLN15 dn_51_15 sky130_fd_pr_reram__reram_cell area_ox=0.0676
XMp_51_16 dp_51_16 WL51 SL16 VSS sky130_fd_pr__nfet_g5v0d10v5 w=1 l=0.5
XRp_51_16 BLP16 dp_51_16 sky130_fd_pr_reram__reram_cell area_ox=0.0676
XMz_51_16 dz_51_16 WL51 SL16 VSS sky130_fd_pr__nfet_g5v0d10v5 w=1 l=0.5
XRz_51_16 BLZ16 dz_51_16 sky130_fd_pr_reram__reram_cell area_ox=0.0676
XMn_51_16 dn_51_16 WL51 SL16 VSS sky130_fd_pr__nfet_g5v0d10v5 w=1 l=0.5
XRn_51_16 BLN16 dn_51_16 sky130_fd_pr_reram__reram_cell area_ox=0.0676
XMp_51_17 dp_51_17 WL51 SL17 VSS sky130_fd_pr__nfet_g5v0d10v5 w=1 l=0.5
XRp_51_17 BLP17 dp_51_17 sky130_fd_pr_reram__reram_cell area_ox=0.0676
XMz_51_17 dz_51_17 WL51 SL17 VSS sky130_fd_pr__nfet_g5v0d10v5 w=1 l=0.5
XRz_51_17 BLZ17 dz_51_17 sky130_fd_pr_reram__reram_cell area_ox=0.0676
XMn_51_17 dn_51_17 WL51 SL17 VSS sky130_fd_pr__nfet_g5v0d10v5 w=1 l=0.5
XRn_51_17 BLN17 dn_51_17 sky130_fd_pr_reram__reram_cell area_ox=0.0676
XMp_51_18 dp_51_18 WL51 SL18 VSS sky130_fd_pr__nfet_g5v0d10v5 w=1 l=0.5
XRp_51_18 BLP18 dp_51_18 sky130_fd_pr_reram__reram_cell area_ox=0.0676
XMz_51_18 dz_51_18 WL51 SL18 VSS sky130_fd_pr__nfet_g5v0d10v5 w=1 l=0.5
XRz_51_18 BLZ18 dz_51_18 sky130_fd_pr_reram__reram_cell area_ox=0.0676
XMn_51_18 dn_51_18 WL51 SL18 VSS sky130_fd_pr__nfet_g5v0d10v5 w=1 l=0.5
XRn_51_18 BLN18 dn_51_18 sky130_fd_pr_reram__reram_cell area_ox=0.0676
XMp_51_19 dp_51_19 WL51 SL19 VSS sky130_fd_pr__nfet_g5v0d10v5 w=1 l=0.5
XRp_51_19 BLP19 dp_51_19 sky130_fd_pr_reram__reram_cell area_ox=0.0676
XMz_51_19 dz_51_19 WL51 SL19 VSS sky130_fd_pr__nfet_g5v0d10v5 w=1 l=0.5
XRz_51_19 BLZ19 dz_51_19 sky130_fd_pr_reram__reram_cell area_ox=0.0676
XMn_51_19 dn_51_19 WL51 SL19 VSS sky130_fd_pr__nfet_g5v0d10v5 w=1 l=0.5
XRn_51_19 BLN19 dn_51_19 sky130_fd_pr_reram__reram_cell area_ox=0.0676
XMp_51_20 dp_51_20 WL51 SL20 VSS sky130_fd_pr__nfet_g5v0d10v5 w=1 l=0.5
XRp_51_20 BLP20 dp_51_20 sky130_fd_pr_reram__reram_cell area_ox=0.0676
XMz_51_20 dz_51_20 WL51 SL20 VSS sky130_fd_pr__nfet_g5v0d10v5 w=1 l=0.5
XRz_51_20 BLZ20 dz_51_20 sky130_fd_pr_reram__reram_cell area_ox=0.0676
XMn_51_20 dn_51_20 WL51 SL20 VSS sky130_fd_pr__nfet_g5v0d10v5 w=1 l=0.5
XRn_51_20 BLN20 dn_51_20 sky130_fd_pr_reram__reram_cell area_ox=0.0676
XMp_51_21 dp_51_21 WL51 SL21 VSS sky130_fd_pr__nfet_g5v0d10v5 w=1 l=0.5
XRp_51_21 BLP21 dp_51_21 sky130_fd_pr_reram__reram_cell area_ox=0.0676
XMz_51_21 dz_51_21 WL51 SL21 VSS sky130_fd_pr__nfet_g5v0d10v5 w=1 l=0.5
XRz_51_21 BLZ21 dz_51_21 sky130_fd_pr_reram__reram_cell area_ox=0.0676
XMn_51_21 dn_51_21 WL51 SL21 VSS sky130_fd_pr__nfet_g5v0d10v5 w=1 l=0.5
XRn_51_21 BLN21 dn_51_21 sky130_fd_pr_reram__reram_cell area_ox=0.0676
XMp_51_22 dp_51_22 WL51 SL22 VSS sky130_fd_pr__nfet_g5v0d10v5 w=1 l=0.5
XRp_51_22 BLP22 dp_51_22 sky130_fd_pr_reram__reram_cell area_ox=0.0676
XMz_51_22 dz_51_22 WL51 SL22 VSS sky130_fd_pr__nfet_g5v0d10v5 w=1 l=0.5
XRz_51_22 BLZ22 dz_51_22 sky130_fd_pr_reram__reram_cell area_ox=0.0676
XMn_51_22 dn_51_22 WL51 SL22 VSS sky130_fd_pr__nfet_g5v0d10v5 w=1 l=0.5
XRn_51_22 BLN22 dn_51_22 sky130_fd_pr_reram__reram_cell area_ox=0.0676
XMp_51_23 dp_51_23 WL51 SL23 VSS sky130_fd_pr__nfet_g5v0d10v5 w=1 l=0.5
XRp_51_23 BLP23 dp_51_23 sky130_fd_pr_reram__reram_cell area_ox=0.0676
XMz_51_23 dz_51_23 WL51 SL23 VSS sky130_fd_pr__nfet_g5v0d10v5 w=1 l=0.5
XRz_51_23 BLZ23 dz_51_23 sky130_fd_pr_reram__reram_cell area_ox=0.0676
XMn_51_23 dn_51_23 WL51 SL23 VSS sky130_fd_pr__nfet_g5v0d10v5 w=1 l=0.5
XRn_51_23 BLN23 dn_51_23 sky130_fd_pr_reram__reram_cell area_ox=0.0676
XMp_52_0 dp_52_0 WL52 SL0 VSS sky130_fd_pr__nfet_g5v0d10v5 w=1 l=0.5
XRp_52_0 BLP0 dp_52_0 sky130_fd_pr_reram__reram_cell area_ox=0.0676
XMz_52_0 dz_52_0 WL52 SL0 VSS sky130_fd_pr__nfet_g5v0d10v5 w=1 l=0.5
XRz_52_0 BLZ0 dz_52_0 sky130_fd_pr_reram__reram_cell area_ox=0.0676
XMn_52_0 dn_52_0 WL52 SL0 VSS sky130_fd_pr__nfet_g5v0d10v5 w=1 l=0.5
XRn_52_0 BLN0 dn_52_0 sky130_fd_pr_reram__reram_cell area_ox=0.0676
XMp_52_1 dp_52_1 WL52 SL1 VSS sky130_fd_pr__nfet_g5v0d10v5 w=1 l=0.5
XRp_52_1 BLP1 dp_52_1 sky130_fd_pr_reram__reram_cell area_ox=0.0676
XMz_52_1 dz_52_1 WL52 SL1 VSS sky130_fd_pr__nfet_g5v0d10v5 w=1 l=0.5
XRz_52_1 BLZ1 dz_52_1 sky130_fd_pr_reram__reram_cell area_ox=0.0676
XMn_52_1 dn_52_1 WL52 SL1 VSS sky130_fd_pr__nfet_g5v0d10v5 w=1 l=0.5
XRn_52_1 BLN1 dn_52_1 sky130_fd_pr_reram__reram_cell area_ox=0.0676
XMp_52_2 dp_52_2 WL52 SL2 VSS sky130_fd_pr__nfet_g5v0d10v5 w=1 l=0.5
XRp_52_2 BLP2 dp_52_2 sky130_fd_pr_reram__reram_cell area_ox=0.0676
XMz_52_2 dz_52_2 WL52 SL2 VSS sky130_fd_pr__nfet_g5v0d10v5 w=1 l=0.5
XRz_52_2 BLZ2 dz_52_2 sky130_fd_pr_reram__reram_cell area_ox=0.0676
XMn_52_2 dn_52_2 WL52 SL2 VSS sky130_fd_pr__nfet_g5v0d10v5 w=1 l=0.5
XRn_52_2 BLN2 dn_52_2 sky130_fd_pr_reram__reram_cell area_ox=0.0676
XMp_52_3 dp_52_3 WL52 SL3 VSS sky130_fd_pr__nfet_g5v0d10v5 w=1 l=0.5
XRp_52_3 BLP3 dp_52_3 sky130_fd_pr_reram__reram_cell area_ox=0.0676
XMz_52_3 dz_52_3 WL52 SL3 VSS sky130_fd_pr__nfet_g5v0d10v5 w=1 l=0.5
XRz_52_3 BLZ3 dz_52_3 sky130_fd_pr_reram__reram_cell area_ox=0.0676
XMn_52_3 dn_52_3 WL52 SL3 VSS sky130_fd_pr__nfet_g5v0d10v5 w=1 l=0.5
XRn_52_3 BLN3 dn_52_3 sky130_fd_pr_reram__reram_cell area_ox=0.0676
XMp_52_4 dp_52_4 WL52 SL4 VSS sky130_fd_pr__nfet_g5v0d10v5 w=1 l=0.5
XRp_52_4 BLP4 dp_52_4 sky130_fd_pr_reram__reram_cell area_ox=0.0676
XMz_52_4 dz_52_4 WL52 SL4 VSS sky130_fd_pr__nfet_g5v0d10v5 w=1 l=0.5
XRz_52_4 BLZ4 dz_52_4 sky130_fd_pr_reram__reram_cell area_ox=0.0676
XMn_52_4 dn_52_4 WL52 SL4 VSS sky130_fd_pr__nfet_g5v0d10v5 w=1 l=0.5
XRn_52_4 BLN4 dn_52_4 sky130_fd_pr_reram__reram_cell area_ox=0.0676
XMp_52_5 dp_52_5 WL52 SL5 VSS sky130_fd_pr__nfet_g5v0d10v5 w=1 l=0.5
XRp_52_5 BLP5 dp_52_5 sky130_fd_pr_reram__reram_cell area_ox=0.0676
XMz_52_5 dz_52_5 WL52 SL5 VSS sky130_fd_pr__nfet_g5v0d10v5 w=1 l=0.5
XRz_52_5 BLZ5 dz_52_5 sky130_fd_pr_reram__reram_cell area_ox=0.0676
XMn_52_5 dn_52_5 WL52 SL5 VSS sky130_fd_pr__nfet_g5v0d10v5 w=1 l=0.5
XRn_52_5 BLN5 dn_52_5 sky130_fd_pr_reram__reram_cell area_ox=0.0676
XMp_52_6 dp_52_6 WL52 SL6 VSS sky130_fd_pr__nfet_g5v0d10v5 w=1 l=0.5
XRp_52_6 BLP6 dp_52_6 sky130_fd_pr_reram__reram_cell area_ox=0.0676
XMz_52_6 dz_52_6 WL52 SL6 VSS sky130_fd_pr__nfet_g5v0d10v5 w=1 l=0.5
XRz_52_6 BLZ6 dz_52_6 sky130_fd_pr_reram__reram_cell area_ox=0.0676
XMn_52_6 dn_52_6 WL52 SL6 VSS sky130_fd_pr__nfet_g5v0d10v5 w=1 l=0.5
XRn_52_6 BLN6 dn_52_6 sky130_fd_pr_reram__reram_cell area_ox=0.0676
XMp_52_7 dp_52_7 WL52 SL7 VSS sky130_fd_pr__nfet_g5v0d10v5 w=1 l=0.5
XRp_52_7 BLP7 dp_52_7 sky130_fd_pr_reram__reram_cell area_ox=0.0676
XMz_52_7 dz_52_7 WL52 SL7 VSS sky130_fd_pr__nfet_g5v0d10v5 w=1 l=0.5
XRz_52_7 BLZ7 dz_52_7 sky130_fd_pr_reram__reram_cell area_ox=0.0676
XMn_52_7 dn_52_7 WL52 SL7 VSS sky130_fd_pr__nfet_g5v0d10v5 w=1 l=0.5
XRn_52_7 BLN7 dn_52_7 sky130_fd_pr_reram__reram_cell area_ox=0.0676
XMp_52_8 dp_52_8 WL52 SL8 VSS sky130_fd_pr__nfet_g5v0d10v5 w=1 l=0.5
XRp_52_8 BLP8 dp_52_8 sky130_fd_pr_reram__reram_cell area_ox=0.0676
XMz_52_8 dz_52_8 WL52 SL8 VSS sky130_fd_pr__nfet_g5v0d10v5 w=1 l=0.5
XRz_52_8 BLZ8 dz_52_8 sky130_fd_pr_reram__reram_cell area_ox=0.0676
XMn_52_8 dn_52_8 WL52 SL8 VSS sky130_fd_pr__nfet_g5v0d10v5 w=1 l=0.5
XRn_52_8 BLN8 dn_52_8 sky130_fd_pr_reram__reram_cell area_ox=0.0676
XMp_52_9 dp_52_9 WL52 SL9 VSS sky130_fd_pr__nfet_g5v0d10v5 w=1 l=0.5
XRp_52_9 BLP9 dp_52_9 sky130_fd_pr_reram__reram_cell area_ox=0.0676
XMz_52_9 dz_52_9 WL52 SL9 VSS sky130_fd_pr__nfet_g5v0d10v5 w=1 l=0.5
XRz_52_9 BLZ9 dz_52_9 sky130_fd_pr_reram__reram_cell area_ox=0.0676
XMn_52_9 dn_52_9 WL52 SL9 VSS sky130_fd_pr__nfet_g5v0d10v5 w=1 l=0.5
XRn_52_9 BLN9 dn_52_9 sky130_fd_pr_reram__reram_cell area_ox=0.0676
XMp_52_10 dp_52_10 WL52 SL10 VSS sky130_fd_pr__nfet_g5v0d10v5 w=1 l=0.5
XRp_52_10 BLP10 dp_52_10 sky130_fd_pr_reram__reram_cell area_ox=0.0676
XMz_52_10 dz_52_10 WL52 SL10 VSS sky130_fd_pr__nfet_g5v0d10v5 w=1 l=0.5
XRz_52_10 BLZ10 dz_52_10 sky130_fd_pr_reram__reram_cell area_ox=0.0676
XMn_52_10 dn_52_10 WL52 SL10 VSS sky130_fd_pr__nfet_g5v0d10v5 w=1 l=0.5
XRn_52_10 BLN10 dn_52_10 sky130_fd_pr_reram__reram_cell area_ox=0.0676
XMp_52_11 dp_52_11 WL52 SL11 VSS sky130_fd_pr__nfet_g5v0d10v5 w=1 l=0.5
XRp_52_11 BLP11 dp_52_11 sky130_fd_pr_reram__reram_cell area_ox=0.0676
XMz_52_11 dz_52_11 WL52 SL11 VSS sky130_fd_pr__nfet_g5v0d10v5 w=1 l=0.5
XRz_52_11 BLZ11 dz_52_11 sky130_fd_pr_reram__reram_cell area_ox=0.0676
XMn_52_11 dn_52_11 WL52 SL11 VSS sky130_fd_pr__nfet_g5v0d10v5 w=1 l=0.5
XRn_52_11 BLN11 dn_52_11 sky130_fd_pr_reram__reram_cell area_ox=0.0676
XMp_52_12 dp_52_12 WL52 SL12 VSS sky130_fd_pr__nfet_g5v0d10v5 w=1 l=0.5
XRp_52_12 BLP12 dp_52_12 sky130_fd_pr_reram__reram_cell area_ox=0.0676
XMz_52_12 dz_52_12 WL52 SL12 VSS sky130_fd_pr__nfet_g5v0d10v5 w=1 l=0.5
XRz_52_12 BLZ12 dz_52_12 sky130_fd_pr_reram__reram_cell area_ox=0.0676
XMn_52_12 dn_52_12 WL52 SL12 VSS sky130_fd_pr__nfet_g5v0d10v5 w=1 l=0.5
XRn_52_12 BLN12 dn_52_12 sky130_fd_pr_reram__reram_cell area_ox=0.0676
XMp_52_13 dp_52_13 WL52 SL13 VSS sky130_fd_pr__nfet_g5v0d10v5 w=1 l=0.5
XRp_52_13 BLP13 dp_52_13 sky130_fd_pr_reram__reram_cell area_ox=0.0676
XMz_52_13 dz_52_13 WL52 SL13 VSS sky130_fd_pr__nfet_g5v0d10v5 w=1 l=0.5
XRz_52_13 BLZ13 dz_52_13 sky130_fd_pr_reram__reram_cell area_ox=0.0676
XMn_52_13 dn_52_13 WL52 SL13 VSS sky130_fd_pr__nfet_g5v0d10v5 w=1 l=0.5
XRn_52_13 BLN13 dn_52_13 sky130_fd_pr_reram__reram_cell area_ox=0.0676
XMp_52_14 dp_52_14 WL52 SL14 VSS sky130_fd_pr__nfet_g5v0d10v5 w=1 l=0.5
XRp_52_14 BLP14 dp_52_14 sky130_fd_pr_reram__reram_cell area_ox=0.0676
XMz_52_14 dz_52_14 WL52 SL14 VSS sky130_fd_pr__nfet_g5v0d10v5 w=1 l=0.5
XRz_52_14 BLZ14 dz_52_14 sky130_fd_pr_reram__reram_cell area_ox=0.0676
XMn_52_14 dn_52_14 WL52 SL14 VSS sky130_fd_pr__nfet_g5v0d10v5 w=1 l=0.5
XRn_52_14 BLN14 dn_52_14 sky130_fd_pr_reram__reram_cell area_ox=0.0676
XMp_52_15 dp_52_15 WL52 SL15 VSS sky130_fd_pr__nfet_g5v0d10v5 w=1 l=0.5
XRp_52_15 BLP15 dp_52_15 sky130_fd_pr_reram__reram_cell area_ox=0.0676
XMz_52_15 dz_52_15 WL52 SL15 VSS sky130_fd_pr__nfet_g5v0d10v5 w=1 l=0.5
XRz_52_15 BLZ15 dz_52_15 sky130_fd_pr_reram__reram_cell area_ox=0.0676
XMn_52_15 dn_52_15 WL52 SL15 VSS sky130_fd_pr__nfet_g5v0d10v5 w=1 l=0.5
XRn_52_15 BLN15 dn_52_15 sky130_fd_pr_reram__reram_cell area_ox=0.0676
XMp_52_16 dp_52_16 WL52 SL16 VSS sky130_fd_pr__nfet_g5v0d10v5 w=1 l=0.5
XRp_52_16 BLP16 dp_52_16 sky130_fd_pr_reram__reram_cell area_ox=0.0676
XMz_52_16 dz_52_16 WL52 SL16 VSS sky130_fd_pr__nfet_g5v0d10v5 w=1 l=0.5
XRz_52_16 BLZ16 dz_52_16 sky130_fd_pr_reram__reram_cell area_ox=0.0676
XMn_52_16 dn_52_16 WL52 SL16 VSS sky130_fd_pr__nfet_g5v0d10v5 w=1 l=0.5
XRn_52_16 BLN16 dn_52_16 sky130_fd_pr_reram__reram_cell area_ox=0.0676
XMp_52_17 dp_52_17 WL52 SL17 VSS sky130_fd_pr__nfet_g5v0d10v5 w=1 l=0.5
XRp_52_17 BLP17 dp_52_17 sky130_fd_pr_reram__reram_cell area_ox=0.0676
XMz_52_17 dz_52_17 WL52 SL17 VSS sky130_fd_pr__nfet_g5v0d10v5 w=1 l=0.5
XRz_52_17 BLZ17 dz_52_17 sky130_fd_pr_reram__reram_cell area_ox=0.0676
XMn_52_17 dn_52_17 WL52 SL17 VSS sky130_fd_pr__nfet_g5v0d10v5 w=1 l=0.5
XRn_52_17 BLN17 dn_52_17 sky130_fd_pr_reram__reram_cell area_ox=0.0676
XMp_52_18 dp_52_18 WL52 SL18 VSS sky130_fd_pr__nfet_g5v0d10v5 w=1 l=0.5
XRp_52_18 BLP18 dp_52_18 sky130_fd_pr_reram__reram_cell area_ox=0.0676
XMz_52_18 dz_52_18 WL52 SL18 VSS sky130_fd_pr__nfet_g5v0d10v5 w=1 l=0.5
XRz_52_18 BLZ18 dz_52_18 sky130_fd_pr_reram__reram_cell area_ox=0.0676
XMn_52_18 dn_52_18 WL52 SL18 VSS sky130_fd_pr__nfet_g5v0d10v5 w=1 l=0.5
XRn_52_18 BLN18 dn_52_18 sky130_fd_pr_reram__reram_cell area_ox=0.0676
XMp_52_19 dp_52_19 WL52 SL19 VSS sky130_fd_pr__nfet_g5v0d10v5 w=1 l=0.5
XRp_52_19 BLP19 dp_52_19 sky130_fd_pr_reram__reram_cell area_ox=0.0676
XMz_52_19 dz_52_19 WL52 SL19 VSS sky130_fd_pr__nfet_g5v0d10v5 w=1 l=0.5
XRz_52_19 BLZ19 dz_52_19 sky130_fd_pr_reram__reram_cell area_ox=0.0676
XMn_52_19 dn_52_19 WL52 SL19 VSS sky130_fd_pr__nfet_g5v0d10v5 w=1 l=0.5
XRn_52_19 BLN19 dn_52_19 sky130_fd_pr_reram__reram_cell area_ox=0.0676
XMp_52_20 dp_52_20 WL52 SL20 VSS sky130_fd_pr__nfet_g5v0d10v5 w=1 l=0.5
XRp_52_20 BLP20 dp_52_20 sky130_fd_pr_reram__reram_cell area_ox=0.0676
XMz_52_20 dz_52_20 WL52 SL20 VSS sky130_fd_pr__nfet_g5v0d10v5 w=1 l=0.5
XRz_52_20 BLZ20 dz_52_20 sky130_fd_pr_reram__reram_cell area_ox=0.0676
XMn_52_20 dn_52_20 WL52 SL20 VSS sky130_fd_pr__nfet_g5v0d10v5 w=1 l=0.5
XRn_52_20 BLN20 dn_52_20 sky130_fd_pr_reram__reram_cell area_ox=0.0676
XMp_52_21 dp_52_21 WL52 SL21 VSS sky130_fd_pr__nfet_g5v0d10v5 w=1 l=0.5
XRp_52_21 BLP21 dp_52_21 sky130_fd_pr_reram__reram_cell area_ox=0.0676
XMz_52_21 dz_52_21 WL52 SL21 VSS sky130_fd_pr__nfet_g5v0d10v5 w=1 l=0.5
XRz_52_21 BLZ21 dz_52_21 sky130_fd_pr_reram__reram_cell area_ox=0.0676
XMn_52_21 dn_52_21 WL52 SL21 VSS sky130_fd_pr__nfet_g5v0d10v5 w=1 l=0.5
XRn_52_21 BLN21 dn_52_21 sky130_fd_pr_reram__reram_cell area_ox=0.0676
XMp_52_22 dp_52_22 WL52 SL22 VSS sky130_fd_pr__nfet_g5v0d10v5 w=1 l=0.5
XRp_52_22 BLP22 dp_52_22 sky130_fd_pr_reram__reram_cell area_ox=0.0676
XMz_52_22 dz_52_22 WL52 SL22 VSS sky130_fd_pr__nfet_g5v0d10v5 w=1 l=0.5
XRz_52_22 BLZ22 dz_52_22 sky130_fd_pr_reram__reram_cell area_ox=0.0676
XMn_52_22 dn_52_22 WL52 SL22 VSS sky130_fd_pr__nfet_g5v0d10v5 w=1 l=0.5
XRn_52_22 BLN22 dn_52_22 sky130_fd_pr_reram__reram_cell area_ox=0.0676
XMp_52_23 dp_52_23 WL52 SL23 VSS sky130_fd_pr__nfet_g5v0d10v5 w=1 l=0.5
XRp_52_23 BLP23 dp_52_23 sky130_fd_pr_reram__reram_cell area_ox=0.0676
XMz_52_23 dz_52_23 WL52 SL23 VSS sky130_fd_pr__nfet_g5v0d10v5 w=1 l=0.5
XRz_52_23 BLZ23 dz_52_23 sky130_fd_pr_reram__reram_cell area_ox=0.0676
XMn_52_23 dn_52_23 WL52 SL23 VSS sky130_fd_pr__nfet_g5v0d10v5 w=1 l=0.5
XRn_52_23 BLN23 dn_52_23 sky130_fd_pr_reram__reram_cell area_ox=0.0676
XMp_53_0 dp_53_0 WL53 SL0 VSS sky130_fd_pr__nfet_g5v0d10v5 w=1 l=0.5
XRp_53_0 BLP0 dp_53_0 sky130_fd_pr_reram__reram_cell area_ox=0.0676
XMz_53_0 dz_53_0 WL53 SL0 VSS sky130_fd_pr__nfet_g5v0d10v5 w=1 l=0.5
XRz_53_0 BLZ0 dz_53_0 sky130_fd_pr_reram__reram_cell area_ox=0.0676
XMn_53_0 dn_53_0 WL53 SL0 VSS sky130_fd_pr__nfet_g5v0d10v5 w=1 l=0.5
XRn_53_0 BLN0 dn_53_0 sky130_fd_pr_reram__reram_cell area_ox=0.0676
XMp_53_1 dp_53_1 WL53 SL1 VSS sky130_fd_pr__nfet_g5v0d10v5 w=1 l=0.5
XRp_53_1 BLP1 dp_53_1 sky130_fd_pr_reram__reram_cell area_ox=0.0676
XMz_53_1 dz_53_1 WL53 SL1 VSS sky130_fd_pr__nfet_g5v0d10v5 w=1 l=0.5
XRz_53_1 BLZ1 dz_53_1 sky130_fd_pr_reram__reram_cell area_ox=0.0676
XMn_53_1 dn_53_1 WL53 SL1 VSS sky130_fd_pr__nfet_g5v0d10v5 w=1 l=0.5
XRn_53_1 BLN1 dn_53_1 sky130_fd_pr_reram__reram_cell area_ox=0.0676
XMp_53_2 dp_53_2 WL53 SL2 VSS sky130_fd_pr__nfet_g5v0d10v5 w=1 l=0.5
XRp_53_2 BLP2 dp_53_2 sky130_fd_pr_reram__reram_cell area_ox=0.0676
XMz_53_2 dz_53_2 WL53 SL2 VSS sky130_fd_pr__nfet_g5v0d10v5 w=1 l=0.5
XRz_53_2 BLZ2 dz_53_2 sky130_fd_pr_reram__reram_cell area_ox=0.0676
XMn_53_2 dn_53_2 WL53 SL2 VSS sky130_fd_pr__nfet_g5v0d10v5 w=1 l=0.5
XRn_53_2 BLN2 dn_53_2 sky130_fd_pr_reram__reram_cell area_ox=0.0676
XMp_53_3 dp_53_3 WL53 SL3 VSS sky130_fd_pr__nfet_g5v0d10v5 w=1 l=0.5
XRp_53_3 BLP3 dp_53_3 sky130_fd_pr_reram__reram_cell area_ox=0.0676
XMz_53_3 dz_53_3 WL53 SL3 VSS sky130_fd_pr__nfet_g5v0d10v5 w=1 l=0.5
XRz_53_3 BLZ3 dz_53_3 sky130_fd_pr_reram__reram_cell area_ox=0.0676
XMn_53_3 dn_53_3 WL53 SL3 VSS sky130_fd_pr__nfet_g5v0d10v5 w=1 l=0.5
XRn_53_3 BLN3 dn_53_3 sky130_fd_pr_reram__reram_cell area_ox=0.0676
XMp_53_4 dp_53_4 WL53 SL4 VSS sky130_fd_pr__nfet_g5v0d10v5 w=1 l=0.5
XRp_53_4 BLP4 dp_53_4 sky130_fd_pr_reram__reram_cell area_ox=0.0676
XMz_53_4 dz_53_4 WL53 SL4 VSS sky130_fd_pr__nfet_g5v0d10v5 w=1 l=0.5
XRz_53_4 BLZ4 dz_53_4 sky130_fd_pr_reram__reram_cell area_ox=0.0676
XMn_53_4 dn_53_4 WL53 SL4 VSS sky130_fd_pr__nfet_g5v0d10v5 w=1 l=0.5
XRn_53_4 BLN4 dn_53_4 sky130_fd_pr_reram__reram_cell area_ox=0.0676
XMp_53_5 dp_53_5 WL53 SL5 VSS sky130_fd_pr__nfet_g5v0d10v5 w=1 l=0.5
XRp_53_5 BLP5 dp_53_5 sky130_fd_pr_reram__reram_cell area_ox=0.0676
XMz_53_5 dz_53_5 WL53 SL5 VSS sky130_fd_pr__nfet_g5v0d10v5 w=1 l=0.5
XRz_53_5 BLZ5 dz_53_5 sky130_fd_pr_reram__reram_cell area_ox=0.0676
XMn_53_5 dn_53_5 WL53 SL5 VSS sky130_fd_pr__nfet_g5v0d10v5 w=1 l=0.5
XRn_53_5 BLN5 dn_53_5 sky130_fd_pr_reram__reram_cell area_ox=0.0676
XMp_53_6 dp_53_6 WL53 SL6 VSS sky130_fd_pr__nfet_g5v0d10v5 w=1 l=0.5
XRp_53_6 BLP6 dp_53_6 sky130_fd_pr_reram__reram_cell area_ox=0.0676
XMz_53_6 dz_53_6 WL53 SL6 VSS sky130_fd_pr__nfet_g5v0d10v5 w=1 l=0.5
XRz_53_6 BLZ6 dz_53_6 sky130_fd_pr_reram__reram_cell area_ox=0.0676
XMn_53_6 dn_53_6 WL53 SL6 VSS sky130_fd_pr__nfet_g5v0d10v5 w=1 l=0.5
XRn_53_6 BLN6 dn_53_6 sky130_fd_pr_reram__reram_cell area_ox=0.0676
XMp_53_7 dp_53_7 WL53 SL7 VSS sky130_fd_pr__nfet_g5v0d10v5 w=1 l=0.5
XRp_53_7 BLP7 dp_53_7 sky130_fd_pr_reram__reram_cell area_ox=0.0676
XMz_53_7 dz_53_7 WL53 SL7 VSS sky130_fd_pr__nfet_g5v0d10v5 w=1 l=0.5
XRz_53_7 BLZ7 dz_53_7 sky130_fd_pr_reram__reram_cell area_ox=0.0676
XMn_53_7 dn_53_7 WL53 SL7 VSS sky130_fd_pr__nfet_g5v0d10v5 w=1 l=0.5
XRn_53_7 BLN7 dn_53_7 sky130_fd_pr_reram__reram_cell area_ox=0.0676
XMp_53_8 dp_53_8 WL53 SL8 VSS sky130_fd_pr__nfet_g5v0d10v5 w=1 l=0.5
XRp_53_8 BLP8 dp_53_8 sky130_fd_pr_reram__reram_cell area_ox=0.0676
XMz_53_8 dz_53_8 WL53 SL8 VSS sky130_fd_pr__nfet_g5v0d10v5 w=1 l=0.5
XRz_53_8 BLZ8 dz_53_8 sky130_fd_pr_reram__reram_cell area_ox=0.0676
XMn_53_8 dn_53_8 WL53 SL8 VSS sky130_fd_pr__nfet_g5v0d10v5 w=1 l=0.5
XRn_53_8 BLN8 dn_53_8 sky130_fd_pr_reram__reram_cell area_ox=0.0676
XMp_53_9 dp_53_9 WL53 SL9 VSS sky130_fd_pr__nfet_g5v0d10v5 w=1 l=0.5
XRp_53_9 BLP9 dp_53_9 sky130_fd_pr_reram__reram_cell area_ox=0.0676
XMz_53_9 dz_53_9 WL53 SL9 VSS sky130_fd_pr__nfet_g5v0d10v5 w=1 l=0.5
XRz_53_9 BLZ9 dz_53_9 sky130_fd_pr_reram__reram_cell area_ox=0.0676
XMn_53_9 dn_53_9 WL53 SL9 VSS sky130_fd_pr__nfet_g5v0d10v5 w=1 l=0.5
XRn_53_9 BLN9 dn_53_9 sky130_fd_pr_reram__reram_cell area_ox=0.0676
XMp_53_10 dp_53_10 WL53 SL10 VSS sky130_fd_pr__nfet_g5v0d10v5 w=1 l=0.5
XRp_53_10 BLP10 dp_53_10 sky130_fd_pr_reram__reram_cell area_ox=0.0676
XMz_53_10 dz_53_10 WL53 SL10 VSS sky130_fd_pr__nfet_g5v0d10v5 w=1 l=0.5
XRz_53_10 BLZ10 dz_53_10 sky130_fd_pr_reram__reram_cell area_ox=0.0676
XMn_53_10 dn_53_10 WL53 SL10 VSS sky130_fd_pr__nfet_g5v0d10v5 w=1 l=0.5
XRn_53_10 BLN10 dn_53_10 sky130_fd_pr_reram__reram_cell area_ox=0.0676
XMp_53_11 dp_53_11 WL53 SL11 VSS sky130_fd_pr__nfet_g5v0d10v5 w=1 l=0.5
XRp_53_11 BLP11 dp_53_11 sky130_fd_pr_reram__reram_cell area_ox=0.0676
XMz_53_11 dz_53_11 WL53 SL11 VSS sky130_fd_pr__nfet_g5v0d10v5 w=1 l=0.5
XRz_53_11 BLZ11 dz_53_11 sky130_fd_pr_reram__reram_cell area_ox=0.0676
XMn_53_11 dn_53_11 WL53 SL11 VSS sky130_fd_pr__nfet_g5v0d10v5 w=1 l=0.5
XRn_53_11 BLN11 dn_53_11 sky130_fd_pr_reram__reram_cell area_ox=0.0676
XMp_53_12 dp_53_12 WL53 SL12 VSS sky130_fd_pr__nfet_g5v0d10v5 w=1 l=0.5
XRp_53_12 BLP12 dp_53_12 sky130_fd_pr_reram__reram_cell area_ox=0.0676
XMz_53_12 dz_53_12 WL53 SL12 VSS sky130_fd_pr__nfet_g5v0d10v5 w=1 l=0.5
XRz_53_12 BLZ12 dz_53_12 sky130_fd_pr_reram__reram_cell area_ox=0.0676
XMn_53_12 dn_53_12 WL53 SL12 VSS sky130_fd_pr__nfet_g5v0d10v5 w=1 l=0.5
XRn_53_12 BLN12 dn_53_12 sky130_fd_pr_reram__reram_cell area_ox=0.0676
XMp_53_13 dp_53_13 WL53 SL13 VSS sky130_fd_pr__nfet_g5v0d10v5 w=1 l=0.5
XRp_53_13 BLP13 dp_53_13 sky130_fd_pr_reram__reram_cell area_ox=0.0676
XMz_53_13 dz_53_13 WL53 SL13 VSS sky130_fd_pr__nfet_g5v0d10v5 w=1 l=0.5
XRz_53_13 BLZ13 dz_53_13 sky130_fd_pr_reram__reram_cell area_ox=0.0676
XMn_53_13 dn_53_13 WL53 SL13 VSS sky130_fd_pr__nfet_g5v0d10v5 w=1 l=0.5
XRn_53_13 BLN13 dn_53_13 sky130_fd_pr_reram__reram_cell area_ox=0.0676
XMp_53_14 dp_53_14 WL53 SL14 VSS sky130_fd_pr__nfet_g5v0d10v5 w=1 l=0.5
XRp_53_14 BLP14 dp_53_14 sky130_fd_pr_reram__reram_cell area_ox=0.0676
XMz_53_14 dz_53_14 WL53 SL14 VSS sky130_fd_pr__nfet_g5v0d10v5 w=1 l=0.5
XRz_53_14 BLZ14 dz_53_14 sky130_fd_pr_reram__reram_cell area_ox=0.0676
XMn_53_14 dn_53_14 WL53 SL14 VSS sky130_fd_pr__nfet_g5v0d10v5 w=1 l=0.5
XRn_53_14 BLN14 dn_53_14 sky130_fd_pr_reram__reram_cell area_ox=0.0676
XMp_53_15 dp_53_15 WL53 SL15 VSS sky130_fd_pr__nfet_g5v0d10v5 w=1 l=0.5
XRp_53_15 BLP15 dp_53_15 sky130_fd_pr_reram__reram_cell area_ox=0.0676
XMz_53_15 dz_53_15 WL53 SL15 VSS sky130_fd_pr__nfet_g5v0d10v5 w=1 l=0.5
XRz_53_15 BLZ15 dz_53_15 sky130_fd_pr_reram__reram_cell area_ox=0.0676
XMn_53_15 dn_53_15 WL53 SL15 VSS sky130_fd_pr__nfet_g5v0d10v5 w=1 l=0.5
XRn_53_15 BLN15 dn_53_15 sky130_fd_pr_reram__reram_cell area_ox=0.0676
XMp_53_16 dp_53_16 WL53 SL16 VSS sky130_fd_pr__nfet_g5v0d10v5 w=1 l=0.5
XRp_53_16 BLP16 dp_53_16 sky130_fd_pr_reram__reram_cell area_ox=0.0676
XMz_53_16 dz_53_16 WL53 SL16 VSS sky130_fd_pr__nfet_g5v0d10v5 w=1 l=0.5
XRz_53_16 BLZ16 dz_53_16 sky130_fd_pr_reram__reram_cell area_ox=0.0676
XMn_53_16 dn_53_16 WL53 SL16 VSS sky130_fd_pr__nfet_g5v0d10v5 w=1 l=0.5
XRn_53_16 BLN16 dn_53_16 sky130_fd_pr_reram__reram_cell area_ox=0.0676
XMp_53_17 dp_53_17 WL53 SL17 VSS sky130_fd_pr__nfet_g5v0d10v5 w=1 l=0.5
XRp_53_17 BLP17 dp_53_17 sky130_fd_pr_reram__reram_cell area_ox=0.0676
XMz_53_17 dz_53_17 WL53 SL17 VSS sky130_fd_pr__nfet_g5v0d10v5 w=1 l=0.5
XRz_53_17 BLZ17 dz_53_17 sky130_fd_pr_reram__reram_cell area_ox=0.0676
XMn_53_17 dn_53_17 WL53 SL17 VSS sky130_fd_pr__nfet_g5v0d10v5 w=1 l=0.5
XRn_53_17 BLN17 dn_53_17 sky130_fd_pr_reram__reram_cell area_ox=0.0676
XMp_53_18 dp_53_18 WL53 SL18 VSS sky130_fd_pr__nfet_g5v0d10v5 w=1 l=0.5
XRp_53_18 BLP18 dp_53_18 sky130_fd_pr_reram__reram_cell area_ox=0.0676
XMz_53_18 dz_53_18 WL53 SL18 VSS sky130_fd_pr__nfet_g5v0d10v5 w=1 l=0.5
XRz_53_18 BLZ18 dz_53_18 sky130_fd_pr_reram__reram_cell area_ox=0.0676
XMn_53_18 dn_53_18 WL53 SL18 VSS sky130_fd_pr__nfet_g5v0d10v5 w=1 l=0.5
XRn_53_18 BLN18 dn_53_18 sky130_fd_pr_reram__reram_cell area_ox=0.0676
XMp_53_19 dp_53_19 WL53 SL19 VSS sky130_fd_pr__nfet_g5v0d10v5 w=1 l=0.5
XRp_53_19 BLP19 dp_53_19 sky130_fd_pr_reram__reram_cell area_ox=0.0676
XMz_53_19 dz_53_19 WL53 SL19 VSS sky130_fd_pr__nfet_g5v0d10v5 w=1 l=0.5
XRz_53_19 BLZ19 dz_53_19 sky130_fd_pr_reram__reram_cell area_ox=0.0676
XMn_53_19 dn_53_19 WL53 SL19 VSS sky130_fd_pr__nfet_g5v0d10v5 w=1 l=0.5
XRn_53_19 BLN19 dn_53_19 sky130_fd_pr_reram__reram_cell area_ox=0.0676
XMp_53_20 dp_53_20 WL53 SL20 VSS sky130_fd_pr__nfet_g5v0d10v5 w=1 l=0.5
XRp_53_20 BLP20 dp_53_20 sky130_fd_pr_reram__reram_cell area_ox=0.0676
XMz_53_20 dz_53_20 WL53 SL20 VSS sky130_fd_pr__nfet_g5v0d10v5 w=1 l=0.5
XRz_53_20 BLZ20 dz_53_20 sky130_fd_pr_reram__reram_cell area_ox=0.0676
XMn_53_20 dn_53_20 WL53 SL20 VSS sky130_fd_pr__nfet_g5v0d10v5 w=1 l=0.5
XRn_53_20 BLN20 dn_53_20 sky130_fd_pr_reram__reram_cell area_ox=0.0676
XMp_53_21 dp_53_21 WL53 SL21 VSS sky130_fd_pr__nfet_g5v0d10v5 w=1 l=0.5
XRp_53_21 BLP21 dp_53_21 sky130_fd_pr_reram__reram_cell area_ox=0.0676
XMz_53_21 dz_53_21 WL53 SL21 VSS sky130_fd_pr__nfet_g5v0d10v5 w=1 l=0.5
XRz_53_21 BLZ21 dz_53_21 sky130_fd_pr_reram__reram_cell area_ox=0.0676
XMn_53_21 dn_53_21 WL53 SL21 VSS sky130_fd_pr__nfet_g5v0d10v5 w=1 l=0.5
XRn_53_21 BLN21 dn_53_21 sky130_fd_pr_reram__reram_cell area_ox=0.0676
XMp_53_22 dp_53_22 WL53 SL22 VSS sky130_fd_pr__nfet_g5v0d10v5 w=1 l=0.5
XRp_53_22 BLP22 dp_53_22 sky130_fd_pr_reram__reram_cell area_ox=0.0676
XMz_53_22 dz_53_22 WL53 SL22 VSS sky130_fd_pr__nfet_g5v0d10v5 w=1 l=0.5
XRz_53_22 BLZ22 dz_53_22 sky130_fd_pr_reram__reram_cell area_ox=0.0676
XMn_53_22 dn_53_22 WL53 SL22 VSS sky130_fd_pr__nfet_g5v0d10v5 w=1 l=0.5
XRn_53_22 BLN22 dn_53_22 sky130_fd_pr_reram__reram_cell area_ox=0.0676
XMp_53_23 dp_53_23 WL53 SL23 VSS sky130_fd_pr__nfet_g5v0d10v5 w=1 l=0.5
XRp_53_23 BLP23 dp_53_23 sky130_fd_pr_reram__reram_cell area_ox=0.0676
XMz_53_23 dz_53_23 WL53 SL23 VSS sky130_fd_pr__nfet_g5v0d10v5 w=1 l=0.5
XRz_53_23 BLZ23 dz_53_23 sky130_fd_pr_reram__reram_cell area_ox=0.0676
XMn_53_23 dn_53_23 WL53 SL23 VSS sky130_fd_pr__nfet_g5v0d10v5 w=1 l=0.5
XRn_53_23 BLN23 dn_53_23 sky130_fd_pr_reram__reram_cell area_ox=0.0676
XMp_54_0 dp_54_0 WL54 SL0 VSS sky130_fd_pr__nfet_g5v0d10v5 w=1 l=0.5
XRp_54_0 BLP0 dp_54_0 sky130_fd_pr_reram__reram_cell area_ox=0.0676
XMz_54_0 dz_54_0 WL54 SL0 VSS sky130_fd_pr__nfet_g5v0d10v5 w=1 l=0.5
XRz_54_0 BLZ0 dz_54_0 sky130_fd_pr_reram__reram_cell area_ox=0.0676
XMn_54_0 dn_54_0 WL54 SL0 VSS sky130_fd_pr__nfet_g5v0d10v5 w=1 l=0.5
XRn_54_0 BLN0 dn_54_0 sky130_fd_pr_reram__reram_cell area_ox=0.0676
XMp_54_1 dp_54_1 WL54 SL1 VSS sky130_fd_pr__nfet_g5v0d10v5 w=1 l=0.5
XRp_54_1 BLP1 dp_54_1 sky130_fd_pr_reram__reram_cell area_ox=0.0676
XMz_54_1 dz_54_1 WL54 SL1 VSS sky130_fd_pr__nfet_g5v0d10v5 w=1 l=0.5
XRz_54_1 BLZ1 dz_54_1 sky130_fd_pr_reram__reram_cell area_ox=0.0676
XMn_54_1 dn_54_1 WL54 SL1 VSS sky130_fd_pr__nfet_g5v0d10v5 w=1 l=0.5
XRn_54_1 BLN1 dn_54_1 sky130_fd_pr_reram__reram_cell area_ox=0.0676
XMp_54_2 dp_54_2 WL54 SL2 VSS sky130_fd_pr__nfet_g5v0d10v5 w=1 l=0.5
XRp_54_2 BLP2 dp_54_2 sky130_fd_pr_reram__reram_cell area_ox=0.0676
XMz_54_2 dz_54_2 WL54 SL2 VSS sky130_fd_pr__nfet_g5v0d10v5 w=1 l=0.5
XRz_54_2 BLZ2 dz_54_2 sky130_fd_pr_reram__reram_cell area_ox=0.0676
XMn_54_2 dn_54_2 WL54 SL2 VSS sky130_fd_pr__nfet_g5v0d10v5 w=1 l=0.5
XRn_54_2 BLN2 dn_54_2 sky130_fd_pr_reram__reram_cell area_ox=0.0676
XMp_54_3 dp_54_3 WL54 SL3 VSS sky130_fd_pr__nfet_g5v0d10v5 w=1 l=0.5
XRp_54_3 BLP3 dp_54_3 sky130_fd_pr_reram__reram_cell area_ox=0.0676
XMz_54_3 dz_54_3 WL54 SL3 VSS sky130_fd_pr__nfet_g5v0d10v5 w=1 l=0.5
XRz_54_3 BLZ3 dz_54_3 sky130_fd_pr_reram__reram_cell area_ox=0.0676
XMn_54_3 dn_54_3 WL54 SL3 VSS sky130_fd_pr__nfet_g5v0d10v5 w=1 l=0.5
XRn_54_3 BLN3 dn_54_3 sky130_fd_pr_reram__reram_cell area_ox=0.0676
XMp_54_4 dp_54_4 WL54 SL4 VSS sky130_fd_pr__nfet_g5v0d10v5 w=1 l=0.5
XRp_54_4 BLP4 dp_54_4 sky130_fd_pr_reram__reram_cell area_ox=0.0676
XMz_54_4 dz_54_4 WL54 SL4 VSS sky130_fd_pr__nfet_g5v0d10v5 w=1 l=0.5
XRz_54_4 BLZ4 dz_54_4 sky130_fd_pr_reram__reram_cell area_ox=0.0676
XMn_54_4 dn_54_4 WL54 SL4 VSS sky130_fd_pr__nfet_g5v0d10v5 w=1 l=0.5
XRn_54_4 BLN4 dn_54_4 sky130_fd_pr_reram__reram_cell area_ox=0.0676
XMp_54_5 dp_54_5 WL54 SL5 VSS sky130_fd_pr__nfet_g5v0d10v5 w=1 l=0.5
XRp_54_5 BLP5 dp_54_5 sky130_fd_pr_reram__reram_cell area_ox=0.0676
XMz_54_5 dz_54_5 WL54 SL5 VSS sky130_fd_pr__nfet_g5v0d10v5 w=1 l=0.5
XRz_54_5 BLZ5 dz_54_5 sky130_fd_pr_reram__reram_cell area_ox=0.0676
XMn_54_5 dn_54_5 WL54 SL5 VSS sky130_fd_pr__nfet_g5v0d10v5 w=1 l=0.5
XRn_54_5 BLN5 dn_54_5 sky130_fd_pr_reram__reram_cell area_ox=0.0676
XMp_54_6 dp_54_6 WL54 SL6 VSS sky130_fd_pr__nfet_g5v0d10v5 w=1 l=0.5
XRp_54_6 BLP6 dp_54_6 sky130_fd_pr_reram__reram_cell area_ox=0.0676
XMz_54_6 dz_54_6 WL54 SL6 VSS sky130_fd_pr__nfet_g5v0d10v5 w=1 l=0.5
XRz_54_6 BLZ6 dz_54_6 sky130_fd_pr_reram__reram_cell area_ox=0.0676
XMn_54_6 dn_54_6 WL54 SL6 VSS sky130_fd_pr__nfet_g5v0d10v5 w=1 l=0.5
XRn_54_6 BLN6 dn_54_6 sky130_fd_pr_reram__reram_cell area_ox=0.0676
XMp_54_7 dp_54_7 WL54 SL7 VSS sky130_fd_pr__nfet_g5v0d10v5 w=1 l=0.5
XRp_54_7 BLP7 dp_54_7 sky130_fd_pr_reram__reram_cell area_ox=0.0676
XMz_54_7 dz_54_7 WL54 SL7 VSS sky130_fd_pr__nfet_g5v0d10v5 w=1 l=0.5
XRz_54_7 BLZ7 dz_54_7 sky130_fd_pr_reram__reram_cell area_ox=0.0676
XMn_54_7 dn_54_7 WL54 SL7 VSS sky130_fd_pr__nfet_g5v0d10v5 w=1 l=0.5
XRn_54_7 BLN7 dn_54_7 sky130_fd_pr_reram__reram_cell area_ox=0.0676
XMp_54_8 dp_54_8 WL54 SL8 VSS sky130_fd_pr__nfet_g5v0d10v5 w=1 l=0.5
XRp_54_8 BLP8 dp_54_8 sky130_fd_pr_reram__reram_cell area_ox=0.0676
XMz_54_8 dz_54_8 WL54 SL8 VSS sky130_fd_pr__nfet_g5v0d10v5 w=1 l=0.5
XRz_54_8 BLZ8 dz_54_8 sky130_fd_pr_reram__reram_cell area_ox=0.0676
XMn_54_8 dn_54_8 WL54 SL8 VSS sky130_fd_pr__nfet_g5v0d10v5 w=1 l=0.5
XRn_54_8 BLN8 dn_54_8 sky130_fd_pr_reram__reram_cell area_ox=0.0676
XMp_54_9 dp_54_9 WL54 SL9 VSS sky130_fd_pr__nfet_g5v0d10v5 w=1 l=0.5
XRp_54_9 BLP9 dp_54_9 sky130_fd_pr_reram__reram_cell area_ox=0.0676
XMz_54_9 dz_54_9 WL54 SL9 VSS sky130_fd_pr__nfet_g5v0d10v5 w=1 l=0.5
XRz_54_9 BLZ9 dz_54_9 sky130_fd_pr_reram__reram_cell area_ox=0.0676
XMn_54_9 dn_54_9 WL54 SL9 VSS sky130_fd_pr__nfet_g5v0d10v5 w=1 l=0.5
XRn_54_9 BLN9 dn_54_9 sky130_fd_pr_reram__reram_cell area_ox=0.0676
XMp_54_10 dp_54_10 WL54 SL10 VSS sky130_fd_pr__nfet_g5v0d10v5 w=1 l=0.5
XRp_54_10 BLP10 dp_54_10 sky130_fd_pr_reram__reram_cell area_ox=0.0676
XMz_54_10 dz_54_10 WL54 SL10 VSS sky130_fd_pr__nfet_g5v0d10v5 w=1 l=0.5
XRz_54_10 BLZ10 dz_54_10 sky130_fd_pr_reram__reram_cell area_ox=0.0676
XMn_54_10 dn_54_10 WL54 SL10 VSS sky130_fd_pr__nfet_g5v0d10v5 w=1 l=0.5
XRn_54_10 BLN10 dn_54_10 sky130_fd_pr_reram__reram_cell area_ox=0.0676
XMp_54_11 dp_54_11 WL54 SL11 VSS sky130_fd_pr__nfet_g5v0d10v5 w=1 l=0.5
XRp_54_11 BLP11 dp_54_11 sky130_fd_pr_reram__reram_cell area_ox=0.0676
XMz_54_11 dz_54_11 WL54 SL11 VSS sky130_fd_pr__nfet_g5v0d10v5 w=1 l=0.5
XRz_54_11 BLZ11 dz_54_11 sky130_fd_pr_reram__reram_cell area_ox=0.0676
XMn_54_11 dn_54_11 WL54 SL11 VSS sky130_fd_pr__nfet_g5v0d10v5 w=1 l=0.5
XRn_54_11 BLN11 dn_54_11 sky130_fd_pr_reram__reram_cell area_ox=0.0676
XMp_54_12 dp_54_12 WL54 SL12 VSS sky130_fd_pr__nfet_g5v0d10v5 w=1 l=0.5
XRp_54_12 BLP12 dp_54_12 sky130_fd_pr_reram__reram_cell area_ox=0.0676
XMz_54_12 dz_54_12 WL54 SL12 VSS sky130_fd_pr__nfet_g5v0d10v5 w=1 l=0.5
XRz_54_12 BLZ12 dz_54_12 sky130_fd_pr_reram__reram_cell area_ox=0.0676
XMn_54_12 dn_54_12 WL54 SL12 VSS sky130_fd_pr__nfet_g5v0d10v5 w=1 l=0.5
XRn_54_12 BLN12 dn_54_12 sky130_fd_pr_reram__reram_cell area_ox=0.0676
XMp_54_13 dp_54_13 WL54 SL13 VSS sky130_fd_pr__nfet_g5v0d10v5 w=1 l=0.5
XRp_54_13 BLP13 dp_54_13 sky130_fd_pr_reram__reram_cell area_ox=0.0676
XMz_54_13 dz_54_13 WL54 SL13 VSS sky130_fd_pr__nfet_g5v0d10v5 w=1 l=0.5
XRz_54_13 BLZ13 dz_54_13 sky130_fd_pr_reram__reram_cell area_ox=0.0676
XMn_54_13 dn_54_13 WL54 SL13 VSS sky130_fd_pr__nfet_g5v0d10v5 w=1 l=0.5
XRn_54_13 BLN13 dn_54_13 sky130_fd_pr_reram__reram_cell area_ox=0.0676
XMp_54_14 dp_54_14 WL54 SL14 VSS sky130_fd_pr__nfet_g5v0d10v5 w=1 l=0.5
XRp_54_14 BLP14 dp_54_14 sky130_fd_pr_reram__reram_cell area_ox=0.0676
XMz_54_14 dz_54_14 WL54 SL14 VSS sky130_fd_pr__nfet_g5v0d10v5 w=1 l=0.5
XRz_54_14 BLZ14 dz_54_14 sky130_fd_pr_reram__reram_cell area_ox=0.0676
XMn_54_14 dn_54_14 WL54 SL14 VSS sky130_fd_pr__nfet_g5v0d10v5 w=1 l=0.5
XRn_54_14 BLN14 dn_54_14 sky130_fd_pr_reram__reram_cell area_ox=0.0676
XMp_54_15 dp_54_15 WL54 SL15 VSS sky130_fd_pr__nfet_g5v0d10v5 w=1 l=0.5
XRp_54_15 BLP15 dp_54_15 sky130_fd_pr_reram__reram_cell area_ox=0.0676
XMz_54_15 dz_54_15 WL54 SL15 VSS sky130_fd_pr__nfet_g5v0d10v5 w=1 l=0.5
XRz_54_15 BLZ15 dz_54_15 sky130_fd_pr_reram__reram_cell area_ox=0.0676
XMn_54_15 dn_54_15 WL54 SL15 VSS sky130_fd_pr__nfet_g5v0d10v5 w=1 l=0.5
XRn_54_15 BLN15 dn_54_15 sky130_fd_pr_reram__reram_cell area_ox=0.0676
XMp_54_16 dp_54_16 WL54 SL16 VSS sky130_fd_pr__nfet_g5v0d10v5 w=1 l=0.5
XRp_54_16 BLP16 dp_54_16 sky130_fd_pr_reram__reram_cell area_ox=0.0676
XMz_54_16 dz_54_16 WL54 SL16 VSS sky130_fd_pr__nfet_g5v0d10v5 w=1 l=0.5
XRz_54_16 BLZ16 dz_54_16 sky130_fd_pr_reram__reram_cell area_ox=0.0676
XMn_54_16 dn_54_16 WL54 SL16 VSS sky130_fd_pr__nfet_g5v0d10v5 w=1 l=0.5
XRn_54_16 BLN16 dn_54_16 sky130_fd_pr_reram__reram_cell area_ox=0.0676
XMp_54_17 dp_54_17 WL54 SL17 VSS sky130_fd_pr__nfet_g5v0d10v5 w=1 l=0.5
XRp_54_17 BLP17 dp_54_17 sky130_fd_pr_reram__reram_cell area_ox=0.0676
XMz_54_17 dz_54_17 WL54 SL17 VSS sky130_fd_pr__nfet_g5v0d10v5 w=1 l=0.5
XRz_54_17 BLZ17 dz_54_17 sky130_fd_pr_reram__reram_cell area_ox=0.0676
XMn_54_17 dn_54_17 WL54 SL17 VSS sky130_fd_pr__nfet_g5v0d10v5 w=1 l=0.5
XRn_54_17 BLN17 dn_54_17 sky130_fd_pr_reram__reram_cell area_ox=0.0676
XMp_54_18 dp_54_18 WL54 SL18 VSS sky130_fd_pr__nfet_g5v0d10v5 w=1 l=0.5
XRp_54_18 BLP18 dp_54_18 sky130_fd_pr_reram__reram_cell area_ox=0.0676
XMz_54_18 dz_54_18 WL54 SL18 VSS sky130_fd_pr__nfet_g5v0d10v5 w=1 l=0.5
XRz_54_18 BLZ18 dz_54_18 sky130_fd_pr_reram__reram_cell area_ox=0.0676
XMn_54_18 dn_54_18 WL54 SL18 VSS sky130_fd_pr__nfet_g5v0d10v5 w=1 l=0.5
XRn_54_18 BLN18 dn_54_18 sky130_fd_pr_reram__reram_cell area_ox=0.0676
XMp_54_19 dp_54_19 WL54 SL19 VSS sky130_fd_pr__nfet_g5v0d10v5 w=1 l=0.5
XRp_54_19 BLP19 dp_54_19 sky130_fd_pr_reram__reram_cell area_ox=0.0676
XMz_54_19 dz_54_19 WL54 SL19 VSS sky130_fd_pr__nfet_g5v0d10v5 w=1 l=0.5
XRz_54_19 BLZ19 dz_54_19 sky130_fd_pr_reram__reram_cell area_ox=0.0676
XMn_54_19 dn_54_19 WL54 SL19 VSS sky130_fd_pr__nfet_g5v0d10v5 w=1 l=0.5
XRn_54_19 BLN19 dn_54_19 sky130_fd_pr_reram__reram_cell area_ox=0.0676
XMp_54_20 dp_54_20 WL54 SL20 VSS sky130_fd_pr__nfet_g5v0d10v5 w=1 l=0.5
XRp_54_20 BLP20 dp_54_20 sky130_fd_pr_reram__reram_cell area_ox=0.0676
XMz_54_20 dz_54_20 WL54 SL20 VSS sky130_fd_pr__nfet_g5v0d10v5 w=1 l=0.5
XRz_54_20 BLZ20 dz_54_20 sky130_fd_pr_reram__reram_cell area_ox=0.0676
XMn_54_20 dn_54_20 WL54 SL20 VSS sky130_fd_pr__nfet_g5v0d10v5 w=1 l=0.5
XRn_54_20 BLN20 dn_54_20 sky130_fd_pr_reram__reram_cell area_ox=0.0676
XMp_54_21 dp_54_21 WL54 SL21 VSS sky130_fd_pr__nfet_g5v0d10v5 w=1 l=0.5
XRp_54_21 BLP21 dp_54_21 sky130_fd_pr_reram__reram_cell area_ox=0.0676
XMz_54_21 dz_54_21 WL54 SL21 VSS sky130_fd_pr__nfet_g5v0d10v5 w=1 l=0.5
XRz_54_21 BLZ21 dz_54_21 sky130_fd_pr_reram__reram_cell area_ox=0.0676
XMn_54_21 dn_54_21 WL54 SL21 VSS sky130_fd_pr__nfet_g5v0d10v5 w=1 l=0.5
XRn_54_21 BLN21 dn_54_21 sky130_fd_pr_reram__reram_cell area_ox=0.0676
XMp_54_22 dp_54_22 WL54 SL22 VSS sky130_fd_pr__nfet_g5v0d10v5 w=1 l=0.5
XRp_54_22 BLP22 dp_54_22 sky130_fd_pr_reram__reram_cell area_ox=0.0676
XMz_54_22 dz_54_22 WL54 SL22 VSS sky130_fd_pr__nfet_g5v0d10v5 w=1 l=0.5
XRz_54_22 BLZ22 dz_54_22 sky130_fd_pr_reram__reram_cell area_ox=0.0676
XMn_54_22 dn_54_22 WL54 SL22 VSS sky130_fd_pr__nfet_g5v0d10v5 w=1 l=0.5
XRn_54_22 BLN22 dn_54_22 sky130_fd_pr_reram__reram_cell area_ox=0.0676
XMp_54_23 dp_54_23 WL54 SL23 VSS sky130_fd_pr__nfet_g5v0d10v5 w=1 l=0.5
XRp_54_23 BLP23 dp_54_23 sky130_fd_pr_reram__reram_cell area_ox=0.0676
XMz_54_23 dz_54_23 WL54 SL23 VSS sky130_fd_pr__nfet_g5v0d10v5 w=1 l=0.5
XRz_54_23 BLZ23 dz_54_23 sky130_fd_pr_reram__reram_cell area_ox=0.0676
XMn_54_23 dn_54_23 WL54 SL23 VSS sky130_fd_pr__nfet_g5v0d10v5 w=1 l=0.5
XRn_54_23 BLN23 dn_54_23 sky130_fd_pr_reram__reram_cell area_ox=0.0676
XMp_55_0 dp_55_0 WL55 SL0 VSS sky130_fd_pr__nfet_g5v0d10v5 w=1 l=0.5
XRp_55_0 BLP0 dp_55_0 sky130_fd_pr_reram__reram_cell area_ox=0.0676
XMz_55_0 dz_55_0 WL55 SL0 VSS sky130_fd_pr__nfet_g5v0d10v5 w=1 l=0.5
XRz_55_0 BLZ0 dz_55_0 sky130_fd_pr_reram__reram_cell area_ox=0.0676
XMn_55_0 dn_55_0 WL55 SL0 VSS sky130_fd_pr__nfet_g5v0d10v5 w=1 l=0.5
XRn_55_0 BLN0 dn_55_0 sky130_fd_pr_reram__reram_cell area_ox=0.0676
XMp_55_1 dp_55_1 WL55 SL1 VSS sky130_fd_pr__nfet_g5v0d10v5 w=1 l=0.5
XRp_55_1 BLP1 dp_55_1 sky130_fd_pr_reram__reram_cell area_ox=0.0676
XMz_55_1 dz_55_1 WL55 SL1 VSS sky130_fd_pr__nfet_g5v0d10v5 w=1 l=0.5
XRz_55_1 BLZ1 dz_55_1 sky130_fd_pr_reram__reram_cell area_ox=0.0676
XMn_55_1 dn_55_1 WL55 SL1 VSS sky130_fd_pr__nfet_g5v0d10v5 w=1 l=0.5
XRn_55_1 BLN1 dn_55_1 sky130_fd_pr_reram__reram_cell area_ox=0.0676
XMp_55_2 dp_55_2 WL55 SL2 VSS sky130_fd_pr__nfet_g5v0d10v5 w=1 l=0.5
XRp_55_2 BLP2 dp_55_2 sky130_fd_pr_reram__reram_cell area_ox=0.0676
XMz_55_2 dz_55_2 WL55 SL2 VSS sky130_fd_pr__nfet_g5v0d10v5 w=1 l=0.5
XRz_55_2 BLZ2 dz_55_2 sky130_fd_pr_reram__reram_cell area_ox=0.0676
XMn_55_2 dn_55_2 WL55 SL2 VSS sky130_fd_pr__nfet_g5v0d10v5 w=1 l=0.5
XRn_55_2 BLN2 dn_55_2 sky130_fd_pr_reram__reram_cell area_ox=0.0676
XMp_55_3 dp_55_3 WL55 SL3 VSS sky130_fd_pr__nfet_g5v0d10v5 w=1 l=0.5
XRp_55_3 BLP3 dp_55_3 sky130_fd_pr_reram__reram_cell area_ox=0.0676
XMz_55_3 dz_55_3 WL55 SL3 VSS sky130_fd_pr__nfet_g5v0d10v5 w=1 l=0.5
XRz_55_3 BLZ3 dz_55_3 sky130_fd_pr_reram__reram_cell area_ox=0.0676
XMn_55_3 dn_55_3 WL55 SL3 VSS sky130_fd_pr__nfet_g5v0d10v5 w=1 l=0.5
XRn_55_3 BLN3 dn_55_3 sky130_fd_pr_reram__reram_cell area_ox=0.0676
XMp_55_4 dp_55_4 WL55 SL4 VSS sky130_fd_pr__nfet_g5v0d10v5 w=1 l=0.5
XRp_55_4 BLP4 dp_55_4 sky130_fd_pr_reram__reram_cell area_ox=0.0676
XMz_55_4 dz_55_4 WL55 SL4 VSS sky130_fd_pr__nfet_g5v0d10v5 w=1 l=0.5
XRz_55_4 BLZ4 dz_55_4 sky130_fd_pr_reram__reram_cell area_ox=0.0676
XMn_55_4 dn_55_4 WL55 SL4 VSS sky130_fd_pr__nfet_g5v0d10v5 w=1 l=0.5
XRn_55_4 BLN4 dn_55_4 sky130_fd_pr_reram__reram_cell area_ox=0.0676
XMp_55_5 dp_55_5 WL55 SL5 VSS sky130_fd_pr__nfet_g5v0d10v5 w=1 l=0.5
XRp_55_5 BLP5 dp_55_5 sky130_fd_pr_reram__reram_cell area_ox=0.0676
XMz_55_5 dz_55_5 WL55 SL5 VSS sky130_fd_pr__nfet_g5v0d10v5 w=1 l=0.5
XRz_55_5 BLZ5 dz_55_5 sky130_fd_pr_reram__reram_cell area_ox=0.0676
XMn_55_5 dn_55_5 WL55 SL5 VSS sky130_fd_pr__nfet_g5v0d10v5 w=1 l=0.5
XRn_55_5 BLN5 dn_55_5 sky130_fd_pr_reram__reram_cell area_ox=0.0676
XMp_55_6 dp_55_6 WL55 SL6 VSS sky130_fd_pr__nfet_g5v0d10v5 w=1 l=0.5
XRp_55_6 BLP6 dp_55_6 sky130_fd_pr_reram__reram_cell area_ox=0.0676
XMz_55_6 dz_55_6 WL55 SL6 VSS sky130_fd_pr__nfet_g5v0d10v5 w=1 l=0.5
XRz_55_6 BLZ6 dz_55_6 sky130_fd_pr_reram__reram_cell area_ox=0.0676
XMn_55_6 dn_55_6 WL55 SL6 VSS sky130_fd_pr__nfet_g5v0d10v5 w=1 l=0.5
XRn_55_6 BLN6 dn_55_6 sky130_fd_pr_reram__reram_cell area_ox=0.0676
XMp_55_7 dp_55_7 WL55 SL7 VSS sky130_fd_pr__nfet_g5v0d10v5 w=1 l=0.5
XRp_55_7 BLP7 dp_55_7 sky130_fd_pr_reram__reram_cell area_ox=0.0676
XMz_55_7 dz_55_7 WL55 SL7 VSS sky130_fd_pr__nfet_g5v0d10v5 w=1 l=0.5
XRz_55_7 BLZ7 dz_55_7 sky130_fd_pr_reram__reram_cell area_ox=0.0676
XMn_55_7 dn_55_7 WL55 SL7 VSS sky130_fd_pr__nfet_g5v0d10v5 w=1 l=0.5
XRn_55_7 BLN7 dn_55_7 sky130_fd_pr_reram__reram_cell area_ox=0.0676
XMp_55_8 dp_55_8 WL55 SL8 VSS sky130_fd_pr__nfet_g5v0d10v5 w=1 l=0.5
XRp_55_8 BLP8 dp_55_8 sky130_fd_pr_reram__reram_cell area_ox=0.0676
XMz_55_8 dz_55_8 WL55 SL8 VSS sky130_fd_pr__nfet_g5v0d10v5 w=1 l=0.5
XRz_55_8 BLZ8 dz_55_8 sky130_fd_pr_reram__reram_cell area_ox=0.0676
XMn_55_8 dn_55_8 WL55 SL8 VSS sky130_fd_pr__nfet_g5v0d10v5 w=1 l=0.5
XRn_55_8 BLN8 dn_55_8 sky130_fd_pr_reram__reram_cell area_ox=0.0676
XMp_55_9 dp_55_9 WL55 SL9 VSS sky130_fd_pr__nfet_g5v0d10v5 w=1 l=0.5
XRp_55_9 BLP9 dp_55_9 sky130_fd_pr_reram__reram_cell area_ox=0.0676
XMz_55_9 dz_55_9 WL55 SL9 VSS sky130_fd_pr__nfet_g5v0d10v5 w=1 l=0.5
XRz_55_9 BLZ9 dz_55_9 sky130_fd_pr_reram__reram_cell area_ox=0.0676
XMn_55_9 dn_55_9 WL55 SL9 VSS sky130_fd_pr__nfet_g5v0d10v5 w=1 l=0.5
XRn_55_9 BLN9 dn_55_9 sky130_fd_pr_reram__reram_cell area_ox=0.0676
XMp_55_10 dp_55_10 WL55 SL10 VSS sky130_fd_pr__nfet_g5v0d10v5 w=1 l=0.5
XRp_55_10 BLP10 dp_55_10 sky130_fd_pr_reram__reram_cell area_ox=0.0676
XMz_55_10 dz_55_10 WL55 SL10 VSS sky130_fd_pr__nfet_g5v0d10v5 w=1 l=0.5
XRz_55_10 BLZ10 dz_55_10 sky130_fd_pr_reram__reram_cell area_ox=0.0676
XMn_55_10 dn_55_10 WL55 SL10 VSS sky130_fd_pr__nfet_g5v0d10v5 w=1 l=0.5
XRn_55_10 BLN10 dn_55_10 sky130_fd_pr_reram__reram_cell area_ox=0.0676
XMp_55_11 dp_55_11 WL55 SL11 VSS sky130_fd_pr__nfet_g5v0d10v5 w=1 l=0.5
XRp_55_11 BLP11 dp_55_11 sky130_fd_pr_reram__reram_cell area_ox=0.0676
XMz_55_11 dz_55_11 WL55 SL11 VSS sky130_fd_pr__nfet_g5v0d10v5 w=1 l=0.5
XRz_55_11 BLZ11 dz_55_11 sky130_fd_pr_reram__reram_cell area_ox=0.0676
XMn_55_11 dn_55_11 WL55 SL11 VSS sky130_fd_pr__nfet_g5v0d10v5 w=1 l=0.5
XRn_55_11 BLN11 dn_55_11 sky130_fd_pr_reram__reram_cell area_ox=0.0676
XMp_55_12 dp_55_12 WL55 SL12 VSS sky130_fd_pr__nfet_g5v0d10v5 w=1 l=0.5
XRp_55_12 BLP12 dp_55_12 sky130_fd_pr_reram__reram_cell area_ox=0.0676
XMz_55_12 dz_55_12 WL55 SL12 VSS sky130_fd_pr__nfet_g5v0d10v5 w=1 l=0.5
XRz_55_12 BLZ12 dz_55_12 sky130_fd_pr_reram__reram_cell area_ox=0.0676
XMn_55_12 dn_55_12 WL55 SL12 VSS sky130_fd_pr__nfet_g5v0d10v5 w=1 l=0.5
XRn_55_12 BLN12 dn_55_12 sky130_fd_pr_reram__reram_cell area_ox=0.0676
XMp_55_13 dp_55_13 WL55 SL13 VSS sky130_fd_pr__nfet_g5v0d10v5 w=1 l=0.5
XRp_55_13 BLP13 dp_55_13 sky130_fd_pr_reram__reram_cell area_ox=0.0676
XMz_55_13 dz_55_13 WL55 SL13 VSS sky130_fd_pr__nfet_g5v0d10v5 w=1 l=0.5
XRz_55_13 BLZ13 dz_55_13 sky130_fd_pr_reram__reram_cell area_ox=0.0676
XMn_55_13 dn_55_13 WL55 SL13 VSS sky130_fd_pr__nfet_g5v0d10v5 w=1 l=0.5
XRn_55_13 BLN13 dn_55_13 sky130_fd_pr_reram__reram_cell area_ox=0.0676
XMp_55_14 dp_55_14 WL55 SL14 VSS sky130_fd_pr__nfet_g5v0d10v5 w=1 l=0.5
XRp_55_14 BLP14 dp_55_14 sky130_fd_pr_reram__reram_cell area_ox=0.0676
XMz_55_14 dz_55_14 WL55 SL14 VSS sky130_fd_pr__nfet_g5v0d10v5 w=1 l=0.5
XRz_55_14 BLZ14 dz_55_14 sky130_fd_pr_reram__reram_cell area_ox=0.0676
XMn_55_14 dn_55_14 WL55 SL14 VSS sky130_fd_pr__nfet_g5v0d10v5 w=1 l=0.5
XRn_55_14 BLN14 dn_55_14 sky130_fd_pr_reram__reram_cell area_ox=0.0676
XMp_55_15 dp_55_15 WL55 SL15 VSS sky130_fd_pr__nfet_g5v0d10v5 w=1 l=0.5
XRp_55_15 BLP15 dp_55_15 sky130_fd_pr_reram__reram_cell area_ox=0.0676
XMz_55_15 dz_55_15 WL55 SL15 VSS sky130_fd_pr__nfet_g5v0d10v5 w=1 l=0.5
XRz_55_15 BLZ15 dz_55_15 sky130_fd_pr_reram__reram_cell area_ox=0.0676
XMn_55_15 dn_55_15 WL55 SL15 VSS sky130_fd_pr__nfet_g5v0d10v5 w=1 l=0.5
XRn_55_15 BLN15 dn_55_15 sky130_fd_pr_reram__reram_cell area_ox=0.0676
XMp_55_16 dp_55_16 WL55 SL16 VSS sky130_fd_pr__nfet_g5v0d10v5 w=1 l=0.5
XRp_55_16 BLP16 dp_55_16 sky130_fd_pr_reram__reram_cell area_ox=0.0676
XMz_55_16 dz_55_16 WL55 SL16 VSS sky130_fd_pr__nfet_g5v0d10v5 w=1 l=0.5
XRz_55_16 BLZ16 dz_55_16 sky130_fd_pr_reram__reram_cell area_ox=0.0676
XMn_55_16 dn_55_16 WL55 SL16 VSS sky130_fd_pr__nfet_g5v0d10v5 w=1 l=0.5
XRn_55_16 BLN16 dn_55_16 sky130_fd_pr_reram__reram_cell area_ox=0.0676
XMp_55_17 dp_55_17 WL55 SL17 VSS sky130_fd_pr__nfet_g5v0d10v5 w=1 l=0.5
XRp_55_17 BLP17 dp_55_17 sky130_fd_pr_reram__reram_cell area_ox=0.0676
XMz_55_17 dz_55_17 WL55 SL17 VSS sky130_fd_pr__nfet_g5v0d10v5 w=1 l=0.5
XRz_55_17 BLZ17 dz_55_17 sky130_fd_pr_reram__reram_cell area_ox=0.0676
XMn_55_17 dn_55_17 WL55 SL17 VSS sky130_fd_pr__nfet_g5v0d10v5 w=1 l=0.5
XRn_55_17 BLN17 dn_55_17 sky130_fd_pr_reram__reram_cell area_ox=0.0676
XMp_55_18 dp_55_18 WL55 SL18 VSS sky130_fd_pr__nfet_g5v0d10v5 w=1 l=0.5
XRp_55_18 BLP18 dp_55_18 sky130_fd_pr_reram__reram_cell area_ox=0.0676
XMz_55_18 dz_55_18 WL55 SL18 VSS sky130_fd_pr__nfet_g5v0d10v5 w=1 l=0.5
XRz_55_18 BLZ18 dz_55_18 sky130_fd_pr_reram__reram_cell area_ox=0.0676
XMn_55_18 dn_55_18 WL55 SL18 VSS sky130_fd_pr__nfet_g5v0d10v5 w=1 l=0.5
XRn_55_18 BLN18 dn_55_18 sky130_fd_pr_reram__reram_cell area_ox=0.0676
XMp_55_19 dp_55_19 WL55 SL19 VSS sky130_fd_pr__nfet_g5v0d10v5 w=1 l=0.5
XRp_55_19 BLP19 dp_55_19 sky130_fd_pr_reram__reram_cell area_ox=0.0676
XMz_55_19 dz_55_19 WL55 SL19 VSS sky130_fd_pr__nfet_g5v0d10v5 w=1 l=0.5
XRz_55_19 BLZ19 dz_55_19 sky130_fd_pr_reram__reram_cell area_ox=0.0676
XMn_55_19 dn_55_19 WL55 SL19 VSS sky130_fd_pr__nfet_g5v0d10v5 w=1 l=0.5
XRn_55_19 BLN19 dn_55_19 sky130_fd_pr_reram__reram_cell area_ox=0.0676
XMp_55_20 dp_55_20 WL55 SL20 VSS sky130_fd_pr__nfet_g5v0d10v5 w=1 l=0.5
XRp_55_20 BLP20 dp_55_20 sky130_fd_pr_reram__reram_cell area_ox=0.0676
XMz_55_20 dz_55_20 WL55 SL20 VSS sky130_fd_pr__nfet_g5v0d10v5 w=1 l=0.5
XRz_55_20 BLZ20 dz_55_20 sky130_fd_pr_reram__reram_cell area_ox=0.0676
XMn_55_20 dn_55_20 WL55 SL20 VSS sky130_fd_pr__nfet_g5v0d10v5 w=1 l=0.5
XRn_55_20 BLN20 dn_55_20 sky130_fd_pr_reram__reram_cell area_ox=0.0676
XMp_55_21 dp_55_21 WL55 SL21 VSS sky130_fd_pr__nfet_g5v0d10v5 w=1 l=0.5
XRp_55_21 BLP21 dp_55_21 sky130_fd_pr_reram__reram_cell area_ox=0.0676
XMz_55_21 dz_55_21 WL55 SL21 VSS sky130_fd_pr__nfet_g5v0d10v5 w=1 l=0.5
XRz_55_21 BLZ21 dz_55_21 sky130_fd_pr_reram__reram_cell area_ox=0.0676
XMn_55_21 dn_55_21 WL55 SL21 VSS sky130_fd_pr__nfet_g5v0d10v5 w=1 l=0.5
XRn_55_21 BLN21 dn_55_21 sky130_fd_pr_reram__reram_cell area_ox=0.0676
XMp_55_22 dp_55_22 WL55 SL22 VSS sky130_fd_pr__nfet_g5v0d10v5 w=1 l=0.5
XRp_55_22 BLP22 dp_55_22 sky130_fd_pr_reram__reram_cell area_ox=0.0676
XMz_55_22 dz_55_22 WL55 SL22 VSS sky130_fd_pr__nfet_g5v0d10v5 w=1 l=0.5
XRz_55_22 BLZ22 dz_55_22 sky130_fd_pr_reram__reram_cell area_ox=0.0676
XMn_55_22 dn_55_22 WL55 SL22 VSS sky130_fd_pr__nfet_g5v0d10v5 w=1 l=0.5
XRn_55_22 BLN22 dn_55_22 sky130_fd_pr_reram__reram_cell area_ox=0.0676
XMp_55_23 dp_55_23 WL55 SL23 VSS sky130_fd_pr__nfet_g5v0d10v5 w=1 l=0.5
XRp_55_23 BLP23 dp_55_23 sky130_fd_pr_reram__reram_cell area_ox=0.0676
XMz_55_23 dz_55_23 WL55 SL23 VSS sky130_fd_pr__nfet_g5v0d10v5 w=1 l=0.5
XRz_55_23 BLZ23 dz_55_23 sky130_fd_pr_reram__reram_cell area_ox=0.0676
XMn_55_23 dn_55_23 WL55 SL23 VSS sky130_fd_pr__nfet_g5v0d10v5 w=1 l=0.5
XRn_55_23 BLN23 dn_55_23 sky130_fd_pr_reram__reram_cell area_ox=0.0676
XMp_56_0 dp_56_0 WL56 SL0 VSS sky130_fd_pr__nfet_g5v0d10v5 w=1 l=0.5
XRp_56_0 BLP0 dp_56_0 sky130_fd_pr_reram__reram_cell area_ox=0.0676
XMz_56_0 dz_56_0 WL56 SL0 VSS sky130_fd_pr__nfet_g5v0d10v5 w=1 l=0.5
XRz_56_0 BLZ0 dz_56_0 sky130_fd_pr_reram__reram_cell area_ox=0.0676
XMn_56_0 dn_56_0 WL56 SL0 VSS sky130_fd_pr__nfet_g5v0d10v5 w=1 l=0.5
XRn_56_0 BLN0 dn_56_0 sky130_fd_pr_reram__reram_cell area_ox=0.0676
XMp_56_1 dp_56_1 WL56 SL1 VSS sky130_fd_pr__nfet_g5v0d10v5 w=1 l=0.5
XRp_56_1 BLP1 dp_56_1 sky130_fd_pr_reram__reram_cell area_ox=0.0676
XMz_56_1 dz_56_1 WL56 SL1 VSS sky130_fd_pr__nfet_g5v0d10v5 w=1 l=0.5
XRz_56_1 BLZ1 dz_56_1 sky130_fd_pr_reram__reram_cell area_ox=0.0676
XMn_56_1 dn_56_1 WL56 SL1 VSS sky130_fd_pr__nfet_g5v0d10v5 w=1 l=0.5
XRn_56_1 BLN1 dn_56_1 sky130_fd_pr_reram__reram_cell area_ox=0.0676
XMp_56_2 dp_56_2 WL56 SL2 VSS sky130_fd_pr__nfet_g5v0d10v5 w=1 l=0.5
XRp_56_2 BLP2 dp_56_2 sky130_fd_pr_reram__reram_cell area_ox=0.0676
XMz_56_2 dz_56_2 WL56 SL2 VSS sky130_fd_pr__nfet_g5v0d10v5 w=1 l=0.5
XRz_56_2 BLZ2 dz_56_2 sky130_fd_pr_reram__reram_cell area_ox=0.0676
XMn_56_2 dn_56_2 WL56 SL2 VSS sky130_fd_pr__nfet_g5v0d10v5 w=1 l=0.5
XRn_56_2 BLN2 dn_56_2 sky130_fd_pr_reram__reram_cell area_ox=0.0676
XMp_56_3 dp_56_3 WL56 SL3 VSS sky130_fd_pr__nfet_g5v0d10v5 w=1 l=0.5
XRp_56_3 BLP3 dp_56_3 sky130_fd_pr_reram__reram_cell area_ox=0.0676
XMz_56_3 dz_56_3 WL56 SL3 VSS sky130_fd_pr__nfet_g5v0d10v5 w=1 l=0.5
XRz_56_3 BLZ3 dz_56_3 sky130_fd_pr_reram__reram_cell area_ox=0.0676
XMn_56_3 dn_56_3 WL56 SL3 VSS sky130_fd_pr__nfet_g5v0d10v5 w=1 l=0.5
XRn_56_3 BLN3 dn_56_3 sky130_fd_pr_reram__reram_cell area_ox=0.0676
XMp_56_4 dp_56_4 WL56 SL4 VSS sky130_fd_pr__nfet_g5v0d10v5 w=1 l=0.5
XRp_56_4 BLP4 dp_56_4 sky130_fd_pr_reram__reram_cell area_ox=0.0676
XMz_56_4 dz_56_4 WL56 SL4 VSS sky130_fd_pr__nfet_g5v0d10v5 w=1 l=0.5
XRz_56_4 BLZ4 dz_56_4 sky130_fd_pr_reram__reram_cell area_ox=0.0676
XMn_56_4 dn_56_4 WL56 SL4 VSS sky130_fd_pr__nfet_g5v0d10v5 w=1 l=0.5
XRn_56_4 BLN4 dn_56_4 sky130_fd_pr_reram__reram_cell area_ox=0.0676
XMp_56_5 dp_56_5 WL56 SL5 VSS sky130_fd_pr__nfet_g5v0d10v5 w=1 l=0.5
XRp_56_5 BLP5 dp_56_5 sky130_fd_pr_reram__reram_cell area_ox=0.0676
XMz_56_5 dz_56_5 WL56 SL5 VSS sky130_fd_pr__nfet_g5v0d10v5 w=1 l=0.5
XRz_56_5 BLZ5 dz_56_5 sky130_fd_pr_reram__reram_cell area_ox=0.0676
XMn_56_5 dn_56_5 WL56 SL5 VSS sky130_fd_pr__nfet_g5v0d10v5 w=1 l=0.5
XRn_56_5 BLN5 dn_56_5 sky130_fd_pr_reram__reram_cell area_ox=0.0676
XMp_56_6 dp_56_6 WL56 SL6 VSS sky130_fd_pr__nfet_g5v0d10v5 w=1 l=0.5
XRp_56_6 BLP6 dp_56_6 sky130_fd_pr_reram__reram_cell area_ox=0.0676
XMz_56_6 dz_56_6 WL56 SL6 VSS sky130_fd_pr__nfet_g5v0d10v5 w=1 l=0.5
XRz_56_6 BLZ6 dz_56_6 sky130_fd_pr_reram__reram_cell area_ox=0.0676
XMn_56_6 dn_56_6 WL56 SL6 VSS sky130_fd_pr__nfet_g5v0d10v5 w=1 l=0.5
XRn_56_6 BLN6 dn_56_6 sky130_fd_pr_reram__reram_cell area_ox=0.0676
XMp_56_7 dp_56_7 WL56 SL7 VSS sky130_fd_pr__nfet_g5v0d10v5 w=1 l=0.5
XRp_56_7 BLP7 dp_56_7 sky130_fd_pr_reram__reram_cell area_ox=0.0676
XMz_56_7 dz_56_7 WL56 SL7 VSS sky130_fd_pr__nfet_g5v0d10v5 w=1 l=0.5
XRz_56_7 BLZ7 dz_56_7 sky130_fd_pr_reram__reram_cell area_ox=0.0676
XMn_56_7 dn_56_7 WL56 SL7 VSS sky130_fd_pr__nfet_g5v0d10v5 w=1 l=0.5
XRn_56_7 BLN7 dn_56_7 sky130_fd_pr_reram__reram_cell area_ox=0.0676
XMp_56_8 dp_56_8 WL56 SL8 VSS sky130_fd_pr__nfet_g5v0d10v5 w=1 l=0.5
XRp_56_8 BLP8 dp_56_8 sky130_fd_pr_reram__reram_cell area_ox=0.0676
XMz_56_8 dz_56_8 WL56 SL8 VSS sky130_fd_pr__nfet_g5v0d10v5 w=1 l=0.5
XRz_56_8 BLZ8 dz_56_8 sky130_fd_pr_reram__reram_cell area_ox=0.0676
XMn_56_8 dn_56_8 WL56 SL8 VSS sky130_fd_pr__nfet_g5v0d10v5 w=1 l=0.5
XRn_56_8 BLN8 dn_56_8 sky130_fd_pr_reram__reram_cell area_ox=0.0676
XMp_56_9 dp_56_9 WL56 SL9 VSS sky130_fd_pr__nfet_g5v0d10v5 w=1 l=0.5
XRp_56_9 BLP9 dp_56_9 sky130_fd_pr_reram__reram_cell area_ox=0.0676
XMz_56_9 dz_56_9 WL56 SL9 VSS sky130_fd_pr__nfet_g5v0d10v5 w=1 l=0.5
XRz_56_9 BLZ9 dz_56_9 sky130_fd_pr_reram__reram_cell area_ox=0.0676
XMn_56_9 dn_56_9 WL56 SL9 VSS sky130_fd_pr__nfet_g5v0d10v5 w=1 l=0.5
XRn_56_9 BLN9 dn_56_9 sky130_fd_pr_reram__reram_cell area_ox=0.0676
XMp_56_10 dp_56_10 WL56 SL10 VSS sky130_fd_pr__nfet_g5v0d10v5 w=1 l=0.5
XRp_56_10 BLP10 dp_56_10 sky130_fd_pr_reram__reram_cell area_ox=0.0676
XMz_56_10 dz_56_10 WL56 SL10 VSS sky130_fd_pr__nfet_g5v0d10v5 w=1 l=0.5
XRz_56_10 BLZ10 dz_56_10 sky130_fd_pr_reram__reram_cell area_ox=0.0676
XMn_56_10 dn_56_10 WL56 SL10 VSS sky130_fd_pr__nfet_g5v0d10v5 w=1 l=0.5
XRn_56_10 BLN10 dn_56_10 sky130_fd_pr_reram__reram_cell area_ox=0.0676
XMp_56_11 dp_56_11 WL56 SL11 VSS sky130_fd_pr__nfet_g5v0d10v5 w=1 l=0.5
XRp_56_11 BLP11 dp_56_11 sky130_fd_pr_reram__reram_cell area_ox=0.0676
XMz_56_11 dz_56_11 WL56 SL11 VSS sky130_fd_pr__nfet_g5v0d10v5 w=1 l=0.5
XRz_56_11 BLZ11 dz_56_11 sky130_fd_pr_reram__reram_cell area_ox=0.0676
XMn_56_11 dn_56_11 WL56 SL11 VSS sky130_fd_pr__nfet_g5v0d10v5 w=1 l=0.5
XRn_56_11 BLN11 dn_56_11 sky130_fd_pr_reram__reram_cell area_ox=0.0676
XMp_56_12 dp_56_12 WL56 SL12 VSS sky130_fd_pr__nfet_g5v0d10v5 w=1 l=0.5
XRp_56_12 BLP12 dp_56_12 sky130_fd_pr_reram__reram_cell area_ox=0.0676
XMz_56_12 dz_56_12 WL56 SL12 VSS sky130_fd_pr__nfet_g5v0d10v5 w=1 l=0.5
XRz_56_12 BLZ12 dz_56_12 sky130_fd_pr_reram__reram_cell area_ox=0.0676
XMn_56_12 dn_56_12 WL56 SL12 VSS sky130_fd_pr__nfet_g5v0d10v5 w=1 l=0.5
XRn_56_12 BLN12 dn_56_12 sky130_fd_pr_reram__reram_cell area_ox=0.0676
XMp_56_13 dp_56_13 WL56 SL13 VSS sky130_fd_pr__nfet_g5v0d10v5 w=1 l=0.5
XRp_56_13 BLP13 dp_56_13 sky130_fd_pr_reram__reram_cell area_ox=0.0676
XMz_56_13 dz_56_13 WL56 SL13 VSS sky130_fd_pr__nfet_g5v0d10v5 w=1 l=0.5
XRz_56_13 BLZ13 dz_56_13 sky130_fd_pr_reram__reram_cell area_ox=0.0676
XMn_56_13 dn_56_13 WL56 SL13 VSS sky130_fd_pr__nfet_g5v0d10v5 w=1 l=0.5
XRn_56_13 BLN13 dn_56_13 sky130_fd_pr_reram__reram_cell area_ox=0.0676
XMp_56_14 dp_56_14 WL56 SL14 VSS sky130_fd_pr__nfet_g5v0d10v5 w=1 l=0.5
XRp_56_14 BLP14 dp_56_14 sky130_fd_pr_reram__reram_cell area_ox=0.0676
XMz_56_14 dz_56_14 WL56 SL14 VSS sky130_fd_pr__nfet_g5v0d10v5 w=1 l=0.5
XRz_56_14 BLZ14 dz_56_14 sky130_fd_pr_reram__reram_cell area_ox=0.0676
XMn_56_14 dn_56_14 WL56 SL14 VSS sky130_fd_pr__nfet_g5v0d10v5 w=1 l=0.5
XRn_56_14 BLN14 dn_56_14 sky130_fd_pr_reram__reram_cell area_ox=0.0676
XMp_56_15 dp_56_15 WL56 SL15 VSS sky130_fd_pr__nfet_g5v0d10v5 w=1 l=0.5
XRp_56_15 BLP15 dp_56_15 sky130_fd_pr_reram__reram_cell area_ox=0.0676
XMz_56_15 dz_56_15 WL56 SL15 VSS sky130_fd_pr__nfet_g5v0d10v5 w=1 l=0.5
XRz_56_15 BLZ15 dz_56_15 sky130_fd_pr_reram__reram_cell area_ox=0.0676
XMn_56_15 dn_56_15 WL56 SL15 VSS sky130_fd_pr__nfet_g5v0d10v5 w=1 l=0.5
XRn_56_15 BLN15 dn_56_15 sky130_fd_pr_reram__reram_cell area_ox=0.0676
XMp_56_16 dp_56_16 WL56 SL16 VSS sky130_fd_pr__nfet_g5v0d10v5 w=1 l=0.5
XRp_56_16 BLP16 dp_56_16 sky130_fd_pr_reram__reram_cell area_ox=0.0676
XMz_56_16 dz_56_16 WL56 SL16 VSS sky130_fd_pr__nfet_g5v0d10v5 w=1 l=0.5
XRz_56_16 BLZ16 dz_56_16 sky130_fd_pr_reram__reram_cell area_ox=0.0676
XMn_56_16 dn_56_16 WL56 SL16 VSS sky130_fd_pr__nfet_g5v0d10v5 w=1 l=0.5
XRn_56_16 BLN16 dn_56_16 sky130_fd_pr_reram__reram_cell area_ox=0.0676
XMp_56_17 dp_56_17 WL56 SL17 VSS sky130_fd_pr__nfet_g5v0d10v5 w=1 l=0.5
XRp_56_17 BLP17 dp_56_17 sky130_fd_pr_reram__reram_cell area_ox=0.0676
XMz_56_17 dz_56_17 WL56 SL17 VSS sky130_fd_pr__nfet_g5v0d10v5 w=1 l=0.5
XRz_56_17 BLZ17 dz_56_17 sky130_fd_pr_reram__reram_cell area_ox=0.0676
XMn_56_17 dn_56_17 WL56 SL17 VSS sky130_fd_pr__nfet_g5v0d10v5 w=1 l=0.5
XRn_56_17 BLN17 dn_56_17 sky130_fd_pr_reram__reram_cell area_ox=0.0676
XMp_56_18 dp_56_18 WL56 SL18 VSS sky130_fd_pr__nfet_g5v0d10v5 w=1 l=0.5
XRp_56_18 BLP18 dp_56_18 sky130_fd_pr_reram__reram_cell area_ox=0.0676
XMz_56_18 dz_56_18 WL56 SL18 VSS sky130_fd_pr__nfet_g5v0d10v5 w=1 l=0.5
XRz_56_18 BLZ18 dz_56_18 sky130_fd_pr_reram__reram_cell area_ox=0.0676
XMn_56_18 dn_56_18 WL56 SL18 VSS sky130_fd_pr__nfet_g5v0d10v5 w=1 l=0.5
XRn_56_18 BLN18 dn_56_18 sky130_fd_pr_reram__reram_cell area_ox=0.0676
XMp_56_19 dp_56_19 WL56 SL19 VSS sky130_fd_pr__nfet_g5v0d10v5 w=1 l=0.5
XRp_56_19 BLP19 dp_56_19 sky130_fd_pr_reram__reram_cell area_ox=0.0676
XMz_56_19 dz_56_19 WL56 SL19 VSS sky130_fd_pr__nfet_g5v0d10v5 w=1 l=0.5
XRz_56_19 BLZ19 dz_56_19 sky130_fd_pr_reram__reram_cell area_ox=0.0676
XMn_56_19 dn_56_19 WL56 SL19 VSS sky130_fd_pr__nfet_g5v0d10v5 w=1 l=0.5
XRn_56_19 BLN19 dn_56_19 sky130_fd_pr_reram__reram_cell area_ox=0.0676
XMp_56_20 dp_56_20 WL56 SL20 VSS sky130_fd_pr__nfet_g5v0d10v5 w=1 l=0.5
XRp_56_20 BLP20 dp_56_20 sky130_fd_pr_reram__reram_cell area_ox=0.0676
XMz_56_20 dz_56_20 WL56 SL20 VSS sky130_fd_pr__nfet_g5v0d10v5 w=1 l=0.5
XRz_56_20 BLZ20 dz_56_20 sky130_fd_pr_reram__reram_cell area_ox=0.0676
XMn_56_20 dn_56_20 WL56 SL20 VSS sky130_fd_pr__nfet_g5v0d10v5 w=1 l=0.5
XRn_56_20 BLN20 dn_56_20 sky130_fd_pr_reram__reram_cell area_ox=0.0676
XMp_56_21 dp_56_21 WL56 SL21 VSS sky130_fd_pr__nfet_g5v0d10v5 w=1 l=0.5
XRp_56_21 BLP21 dp_56_21 sky130_fd_pr_reram__reram_cell area_ox=0.0676
XMz_56_21 dz_56_21 WL56 SL21 VSS sky130_fd_pr__nfet_g5v0d10v5 w=1 l=0.5
XRz_56_21 BLZ21 dz_56_21 sky130_fd_pr_reram__reram_cell area_ox=0.0676
XMn_56_21 dn_56_21 WL56 SL21 VSS sky130_fd_pr__nfet_g5v0d10v5 w=1 l=0.5
XRn_56_21 BLN21 dn_56_21 sky130_fd_pr_reram__reram_cell area_ox=0.0676
XMp_56_22 dp_56_22 WL56 SL22 VSS sky130_fd_pr__nfet_g5v0d10v5 w=1 l=0.5
XRp_56_22 BLP22 dp_56_22 sky130_fd_pr_reram__reram_cell area_ox=0.0676
XMz_56_22 dz_56_22 WL56 SL22 VSS sky130_fd_pr__nfet_g5v0d10v5 w=1 l=0.5
XRz_56_22 BLZ22 dz_56_22 sky130_fd_pr_reram__reram_cell area_ox=0.0676
XMn_56_22 dn_56_22 WL56 SL22 VSS sky130_fd_pr__nfet_g5v0d10v5 w=1 l=0.5
XRn_56_22 BLN22 dn_56_22 sky130_fd_pr_reram__reram_cell area_ox=0.0676
XMp_56_23 dp_56_23 WL56 SL23 VSS sky130_fd_pr__nfet_g5v0d10v5 w=1 l=0.5
XRp_56_23 BLP23 dp_56_23 sky130_fd_pr_reram__reram_cell area_ox=0.0676
XMz_56_23 dz_56_23 WL56 SL23 VSS sky130_fd_pr__nfet_g5v0d10v5 w=1 l=0.5
XRz_56_23 BLZ23 dz_56_23 sky130_fd_pr_reram__reram_cell area_ox=0.0676
XMn_56_23 dn_56_23 WL56 SL23 VSS sky130_fd_pr__nfet_g5v0d10v5 w=1 l=0.5
XRn_56_23 BLN23 dn_56_23 sky130_fd_pr_reram__reram_cell area_ox=0.0676
XMp_57_0 dp_57_0 WL57 SL0 VSS sky130_fd_pr__nfet_g5v0d10v5 w=1 l=0.5
XRp_57_0 BLP0 dp_57_0 sky130_fd_pr_reram__reram_cell area_ox=0.0676
XMz_57_0 dz_57_0 WL57 SL0 VSS sky130_fd_pr__nfet_g5v0d10v5 w=1 l=0.5
XRz_57_0 BLZ0 dz_57_0 sky130_fd_pr_reram__reram_cell area_ox=0.0676
XMn_57_0 dn_57_0 WL57 SL0 VSS sky130_fd_pr__nfet_g5v0d10v5 w=1 l=0.5
XRn_57_0 BLN0 dn_57_0 sky130_fd_pr_reram__reram_cell area_ox=0.0676
XMp_57_1 dp_57_1 WL57 SL1 VSS sky130_fd_pr__nfet_g5v0d10v5 w=1 l=0.5
XRp_57_1 BLP1 dp_57_1 sky130_fd_pr_reram__reram_cell area_ox=0.0676
XMz_57_1 dz_57_1 WL57 SL1 VSS sky130_fd_pr__nfet_g5v0d10v5 w=1 l=0.5
XRz_57_1 BLZ1 dz_57_1 sky130_fd_pr_reram__reram_cell area_ox=0.0676
XMn_57_1 dn_57_1 WL57 SL1 VSS sky130_fd_pr__nfet_g5v0d10v5 w=1 l=0.5
XRn_57_1 BLN1 dn_57_1 sky130_fd_pr_reram__reram_cell area_ox=0.0676
XMp_57_2 dp_57_2 WL57 SL2 VSS sky130_fd_pr__nfet_g5v0d10v5 w=1 l=0.5
XRp_57_2 BLP2 dp_57_2 sky130_fd_pr_reram__reram_cell area_ox=0.0676
XMz_57_2 dz_57_2 WL57 SL2 VSS sky130_fd_pr__nfet_g5v0d10v5 w=1 l=0.5
XRz_57_2 BLZ2 dz_57_2 sky130_fd_pr_reram__reram_cell area_ox=0.0676
XMn_57_2 dn_57_2 WL57 SL2 VSS sky130_fd_pr__nfet_g5v0d10v5 w=1 l=0.5
XRn_57_2 BLN2 dn_57_2 sky130_fd_pr_reram__reram_cell area_ox=0.0676
XMp_57_3 dp_57_3 WL57 SL3 VSS sky130_fd_pr__nfet_g5v0d10v5 w=1 l=0.5
XRp_57_3 BLP3 dp_57_3 sky130_fd_pr_reram__reram_cell area_ox=0.0676
XMz_57_3 dz_57_3 WL57 SL3 VSS sky130_fd_pr__nfet_g5v0d10v5 w=1 l=0.5
XRz_57_3 BLZ3 dz_57_3 sky130_fd_pr_reram__reram_cell area_ox=0.0676
XMn_57_3 dn_57_3 WL57 SL3 VSS sky130_fd_pr__nfet_g5v0d10v5 w=1 l=0.5
XRn_57_3 BLN3 dn_57_3 sky130_fd_pr_reram__reram_cell area_ox=0.0676
XMp_57_4 dp_57_4 WL57 SL4 VSS sky130_fd_pr__nfet_g5v0d10v5 w=1 l=0.5
XRp_57_4 BLP4 dp_57_4 sky130_fd_pr_reram__reram_cell area_ox=0.0676
XMz_57_4 dz_57_4 WL57 SL4 VSS sky130_fd_pr__nfet_g5v0d10v5 w=1 l=0.5
XRz_57_4 BLZ4 dz_57_4 sky130_fd_pr_reram__reram_cell area_ox=0.0676
XMn_57_4 dn_57_4 WL57 SL4 VSS sky130_fd_pr__nfet_g5v0d10v5 w=1 l=0.5
XRn_57_4 BLN4 dn_57_4 sky130_fd_pr_reram__reram_cell area_ox=0.0676
XMp_57_5 dp_57_5 WL57 SL5 VSS sky130_fd_pr__nfet_g5v0d10v5 w=1 l=0.5
XRp_57_5 BLP5 dp_57_5 sky130_fd_pr_reram__reram_cell area_ox=0.0676
XMz_57_5 dz_57_5 WL57 SL5 VSS sky130_fd_pr__nfet_g5v0d10v5 w=1 l=0.5
XRz_57_5 BLZ5 dz_57_5 sky130_fd_pr_reram__reram_cell area_ox=0.0676
XMn_57_5 dn_57_5 WL57 SL5 VSS sky130_fd_pr__nfet_g5v0d10v5 w=1 l=0.5
XRn_57_5 BLN5 dn_57_5 sky130_fd_pr_reram__reram_cell area_ox=0.0676
XMp_57_6 dp_57_6 WL57 SL6 VSS sky130_fd_pr__nfet_g5v0d10v5 w=1 l=0.5
XRp_57_6 BLP6 dp_57_6 sky130_fd_pr_reram__reram_cell area_ox=0.0676
XMz_57_6 dz_57_6 WL57 SL6 VSS sky130_fd_pr__nfet_g5v0d10v5 w=1 l=0.5
XRz_57_6 BLZ6 dz_57_6 sky130_fd_pr_reram__reram_cell area_ox=0.0676
XMn_57_6 dn_57_6 WL57 SL6 VSS sky130_fd_pr__nfet_g5v0d10v5 w=1 l=0.5
XRn_57_6 BLN6 dn_57_6 sky130_fd_pr_reram__reram_cell area_ox=0.0676
XMp_57_7 dp_57_7 WL57 SL7 VSS sky130_fd_pr__nfet_g5v0d10v5 w=1 l=0.5
XRp_57_7 BLP7 dp_57_7 sky130_fd_pr_reram__reram_cell area_ox=0.0676
XMz_57_7 dz_57_7 WL57 SL7 VSS sky130_fd_pr__nfet_g5v0d10v5 w=1 l=0.5
XRz_57_7 BLZ7 dz_57_7 sky130_fd_pr_reram__reram_cell area_ox=0.0676
XMn_57_7 dn_57_7 WL57 SL7 VSS sky130_fd_pr__nfet_g5v0d10v5 w=1 l=0.5
XRn_57_7 BLN7 dn_57_7 sky130_fd_pr_reram__reram_cell area_ox=0.0676
XMp_57_8 dp_57_8 WL57 SL8 VSS sky130_fd_pr__nfet_g5v0d10v5 w=1 l=0.5
XRp_57_8 BLP8 dp_57_8 sky130_fd_pr_reram__reram_cell area_ox=0.0676
XMz_57_8 dz_57_8 WL57 SL8 VSS sky130_fd_pr__nfet_g5v0d10v5 w=1 l=0.5
XRz_57_8 BLZ8 dz_57_8 sky130_fd_pr_reram__reram_cell area_ox=0.0676
XMn_57_8 dn_57_8 WL57 SL8 VSS sky130_fd_pr__nfet_g5v0d10v5 w=1 l=0.5
XRn_57_8 BLN8 dn_57_8 sky130_fd_pr_reram__reram_cell area_ox=0.0676
XMp_57_9 dp_57_9 WL57 SL9 VSS sky130_fd_pr__nfet_g5v0d10v5 w=1 l=0.5
XRp_57_9 BLP9 dp_57_9 sky130_fd_pr_reram__reram_cell area_ox=0.0676
XMz_57_9 dz_57_9 WL57 SL9 VSS sky130_fd_pr__nfet_g5v0d10v5 w=1 l=0.5
XRz_57_9 BLZ9 dz_57_9 sky130_fd_pr_reram__reram_cell area_ox=0.0676
XMn_57_9 dn_57_9 WL57 SL9 VSS sky130_fd_pr__nfet_g5v0d10v5 w=1 l=0.5
XRn_57_9 BLN9 dn_57_9 sky130_fd_pr_reram__reram_cell area_ox=0.0676
XMp_57_10 dp_57_10 WL57 SL10 VSS sky130_fd_pr__nfet_g5v0d10v5 w=1 l=0.5
XRp_57_10 BLP10 dp_57_10 sky130_fd_pr_reram__reram_cell area_ox=0.0676
XMz_57_10 dz_57_10 WL57 SL10 VSS sky130_fd_pr__nfet_g5v0d10v5 w=1 l=0.5
XRz_57_10 BLZ10 dz_57_10 sky130_fd_pr_reram__reram_cell area_ox=0.0676
XMn_57_10 dn_57_10 WL57 SL10 VSS sky130_fd_pr__nfet_g5v0d10v5 w=1 l=0.5
XRn_57_10 BLN10 dn_57_10 sky130_fd_pr_reram__reram_cell area_ox=0.0676
XMp_57_11 dp_57_11 WL57 SL11 VSS sky130_fd_pr__nfet_g5v0d10v5 w=1 l=0.5
XRp_57_11 BLP11 dp_57_11 sky130_fd_pr_reram__reram_cell area_ox=0.0676
XMz_57_11 dz_57_11 WL57 SL11 VSS sky130_fd_pr__nfet_g5v0d10v5 w=1 l=0.5
XRz_57_11 BLZ11 dz_57_11 sky130_fd_pr_reram__reram_cell area_ox=0.0676
XMn_57_11 dn_57_11 WL57 SL11 VSS sky130_fd_pr__nfet_g5v0d10v5 w=1 l=0.5
XRn_57_11 BLN11 dn_57_11 sky130_fd_pr_reram__reram_cell area_ox=0.0676
XMp_57_12 dp_57_12 WL57 SL12 VSS sky130_fd_pr__nfet_g5v0d10v5 w=1 l=0.5
XRp_57_12 BLP12 dp_57_12 sky130_fd_pr_reram__reram_cell area_ox=0.0676
XMz_57_12 dz_57_12 WL57 SL12 VSS sky130_fd_pr__nfet_g5v0d10v5 w=1 l=0.5
XRz_57_12 BLZ12 dz_57_12 sky130_fd_pr_reram__reram_cell area_ox=0.0676
XMn_57_12 dn_57_12 WL57 SL12 VSS sky130_fd_pr__nfet_g5v0d10v5 w=1 l=0.5
XRn_57_12 BLN12 dn_57_12 sky130_fd_pr_reram__reram_cell area_ox=0.0676
XMp_57_13 dp_57_13 WL57 SL13 VSS sky130_fd_pr__nfet_g5v0d10v5 w=1 l=0.5
XRp_57_13 BLP13 dp_57_13 sky130_fd_pr_reram__reram_cell area_ox=0.0676
XMz_57_13 dz_57_13 WL57 SL13 VSS sky130_fd_pr__nfet_g5v0d10v5 w=1 l=0.5
XRz_57_13 BLZ13 dz_57_13 sky130_fd_pr_reram__reram_cell area_ox=0.0676
XMn_57_13 dn_57_13 WL57 SL13 VSS sky130_fd_pr__nfet_g5v0d10v5 w=1 l=0.5
XRn_57_13 BLN13 dn_57_13 sky130_fd_pr_reram__reram_cell area_ox=0.0676
XMp_57_14 dp_57_14 WL57 SL14 VSS sky130_fd_pr__nfet_g5v0d10v5 w=1 l=0.5
XRp_57_14 BLP14 dp_57_14 sky130_fd_pr_reram__reram_cell area_ox=0.0676
XMz_57_14 dz_57_14 WL57 SL14 VSS sky130_fd_pr__nfet_g5v0d10v5 w=1 l=0.5
XRz_57_14 BLZ14 dz_57_14 sky130_fd_pr_reram__reram_cell area_ox=0.0676
XMn_57_14 dn_57_14 WL57 SL14 VSS sky130_fd_pr__nfet_g5v0d10v5 w=1 l=0.5
XRn_57_14 BLN14 dn_57_14 sky130_fd_pr_reram__reram_cell area_ox=0.0676
XMp_57_15 dp_57_15 WL57 SL15 VSS sky130_fd_pr__nfet_g5v0d10v5 w=1 l=0.5
XRp_57_15 BLP15 dp_57_15 sky130_fd_pr_reram__reram_cell area_ox=0.0676
XMz_57_15 dz_57_15 WL57 SL15 VSS sky130_fd_pr__nfet_g5v0d10v5 w=1 l=0.5
XRz_57_15 BLZ15 dz_57_15 sky130_fd_pr_reram__reram_cell area_ox=0.0676
XMn_57_15 dn_57_15 WL57 SL15 VSS sky130_fd_pr__nfet_g5v0d10v5 w=1 l=0.5
XRn_57_15 BLN15 dn_57_15 sky130_fd_pr_reram__reram_cell area_ox=0.0676
XMp_57_16 dp_57_16 WL57 SL16 VSS sky130_fd_pr__nfet_g5v0d10v5 w=1 l=0.5
XRp_57_16 BLP16 dp_57_16 sky130_fd_pr_reram__reram_cell area_ox=0.0676
XMz_57_16 dz_57_16 WL57 SL16 VSS sky130_fd_pr__nfet_g5v0d10v5 w=1 l=0.5
XRz_57_16 BLZ16 dz_57_16 sky130_fd_pr_reram__reram_cell area_ox=0.0676
XMn_57_16 dn_57_16 WL57 SL16 VSS sky130_fd_pr__nfet_g5v0d10v5 w=1 l=0.5
XRn_57_16 BLN16 dn_57_16 sky130_fd_pr_reram__reram_cell area_ox=0.0676
XMp_57_17 dp_57_17 WL57 SL17 VSS sky130_fd_pr__nfet_g5v0d10v5 w=1 l=0.5
XRp_57_17 BLP17 dp_57_17 sky130_fd_pr_reram__reram_cell area_ox=0.0676
XMz_57_17 dz_57_17 WL57 SL17 VSS sky130_fd_pr__nfet_g5v0d10v5 w=1 l=0.5
XRz_57_17 BLZ17 dz_57_17 sky130_fd_pr_reram__reram_cell area_ox=0.0676
XMn_57_17 dn_57_17 WL57 SL17 VSS sky130_fd_pr__nfet_g5v0d10v5 w=1 l=0.5
XRn_57_17 BLN17 dn_57_17 sky130_fd_pr_reram__reram_cell area_ox=0.0676
XMp_57_18 dp_57_18 WL57 SL18 VSS sky130_fd_pr__nfet_g5v0d10v5 w=1 l=0.5
XRp_57_18 BLP18 dp_57_18 sky130_fd_pr_reram__reram_cell area_ox=0.0676
XMz_57_18 dz_57_18 WL57 SL18 VSS sky130_fd_pr__nfet_g5v0d10v5 w=1 l=0.5
XRz_57_18 BLZ18 dz_57_18 sky130_fd_pr_reram__reram_cell area_ox=0.0676
XMn_57_18 dn_57_18 WL57 SL18 VSS sky130_fd_pr__nfet_g5v0d10v5 w=1 l=0.5
XRn_57_18 BLN18 dn_57_18 sky130_fd_pr_reram__reram_cell area_ox=0.0676
XMp_57_19 dp_57_19 WL57 SL19 VSS sky130_fd_pr__nfet_g5v0d10v5 w=1 l=0.5
XRp_57_19 BLP19 dp_57_19 sky130_fd_pr_reram__reram_cell area_ox=0.0676
XMz_57_19 dz_57_19 WL57 SL19 VSS sky130_fd_pr__nfet_g5v0d10v5 w=1 l=0.5
XRz_57_19 BLZ19 dz_57_19 sky130_fd_pr_reram__reram_cell area_ox=0.0676
XMn_57_19 dn_57_19 WL57 SL19 VSS sky130_fd_pr__nfet_g5v0d10v5 w=1 l=0.5
XRn_57_19 BLN19 dn_57_19 sky130_fd_pr_reram__reram_cell area_ox=0.0676
XMp_57_20 dp_57_20 WL57 SL20 VSS sky130_fd_pr__nfet_g5v0d10v5 w=1 l=0.5
XRp_57_20 BLP20 dp_57_20 sky130_fd_pr_reram__reram_cell area_ox=0.0676
XMz_57_20 dz_57_20 WL57 SL20 VSS sky130_fd_pr__nfet_g5v0d10v5 w=1 l=0.5
XRz_57_20 BLZ20 dz_57_20 sky130_fd_pr_reram__reram_cell area_ox=0.0676
XMn_57_20 dn_57_20 WL57 SL20 VSS sky130_fd_pr__nfet_g5v0d10v5 w=1 l=0.5
XRn_57_20 BLN20 dn_57_20 sky130_fd_pr_reram__reram_cell area_ox=0.0676
XMp_57_21 dp_57_21 WL57 SL21 VSS sky130_fd_pr__nfet_g5v0d10v5 w=1 l=0.5
XRp_57_21 BLP21 dp_57_21 sky130_fd_pr_reram__reram_cell area_ox=0.0676
XMz_57_21 dz_57_21 WL57 SL21 VSS sky130_fd_pr__nfet_g5v0d10v5 w=1 l=0.5
XRz_57_21 BLZ21 dz_57_21 sky130_fd_pr_reram__reram_cell area_ox=0.0676
XMn_57_21 dn_57_21 WL57 SL21 VSS sky130_fd_pr__nfet_g5v0d10v5 w=1 l=0.5
XRn_57_21 BLN21 dn_57_21 sky130_fd_pr_reram__reram_cell area_ox=0.0676
XMp_57_22 dp_57_22 WL57 SL22 VSS sky130_fd_pr__nfet_g5v0d10v5 w=1 l=0.5
XRp_57_22 BLP22 dp_57_22 sky130_fd_pr_reram__reram_cell area_ox=0.0676
XMz_57_22 dz_57_22 WL57 SL22 VSS sky130_fd_pr__nfet_g5v0d10v5 w=1 l=0.5
XRz_57_22 BLZ22 dz_57_22 sky130_fd_pr_reram__reram_cell area_ox=0.0676
XMn_57_22 dn_57_22 WL57 SL22 VSS sky130_fd_pr__nfet_g5v0d10v5 w=1 l=0.5
XRn_57_22 BLN22 dn_57_22 sky130_fd_pr_reram__reram_cell area_ox=0.0676
XMp_57_23 dp_57_23 WL57 SL23 VSS sky130_fd_pr__nfet_g5v0d10v5 w=1 l=0.5
XRp_57_23 BLP23 dp_57_23 sky130_fd_pr_reram__reram_cell area_ox=0.0676
XMz_57_23 dz_57_23 WL57 SL23 VSS sky130_fd_pr__nfet_g5v0d10v5 w=1 l=0.5
XRz_57_23 BLZ23 dz_57_23 sky130_fd_pr_reram__reram_cell area_ox=0.0676
XMn_57_23 dn_57_23 WL57 SL23 VSS sky130_fd_pr__nfet_g5v0d10v5 w=1 l=0.5
XRn_57_23 BLN23 dn_57_23 sky130_fd_pr_reram__reram_cell area_ox=0.0676
XMp_58_0 dp_58_0 WL58 SL0 VSS sky130_fd_pr__nfet_g5v0d10v5 w=1 l=0.5
XRp_58_0 BLP0 dp_58_0 sky130_fd_pr_reram__reram_cell area_ox=0.0676
XMz_58_0 dz_58_0 WL58 SL0 VSS sky130_fd_pr__nfet_g5v0d10v5 w=1 l=0.5
XRz_58_0 BLZ0 dz_58_0 sky130_fd_pr_reram__reram_cell area_ox=0.0676
XMn_58_0 dn_58_0 WL58 SL0 VSS sky130_fd_pr__nfet_g5v0d10v5 w=1 l=0.5
XRn_58_0 BLN0 dn_58_0 sky130_fd_pr_reram__reram_cell area_ox=0.0676
XMp_58_1 dp_58_1 WL58 SL1 VSS sky130_fd_pr__nfet_g5v0d10v5 w=1 l=0.5
XRp_58_1 BLP1 dp_58_1 sky130_fd_pr_reram__reram_cell area_ox=0.0676
XMz_58_1 dz_58_1 WL58 SL1 VSS sky130_fd_pr__nfet_g5v0d10v5 w=1 l=0.5
XRz_58_1 BLZ1 dz_58_1 sky130_fd_pr_reram__reram_cell area_ox=0.0676
XMn_58_1 dn_58_1 WL58 SL1 VSS sky130_fd_pr__nfet_g5v0d10v5 w=1 l=0.5
XRn_58_1 BLN1 dn_58_1 sky130_fd_pr_reram__reram_cell area_ox=0.0676
XMp_58_2 dp_58_2 WL58 SL2 VSS sky130_fd_pr__nfet_g5v0d10v5 w=1 l=0.5
XRp_58_2 BLP2 dp_58_2 sky130_fd_pr_reram__reram_cell area_ox=0.0676
XMz_58_2 dz_58_2 WL58 SL2 VSS sky130_fd_pr__nfet_g5v0d10v5 w=1 l=0.5
XRz_58_2 BLZ2 dz_58_2 sky130_fd_pr_reram__reram_cell area_ox=0.0676
XMn_58_2 dn_58_2 WL58 SL2 VSS sky130_fd_pr__nfet_g5v0d10v5 w=1 l=0.5
XRn_58_2 BLN2 dn_58_2 sky130_fd_pr_reram__reram_cell area_ox=0.0676
XMp_58_3 dp_58_3 WL58 SL3 VSS sky130_fd_pr__nfet_g5v0d10v5 w=1 l=0.5
XRp_58_3 BLP3 dp_58_3 sky130_fd_pr_reram__reram_cell area_ox=0.0676
XMz_58_3 dz_58_3 WL58 SL3 VSS sky130_fd_pr__nfet_g5v0d10v5 w=1 l=0.5
XRz_58_3 BLZ3 dz_58_3 sky130_fd_pr_reram__reram_cell area_ox=0.0676
XMn_58_3 dn_58_3 WL58 SL3 VSS sky130_fd_pr__nfet_g5v0d10v5 w=1 l=0.5
XRn_58_3 BLN3 dn_58_3 sky130_fd_pr_reram__reram_cell area_ox=0.0676
XMp_58_4 dp_58_4 WL58 SL4 VSS sky130_fd_pr__nfet_g5v0d10v5 w=1 l=0.5
XRp_58_4 BLP4 dp_58_4 sky130_fd_pr_reram__reram_cell area_ox=0.0676
XMz_58_4 dz_58_4 WL58 SL4 VSS sky130_fd_pr__nfet_g5v0d10v5 w=1 l=0.5
XRz_58_4 BLZ4 dz_58_4 sky130_fd_pr_reram__reram_cell area_ox=0.0676
XMn_58_4 dn_58_4 WL58 SL4 VSS sky130_fd_pr__nfet_g5v0d10v5 w=1 l=0.5
XRn_58_4 BLN4 dn_58_4 sky130_fd_pr_reram__reram_cell area_ox=0.0676
XMp_58_5 dp_58_5 WL58 SL5 VSS sky130_fd_pr__nfet_g5v0d10v5 w=1 l=0.5
XRp_58_5 BLP5 dp_58_5 sky130_fd_pr_reram__reram_cell area_ox=0.0676
XMz_58_5 dz_58_5 WL58 SL5 VSS sky130_fd_pr__nfet_g5v0d10v5 w=1 l=0.5
XRz_58_5 BLZ5 dz_58_5 sky130_fd_pr_reram__reram_cell area_ox=0.0676
XMn_58_5 dn_58_5 WL58 SL5 VSS sky130_fd_pr__nfet_g5v0d10v5 w=1 l=0.5
XRn_58_5 BLN5 dn_58_5 sky130_fd_pr_reram__reram_cell area_ox=0.0676
XMp_58_6 dp_58_6 WL58 SL6 VSS sky130_fd_pr__nfet_g5v0d10v5 w=1 l=0.5
XRp_58_6 BLP6 dp_58_6 sky130_fd_pr_reram__reram_cell area_ox=0.0676
XMz_58_6 dz_58_6 WL58 SL6 VSS sky130_fd_pr__nfet_g5v0d10v5 w=1 l=0.5
XRz_58_6 BLZ6 dz_58_6 sky130_fd_pr_reram__reram_cell area_ox=0.0676
XMn_58_6 dn_58_6 WL58 SL6 VSS sky130_fd_pr__nfet_g5v0d10v5 w=1 l=0.5
XRn_58_6 BLN6 dn_58_6 sky130_fd_pr_reram__reram_cell area_ox=0.0676
XMp_58_7 dp_58_7 WL58 SL7 VSS sky130_fd_pr__nfet_g5v0d10v5 w=1 l=0.5
XRp_58_7 BLP7 dp_58_7 sky130_fd_pr_reram__reram_cell area_ox=0.0676
XMz_58_7 dz_58_7 WL58 SL7 VSS sky130_fd_pr__nfet_g5v0d10v5 w=1 l=0.5
XRz_58_7 BLZ7 dz_58_7 sky130_fd_pr_reram__reram_cell area_ox=0.0676
XMn_58_7 dn_58_7 WL58 SL7 VSS sky130_fd_pr__nfet_g5v0d10v5 w=1 l=0.5
XRn_58_7 BLN7 dn_58_7 sky130_fd_pr_reram__reram_cell area_ox=0.0676
XMp_58_8 dp_58_8 WL58 SL8 VSS sky130_fd_pr__nfet_g5v0d10v5 w=1 l=0.5
XRp_58_8 BLP8 dp_58_8 sky130_fd_pr_reram__reram_cell area_ox=0.0676
XMz_58_8 dz_58_8 WL58 SL8 VSS sky130_fd_pr__nfet_g5v0d10v5 w=1 l=0.5
XRz_58_8 BLZ8 dz_58_8 sky130_fd_pr_reram__reram_cell area_ox=0.0676
XMn_58_8 dn_58_8 WL58 SL8 VSS sky130_fd_pr__nfet_g5v0d10v5 w=1 l=0.5
XRn_58_8 BLN8 dn_58_8 sky130_fd_pr_reram__reram_cell area_ox=0.0676
XMp_58_9 dp_58_9 WL58 SL9 VSS sky130_fd_pr__nfet_g5v0d10v5 w=1 l=0.5
XRp_58_9 BLP9 dp_58_9 sky130_fd_pr_reram__reram_cell area_ox=0.0676
XMz_58_9 dz_58_9 WL58 SL9 VSS sky130_fd_pr__nfet_g5v0d10v5 w=1 l=0.5
XRz_58_9 BLZ9 dz_58_9 sky130_fd_pr_reram__reram_cell area_ox=0.0676
XMn_58_9 dn_58_9 WL58 SL9 VSS sky130_fd_pr__nfet_g5v0d10v5 w=1 l=0.5
XRn_58_9 BLN9 dn_58_9 sky130_fd_pr_reram__reram_cell area_ox=0.0676
XMp_58_10 dp_58_10 WL58 SL10 VSS sky130_fd_pr__nfet_g5v0d10v5 w=1 l=0.5
XRp_58_10 BLP10 dp_58_10 sky130_fd_pr_reram__reram_cell area_ox=0.0676
XMz_58_10 dz_58_10 WL58 SL10 VSS sky130_fd_pr__nfet_g5v0d10v5 w=1 l=0.5
XRz_58_10 BLZ10 dz_58_10 sky130_fd_pr_reram__reram_cell area_ox=0.0676
XMn_58_10 dn_58_10 WL58 SL10 VSS sky130_fd_pr__nfet_g5v0d10v5 w=1 l=0.5
XRn_58_10 BLN10 dn_58_10 sky130_fd_pr_reram__reram_cell area_ox=0.0676
XMp_58_11 dp_58_11 WL58 SL11 VSS sky130_fd_pr__nfet_g5v0d10v5 w=1 l=0.5
XRp_58_11 BLP11 dp_58_11 sky130_fd_pr_reram__reram_cell area_ox=0.0676
XMz_58_11 dz_58_11 WL58 SL11 VSS sky130_fd_pr__nfet_g5v0d10v5 w=1 l=0.5
XRz_58_11 BLZ11 dz_58_11 sky130_fd_pr_reram__reram_cell area_ox=0.0676
XMn_58_11 dn_58_11 WL58 SL11 VSS sky130_fd_pr__nfet_g5v0d10v5 w=1 l=0.5
XRn_58_11 BLN11 dn_58_11 sky130_fd_pr_reram__reram_cell area_ox=0.0676
XMp_58_12 dp_58_12 WL58 SL12 VSS sky130_fd_pr__nfet_g5v0d10v5 w=1 l=0.5
XRp_58_12 BLP12 dp_58_12 sky130_fd_pr_reram__reram_cell area_ox=0.0676
XMz_58_12 dz_58_12 WL58 SL12 VSS sky130_fd_pr__nfet_g5v0d10v5 w=1 l=0.5
XRz_58_12 BLZ12 dz_58_12 sky130_fd_pr_reram__reram_cell area_ox=0.0676
XMn_58_12 dn_58_12 WL58 SL12 VSS sky130_fd_pr__nfet_g5v0d10v5 w=1 l=0.5
XRn_58_12 BLN12 dn_58_12 sky130_fd_pr_reram__reram_cell area_ox=0.0676
XMp_58_13 dp_58_13 WL58 SL13 VSS sky130_fd_pr__nfet_g5v0d10v5 w=1 l=0.5
XRp_58_13 BLP13 dp_58_13 sky130_fd_pr_reram__reram_cell area_ox=0.0676
XMz_58_13 dz_58_13 WL58 SL13 VSS sky130_fd_pr__nfet_g5v0d10v5 w=1 l=0.5
XRz_58_13 BLZ13 dz_58_13 sky130_fd_pr_reram__reram_cell area_ox=0.0676
XMn_58_13 dn_58_13 WL58 SL13 VSS sky130_fd_pr__nfet_g5v0d10v5 w=1 l=0.5
XRn_58_13 BLN13 dn_58_13 sky130_fd_pr_reram__reram_cell area_ox=0.0676
XMp_58_14 dp_58_14 WL58 SL14 VSS sky130_fd_pr__nfet_g5v0d10v5 w=1 l=0.5
XRp_58_14 BLP14 dp_58_14 sky130_fd_pr_reram__reram_cell area_ox=0.0676
XMz_58_14 dz_58_14 WL58 SL14 VSS sky130_fd_pr__nfet_g5v0d10v5 w=1 l=0.5
XRz_58_14 BLZ14 dz_58_14 sky130_fd_pr_reram__reram_cell area_ox=0.0676
XMn_58_14 dn_58_14 WL58 SL14 VSS sky130_fd_pr__nfet_g5v0d10v5 w=1 l=0.5
XRn_58_14 BLN14 dn_58_14 sky130_fd_pr_reram__reram_cell area_ox=0.0676
XMp_58_15 dp_58_15 WL58 SL15 VSS sky130_fd_pr__nfet_g5v0d10v5 w=1 l=0.5
XRp_58_15 BLP15 dp_58_15 sky130_fd_pr_reram__reram_cell area_ox=0.0676
XMz_58_15 dz_58_15 WL58 SL15 VSS sky130_fd_pr__nfet_g5v0d10v5 w=1 l=0.5
XRz_58_15 BLZ15 dz_58_15 sky130_fd_pr_reram__reram_cell area_ox=0.0676
XMn_58_15 dn_58_15 WL58 SL15 VSS sky130_fd_pr__nfet_g5v0d10v5 w=1 l=0.5
XRn_58_15 BLN15 dn_58_15 sky130_fd_pr_reram__reram_cell area_ox=0.0676
XMp_58_16 dp_58_16 WL58 SL16 VSS sky130_fd_pr__nfet_g5v0d10v5 w=1 l=0.5
XRp_58_16 BLP16 dp_58_16 sky130_fd_pr_reram__reram_cell area_ox=0.0676
XMz_58_16 dz_58_16 WL58 SL16 VSS sky130_fd_pr__nfet_g5v0d10v5 w=1 l=0.5
XRz_58_16 BLZ16 dz_58_16 sky130_fd_pr_reram__reram_cell area_ox=0.0676
XMn_58_16 dn_58_16 WL58 SL16 VSS sky130_fd_pr__nfet_g5v0d10v5 w=1 l=0.5
XRn_58_16 BLN16 dn_58_16 sky130_fd_pr_reram__reram_cell area_ox=0.0676
XMp_58_17 dp_58_17 WL58 SL17 VSS sky130_fd_pr__nfet_g5v0d10v5 w=1 l=0.5
XRp_58_17 BLP17 dp_58_17 sky130_fd_pr_reram__reram_cell area_ox=0.0676
XMz_58_17 dz_58_17 WL58 SL17 VSS sky130_fd_pr__nfet_g5v0d10v5 w=1 l=0.5
XRz_58_17 BLZ17 dz_58_17 sky130_fd_pr_reram__reram_cell area_ox=0.0676
XMn_58_17 dn_58_17 WL58 SL17 VSS sky130_fd_pr__nfet_g5v0d10v5 w=1 l=0.5
XRn_58_17 BLN17 dn_58_17 sky130_fd_pr_reram__reram_cell area_ox=0.0676
XMp_58_18 dp_58_18 WL58 SL18 VSS sky130_fd_pr__nfet_g5v0d10v5 w=1 l=0.5
XRp_58_18 BLP18 dp_58_18 sky130_fd_pr_reram__reram_cell area_ox=0.0676
XMz_58_18 dz_58_18 WL58 SL18 VSS sky130_fd_pr__nfet_g5v0d10v5 w=1 l=0.5
XRz_58_18 BLZ18 dz_58_18 sky130_fd_pr_reram__reram_cell area_ox=0.0676
XMn_58_18 dn_58_18 WL58 SL18 VSS sky130_fd_pr__nfet_g5v0d10v5 w=1 l=0.5
XRn_58_18 BLN18 dn_58_18 sky130_fd_pr_reram__reram_cell area_ox=0.0676
XMp_58_19 dp_58_19 WL58 SL19 VSS sky130_fd_pr__nfet_g5v0d10v5 w=1 l=0.5
XRp_58_19 BLP19 dp_58_19 sky130_fd_pr_reram__reram_cell area_ox=0.0676
XMz_58_19 dz_58_19 WL58 SL19 VSS sky130_fd_pr__nfet_g5v0d10v5 w=1 l=0.5
XRz_58_19 BLZ19 dz_58_19 sky130_fd_pr_reram__reram_cell area_ox=0.0676
XMn_58_19 dn_58_19 WL58 SL19 VSS sky130_fd_pr__nfet_g5v0d10v5 w=1 l=0.5
XRn_58_19 BLN19 dn_58_19 sky130_fd_pr_reram__reram_cell area_ox=0.0676
XMp_58_20 dp_58_20 WL58 SL20 VSS sky130_fd_pr__nfet_g5v0d10v5 w=1 l=0.5
XRp_58_20 BLP20 dp_58_20 sky130_fd_pr_reram__reram_cell area_ox=0.0676
XMz_58_20 dz_58_20 WL58 SL20 VSS sky130_fd_pr__nfet_g5v0d10v5 w=1 l=0.5
XRz_58_20 BLZ20 dz_58_20 sky130_fd_pr_reram__reram_cell area_ox=0.0676
XMn_58_20 dn_58_20 WL58 SL20 VSS sky130_fd_pr__nfet_g5v0d10v5 w=1 l=0.5
XRn_58_20 BLN20 dn_58_20 sky130_fd_pr_reram__reram_cell area_ox=0.0676
XMp_58_21 dp_58_21 WL58 SL21 VSS sky130_fd_pr__nfet_g5v0d10v5 w=1 l=0.5
XRp_58_21 BLP21 dp_58_21 sky130_fd_pr_reram__reram_cell area_ox=0.0676
XMz_58_21 dz_58_21 WL58 SL21 VSS sky130_fd_pr__nfet_g5v0d10v5 w=1 l=0.5
XRz_58_21 BLZ21 dz_58_21 sky130_fd_pr_reram__reram_cell area_ox=0.0676
XMn_58_21 dn_58_21 WL58 SL21 VSS sky130_fd_pr__nfet_g5v0d10v5 w=1 l=0.5
XRn_58_21 BLN21 dn_58_21 sky130_fd_pr_reram__reram_cell area_ox=0.0676
XMp_58_22 dp_58_22 WL58 SL22 VSS sky130_fd_pr__nfet_g5v0d10v5 w=1 l=0.5
XRp_58_22 BLP22 dp_58_22 sky130_fd_pr_reram__reram_cell area_ox=0.0676
XMz_58_22 dz_58_22 WL58 SL22 VSS sky130_fd_pr__nfet_g5v0d10v5 w=1 l=0.5
XRz_58_22 BLZ22 dz_58_22 sky130_fd_pr_reram__reram_cell area_ox=0.0676
XMn_58_22 dn_58_22 WL58 SL22 VSS sky130_fd_pr__nfet_g5v0d10v5 w=1 l=0.5
XRn_58_22 BLN22 dn_58_22 sky130_fd_pr_reram__reram_cell area_ox=0.0676
XMp_58_23 dp_58_23 WL58 SL23 VSS sky130_fd_pr__nfet_g5v0d10v5 w=1 l=0.5
XRp_58_23 BLP23 dp_58_23 sky130_fd_pr_reram__reram_cell area_ox=0.0676
XMz_58_23 dz_58_23 WL58 SL23 VSS sky130_fd_pr__nfet_g5v0d10v5 w=1 l=0.5
XRz_58_23 BLZ23 dz_58_23 sky130_fd_pr_reram__reram_cell area_ox=0.0676
XMn_58_23 dn_58_23 WL58 SL23 VSS sky130_fd_pr__nfet_g5v0d10v5 w=1 l=0.5
XRn_58_23 BLN23 dn_58_23 sky130_fd_pr_reram__reram_cell area_ox=0.0676
XMp_59_0 dp_59_0 WL59 SL0 VSS sky130_fd_pr__nfet_g5v0d10v5 w=1 l=0.5
XRp_59_0 BLP0 dp_59_0 sky130_fd_pr_reram__reram_cell area_ox=0.0676
XMz_59_0 dz_59_0 WL59 SL0 VSS sky130_fd_pr__nfet_g5v0d10v5 w=1 l=0.5
XRz_59_0 BLZ0 dz_59_0 sky130_fd_pr_reram__reram_cell area_ox=0.0676
XMn_59_0 dn_59_0 WL59 SL0 VSS sky130_fd_pr__nfet_g5v0d10v5 w=1 l=0.5
XRn_59_0 BLN0 dn_59_0 sky130_fd_pr_reram__reram_cell area_ox=0.0676
XMp_59_1 dp_59_1 WL59 SL1 VSS sky130_fd_pr__nfet_g5v0d10v5 w=1 l=0.5
XRp_59_1 BLP1 dp_59_1 sky130_fd_pr_reram__reram_cell area_ox=0.0676
XMz_59_1 dz_59_1 WL59 SL1 VSS sky130_fd_pr__nfet_g5v0d10v5 w=1 l=0.5
XRz_59_1 BLZ1 dz_59_1 sky130_fd_pr_reram__reram_cell area_ox=0.0676
XMn_59_1 dn_59_1 WL59 SL1 VSS sky130_fd_pr__nfet_g5v0d10v5 w=1 l=0.5
XRn_59_1 BLN1 dn_59_1 sky130_fd_pr_reram__reram_cell area_ox=0.0676
XMp_59_2 dp_59_2 WL59 SL2 VSS sky130_fd_pr__nfet_g5v0d10v5 w=1 l=0.5
XRp_59_2 BLP2 dp_59_2 sky130_fd_pr_reram__reram_cell area_ox=0.0676
XMz_59_2 dz_59_2 WL59 SL2 VSS sky130_fd_pr__nfet_g5v0d10v5 w=1 l=0.5
XRz_59_2 BLZ2 dz_59_2 sky130_fd_pr_reram__reram_cell area_ox=0.0676
XMn_59_2 dn_59_2 WL59 SL2 VSS sky130_fd_pr__nfet_g5v0d10v5 w=1 l=0.5
XRn_59_2 BLN2 dn_59_2 sky130_fd_pr_reram__reram_cell area_ox=0.0676
XMp_59_3 dp_59_3 WL59 SL3 VSS sky130_fd_pr__nfet_g5v0d10v5 w=1 l=0.5
XRp_59_3 BLP3 dp_59_3 sky130_fd_pr_reram__reram_cell area_ox=0.0676
XMz_59_3 dz_59_3 WL59 SL3 VSS sky130_fd_pr__nfet_g5v0d10v5 w=1 l=0.5
XRz_59_3 BLZ3 dz_59_3 sky130_fd_pr_reram__reram_cell area_ox=0.0676
XMn_59_3 dn_59_3 WL59 SL3 VSS sky130_fd_pr__nfet_g5v0d10v5 w=1 l=0.5
XRn_59_3 BLN3 dn_59_3 sky130_fd_pr_reram__reram_cell area_ox=0.0676
XMp_59_4 dp_59_4 WL59 SL4 VSS sky130_fd_pr__nfet_g5v0d10v5 w=1 l=0.5
XRp_59_4 BLP4 dp_59_4 sky130_fd_pr_reram__reram_cell area_ox=0.0676
XMz_59_4 dz_59_4 WL59 SL4 VSS sky130_fd_pr__nfet_g5v0d10v5 w=1 l=0.5
XRz_59_4 BLZ4 dz_59_4 sky130_fd_pr_reram__reram_cell area_ox=0.0676
XMn_59_4 dn_59_4 WL59 SL4 VSS sky130_fd_pr__nfet_g5v0d10v5 w=1 l=0.5
XRn_59_4 BLN4 dn_59_4 sky130_fd_pr_reram__reram_cell area_ox=0.0676
XMp_59_5 dp_59_5 WL59 SL5 VSS sky130_fd_pr__nfet_g5v0d10v5 w=1 l=0.5
XRp_59_5 BLP5 dp_59_5 sky130_fd_pr_reram__reram_cell area_ox=0.0676
XMz_59_5 dz_59_5 WL59 SL5 VSS sky130_fd_pr__nfet_g5v0d10v5 w=1 l=0.5
XRz_59_5 BLZ5 dz_59_5 sky130_fd_pr_reram__reram_cell area_ox=0.0676
XMn_59_5 dn_59_5 WL59 SL5 VSS sky130_fd_pr__nfet_g5v0d10v5 w=1 l=0.5
XRn_59_5 BLN5 dn_59_5 sky130_fd_pr_reram__reram_cell area_ox=0.0676
XMp_59_6 dp_59_6 WL59 SL6 VSS sky130_fd_pr__nfet_g5v0d10v5 w=1 l=0.5
XRp_59_6 BLP6 dp_59_6 sky130_fd_pr_reram__reram_cell area_ox=0.0676
XMz_59_6 dz_59_6 WL59 SL6 VSS sky130_fd_pr__nfet_g5v0d10v5 w=1 l=0.5
XRz_59_6 BLZ6 dz_59_6 sky130_fd_pr_reram__reram_cell area_ox=0.0676
XMn_59_6 dn_59_6 WL59 SL6 VSS sky130_fd_pr__nfet_g5v0d10v5 w=1 l=0.5
XRn_59_6 BLN6 dn_59_6 sky130_fd_pr_reram__reram_cell area_ox=0.0676
XMp_59_7 dp_59_7 WL59 SL7 VSS sky130_fd_pr__nfet_g5v0d10v5 w=1 l=0.5
XRp_59_7 BLP7 dp_59_7 sky130_fd_pr_reram__reram_cell area_ox=0.0676
XMz_59_7 dz_59_7 WL59 SL7 VSS sky130_fd_pr__nfet_g5v0d10v5 w=1 l=0.5
XRz_59_7 BLZ7 dz_59_7 sky130_fd_pr_reram__reram_cell area_ox=0.0676
XMn_59_7 dn_59_7 WL59 SL7 VSS sky130_fd_pr__nfet_g5v0d10v5 w=1 l=0.5
XRn_59_7 BLN7 dn_59_7 sky130_fd_pr_reram__reram_cell area_ox=0.0676
XMp_59_8 dp_59_8 WL59 SL8 VSS sky130_fd_pr__nfet_g5v0d10v5 w=1 l=0.5
XRp_59_8 BLP8 dp_59_8 sky130_fd_pr_reram__reram_cell area_ox=0.0676
XMz_59_8 dz_59_8 WL59 SL8 VSS sky130_fd_pr__nfet_g5v0d10v5 w=1 l=0.5
XRz_59_8 BLZ8 dz_59_8 sky130_fd_pr_reram__reram_cell area_ox=0.0676
XMn_59_8 dn_59_8 WL59 SL8 VSS sky130_fd_pr__nfet_g5v0d10v5 w=1 l=0.5
XRn_59_8 BLN8 dn_59_8 sky130_fd_pr_reram__reram_cell area_ox=0.0676
XMp_59_9 dp_59_9 WL59 SL9 VSS sky130_fd_pr__nfet_g5v0d10v5 w=1 l=0.5
XRp_59_9 BLP9 dp_59_9 sky130_fd_pr_reram__reram_cell area_ox=0.0676
XMz_59_9 dz_59_9 WL59 SL9 VSS sky130_fd_pr__nfet_g5v0d10v5 w=1 l=0.5
XRz_59_9 BLZ9 dz_59_9 sky130_fd_pr_reram__reram_cell area_ox=0.0676
XMn_59_9 dn_59_9 WL59 SL9 VSS sky130_fd_pr__nfet_g5v0d10v5 w=1 l=0.5
XRn_59_9 BLN9 dn_59_9 sky130_fd_pr_reram__reram_cell area_ox=0.0676
XMp_59_10 dp_59_10 WL59 SL10 VSS sky130_fd_pr__nfet_g5v0d10v5 w=1 l=0.5
XRp_59_10 BLP10 dp_59_10 sky130_fd_pr_reram__reram_cell area_ox=0.0676
XMz_59_10 dz_59_10 WL59 SL10 VSS sky130_fd_pr__nfet_g5v0d10v5 w=1 l=0.5
XRz_59_10 BLZ10 dz_59_10 sky130_fd_pr_reram__reram_cell area_ox=0.0676
XMn_59_10 dn_59_10 WL59 SL10 VSS sky130_fd_pr__nfet_g5v0d10v5 w=1 l=0.5
XRn_59_10 BLN10 dn_59_10 sky130_fd_pr_reram__reram_cell area_ox=0.0676
XMp_59_11 dp_59_11 WL59 SL11 VSS sky130_fd_pr__nfet_g5v0d10v5 w=1 l=0.5
XRp_59_11 BLP11 dp_59_11 sky130_fd_pr_reram__reram_cell area_ox=0.0676
XMz_59_11 dz_59_11 WL59 SL11 VSS sky130_fd_pr__nfet_g5v0d10v5 w=1 l=0.5
XRz_59_11 BLZ11 dz_59_11 sky130_fd_pr_reram__reram_cell area_ox=0.0676
XMn_59_11 dn_59_11 WL59 SL11 VSS sky130_fd_pr__nfet_g5v0d10v5 w=1 l=0.5
XRn_59_11 BLN11 dn_59_11 sky130_fd_pr_reram__reram_cell area_ox=0.0676
XMp_59_12 dp_59_12 WL59 SL12 VSS sky130_fd_pr__nfet_g5v0d10v5 w=1 l=0.5
XRp_59_12 BLP12 dp_59_12 sky130_fd_pr_reram__reram_cell area_ox=0.0676
XMz_59_12 dz_59_12 WL59 SL12 VSS sky130_fd_pr__nfet_g5v0d10v5 w=1 l=0.5
XRz_59_12 BLZ12 dz_59_12 sky130_fd_pr_reram__reram_cell area_ox=0.0676
XMn_59_12 dn_59_12 WL59 SL12 VSS sky130_fd_pr__nfet_g5v0d10v5 w=1 l=0.5
XRn_59_12 BLN12 dn_59_12 sky130_fd_pr_reram__reram_cell area_ox=0.0676
XMp_59_13 dp_59_13 WL59 SL13 VSS sky130_fd_pr__nfet_g5v0d10v5 w=1 l=0.5
XRp_59_13 BLP13 dp_59_13 sky130_fd_pr_reram__reram_cell area_ox=0.0676
XMz_59_13 dz_59_13 WL59 SL13 VSS sky130_fd_pr__nfet_g5v0d10v5 w=1 l=0.5
XRz_59_13 BLZ13 dz_59_13 sky130_fd_pr_reram__reram_cell area_ox=0.0676
XMn_59_13 dn_59_13 WL59 SL13 VSS sky130_fd_pr__nfet_g5v0d10v5 w=1 l=0.5
XRn_59_13 BLN13 dn_59_13 sky130_fd_pr_reram__reram_cell area_ox=0.0676
XMp_59_14 dp_59_14 WL59 SL14 VSS sky130_fd_pr__nfet_g5v0d10v5 w=1 l=0.5
XRp_59_14 BLP14 dp_59_14 sky130_fd_pr_reram__reram_cell area_ox=0.0676
XMz_59_14 dz_59_14 WL59 SL14 VSS sky130_fd_pr__nfet_g5v0d10v5 w=1 l=0.5
XRz_59_14 BLZ14 dz_59_14 sky130_fd_pr_reram__reram_cell area_ox=0.0676
XMn_59_14 dn_59_14 WL59 SL14 VSS sky130_fd_pr__nfet_g5v0d10v5 w=1 l=0.5
XRn_59_14 BLN14 dn_59_14 sky130_fd_pr_reram__reram_cell area_ox=0.0676
XMp_59_15 dp_59_15 WL59 SL15 VSS sky130_fd_pr__nfet_g5v0d10v5 w=1 l=0.5
XRp_59_15 BLP15 dp_59_15 sky130_fd_pr_reram__reram_cell area_ox=0.0676
XMz_59_15 dz_59_15 WL59 SL15 VSS sky130_fd_pr__nfet_g5v0d10v5 w=1 l=0.5
XRz_59_15 BLZ15 dz_59_15 sky130_fd_pr_reram__reram_cell area_ox=0.0676
XMn_59_15 dn_59_15 WL59 SL15 VSS sky130_fd_pr__nfet_g5v0d10v5 w=1 l=0.5
XRn_59_15 BLN15 dn_59_15 sky130_fd_pr_reram__reram_cell area_ox=0.0676
XMp_59_16 dp_59_16 WL59 SL16 VSS sky130_fd_pr__nfet_g5v0d10v5 w=1 l=0.5
XRp_59_16 BLP16 dp_59_16 sky130_fd_pr_reram__reram_cell area_ox=0.0676
XMz_59_16 dz_59_16 WL59 SL16 VSS sky130_fd_pr__nfet_g5v0d10v5 w=1 l=0.5
XRz_59_16 BLZ16 dz_59_16 sky130_fd_pr_reram__reram_cell area_ox=0.0676
XMn_59_16 dn_59_16 WL59 SL16 VSS sky130_fd_pr__nfet_g5v0d10v5 w=1 l=0.5
XRn_59_16 BLN16 dn_59_16 sky130_fd_pr_reram__reram_cell area_ox=0.0676
XMp_59_17 dp_59_17 WL59 SL17 VSS sky130_fd_pr__nfet_g5v0d10v5 w=1 l=0.5
XRp_59_17 BLP17 dp_59_17 sky130_fd_pr_reram__reram_cell area_ox=0.0676
XMz_59_17 dz_59_17 WL59 SL17 VSS sky130_fd_pr__nfet_g5v0d10v5 w=1 l=0.5
XRz_59_17 BLZ17 dz_59_17 sky130_fd_pr_reram__reram_cell area_ox=0.0676
XMn_59_17 dn_59_17 WL59 SL17 VSS sky130_fd_pr__nfet_g5v0d10v5 w=1 l=0.5
XRn_59_17 BLN17 dn_59_17 sky130_fd_pr_reram__reram_cell area_ox=0.0676
XMp_59_18 dp_59_18 WL59 SL18 VSS sky130_fd_pr__nfet_g5v0d10v5 w=1 l=0.5
XRp_59_18 BLP18 dp_59_18 sky130_fd_pr_reram__reram_cell area_ox=0.0676
XMz_59_18 dz_59_18 WL59 SL18 VSS sky130_fd_pr__nfet_g5v0d10v5 w=1 l=0.5
XRz_59_18 BLZ18 dz_59_18 sky130_fd_pr_reram__reram_cell area_ox=0.0676
XMn_59_18 dn_59_18 WL59 SL18 VSS sky130_fd_pr__nfet_g5v0d10v5 w=1 l=0.5
XRn_59_18 BLN18 dn_59_18 sky130_fd_pr_reram__reram_cell area_ox=0.0676
XMp_59_19 dp_59_19 WL59 SL19 VSS sky130_fd_pr__nfet_g5v0d10v5 w=1 l=0.5
XRp_59_19 BLP19 dp_59_19 sky130_fd_pr_reram__reram_cell area_ox=0.0676
XMz_59_19 dz_59_19 WL59 SL19 VSS sky130_fd_pr__nfet_g5v0d10v5 w=1 l=0.5
XRz_59_19 BLZ19 dz_59_19 sky130_fd_pr_reram__reram_cell area_ox=0.0676
XMn_59_19 dn_59_19 WL59 SL19 VSS sky130_fd_pr__nfet_g5v0d10v5 w=1 l=0.5
XRn_59_19 BLN19 dn_59_19 sky130_fd_pr_reram__reram_cell area_ox=0.0676
XMp_59_20 dp_59_20 WL59 SL20 VSS sky130_fd_pr__nfet_g5v0d10v5 w=1 l=0.5
XRp_59_20 BLP20 dp_59_20 sky130_fd_pr_reram__reram_cell area_ox=0.0676
XMz_59_20 dz_59_20 WL59 SL20 VSS sky130_fd_pr__nfet_g5v0d10v5 w=1 l=0.5
XRz_59_20 BLZ20 dz_59_20 sky130_fd_pr_reram__reram_cell area_ox=0.0676
XMn_59_20 dn_59_20 WL59 SL20 VSS sky130_fd_pr__nfet_g5v0d10v5 w=1 l=0.5
XRn_59_20 BLN20 dn_59_20 sky130_fd_pr_reram__reram_cell area_ox=0.0676
XMp_59_21 dp_59_21 WL59 SL21 VSS sky130_fd_pr__nfet_g5v0d10v5 w=1 l=0.5
XRp_59_21 BLP21 dp_59_21 sky130_fd_pr_reram__reram_cell area_ox=0.0676
XMz_59_21 dz_59_21 WL59 SL21 VSS sky130_fd_pr__nfet_g5v0d10v5 w=1 l=0.5
XRz_59_21 BLZ21 dz_59_21 sky130_fd_pr_reram__reram_cell area_ox=0.0676
XMn_59_21 dn_59_21 WL59 SL21 VSS sky130_fd_pr__nfet_g5v0d10v5 w=1 l=0.5
XRn_59_21 BLN21 dn_59_21 sky130_fd_pr_reram__reram_cell area_ox=0.0676
XMp_59_22 dp_59_22 WL59 SL22 VSS sky130_fd_pr__nfet_g5v0d10v5 w=1 l=0.5
XRp_59_22 BLP22 dp_59_22 sky130_fd_pr_reram__reram_cell area_ox=0.0676
XMz_59_22 dz_59_22 WL59 SL22 VSS sky130_fd_pr__nfet_g5v0d10v5 w=1 l=0.5
XRz_59_22 BLZ22 dz_59_22 sky130_fd_pr_reram__reram_cell area_ox=0.0676
XMn_59_22 dn_59_22 WL59 SL22 VSS sky130_fd_pr__nfet_g5v0d10v5 w=1 l=0.5
XRn_59_22 BLN22 dn_59_22 sky130_fd_pr_reram__reram_cell area_ox=0.0676
XMp_59_23 dp_59_23 WL59 SL23 VSS sky130_fd_pr__nfet_g5v0d10v5 w=1 l=0.5
XRp_59_23 BLP23 dp_59_23 sky130_fd_pr_reram__reram_cell area_ox=0.0676
XMz_59_23 dz_59_23 WL59 SL23 VSS sky130_fd_pr__nfet_g5v0d10v5 w=1 l=0.5
XRz_59_23 BLZ23 dz_59_23 sky130_fd_pr_reram__reram_cell area_ox=0.0676
XMn_59_23 dn_59_23 WL59 SL23 VSS sky130_fd_pr__nfet_g5v0d10v5 w=1 l=0.5
XRn_59_23 BLN23 dn_59_23 sky130_fd_pr_reram__reram_cell area_ox=0.0676
XMp_60_0 dp_60_0 WL60 SL0 VSS sky130_fd_pr__nfet_g5v0d10v5 w=1 l=0.5
XRp_60_0 BLP0 dp_60_0 sky130_fd_pr_reram__reram_cell area_ox=0.0676
XMz_60_0 dz_60_0 WL60 SL0 VSS sky130_fd_pr__nfet_g5v0d10v5 w=1 l=0.5
XRz_60_0 BLZ0 dz_60_0 sky130_fd_pr_reram__reram_cell area_ox=0.0676
XMn_60_0 dn_60_0 WL60 SL0 VSS sky130_fd_pr__nfet_g5v0d10v5 w=1 l=0.5
XRn_60_0 BLN0 dn_60_0 sky130_fd_pr_reram__reram_cell area_ox=0.0676
XMp_60_1 dp_60_1 WL60 SL1 VSS sky130_fd_pr__nfet_g5v0d10v5 w=1 l=0.5
XRp_60_1 BLP1 dp_60_1 sky130_fd_pr_reram__reram_cell area_ox=0.0676
XMz_60_1 dz_60_1 WL60 SL1 VSS sky130_fd_pr__nfet_g5v0d10v5 w=1 l=0.5
XRz_60_1 BLZ1 dz_60_1 sky130_fd_pr_reram__reram_cell area_ox=0.0676
XMn_60_1 dn_60_1 WL60 SL1 VSS sky130_fd_pr__nfet_g5v0d10v5 w=1 l=0.5
XRn_60_1 BLN1 dn_60_1 sky130_fd_pr_reram__reram_cell area_ox=0.0676
XMp_60_2 dp_60_2 WL60 SL2 VSS sky130_fd_pr__nfet_g5v0d10v5 w=1 l=0.5
XRp_60_2 BLP2 dp_60_2 sky130_fd_pr_reram__reram_cell area_ox=0.0676
XMz_60_2 dz_60_2 WL60 SL2 VSS sky130_fd_pr__nfet_g5v0d10v5 w=1 l=0.5
XRz_60_2 BLZ2 dz_60_2 sky130_fd_pr_reram__reram_cell area_ox=0.0676
XMn_60_2 dn_60_2 WL60 SL2 VSS sky130_fd_pr__nfet_g5v0d10v5 w=1 l=0.5
XRn_60_2 BLN2 dn_60_2 sky130_fd_pr_reram__reram_cell area_ox=0.0676
XMp_60_3 dp_60_3 WL60 SL3 VSS sky130_fd_pr__nfet_g5v0d10v5 w=1 l=0.5
XRp_60_3 BLP3 dp_60_3 sky130_fd_pr_reram__reram_cell area_ox=0.0676
XMz_60_3 dz_60_3 WL60 SL3 VSS sky130_fd_pr__nfet_g5v0d10v5 w=1 l=0.5
XRz_60_3 BLZ3 dz_60_3 sky130_fd_pr_reram__reram_cell area_ox=0.0676
XMn_60_3 dn_60_3 WL60 SL3 VSS sky130_fd_pr__nfet_g5v0d10v5 w=1 l=0.5
XRn_60_3 BLN3 dn_60_3 sky130_fd_pr_reram__reram_cell area_ox=0.0676
XMp_60_4 dp_60_4 WL60 SL4 VSS sky130_fd_pr__nfet_g5v0d10v5 w=1 l=0.5
XRp_60_4 BLP4 dp_60_4 sky130_fd_pr_reram__reram_cell area_ox=0.0676
XMz_60_4 dz_60_4 WL60 SL4 VSS sky130_fd_pr__nfet_g5v0d10v5 w=1 l=0.5
XRz_60_4 BLZ4 dz_60_4 sky130_fd_pr_reram__reram_cell area_ox=0.0676
XMn_60_4 dn_60_4 WL60 SL4 VSS sky130_fd_pr__nfet_g5v0d10v5 w=1 l=0.5
XRn_60_4 BLN4 dn_60_4 sky130_fd_pr_reram__reram_cell area_ox=0.0676
XMp_60_5 dp_60_5 WL60 SL5 VSS sky130_fd_pr__nfet_g5v0d10v5 w=1 l=0.5
XRp_60_5 BLP5 dp_60_5 sky130_fd_pr_reram__reram_cell area_ox=0.0676
XMz_60_5 dz_60_5 WL60 SL5 VSS sky130_fd_pr__nfet_g5v0d10v5 w=1 l=0.5
XRz_60_5 BLZ5 dz_60_5 sky130_fd_pr_reram__reram_cell area_ox=0.0676
XMn_60_5 dn_60_5 WL60 SL5 VSS sky130_fd_pr__nfet_g5v0d10v5 w=1 l=0.5
XRn_60_5 BLN5 dn_60_5 sky130_fd_pr_reram__reram_cell area_ox=0.0676
XMp_60_6 dp_60_6 WL60 SL6 VSS sky130_fd_pr__nfet_g5v0d10v5 w=1 l=0.5
XRp_60_6 BLP6 dp_60_6 sky130_fd_pr_reram__reram_cell area_ox=0.0676
XMz_60_6 dz_60_6 WL60 SL6 VSS sky130_fd_pr__nfet_g5v0d10v5 w=1 l=0.5
XRz_60_6 BLZ6 dz_60_6 sky130_fd_pr_reram__reram_cell area_ox=0.0676
XMn_60_6 dn_60_6 WL60 SL6 VSS sky130_fd_pr__nfet_g5v0d10v5 w=1 l=0.5
XRn_60_6 BLN6 dn_60_6 sky130_fd_pr_reram__reram_cell area_ox=0.0676
XMp_60_7 dp_60_7 WL60 SL7 VSS sky130_fd_pr__nfet_g5v0d10v5 w=1 l=0.5
XRp_60_7 BLP7 dp_60_7 sky130_fd_pr_reram__reram_cell area_ox=0.0676
XMz_60_7 dz_60_7 WL60 SL7 VSS sky130_fd_pr__nfet_g5v0d10v5 w=1 l=0.5
XRz_60_7 BLZ7 dz_60_7 sky130_fd_pr_reram__reram_cell area_ox=0.0676
XMn_60_7 dn_60_7 WL60 SL7 VSS sky130_fd_pr__nfet_g5v0d10v5 w=1 l=0.5
XRn_60_7 BLN7 dn_60_7 sky130_fd_pr_reram__reram_cell area_ox=0.0676
XMp_60_8 dp_60_8 WL60 SL8 VSS sky130_fd_pr__nfet_g5v0d10v5 w=1 l=0.5
XRp_60_8 BLP8 dp_60_8 sky130_fd_pr_reram__reram_cell area_ox=0.0676
XMz_60_8 dz_60_8 WL60 SL8 VSS sky130_fd_pr__nfet_g5v0d10v5 w=1 l=0.5
XRz_60_8 BLZ8 dz_60_8 sky130_fd_pr_reram__reram_cell area_ox=0.0676
XMn_60_8 dn_60_8 WL60 SL8 VSS sky130_fd_pr__nfet_g5v0d10v5 w=1 l=0.5
XRn_60_8 BLN8 dn_60_8 sky130_fd_pr_reram__reram_cell area_ox=0.0676
XMp_60_9 dp_60_9 WL60 SL9 VSS sky130_fd_pr__nfet_g5v0d10v5 w=1 l=0.5
XRp_60_9 BLP9 dp_60_9 sky130_fd_pr_reram__reram_cell area_ox=0.0676
XMz_60_9 dz_60_9 WL60 SL9 VSS sky130_fd_pr__nfet_g5v0d10v5 w=1 l=0.5
XRz_60_9 BLZ9 dz_60_9 sky130_fd_pr_reram__reram_cell area_ox=0.0676
XMn_60_9 dn_60_9 WL60 SL9 VSS sky130_fd_pr__nfet_g5v0d10v5 w=1 l=0.5
XRn_60_9 BLN9 dn_60_9 sky130_fd_pr_reram__reram_cell area_ox=0.0676
XMp_60_10 dp_60_10 WL60 SL10 VSS sky130_fd_pr__nfet_g5v0d10v5 w=1 l=0.5
XRp_60_10 BLP10 dp_60_10 sky130_fd_pr_reram__reram_cell area_ox=0.0676
XMz_60_10 dz_60_10 WL60 SL10 VSS sky130_fd_pr__nfet_g5v0d10v5 w=1 l=0.5
XRz_60_10 BLZ10 dz_60_10 sky130_fd_pr_reram__reram_cell area_ox=0.0676
XMn_60_10 dn_60_10 WL60 SL10 VSS sky130_fd_pr__nfet_g5v0d10v5 w=1 l=0.5
XRn_60_10 BLN10 dn_60_10 sky130_fd_pr_reram__reram_cell area_ox=0.0676
XMp_60_11 dp_60_11 WL60 SL11 VSS sky130_fd_pr__nfet_g5v0d10v5 w=1 l=0.5
XRp_60_11 BLP11 dp_60_11 sky130_fd_pr_reram__reram_cell area_ox=0.0676
XMz_60_11 dz_60_11 WL60 SL11 VSS sky130_fd_pr__nfet_g5v0d10v5 w=1 l=0.5
XRz_60_11 BLZ11 dz_60_11 sky130_fd_pr_reram__reram_cell area_ox=0.0676
XMn_60_11 dn_60_11 WL60 SL11 VSS sky130_fd_pr__nfet_g5v0d10v5 w=1 l=0.5
XRn_60_11 BLN11 dn_60_11 sky130_fd_pr_reram__reram_cell area_ox=0.0676
XMp_60_12 dp_60_12 WL60 SL12 VSS sky130_fd_pr__nfet_g5v0d10v5 w=1 l=0.5
XRp_60_12 BLP12 dp_60_12 sky130_fd_pr_reram__reram_cell area_ox=0.0676
XMz_60_12 dz_60_12 WL60 SL12 VSS sky130_fd_pr__nfet_g5v0d10v5 w=1 l=0.5
XRz_60_12 BLZ12 dz_60_12 sky130_fd_pr_reram__reram_cell area_ox=0.0676
XMn_60_12 dn_60_12 WL60 SL12 VSS sky130_fd_pr__nfet_g5v0d10v5 w=1 l=0.5
XRn_60_12 BLN12 dn_60_12 sky130_fd_pr_reram__reram_cell area_ox=0.0676
XMp_60_13 dp_60_13 WL60 SL13 VSS sky130_fd_pr__nfet_g5v0d10v5 w=1 l=0.5
XRp_60_13 BLP13 dp_60_13 sky130_fd_pr_reram__reram_cell area_ox=0.0676
XMz_60_13 dz_60_13 WL60 SL13 VSS sky130_fd_pr__nfet_g5v0d10v5 w=1 l=0.5
XRz_60_13 BLZ13 dz_60_13 sky130_fd_pr_reram__reram_cell area_ox=0.0676
XMn_60_13 dn_60_13 WL60 SL13 VSS sky130_fd_pr__nfet_g5v0d10v5 w=1 l=0.5
XRn_60_13 BLN13 dn_60_13 sky130_fd_pr_reram__reram_cell area_ox=0.0676
XMp_60_14 dp_60_14 WL60 SL14 VSS sky130_fd_pr__nfet_g5v0d10v5 w=1 l=0.5
XRp_60_14 BLP14 dp_60_14 sky130_fd_pr_reram__reram_cell area_ox=0.0676
XMz_60_14 dz_60_14 WL60 SL14 VSS sky130_fd_pr__nfet_g5v0d10v5 w=1 l=0.5
XRz_60_14 BLZ14 dz_60_14 sky130_fd_pr_reram__reram_cell area_ox=0.0676
XMn_60_14 dn_60_14 WL60 SL14 VSS sky130_fd_pr__nfet_g5v0d10v5 w=1 l=0.5
XRn_60_14 BLN14 dn_60_14 sky130_fd_pr_reram__reram_cell area_ox=0.0676
XMp_60_15 dp_60_15 WL60 SL15 VSS sky130_fd_pr__nfet_g5v0d10v5 w=1 l=0.5
XRp_60_15 BLP15 dp_60_15 sky130_fd_pr_reram__reram_cell area_ox=0.0676
XMz_60_15 dz_60_15 WL60 SL15 VSS sky130_fd_pr__nfet_g5v0d10v5 w=1 l=0.5
XRz_60_15 BLZ15 dz_60_15 sky130_fd_pr_reram__reram_cell area_ox=0.0676
XMn_60_15 dn_60_15 WL60 SL15 VSS sky130_fd_pr__nfet_g5v0d10v5 w=1 l=0.5
XRn_60_15 BLN15 dn_60_15 sky130_fd_pr_reram__reram_cell area_ox=0.0676
XMp_60_16 dp_60_16 WL60 SL16 VSS sky130_fd_pr__nfet_g5v0d10v5 w=1 l=0.5
XRp_60_16 BLP16 dp_60_16 sky130_fd_pr_reram__reram_cell area_ox=0.0676
XMz_60_16 dz_60_16 WL60 SL16 VSS sky130_fd_pr__nfet_g5v0d10v5 w=1 l=0.5
XRz_60_16 BLZ16 dz_60_16 sky130_fd_pr_reram__reram_cell area_ox=0.0676
XMn_60_16 dn_60_16 WL60 SL16 VSS sky130_fd_pr__nfet_g5v0d10v5 w=1 l=0.5
XRn_60_16 BLN16 dn_60_16 sky130_fd_pr_reram__reram_cell area_ox=0.0676
XMp_60_17 dp_60_17 WL60 SL17 VSS sky130_fd_pr__nfet_g5v0d10v5 w=1 l=0.5
XRp_60_17 BLP17 dp_60_17 sky130_fd_pr_reram__reram_cell area_ox=0.0676
XMz_60_17 dz_60_17 WL60 SL17 VSS sky130_fd_pr__nfet_g5v0d10v5 w=1 l=0.5
XRz_60_17 BLZ17 dz_60_17 sky130_fd_pr_reram__reram_cell area_ox=0.0676
XMn_60_17 dn_60_17 WL60 SL17 VSS sky130_fd_pr__nfet_g5v0d10v5 w=1 l=0.5
XRn_60_17 BLN17 dn_60_17 sky130_fd_pr_reram__reram_cell area_ox=0.0676
XMp_60_18 dp_60_18 WL60 SL18 VSS sky130_fd_pr__nfet_g5v0d10v5 w=1 l=0.5
XRp_60_18 BLP18 dp_60_18 sky130_fd_pr_reram__reram_cell area_ox=0.0676
XMz_60_18 dz_60_18 WL60 SL18 VSS sky130_fd_pr__nfet_g5v0d10v5 w=1 l=0.5
XRz_60_18 BLZ18 dz_60_18 sky130_fd_pr_reram__reram_cell area_ox=0.0676
XMn_60_18 dn_60_18 WL60 SL18 VSS sky130_fd_pr__nfet_g5v0d10v5 w=1 l=0.5
XRn_60_18 BLN18 dn_60_18 sky130_fd_pr_reram__reram_cell area_ox=0.0676
XMp_60_19 dp_60_19 WL60 SL19 VSS sky130_fd_pr__nfet_g5v0d10v5 w=1 l=0.5
XRp_60_19 BLP19 dp_60_19 sky130_fd_pr_reram__reram_cell area_ox=0.0676
XMz_60_19 dz_60_19 WL60 SL19 VSS sky130_fd_pr__nfet_g5v0d10v5 w=1 l=0.5
XRz_60_19 BLZ19 dz_60_19 sky130_fd_pr_reram__reram_cell area_ox=0.0676
XMn_60_19 dn_60_19 WL60 SL19 VSS sky130_fd_pr__nfet_g5v0d10v5 w=1 l=0.5
XRn_60_19 BLN19 dn_60_19 sky130_fd_pr_reram__reram_cell area_ox=0.0676
XMp_60_20 dp_60_20 WL60 SL20 VSS sky130_fd_pr__nfet_g5v0d10v5 w=1 l=0.5
XRp_60_20 BLP20 dp_60_20 sky130_fd_pr_reram__reram_cell area_ox=0.0676
XMz_60_20 dz_60_20 WL60 SL20 VSS sky130_fd_pr__nfet_g5v0d10v5 w=1 l=0.5
XRz_60_20 BLZ20 dz_60_20 sky130_fd_pr_reram__reram_cell area_ox=0.0676
XMn_60_20 dn_60_20 WL60 SL20 VSS sky130_fd_pr__nfet_g5v0d10v5 w=1 l=0.5
XRn_60_20 BLN20 dn_60_20 sky130_fd_pr_reram__reram_cell area_ox=0.0676
XMp_60_21 dp_60_21 WL60 SL21 VSS sky130_fd_pr__nfet_g5v0d10v5 w=1 l=0.5
XRp_60_21 BLP21 dp_60_21 sky130_fd_pr_reram__reram_cell area_ox=0.0676
XMz_60_21 dz_60_21 WL60 SL21 VSS sky130_fd_pr__nfet_g5v0d10v5 w=1 l=0.5
XRz_60_21 BLZ21 dz_60_21 sky130_fd_pr_reram__reram_cell area_ox=0.0676
XMn_60_21 dn_60_21 WL60 SL21 VSS sky130_fd_pr__nfet_g5v0d10v5 w=1 l=0.5
XRn_60_21 BLN21 dn_60_21 sky130_fd_pr_reram__reram_cell area_ox=0.0676
XMp_60_22 dp_60_22 WL60 SL22 VSS sky130_fd_pr__nfet_g5v0d10v5 w=1 l=0.5
XRp_60_22 BLP22 dp_60_22 sky130_fd_pr_reram__reram_cell area_ox=0.0676
XMz_60_22 dz_60_22 WL60 SL22 VSS sky130_fd_pr__nfet_g5v0d10v5 w=1 l=0.5
XRz_60_22 BLZ22 dz_60_22 sky130_fd_pr_reram__reram_cell area_ox=0.0676
XMn_60_22 dn_60_22 WL60 SL22 VSS sky130_fd_pr__nfet_g5v0d10v5 w=1 l=0.5
XRn_60_22 BLN22 dn_60_22 sky130_fd_pr_reram__reram_cell area_ox=0.0676
XMp_60_23 dp_60_23 WL60 SL23 VSS sky130_fd_pr__nfet_g5v0d10v5 w=1 l=0.5
XRp_60_23 BLP23 dp_60_23 sky130_fd_pr_reram__reram_cell area_ox=0.0676
XMz_60_23 dz_60_23 WL60 SL23 VSS sky130_fd_pr__nfet_g5v0d10v5 w=1 l=0.5
XRz_60_23 BLZ23 dz_60_23 sky130_fd_pr_reram__reram_cell area_ox=0.0676
XMn_60_23 dn_60_23 WL60 SL23 VSS sky130_fd_pr__nfet_g5v0d10v5 w=1 l=0.5
XRn_60_23 BLN23 dn_60_23 sky130_fd_pr_reram__reram_cell area_ox=0.0676
XMp_61_0 dp_61_0 WL61 SL0 VSS sky130_fd_pr__nfet_g5v0d10v5 w=1 l=0.5
XRp_61_0 BLP0 dp_61_0 sky130_fd_pr_reram__reram_cell area_ox=0.0676
XMz_61_0 dz_61_0 WL61 SL0 VSS sky130_fd_pr__nfet_g5v0d10v5 w=1 l=0.5
XRz_61_0 BLZ0 dz_61_0 sky130_fd_pr_reram__reram_cell area_ox=0.0676
XMn_61_0 dn_61_0 WL61 SL0 VSS sky130_fd_pr__nfet_g5v0d10v5 w=1 l=0.5
XRn_61_0 BLN0 dn_61_0 sky130_fd_pr_reram__reram_cell area_ox=0.0676
XMp_61_1 dp_61_1 WL61 SL1 VSS sky130_fd_pr__nfet_g5v0d10v5 w=1 l=0.5
XRp_61_1 BLP1 dp_61_1 sky130_fd_pr_reram__reram_cell area_ox=0.0676
XMz_61_1 dz_61_1 WL61 SL1 VSS sky130_fd_pr__nfet_g5v0d10v5 w=1 l=0.5
XRz_61_1 BLZ1 dz_61_1 sky130_fd_pr_reram__reram_cell area_ox=0.0676
XMn_61_1 dn_61_1 WL61 SL1 VSS sky130_fd_pr__nfet_g5v0d10v5 w=1 l=0.5
XRn_61_1 BLN1 dn_61_1 sky130_fd_pr_reram__reram_cell area_ox=0.0676
XMp_61_2 dp_61_2 WL61 SL2 VSS sky130_fd_pr__nfet_g5v0d10v5 w=1 l=0.5
XRp_61_2 BLP2 dp_61_2 sky130_fd_pr_reram__reram_cell area_ox=0.0676
XMz_61_2 dz_61_2 WL61 SL2 VSS sky130_fd_pr__nfet_g5v0d10v5 w=1 l=0.5
XRz_61_2 BLZ2 dz_61_2 sky130_fd_pr_reram__reram_cell area_ox=0.0676
XMn_61_2 dn_61_2 WL61 SL2 VSS sky130_fd_pr__nfet_g5v0d10v5 w=1 l=0.5
XRn_61_2 BLN2 dn_61_2 sky130_fd_pr_reram__reram_cell area_ox=0.0676
XMp_61_3 dp_61_3 WL61 SL3 VSS sky130_fd_pr__nfet_g5v0d10v5 w=1 l=0.5
XRp_61_3 BLP3 dp_61_3 sky130_fd_pr_reram__reram_cell area_ox=0.0676
XMz_61_3 dz_61_3 WL61 SL3 VSS sky130_fd_pr__nfet_g5v0d10v5 w=1 l=0.5
XRz_61_3 BLZ3 dz_61_3 sky130_fd_pr_reram__reram_cell area_ox=0.0676
XMn_61_3 dn_61_3 WL61 SL3 VSS sky130_fd_pr__nfet_g5v0d10v5 w=1 l=0.5
XRn_61_3 BLN3 dn_61_3 sky130_fd_pr_reram__reram_cell area_ox=0.0676
XMp_61_4 dp_61_4 WL61 SL4 VSS sky130_fd_pr__nfet_g5v0d10v5 w=1 l=0.5
XRp_61_4 BLP4 dp_61_4 sky130_fd_pr_reram__reram_cell area_ox=0.0676
XMz_61_4 dz_61_4 WL61 SL4 VSS sky130_fd_pr__nfet_g5v0d10v5 w=1 l=0.5
XRz_61_4 BLZ4 dz_61_4 sky130_fd_pr_reram__reram_cell area_ox=0.0676
XMn_61_4 dn_61_4 WL61 SL4 VSS sky130_fd_pr__nfet_g5v0d10v5 w=1 l=0.5
XRn_61_4 BLN4 dn_61_4 sky130_fd_pr_reram__reram_cell area_ox=0.0676
XMp_61_5 dp_61_5 WL61 SL5 VSS sky130_fd_pr__nfet_g5v0d10v5 w=1 l=0.5
XRp_61_5 BLP5 dp_61_5 sky130_fd_pr_reram__reram_cell area_ox=0.0676
XMz_61_5 dz_61_5 WL61 SL5 VSS sky130_fd_pr__nfet_g5v0d10v5 w=1 l=0.5
XRz_61_5 BLZ5 dz_61_5 sky130_fd_pr_reram__reram_cell area_ox=0.0676
XMn_61_5 dn_61_5 WL61 SL5 VSS sky130_fd_pr__nfet_g5v0d10v5 w=1 l=0.5
XRn_61_5 BLN5 dn_61_5 sky130_fd_pr_reram__reram_cell area_ox=0.0676
XMp_61_6 dp_61_6 WL61 SL6 VSS sky130_fd_pr__nfet_g5v0d10v5 w=1 l=0.5
XRp_61_6 BLP6 dp_61_6 sky130_fd_pr_reram__reram_cell area_ox=0.0676
XMz_61_6 dz_61_6 WL61 SL6 VSS sky130_fd_pr__nfet_g5v0d10v5 w=1 l=0.5
XRz_61_6 BLZ6 dz_61_6 sky130_fd_pr_reram__reram_cell area_ox=0.0676
XMn_61_6 dn_61_6 WL61 SL6 VSS sky130_fd_pr__nfet_g5v0d10v5 w=1 l=0.5
XRn_61_6 BLN6 dn_61_6 sky130_fd_pr_reram__reram_cell area_ox=0.0676
XMp_61_7 dp_61_7 WL61 SL7 VSS sky130_fd_pr__nfet_g5v0d10v5 w=1 l=0.5
XRp_61_7 BLP7 dp_61_7 sky130_fd_pr_reram__reram_cell area_ox=0.0676
XMz_61_7 dz_61_7 WL61 SL7 VSS sky130_fd_pr__nfet_g5v0d10v5 w=1 l=0.5
XRz_61_7 BLZ7 dz_61_7 sky130_fd_pr_reram__reram_cell area_ox=0.0676
XMn_61_7 dn_61_7 WL61 SL7 VSS sky130_fd_pr__nfet_g5v0d10v5 w=1 l=0.5
XRn_61_7 BLN7 dn_61_7 sky130_fd_pr_reram__reram_cell area_ox=0.0676
XMp_61_8 dp_61_8 WL61 SL8 VSS sky130_fd_pr__nfet_g5v0d10v5 w=1 l=0.5
XRp_61_8 BLP8 dp_61_8 sky130_fd_pr_reram__reram_cell area_ox=0.0676
XMz_61_8 dz_61_8 WL61 SL8 VSS sky130_fd_pr__nfet_g5v0d10v5 w=1 l=0.5
XRz_61_8 BLZ8 dz_61_8 sky130_fd_pr_reram__reram_cell area_ox=0.0676
XMn_61_8 dn_61_8 WL61 SL8 VSS sky130_fd_pr__nfet_g5v0d10v5 w=1 l=0.5
XRn_61_8 BLN8 dn_61_8 sky130_fd_pr_reram__reram_cell area_ox=0.0676
XMp_61_9 dp_61_9 WL61 SL9 VSS sky130_fd_pr__nfet_g5v0d10v5 w=1 l=0.5
XRp_61_9 BLP9 dp_61_9 sky130_fd_pr_reram__reram_cell area_ox=0.0676
XMz_61_9 dz_61_9 WL61 SL9 VSS sky130_fd_pr__nfet_g5v0d10v5 w=1 l=0.5
XRz_61_9 BLZ9 dz_61_9 sky130_fd_pr_reram__reram_cell area_ox=0.0676
XMn_61_9 dn_61_9 WL61 SL9 VSS sky130_fd_pr__nfet_g5v0d10v5 w=1 l=0.5
XRn_61_9 BLN9 dn_61_9 sky130_fd_pr_reram__reram_cell area_ox=0.0676
XMp_61_10 dp_61_10 WL61 SL10 VSS sky130_fd_pr__nfet_g5v0d10v5 w=1 l=0.5
XRp_61_10 BLP10 dp_61_10 sky130_fd_pr_reram__reram_cell area_ox=0.0676
XMz_61_10 dz_61_10 WL61 SL10 VSS sky130_fd_pr__nfet_g5v0d10v5 w=1 l=0.5
XRz_61_10 BLZ10 dz_61_10 sky130_fd_pr_reram__reram_cell area_ox=0.0676
XMn_61_10 dn_61_10 WL61 SL10 VSS sky130_fd_pr__nfet_g5v0d10v5 w=1 l=0.5
XRn_61_10 BLN10 dn_61_10 sky130_fd_pr_reram__reram_cell area_ox=0.0676
XMp_61_11 dp_61_11 WL61 SL11 VSS sky130_fd_pr__nfet_g5v0d10v5 w=1 l=0.5
XRp_61_11 BLP11 dp_61_11 sky130_fd_pr_reram__reram_cell area_ox=0.0676
XMz_61_11 dz_61_11 WL61 SL11 VSS sky130_fd_pr__nfet_g5v0d10v5 w=1 l=0.5
XRz_61_11 BLZ11 dz_61_11 sky130_fd_pr_reram__reram_cell area_ox=0.0676
XMn_61_11 dn_61_11 WL61 SL11 VSS sky130_fd_pr__nfet_g5v0d10v5 w=1 l=0.5
XRn_61_11 BLN11 dn_61_11 sky130_fd_pr_reram__reram_cell area_ox=0.0676
XMp_61_12 dp_61_12 WL61 SL12 VSS sky130_fd_pr__nfet_g5v0d10v5 w=1 l=0.5
XRp_61_12 BLP12 dp_61_12 sky130_fd_pr_reram__reram_cell area_ox=0.0676
XMz_61_12 dz_61_12 WL61 SL12 VSS sky130_fd_pr__nfet_g5v0d10v5 w=1 l=0.5
XRz_61_12 BLZ12 dz_61_12 sky130_fd_pr_reram__reram_cell area_ox=0.0676
XMn_61_12 dn_61_12 WL61 SL12 VSS sky130_fd_pr__nfet_g5v0d10v5 w=1 l=0.5
XRn_61_12 BLN12 dn_61_12 sky130_fd_pr_reram__reram_cell area_ox=0.0676
XMp_61_13 dp_61_13 WL61 SL13 VSS sky130_fd_pr__nfet_g5v0d10v5 w=1 l=0.5
XRp_61_13 BLP13 dp_61_13 sky130_fd_pr_reram__reram_cell area_ox=0.0676
XMz_61_13 dz_61_13 WL61 SL13 VSS sky130_fd_pr__nfet_g5v0d10v5 w=1 l=0.5
XRz_61_13 BLZ13 dz_61_13 sky130_fd_pr_reram__reram_cell area_ox=0.0676
XMn_61_13 dn_61_13 WL61 SL13 VSS sky130_fd_pr__nfet_g5v0d10v5 w=1 l=0.5
XRn_61_13 BLN13 dn_61_13 sky130_fd_pr_reram__reram_cell area_ox=0.0676
XMp_61_14 dp_61_14 WL61 SL14 VSS sky130_fd_pr__nfet_g5v0d10v5 w=1 l=0.5
XRp_61_14 BLP14 dp_61_14 sky130_fd_pr_reram__reram_cell area_ox=0.0676
XMz_61_14 dz_61_14 WL61 SL14 VSS sky130_fd_pr__nfet_g5v0d10v5 w=1 l=0.5
XRz_61_14 BLZ14 dz_61_14 sky130_fd_pr_reram__reram_cell area_ox=0.0676
XMn_61_14 dn_61_14 WL61 SL14 VSS sky130_fd_pr__nfet_g5v0d10v5 w=1 l=0.5
XRn_61_14 BLN14 dn_61_14 sky130_fd_pr_reram__reram_cell area_ox=0.0676
XMp_61_15 dp_61_15 WL61 SL15 VSS sky130_fd_pr__nfet_g5v0d10v5 w=1 l=0.5
XRp_61_15 BLP15 dp_61_15 sky130_fd_pr_reram__reram_cell area_ox=0.0676
XMz_61_15 dz_61_15 WL61 SL15 VSS sky130_fd_pr__nfet_g5v0d10v5 w=1 l=0.5
XRz_61_15 BLZ15 dz_61_15 sky130_fd_pr_reram__reram_cell area_ox=0.0676
XMn_61_15 dn_61_15 WL61 SL15 VSS sky130_fd_pr__nfet_g5v0d10v5 w=1 l=0.5
XRn_61_15 BLN15 dn_61_15 sky130_fd_pr_reram__reram_cell area_ox=0.0676
XMp_61_16 dp_61_16 WL61 SL16 VSS sky130_fd_pr__nfet_g5v0d10v5 w=1 l=0.5
XRp_61_16 BLP16 dp_61_16 sky130_fd_pr_reram__reram_cell area_ox=0.0676
XMz_61_16 dz_61_16 WL61 SL16 VSS sky130_fd_pr__nfet_g5v0d10v5 w=1 l=0.5
XRz_61_16 BLZ16 dz_61_16 sky130_fd_pr_reram__reram_cell area_ox=0.0676
XMn_61_16 dn_61_16 WL61 SL16 VSS sky130_fd_pr__nfet_g5v0d10v5 w=1 l=0.5
XRn_61_16 BLN16 dn_61_16 sky130_fd_pr_reram__reram_cell area_ox=0.0676
XMp_61_17 dp_61_17 WL61 SL17 VSS sky130_fd_pr__nfet_g5v0d10v5 w=1 l=0.5
XRp_61_17 BLP17 dp_61_17 sky130_fd_pr_reram__reram_cell area_ox=0.0676
XMz_61_17 dz_61_17 WL61 SL17 VSS sky130_fd_pr__nfet_g5v0d10v5 w=1 l=0.5
XRz_61_17 BLZ17 dz_61_17 sky130_fd_pr_reram__reram_cell area_ox=0.0676
XMn_61_17 dn_61_17 WL61 SL17 VSS sky130_fd_pr__nfet_g5v0d10v5 w=1 l=0.5
XRn_61_17 BLN17 dn_61_17 sky130_fd_pr_reram__reram_cell area_ox=0.0676
XMp_61_18 dp_61_18 WL61 SL18 VSS sky130_fd_pr__nfet_g5v0d10v5 w=1 l=0.5
XRp_61_18 BLP18 dp_61_18 sky130_fd_pr_reram__reram_cell area_ox=0.0676
XMz_61_18 dz_61_18 WL61 SL18 VSS sky130_fd_pr__nfet_g5v0d10v5 w=1 l=0.5
XRz_61_18 BLZ18 dz_61_18 sky130_fd_pr_reram__reram_cell area_ox=0.0676
XMn_61_18 dn_61_18 WL61 SL18 VSS sky130_fd_pr__nfet_g5v0d10v5 w=1 l=0.5
XRn_61_18 BLN18 dn_61_18 sky130_fd_pr_reram__reram_cell area_ox=0.0676
XMp_61_19 dp_61_19 WL61 SL19 VSS sky130_fd_pr__nfet_g5v0d10v5 w=1 l=0.5
XRp_61_19 BLP19 dp_61_19 sky130_fd_pr_reram__reram_cell area_ox=0.0676
XMz_61_19 dz_61_19 WL61 SL19 VSS sky130_fd_pr__nfet_g5v0d10v5 w=1 l=0.5
XRz_61_19 BLZ19 dz_61_19 sky130_fd_pr_reram__reram_cell area_ox=0.0676
XMn_61_19 dn_61_19 WL61 SL19 VSS sky130_fd_pr__nfet_g5v0d10v5 w=1 l=0.5
XRn_61_19 BLN19 dn_61_19 sky130_fd_pr_reram__reram_cell area_ox=0.0676
XMp_61_20 dp_61_20 WL61 SL20 VSS sky130_fd_pr__nfet_g5v0d10v5 w=1 l=0.5
XRp_61_20 BLP20 dp_61_20 sky130_fd_pr_reram__reram_cell area_ox=0.0676
XMz_61_20 dz_61_20 WL61 SL20 VSS sky130_fd_pr__nfet_g5v0d10v5 w=1 l=0.5
XRz_61_20 BLZ20 dz_61_20 sky130_fd_pr_reram__reram_cell area_ox=0.0676
XMn_61_20 dn_61_20 WL61 SL20 VSS sky130_fd_pr__nfet_g5v0d10v5 w=1 l=0.5
XRn_61_20 BLN20 dn_61_20 sky130_fd_pr_reram__reram_cell area_ox=0.0676
XMp_61_21 dp_61_21 WL61 SL21 VSS sky130_fd_pr__nfet_g5v0d10v5 w=1 l=0.5
XRp_61_21 BLP21 dp_61_21 sky130_fd_pr_reram__reram_cell area_ox=0.0676
XMz_61_21 dz_61_21 WL61 SL21 VSS sky130_fd_pr__nfet_g5v0d10v5 w=1 l=0.5
XRz_61_21 BLZ21 dz_61_21 sky130_fd_pr_reram__reram_cell area_ox=0.0676
XMn_61_21 dn_61_21 WL61 SL21 VSS sky130_fd_pr__nfet_g5v0d10v5 w=1 l=0.5
XRn_61_21 BLN21 dn_61_21 sky130_fd_pr_reram__reram_cell area_ox=0.0676
XMp_61_22 dp_61_22 WL61 SL22 VSS sky130_fd_pr__nfet_g5v0d10v5 w=1 l=0.5
XRp_61_22 BLP22 dp_61_22 sky130_fd_pr_reram__reram_cell area_ox=0.0676
XMz_61_22 dz_61_22 WL61 SL22 VSS sky130_fd_pr__nfet_g5v0d10v5 w=1 l=0.5
XRz_61_22 BLZ22 dz_61_22 sky130_fd_pr_reram__reram_cell area_ox=0.0676
XMn_61_22 dn_61_22 WL61 SL22 VSS sky130_fd_pr__nfet_g5v0d10v5 w=1 l=0.5
XRn_61_22 BLN22 dn_61_22 sky130_fd_pr_reram__reram_cell area_ox=0.0676
XMp_61_23 dp_61_23 WL61 SL23 VSS sky130_fd_pr__nfet_g5v0d10v5 w=1 l=0.5
XRp_61_23 BLP23 dp_61_23 sky130_fd_pr_reram__reram_cell area_ox=0.0676
XMz_61_23 dz_61_23 WL61 SL23 VSS sky130_fd_pr__nfet_g5v0d10v5 w=1 l=0.5
XRz_61_23 BLZ23 dz_61_23 sky130_fd_pr_reram__reram_cell area_ox=0.0676
XMn_61_23 dn_61_23 WL61 SL23 VSS sky130_fd_pr__nfet_g5v0d10v5 w=1 l=0.5
XRn_61_23 BLN23 dn_61_23 sky130_fd_pr_reram__reram_cell area_ox=0.0676
XMp_62_0 dp_62_0 WL62 SL0 VSS sky130_fd_pr__nfet_g5v0d10v5 w=1 l=0.5
XRp_62_0 BLP0 dp_62_0 sky130_fd_pr_reram__reram_cell area_ox=0.0676
XMz_62_0 dz_62_0 WL62 SL0 VSS sky130_fd_pr__nfet_g5v0d10v5 w=1 l=0.5
XRz_62_0 BLZ0 dz_62_0 sky130_fd_pr_reram__reram_cell area_ox=0.0676
XMn_62_0 dn_62_0 WL62 SL0 VSS sky130_fd_pr__nfet_g5v0d10v5 w=1 l=0.5
XRn_62_0 BLN0 dn_62_0 sky130_fd_pr_reram__reram_cell area_ox=0.0676
XMp_62_1 dp_62_1 WL62 SL1 VSS sky130_fd_pr__nfet_g5v0d10v5 w=1 l=0.5
XRp_62_1 BLP1 dp_62_1 sky130_fd_pr_reram__reram_cell area_ox=0.0676
XMz_62_1 dz_62_1 WL62 SL1 VSS sky130_fd_pr__nfet_g5v0d10v5 w=1 l=0.5
XRz_62_1 BLZ1 dz_62_1 sky130_fd_pr_reram__reram_cell area_ox=0.0676
XMn_62_1 dn_62_1 WL62 SL1 VSS sky130_fd_pr__nfet_g5v0d10v5 w=1 l=0.5
XRn_62_1 BLN1 dn_62_1 sky130_fd_pr_reram__reram_cell area_ox=0.0676
XMp_62_2 dp_62_2 WL62 SL2 VSS sky130_fd_pr__nfet_g5v0d10v5 w=1 l=0.5
XRp_62_2 BLP2 dp_62_2 sky130_fd_pr_reram__reram_cell area_ox=0.0676
XMz_62_2 dz_62_2 WL62 SL2 VSS sky130_fd_pr__nfet_g5v0d10v5 w=1 l=0.5
XRz_62_2 BLZ2 dz_62_2 sky130_fd_pr_reram__reram_cell area_ox=0.0676
XMn_62_2 dn_62_2 WL62 SL2 VSS sky130_fd_pr__nfet_g5v0d10v5 w=1 l=0.5
XRn_62_2 BLN2 dn_62_2 sky130_fd_pr_reram__reram_cell area_ox=0.0676
XMp_62_3 dp_62_3 WL62 SL3 VSS sky130_fd_pr__nfet_g5v0d10v5 w=1 l=0.5
XRp_62_3 BLP3 dp_62_3 sky130_fd_pr_reram__reram_cell area_ox=0.0676
XMz_62_3 dz_62_3 WL62 SL3 VSS sky130_fd_pr__nfet_g5v0d10v5 w=1 l=0.5
XRz_62_3 BLZ3 dz_62_3 sky130_fd_pr_reram__reram_cell area_ox=0.0676
XMn_62_3 dn_62_3 WL62 SL3 VSS sky130_fd_pr__nfet_g5v0d10v5 w=1 l=0.5
XRn_62_3 BLN3 dn_62_3 sky130_fd_pr_reram__reram_cell area_ox=0.0676
XMp_62_4 dp_62_4 WL62 SL4 VSS sky130_fd_pr__nfet_g5v0d10v5 w=1 l=0.5
XRp_62_4 BLP4 dp_62_4 sky130_fd_pr_reram__reram_cell area_ox=0.0676
XMz_62_4 dz_62_4 WL62 SL4 VSS sky130_fd_pr__nfet_g5v0d10v5 w=1 l=0.5
XRz_62_4 BLZ4 dz_62_4 sky130_fd_pr_reram__reram_cell area_ox=0.0676
XMn_62_4 dn_62_4 WL62 SL4 VSS sky130_fd_pr__nfet_g5v0d10v5 w=1 l=0.5
XRn_62_4 BLN4 dn_62_4 sky130_fd_pr_reram__reram_cell area_ox=0.0676
XMp_62_5 dp_62_5 WL62 SL5 VSS sky130_fd_pr__nfet_g5v0d10v5 w=1 l=0.5
XRp_62_5 BLP5 dp_62_5 sky130_fd_pr_reram__reram_cell area_ox=0.0676
XMz_62_5 dz_62_5 WL62 SL5 VSS sky130_fd_pr__nfet_g5v0d10v5 w=1 l=0.5
XRz_62_5 BLZ5 dz_62_5 sky130_fd_pr_reram__reram_cell area_ox=0.0676
XMn_62_5 dn_62_5 WL62 SL5 VSS sky130_fd_pr__nfet_g5v0d10v5 w=1 l=0.5
XRn_62_5 BLN5 dn_62_5 sky130_fd_pr_reram__reram_cell area_ox=0.0676
XMp_62_6 dp_62_6 WL62 SL6 VSS sky130_fd_pr__nfet_g5v0d10v5 w=1 l=0.5
XRp_62_6 BLP6 dp_62_6 sky130_fd_pr_reram__reram_cell area_ox=0.0676
XMz_62_6 dz_62_6 WL62 SL6 VSS sky130_fd_pr__nfet_g5v0d10v5 w=1 l=0.5
XRz_62_6 BLZ6 dz_62_6 sky130_fd_pr_reram__reram_cell area_ox=0.0676
XMn_62_6 dn_62_6 WL62 SL6 VSS sky130_fd_pr__nfet_g5v0d10v5 w=1 l=0.5
XRn_62_6 BLN6 dn_62_6 sky130_fd_pr_reram__reram_cell area_ox=0.0676
XMp_62_7 dp_62_7 WL62 SL7 VSS sky130_fd_pr__nfet_g5v0d10v5 w=1 l=0.5
XRp_62_7 BLP7 dp_62_7 sky130_fd_pr_reram__reram_cell area_ox=0.0676
XMz_62_7 dz_62_7 WL62 SL7 VSS sky130_fd_pr__nfet_g5v0d10v5 w=1 l=0.5
XRz_62_7 BLZ7 dz_62_7 sky130_fd_pr_reram__reram_cell area_ox=0.0676
XMn_62_7 dn_62_7 WL62 SL7 VSS sky130_fd_pr__nfet_g5v0d10v5 w=1 l=0.5
XRn_62_7 BLN7 dn_62_7 sky130_fd_pr_reram__reram_cell area_ox=0.0676
XMp_62_8 dp_62_8 WL62 SL8 VSS sky130_fd_pr__nfet_g5v0d10v5 w=1 l=0.5
XRp_62_8 BLP8 dp_62_8 sky130_fd_pr_reram__reram_cell area_ox=0.0676
XMz_62_8 dz_62_8 WL62 SL8 VSS sky130_fd_pr__nfet_g5v0d10v5 w=1 l=0.5
XRz_62_8 BLZ8 dz_62_8 sky130_fd_pr_reram__reram_cell area_ox=0.0676
XMn_62_8 dn_62_8 WL62 SL8 VSS sky130_fd_pr__nfet_g5v0d10v5 w=1 l=0.5
XRn_62_8 BLN8 dn_62_8 sky130_fd_pr_reram__reram_cell area_ox=0.0676
XMp_62_9 dp_62_9 WL62 SL9 VSS sky130_fd_pr__nfet_g5v0d10v5 w=1 l=0.5
XRp_62_9 BLP9 dp_62_9 sky130_fd_pr_reram__reram_cell area_ox=0.0676
XMz_62_9 dz_62_9 WL62 SL9 VSS sky130_fd_pr__nfet_g5v0d10v5 w=1 l=0.5
XRz_62_9 BLZ9 dz_62_9 sky130_fd_pr_reram__reram_cell area_ox=0.0676
XMn_62_9 dn_62_9 WL62 SL9 VSS sky130_fd_pr__nfet_g5v0d10v5 w=1 l=0.5
XRn_62_9 BLN9 dn_62_9 sky130_fd_pr_reram__reram_cell area_ox=0.0676
XMp_62_10 dp_62_10 WL62 SL10 VSS sky130_fd_pr__nfet_g5v0d10v5 w=1 l=0.5
XRp_62_10 BLP10 dp_62_10 sky130_fd_pr_reram__reram_cell area_ox=0.0676
XMz_62_10 dz_62_10 WL62 SL10 VSS sky130_fd_pr__nfet_g5v0d10v5 w=1 l=0.5
XRz_62_10 BLZ10 dz_62_10 sky130_fd_pr_reram__reram_cell area_ox=0.0676
XMn_62_10 dn_62_10 WL62 SL10 VSS sky130_fd_pr__nfet_g5v0d10v5 w=1 l=0.5
XRn_62_10 BLN10 dn_62_10 sky130_fd_pr_reram__reram_cell area_ox=0.0676
XMp_62_11 dp_62_11 WL62 SL11 VSS sky130_fd_pr__nfet_g5v0d10v5 w=1 l=0.5
XRp_62_11 BLP11 dp_62_11 sky130_fd_pr_reram__reram_cell area_ox=0.0676
XMz_62_11 dz_62_11 WL62 SL11 VSS sky130_fd_pr__nfet_g5v0d10v5 w=1 l=0.5
XRz_62_11 BLZ11 dz_62_11 sky130_fd_pr_reram__reram_cell area_ox=0.0676
XMn_62_11 dn_62_11 WL62 SL11 VSS sky130_fd_pr__nfet_g5v0d10v5 w=1 l=0.5
XRn_62_11 BLN11 dn_62_11 sky130_fd_pr_reram__reram_cell area_ox=0.0676
XMp_62_12 dp_62_12 WL62 SL12 VSS sky130_fd_pr__nfet_g5v0d10v5 w=1 l=0.5
XRp_62_12 BLP12 dp_62_12 sky130_fd_pr_reram__reram_cell area_ox=0.0676
XMz_62_12 dz_62_12 WL62 SL12 VSS sky130_fd_pr__nfet_g5v0d10v5 w=1 l=0.5
XRz_62_12 BLZ12 dz_62_12 sky130_fd_pr_reram__reram_cell area_ox=0.0676
XMn_62_12 dn_62_12 WL62 SL12 VSS sky130_fd_pr__nfet_g5v0d10v5 w=1 l=0.5
XRn_62_12 BLN12 dn_62_12 sky130_fd_pr_reram__reram_cell area_ox=0.0676
XMp_62_13 dp_62_13 WL62 SL13 VSS sky130_fd_pr__nfet_g5v0d10v5 w=1 l=0.5
XRp_62_13 BLP13 dp_62_13 sky130_fd_pr_reram__reram_cell area_ox=0.0676
XMz_62_13 dz_62_13 WL62 SL13 VSS sky130_fd_pr__nfet_g5v0d10v5 w=1 l=0.5
XRz_62_13 BLZ13 dz_62_13 sky130_fd_pr_reram__reram_cell area_ox=0.0676
XMn_62_13 dn_62_13 WL62 SL13 VSS sky130_fd_pr__nfet_g5v0d10v5 w=1 l=0.5
XRn_62_13 BLN13 dn_62_13 sky130_fd_pr_reram__reram_cell area_ox=0.0676
XMp_62_14 dp_62_14 WL62 SL14 VSS sky130_fd_pr__nfet_g5v0d10v5 w=1 l=0.5
XRp_62_14 BLP14 dp_62_14 sky130_fd_pr_reram__reram_cell area_ox=0.0676
XMz_62_14 dz_62_14 WL62 SL14 VSS sky130_fd_pr__nfet_g5v0d10v5 w=1 l=0.5
XRz_62_14 BLZ14 dz_62_14 sky130_fd_pr_reram__reram_cell area_ox=0.0676
XMn_62_14 dn_62_14 WL62 SL14 VSS sky130_fd_pr__nfet_g5v0d10v5 w=1 l=0.5
XRn_62_14 BLN14 dn_62_14 sky130_fd_pr_reram__reram_cell area_ox=0.0676
XMp_62_15 dp_62_15 WL62 SL15 VSS sky130_fd_pr__nfet_g5v0d10v5 w=1 l=0.5
XRp_62_15 BLP15 dp_62_15 sky130_fd_pr_reram__reram_cell area_ox=0.0676
XMz_62_15 dz_62_15 WL62 SL15 VSS sky130_fd_pr__nfet_g5v0d10v5 w=1 l=0.5
XRz_62_15 BLZ15 dz_62_15 sky130_fd_pr_reram__reram_cell area_ox=0.0676
XMn_62_15 dn_62_15 WL62 SL15 VSS sky130_fd_pr__nfet_g5v0d10v5 w=1 l=0.5
XRn_62_15 BLN15 dn_62_15 sky130_fd_pr_reram__reram_cell area_ox=0.0676
XMp_62_16 dp_62_16 WL62 SL16 VSS sky130_fd_pr__nfet_g5v0d10v5 w=1 l=0.5
XRp_62_16 BLP16 dp_62_16 sky130_fd_pr_reram__reram_cell area_ox=0.0676
XMz_62_16 dz_62_16 WL62 SL16 VSS sky130_fd_pr__nfet_g5v0d10v5 w=1 l=0.5
XRz_62_16 BLZ16 dz_62_16 sky130_fd_pr_reram__reram_cell area_ox=0.0676
XMn_62_16 dn_62_16 WL62 SL16 VSS sky130_fd_pr__nfet_g5v0d10v5 w=1 l=0.5
XRn_62_16 BLN16 dn_62_16 sky130_fd_pr_reram__reram_cell area_ox=0.0676
XMp_62_17 dp_62_17 WL62 SL17 VSS sky130_fd_pr__nfet_g5v0d10v5 w=1 l=0.5
XRp_62_17 BLP17 dp_62_17 sky130_fd_pr_reram__reram_cell area_ox=0.0676
XMz_62_17 dz_62_17 WL62 SL17 VSS sky130_fd_pr__nfet_g5v0d10v5 w=1 l=0.5
XRz_62_17 BLZ17 dz_62_17 sky130_fd_pr_reram__reram_cell area_ox=0.0676
XMn_62_17 dn_62_17 WL62 SL17 VSS sky130_fd_pr__nfet_g5v0d10v5 w=1 l=0.5
XRn_62_17 BLN17 dn_62_17 sky130_fd_pr_reram__reram_cell area_ox=0.0676
XMp_62_18 dp_62_18 WL62 SL18 VSS sky130_fd_pr__nfet_g5v0d10v5 w=1 l=0.5
XRp_62_18 BLP18 dp_62_18 sky130_fd_pr_reram__reram_cell area_ox=0.0676
XMz_62_18 dz_62_18 WL62 SL18 VSS sky130_fd_pr__nfet_g5v0d10v5 w=1 l=0.5
XRz_62_18 BLZ18 dz_62_18 sky130_fd_pr_reram__reram_cell area_ox=0.0676
XMn_62_18 dn_62_18 WL62 SL18 VSS sky130_fd_pr__nfet_g5v0d10v5 w=1 l=0.5
XRn_62_18 BLN18 dn_62_18 sky130_fd_pr_reram__reram_cell area_ox=0.0676
XMp_62_19 dp_62_19 WL62 SL19 VSS sky130_fd_pr__nfet_g5v0d10v5 w=1 l=0.5
XRp_62_19 BLP19 dp_62_19 sky130_fd_pr_reram__reram_cell area_ox=0.0676
XMz_62_19 dz_62_19 WL62 SL19 VSS sky130_fd_pr__nfet_g5v0d10v5 w=1 l=0.5
XRz_62_19 BLZ19 dz_62_19 sky130_fd_pr_reram__reram_cell area_ox=0.0676
XMn_62_19 dn_62_19 WL62 SL19 VSS sky130_fd_pr__nfet_g5v0d10v5 w=1 l=0.5
XRn_62_19 BLN19 dn_62_19 sky130_fd_pr_reram__reram_cell area_ox=0.0676
XMp_62_20 dp_62_20 WL62 SL20 VSS sky130_fd_pr__nfet_g5v0d10v5 w=1 l=0.5
XRp_62_20 BLP20 dp_62_20 sky130_fd_pr_reram__reram_cell area_ox=0.0676
XMz_62_20 dz_62_20 WL62 SL20 VSS sky130_fd_pr__nfet_g5v0d10v5 w=1 l=0.5
XRz_62_20 BLZ20 dz_62_20 sky130_fd_pr_reram__reram_cell area_ox=0.0676
XMn_62_20 dn_62_20 WL62 SL20 VSS sky130_fd_pr__nfet_g5v0d10v5 w=1 l=0.5
XRn_62_20 BLN20 dn_62_20 sky130_fd_pr_reram__reram_cell area_ox=0.0676
XMp_62_21 dp_62_21 WL62 SL21 VSS sky130_fd_pr__nfet_g5v0d10v5 w=1 l=0.5
XRp_62_21 BLP21 dp_62_21 sky130_fd_pr_reram__reram_cell area_ox=0.0676
XMz_62_21 dz_62_21 WL62 SL21 VSS sky130_fd_pr__nfet_g5v0d10v5 w=1 l=0.5
XRz_62_21 BLZ21 dz_62_21 sky130_fd_pr_reram__reram_cell area_ox=0.0676
XMn_62_21 dn_62_21 WL62 SL21 VSS sky130_fd_pr__nfet_g5v0d10v5 w=1 l=0.5
XRn_62_21 BLN21 dn_62_21 sky130_fd_pr_reram__reram_cell area_ox=0.0676
XMp_62_22 dp_62_22 WL62 SL22 VSS sky130_fd_pr__nfet_g5v0d10v5 w=1 l=0.5
XRp_62_22 BLP22 dp_62_22 sky130_fd_pr_reram__reram_cell area_ox=0.0676
XMz_62_22 dz_62_22 WL62 SL22 VSS sky130_fd_pr__nfet_g5v0d10v5 w=1 l=0.5
XRz_62_22 BLZ22 dz_62_22 sky130_fd_pr_reram__reram_cell area_ox=0.0676
XMn_62_22 dn_62_22 WL62 SL22 VSS sky130_fd_pr__nfet_g5v0d10v5 w=1 l=0.5
XRn_62_22 BLN22 dn_62_22 sky130_fd_pr_reram__reram_cell area_ox=0.0676
XMp_62_23 dp_62_23 WL62 SL23 VSS sky130_fd_pr__nfet_g5v0d10v5 w=1 l=0.5
XRp_62_23 BLP23 dp_62_23 sky130_fd_pr_reram__reram_cell area_ox=0.0676
XMz_62_23 dz_62_23 WL62 SL23 VSS sky130_fd_pr__nfet_g5v0d10v5 w=1 l=0.5
XRz_62_23 BLZ23 dz_62_23 sky130_fd_pr_reram__reram_cell area_ox=0.0676
XMn_62_23 dn_62_23 WL62 SL23 VSS sky130_fd_pr__nfet_g5v0d10v5 w=1 l=0.5
XRn_62_23 BLN23 dn_62_23 sky130_fd_pr_reram__reram_cell area_ox=0.0676
XMp_63_0 dp_63_0 WL63 SL0 VSS sky130_fd_pr__nfet_g5v0d10v5 w=1 l=0.5
XRp_63_0 BLP0 dp_63_0 sky130_fd_pr_reram__reram_cell area_ox=0.0676
XMz_63_0 dz_63_0 WL63 SL0 VSS sky130_fd_pr__nfet_g5v0d10v5 w=1 l=0.5
XRz_63_0 BLZ0 dz_63_0 sky130_fd_pr_reram__reram_cell area_ox=0.0676
XMn_63_0 dn_63_0 WL63 SL0 VSS sky130_fd_pr__nfet_g5v0d10v5 w=1 l=0.5
XRn_63_0 BLN0 dn_63_0 sky130_fd_pr_reram__reram_cell area_ox=0.0676
XMp_63_1 dp_63_1 WL63 SL1 VSS sky130_fd_pr__nfet_g5v0d10v5 w=1 l=0.5
XRp_63_1 BLP1 dp_63_1 sky130_fd_pr_reram__reram_cell area_ox=0.0676
XMz_63_1 dz_63_1 WL63 SL1 VSS sky130_fd_pr__nfet_g5v0d10v5 w=1 l=0.5
XRz_63_1 BLZ1 dz_63_1 sky130_fd_pr_reram__reram_cell area_ox=0.0676
XMn_63_1 dn_63_1 WL63 SL1 VSS sky130_fd_pr__nfet_g5v0d10v5 w=1 l=0.5
XRn_63_1 BLN1 dn_63_1 sky130_fd_pr_reram__reram_cell area_ox=0.0676
XMp_63_2 dp_63_2 WL63 SL2 VSS sky130_fd_pr__nfet_g5v0d10v5 w=1 l=0.5
XRp_63_2 BLP2 dp_63_2 sky130_fd_pr_reram__reram_cell area_ox=0.0676
XMz_63_2 dz_63_2 WL63 SL2 VSS sky130_fd_pr__nfet_g5v0d10v5 w=1 l=0.5
XRz_63_2 BLZ2 dz_63_2 sky130_fd_pr_reram__reram_cell area_ox=0.0676
XMn_63_2 dn_63_2 WL63 SL2 VSS sky130_fd_pr__nfet_g5v0d10v5 w=1 l=0.5
XRn_63_2 BLN2 dn_63_2 sky130_fd_pr_reram__reram_cell area_ox=0.0676
XMp_63_3 dp_63_3 WL63 SL3 VSS sky130_fd_pr__nfet_g5v0d10v5 w=1 l=0.5
XRp_63_3 BLP3 dp_63_3 sky130_fd_pr_reram__reram_cell area_ox=0.0676
XMz_63_3 dz_63_3 WL63 SL3 VSS sky130_fd_pr__nfet_g5v0d10v5 w=1 l=0.5
XRz_63_3 BLZ3 dz_63_3 sky130_fd_pr_reram__reram_cell area_ox=0.0676
XMn_63_3 dn_63_3 WL63 SL3 VSS sky130_fd_pr__nfet_g5v0d10v5 w=1 l=0.5
XRn_63_3 BLN3 dn_63_3 sky130_fd_pr_reram__reram_cell area_ox=0.0676
XMp_63_4 dp_63_4 WL63 SL4 VSS sky130_fd_pr__nfet_g5v0d10v5 w=1 l=0.5
XRp_63_4 BLP4 dp_63_4 sky130_fd_pr_reram__reram_cell area_ox=0.0676
XMz_63_4 dz_63_4 WL63 SL4 VSS sky130_fd_pr__nfet_g5v0d10v5 w=1 l=0.5
XRz_63_4 BLZ4 dz_63_4 sky130_fd_pr_reram__reram_cell area_ox=0.0676
XMn_63_4 dn_63_4 WL63 SL4 VSS sky130_fd_pr__nfet_g5v0d10v5 w=1 l=0.5
XRn_63_4 BLN4 dn_63_4 sky130_fd_pr_reram__reram_cell area_ox=0.0676
XMp_63_5 dp_63_5 WL63 SL5 VSS sky130_fd_pr__nfet_g5v0d10v5 w=1 l=0.5
XRp_63_5 BLP5 dp_63_5 sky130_fd_pr_reram__reram_cell area_ox=0.0676
XMz_63_5 dz_63_5 WL63 SL5 VSS sky130_fd_pr__nfet_g5v0d10v5 w=1 l=0.5
XRz_63_5 BLZ5 dz_63_5 sky130_fd_pr_reram__reram_cell area_ox=0.0676
XMn_63_5 dn_63_5 WL63 SL5 VSS sky130_fd_pr__nfet_g5v0d10v5 w=1 l=0.5
XRn_63_5 BLN5 dn_63_5 sky130_fd_pr_reram__reram_cell area_ox=0.0676
XMp_63_6 dp_63_6 WL63 SL6 VSS sky130_fd_pr__nfet_g5v0d10v5 w=1 l=0.5
XRp_63_6 BLP6 dp_63_6 sky130_fd_pr_reram__reram_cell area_ox=0.0676
XMz_63_6 dz_63_6 WL63 SL6 VSS sky130_fd_pr__nfet_g5v0d10v5 w=1 l=0.5
XRz_63_6 BLZ6 dz_63_6 sky130_fd_pr_reram__reram_cell area_ox=0.0676
XMn_63_6 dn_63_6 WL63 SL6 VSS sky130_fd_pr__nfet_g5v0d10v5 w=1 l=0.5
XRn_63_6 BLN6 dn_63_6 sky130_fd_pr_reram__reram_cell area_ox=0.0676
XMp_63_7 dp_63_7 WL63 SL7 VSS sky130_fd_pr__nfet_g5v0d10v5 w=1 l=0.5
XRp_63_7 BLP7 dp_63_7 sky130_fd_pr_reram__reram_cell area_ox=0.0676
XMz_63_7 dz_63_7 WL63 SL7 VSS sky130_fd_pr__nfet_g5v0d10v5 w=1 l=0.5
XRz_63_7 BLZ7 dz_63_7 sky130_fd_pr_reram__reram_cell area_ox=0.0676
XMn_63_7 dn_63_7 WL63 SL7 VSS sky130_fd_pr__nfet_g5v0d10v5 w=1 l=0.5
XRn_63_7 BLN7 dn_63_7 sky130_fd_pr_reram__reram_cell area_ox=0.0676
XMp_63_8 dp_63_8 WL63 SL8 VSS sky130_fd_pr__nfet_g5v0d10v5 w=1 l=0.5
XRp_63_8 BLP8 dp_63_8 sky130_fd_pr_reram__reram_cell area_ox=0.0676
XMz_63_8 dz_63_8 WL63 SL8 VSS sky130_fd_pr__nfet_g5v0d10v5 w=1 l=0.5
XRz_63_8 BLZ8 dz_63_8 sky130_fd_pr_reram__reram_cell area_ox=0.0676
XMn_63_8 dn_63_8 WL63 SL8 VSS sky130_fd_pr__nfet_g5v0d10v5 w=1 l=0.5
XRn_63_8 BLN8 dn_63_8 sky130_fd_pr_reram__reram_cell area_ox=0.0676
XMp_63_9 dp_63_9 WL63 SL9 VSS sky130_fd_pr__nfet_g5v0d10v5 w=1 l=0.5
XRp_63_9 BLP9 dp_63_9 sky130_fd_pr_reram__reram_cell area_ox=0.0676
XMz_63_9 dz_63_9 WL63 SL9 VSS sky130_fd_pr__nfet_g5v0d10v5 w=1 l=0.5
XRz_63_9 BLZ9 dz_63_9 sky130_fd_pr_reram__reram_cell area_ox=0.0676
XMn_63_9 dn_63_9 WL63 SL9 VSS sky130_fd_pr__nfet_g5v0d10v5 w=1 l=0.5
XRn_63_9 BLN9 dn_63_9 sky130_fd_pr_reram__reram_cell area_ox=0.0676
XMp_63_10 dp_63_10 WL63 SL10 VSS sky130_fd_pr__nfet_g5v0d10v5 w=1 l=0.5
XRp_63_10 BLP10 dp_63_10 sky130_fd_pr_reram__reram_cell area_ox=0.0676
XMz_63_10 dz_63_10 WL63 SL10 VSS sky130_fd_pr__nfet_g5v0d10v5 w=1 l=0.5
XRz_63_10 BLZ10 dz_63_10 sky130_fd_pr_reram__reram_cell area_ox=0.0676
XMn_63_10 dn_63_10 WL63 SL10 VSS sky130_fd_pr__nfet_g5v0d10v5 w=1 l=0.5
XRn_63_10 BLN10 dn_63_10 sky130_fd_pr_reram__reram_cell area_ox=0.0676
XMp_63_11 dp_63_11 WL63 SL11 VSS sky130_fd_pr__nfet_g5v0d10v5 w=1 l=0.5
XRp_63_11 BLP11 dp_63_11 sky130_fd_pr_reram__reram_cell area_ox=0.0676
XMz_63_11 dz_63_11 WL63 SL11 VSS sky130_fd_pr__nfet_g5v0d10v5 w=1 l=0.5
XRz_63_11 BLZ11 dz_63_11 sky130_fd_pr_reram__reram_cell area_ox=0.0676
XMn_63_11 dn_63_11 WL63 SL11 VSS sky130_fd_pr__nfet_g5v0d10v5 w=1 l=0.5
XRn_63_11 BLN11 dn_63_11 sky130_fd_pr_reram__reram_cell area_ox=0.0676
XMp_63_12 dp_63_12 WL63 SL12 VSS sky130_fd_pr__nfet_g5v0d10v5 w=1 l=0.5
XRp_63_12 BLP12 dp_63_12 sky130_fd_pr_reram__reram_cell area_ox=0.0676
XMz_63_12 dz_63_12 WL63 SL12 VSS sky130_fd_pr__nfet_g5v0d10v5 w=1 l=0.5
XRz_63_12 BLZ12 dz_63_12 sky130_fd_pr_reram__reram_cell area_ox=0.0676
XMn_63_12 dn_63_12 WL63 SL12 VSS sky130_fd_pr__nfet_g5v0d10v5 w=1 l=0.5
XRn_63_12 BLN12 dn_63_12 sky130_fd_pr_reram__reram_cell area_ox=0.0676
XMp_63_13 dp_63_13 WL63 SL13 VSS sky130_fd_pr__nfet_g5v0d10v5 w=1 l=0.5
XRp_63_13 BLP13 dp_63_13 sky130_fd_pr_reram__reram_cell area_ox=0.0676
XMz_63_13 dz_63_13 WL63 SL13 VSS sky130_fd_pr__nfet_g5v0d10v5 w=1 l=0.5
XRz_63_13 BLZ13 dz_63_13 sky130_fd_pr_reram__reram_cell area_ox=0.0676
XMn_63_13 dn_63_13 WL63 SL13 VSS sky130_fd_pr__nfet_g5v0d10v5 w=1 l=0.5
XRn_63_13 BLN13 dn_63_13 sky130_fd_pr_reram__reram_cell area_ox=0.0676
XMp_63_14 dp_63_14 WL63 SL14 VSS sky130_fd_pr__nfet_g5v0d10v5 w=1 l=0.5
XRp_63_14 BLP14 dp_63_14 sky130_fd_pr_reram__reram_cell area_ox=0.0676
XMz_63_14 dz_63_14 WL63 SL14 VSS sky130_fd_pr__nfet_g5v0d10v5 w=1 l=0.5
XRz_63_14 BLZ14 dz_63_14 sky130_fd_pr_reram__reram_cell area_ox=0.0676
XMn_63_14 dn_63_14 WL63 SL14 VSS sky130_fd_pr__nfet_g5v0d10v5 w=1 l=0.5
XRn_63_14 BLN14 dn_63_14 sky130_fd_pr_reram__reram_cell area_ox=0.0676
XMp_63_15 dp_63_15 WL63 SL15 VSS sky130_fd_pr__nfet_g5v0d10v5 w=1 l=0.5
XRp_63_15 BLP15 dp_63_15 sky130_fd_pr_reram__reram_cell area_ox=0.0676
XMz_63_15 dz_63_15 WL63 SL15 VSS sky130_fd_pr__nfet_g5v0d10v5 w=1 l=0.5
XRz_63_15 BLZ15 dz_63_15 sky130_fd_pr_reram__reram_cell area_ox=0.0676
XMn_63_15 dn_63_15 WL63 SL15 VSS sky130_fd_pr__nfet_g5v0d10v5 w=1 l=0.5
XRn_63_15 BLN15 dn_63_15 sky130_fd_pr_reram__reram_cell area_ox=0.0676
XMp_63_16 dp_63_16 WL63 SL16 VSS sky130_fd_pr__nfet_g5v0d10v5 w=1 l=0.5
XRp_63_16 BLP16 dp_63_16 sky130_fd_pr_reram__reram_cell area_ox=0.0676
XMz_63_16 dz_63_16 WL63 SL16 VSS sky130_fd_pr__nfet_g5v0d10v5 w=1 l=0.5
XRz_63_16 BLZ16 dz_63_16 sky130_fd_pr_reram__reram_cell area_ox=0.0676
XMn_63_16 dn_63_16 WL63 SL16 VSS sky130_fd_pr__nfet_g5v0d10v5 w=1 l=0.5
XRn_63_16 BLN16 dn_63_16 sky130_fd_pr_reram__reram_cell area_ox=0.0676
XMp_63_17 dp_63_17 WL63 SL17 VSS sky130_fd_pr__nfet_g5v0d10v5 w=1 l=0.5
XRp_63_17 BLP17 dp_63_17 sky130_fd_pr_reram__reram_cell area_ox=0.0676
XMz_63_17 dz_63_17 WL63 SL17 VSS sky130_fd_pr__nfet_g5v0d10v5 w=1 l=0.5
XRz_63_17 BLZ17 dz_63_17 sky130_fd_pr_reram__reram_cell area_ox=0.0676
XMn_63_17 dn_63_17 WL63 SL17 VSS sky130_fd_pr__nfet_g5v0d10v5 w=1 l=0.5
XRn_63_17 BLN17 dn_63_17 sky130_fd_pr_reram__reram_cell area_ox=0.0676
XMp_63_18 dp_63_18 WL63 SL18 VSS sky130_fd_pr__nfet_g5v0d10v5 w=1 l=0.5
XRp_63_18 BLP18 dp_63_18 sky130_fd_pr_reram__reram_cell area_ox=0.0676
XMz_63_18 dz_63_18 WL63 SL18 VSS sky130_fd_pr__nfet_g5v0d10v5 w=1 l=0.5
XRz_63_18 BLZ18 dz_63_18 sky130_fd_pr_reram__reram_cell area_ox=0.0676
XMn_63_18 dn_63_18 WL63 SL18 VSS sky130_fd_pr__nfet_g5v0d10v5 w=1 l=0.5
XRn_63_18 BLN18 dn_63_18 sky130_fd_pr_reram__reram_cell area_ox=0.0676
XMp_63_19 dp_63_19 WL63 SL19 VSS sky130_fd_pr__nfet_g5v0d10v5 w=1 l=0.5
XRp_63_19 BLP19 dp_63_19 sky130_fd_pr_reram__reram_cell area_ox=0.0676
XMz_63_19 dz_63_19 WL63 SL19 VSS sky130_fd_pr__nfet_g5v0d10v5 w=1 l=0.5
XRz_63_19 BLZ19 dz_63_19 sky130_fd_pr_reram__reram_cell area_ox=0.0676
XMn_63_19 dn_63_19 WL63 SL19 VSS sky130_fd_pr__nfet_g5v0d10v5 w=1 l=0.5
XRn_63_19 BLN19 dn_63_19 sky130_fd_pr_reram__reram_cell area_ox=0.0676
XMp_63_20 dp_63_20 WL63 SL20 VSS sky130_fd_pr__nfet_g5v0d10v5 w=1 l=0.5
XRp_63_20 BLP20 dp_63_20 sky130_fd_pr_reram__reram_cell area_ox=0.0676
XMz_63_20 dz_63_20 WL63 SL20 VSS sky130_fd_pr__nfet_g5v0d10v5 w=1 l=0.5
XRz_63_20 BLZ20 dz_63_20 sky130_fd_pr_reram__reram_cell area_ox=0.0676
XMn_63_20 dn_63_20 WL63 SL20 VSS sky130_fd_pr__nfet_g5v0d10v5 w=1 l=0.5
XRn_63_20 BLN20 dn_63_20 sky130_fd_pr_reram__reram_cell area_ox=0.0676
XMp_63_21 dp_63_21 WL63 SL21 VSS sky130_fd_pr__nfet_g5v0d10v5 w=1 l=0.5
XRp_63_21 BLP21 dp_63_21 sky130_fd_pr_reram__reram_cell area_ox=0.0676
XMz_63_21 dz_63_21 WL63 SL21 VSS sky130_fd_pr__nfet_g5v0d10v5 w=1 l=0.5
XRz_63_21 BLZ21 dz_63_21 sky130_fd_pr_reram__reram_cell area_ox=0.0676
XMn_63_21 dn_63_21 WL63 SL21 VSS sky130_fd_pr__nfet_g5v0d10v5 w=1 l=0.5
XRn_63_21 BLN21 dn_63_21 sky130_fd_pr_reram__reram_cell area_ox=0.0676
XMp_63_22 dp_63_22 WL63 SL22 VSS sky130_fd_pr__nfet_g5v0d10v5 w=1 l=0.5
XRp_63_22 BLP22 dp_63_22 sky130_fd_pr_reram__reram_cell area_ox=0.0676
XMz_63_22 dz_63_22 WL63 SL22 VSS sky130_fd_pr__nfet_g5v0d10v5 w=1 l=0.5
XRz_63_22 BLZ22 dz_63_22 sky130_fd_pr_reram__reram_cell area_ox=0.0676
XMn_63_22 dn_63_22 WL63 SL22 VSS sky130_fd_pr__nfet_g5v0d10v5 w=1 l=0.5
XRn_63_22 BLN22 dn_63_22 sky130_fd_pr_reram__reram_cell area_ox=0.0676
XMp_63_23 dp_63_23 WL63 SL23 VSS sky130_fd_pr__nfet_g5v0d10v5 w=1 l=0.5
XRp_63_23 BLP23 dp_63_23 sky130_fd_pr_reram__reram_cell area_ox=0.0676
XMz_63_23 dz_63_23 WL63 SL23 VSS sky130_fd_pr__nfet_g5v0d10v5 w=1 l=0.5
XRz_63_23 BLZ23 dz_63_23 sky130_fd_pr_reram__reram_cell area_ox=0.0676
XMn_63_23 dn_63_23 WL63 SL23 VSS sky130_fd_pr__nfet_g5v0d10v5 w=1 l=0.5
XRn_63_23 BLN23 dn_63_23 sky130_fd_pr_reram__reram_cell area_ox=0.0676
XMp_64_0 dp_64_0 WL64 SL0 VSS sky130_fd_pr__nfet_g5v0d10v5 w=1 l=0.5
XRp_64_0 BLP0 dp_64_0 sky130_fd_pr_reram__reram_cell area_ox=0.0676
XMz_64_0 dz_64_0 WL64 SL0 VSS sky130_fd_pr__nfet_g5v0d10v5 w=1 l=0.5
XRz_64_0 BLZ0 dz_64_0 sky130_fd_pr_reram__reram_cell area_ox=0.0676
XMn_64_0 dn_64_0 WL64 SL0 VSS sky130_fd_pr__nfet_g5v0d10v5 w=1 l=0.5
XRn_64_0 BLN0 dn_64_0 sky130_fd_pr_reram__reram_cell area_ox=0.0676
XMp_64_1 dp_64_1 WL64 SL1 VSS sky130_fd_pr__nfet_g5v0d10v5 w=1 l=0.5
XRp_64_1 BLP1 dp_64_1 sky130_fd_pr_reram__reram_cell area_ox=0.0676
XMz_64_1 dz_64_1 WL64 SL1 VSS sky130_fd_pr__nfet_g5v0d10v5 w=1 l=0.5
XRz_64_1 BLZ1 dz_64_1 sky130_fd_pr_reram__reram_cell area_ox=0.0676
XMn_64_1 dn_64_1 WL64 SL1 VSS sky130_fd_pr__nfet_g5v0d10v5 w=1 l=0.5
XRn_64_1 BLN1 dn_64_1 sky130_fd_pr_reram__reram_cell area_ox=0.0676
XMp_64_2 dp_64_2 WL64 SL2 VSS sky130_fd_pr__nfet_g5v0d10v5 w=1 l=0.5
XRp_64_2 BLP2 dp_64_2 sky130_fd_pr_reram__reram_cell area_ox=0.0676
XMz_64_2 dz_64_2 WL64 SL2 VSS sky130_fd_pr__nfet_g5v0d10v5 w=1 l=0.5
XRz_64_2 BLZ2 dz_64_2 sky130_fd_pr_reram__reram_cell area_ox=0.0676
XMn_64_2 dn_64_2 WL64 SL2 VSS sky130_fd_pr__nfet_g5v0d10v5 w=1 l=0.5
XRn_64_2 BLN2 dn_64_2 sky130_fd_pr_reram__reram_cell area_ox=0.0676
XMp_64_3 dp_64_3 WL64 SL3 VSS sky130_fd_pr__nfet_g5v0d10v5 w=1 l=0.5
XRp_64_3 BLP3 dp_64_3 sky130_fd_pr_reram__reram_cell area_ox=0.0676
XMz_64_3 dz_64_3 WL64 SL3 VSS sky130_fd_pr__nfet_g5v0d10v5 w=1 l=0.5
XRz_64_3 BLZ3 dz_64_3 sky130_fd_pr_reram__reram_cell area_ox=0.0676
XMn_64_3 dn_64_3 WL64 SL3 VSS sky130_fd_pr__nfet_g5v0d10v5 w=1 l=0.5
XRn_64_3 BLN3 dn_64_3 sky130_fd_pr_reram__reram_cell area_ox=0.0676
XMp_64_4 dp_64_4 WL64 SL4 VSS sky130_fd_pr__nfet_g5v0d10v5 w=1 l=0.5
XRp_64_4 BLP4 dp_64_4 sky130_fd_pr_reram__reram_cell area_ox=0.0676
XMz_64_4 dz_64_4 WL64 SL4 VSS sky130_fd_pr__nfet_g5v0d10v5 w=1 l=0.5
XRz_64_4 BLZ4 dz_64_4 sky130_fd_pr_reram__reram_cell area_ox=0.0676
XMn_64_4 dn_64_4 WL64 SL4 VSS sky130_fd_pr__nfet_g5v0d10v5 w=1 l=0.5
XRn_64_4 BLN4 dn_64_4 sky130_fd_pr_reram__reram_cell area_ox=0.0676
XMp_64_5 dp_64_5 WL64 SL5 VSS sky130_fd_pr__nfet_g5v0d10v5 w=1 l=0.5
XRp_64_5 BLP5 dp_64_5 sky130_fd_pr_reram__reram_cell area_ox=0.0676
XMz_64_5 dz_64_5 WL64 SL5 VSS sky130_fd_pr__nfet_g5v0d10v5 w=1 l=0.5
XRz_64_5 BLZ5 dz_64_5 sky130_fd_pr_reram__reram_cell area_ox=0.0676
XMn_64_5 dn_64_5 WL64 SL5 VSS sky130_fd_pr__nfet_g5v0d10v5 w=1 l=0.5
XRn_64_5 BLN5 dn_64_5 sky130_fd_pr_reram__reram_cell area_ox=0.0676
XMp_64_6 dp_64_6 WL64 SL6 VSS sky130_fd_pr__nfet_g5v0d10v5 w=1 l=0.5
XRp_64_6 BLP6 dp_64_6 sky130_fd_pr_reram__reram_cell area_ox=0.0676
XMz_64_6 dz_64_6 WL64 SL6 VSS sky130_fd_pr__nfet_g5v0d10v5 w=1 l=0.5
XRz_64_6 BLZ6 dz_64_6 sky130_fd_pr_reram__reram_cell area_ox=0.0676
XMn_64_6 dn_64_6 WL64 SL6 VSS sky130_fd_pr__nfet_g5v0d10v5 w=1 l=0.5
XRn_64_6 BLN6 dn_64_6 sky130_fd_pr_reram__reram_cell area_ox=0.0676
XMp_64_7 dp_64_7 WL64 SL7 VSS sky130_fd_pr__nfet_g5v0d10v5 w=1 l=0.5
XRp_64_7 BLP7 dp_64_7 sky130_fd_pr_reram__reram_cell area_ox=0.0676
XMz_64_7 dz_64_7 WL64 SL7 VSS sky130_fd_pr__nfet_g5v0d10v5 w=1 l=0.5
XRz_64_7 BLZ7 dz_64_7 sky130_fd_pr_reram__reram_cell area_ox=0.0676
XMn_64_7 dn_64_7 WL64 SL7 VSS sky130_fd_pr__nfet_g5v0d10v5 w=1 l=0.5
XRn_64_7 BLN7 dn_64_7 sky130_fd_pr_reram__reram_cell area_ox=0.0676
XMp_64_8 dp_64_8 WL64 SL8 VSS sky130_fd_pr__nfet_g5v0d10v5 w=1 l=0.5
XRp_64_8 BLP8 dp_64_8 sky130_fd_pr_reram__reram_cell area_ox=0.0676
XMz_64_8 dz_64_8 WL64 SL8 VSS sky130_fd_pr__nfet_g5v0d10v5 w=1 l=0.5
XRz_64_8 BLZ8 dz_64_8 sky130_fd_pr_reram__reram_cell area_ox=0.0676
XMn_64_8 dn_64_8 WL64 SL8 VSS sky130_fd_pr__nfet_g5v0d10v5 w=1 l=0.5
XRn_64_8 BLN8 dn_64_8 sky130_fd_pr_reram__reram_cell area_ox=0.0676
XMp_64_9 dp_64_9 WL64 SL9 VSS sky130_fd_pr__nfet_g5v0d10v5 w=1 l=0.5
XRp_64_9 BLP9 dp_64_9 sky130_fd_pr_reram__reram_cell area_ox=0.0676
XMz_64_9 dz_64_9 WL64 SL9 VSS sky130_fd_pr__nfet_g5v0d10v5 w=1 l=0.5
XRz_64_9 BLZ9 dz_64_9 sky130_fd_pr_reram__reram_cell area_ox=0.0676
XMn_64_9 dn_64_9 WL64 SL9 VSS sky130_fd_pr__nfet_g5v0d10v5 w=1 l=0.5
XRn_64_9 BLN9 dn_64_9 sky130_fd_pr_reram__reram_cell area_ox=0.0676
XMp_64_10 dp_64_10 WL64 SL10 VSS sky130_fd_pr__nfet_g5v0d10v5 w=1 l=0.5
XRp_64_10 BLP10 dp_64_10 sky130_fd_pr_reram__reram_cell area_ox=0.0676
XMz_64_10 dz_64_10 WL64 SL10 VSS sky130_fd_pr__nfet_g5v0d10v5 w=1 l=0.5
XRz_64_10 BLZ10 dz_64_10 sky130_fd_pr_reram__reram_cell area_ox=0.0676
XMn_64_10 dn_64_10 WL64 SL10 VSS sky130_fd_pr__nfet_g5v0d10v5 w=1 l=0.5
XRn_64_10 BLN10 dn_64_10 sky130_fd_pr_reram__reram_cell area_ox=0.0676
XMp_64_11 dp_64_11 WL64 SL11 VSS sky130_fd_pr__nfet_g5v0d10v5 w=1 l=0.5
XRp_64_11 BLP11 dp_64_11 sky130_fd_pr_reram__reram_cell area_ox=0.0676
XMz_64_11 dz_64_11 WL64 SL11 VSS sky130_fd_pr__nfet_g5v0d10v5 w=1 l=0.5
XRz_64_11 BLZ11 dz_64_11 sky130_fd_pr_reram__reram_cell area_ox=0.0676
XMn_64_11 dn_64_11 WL64 SL11 VSS sky130_fd_pr__nfet_g5v0d10v5 w=1 l=0.5
XRn_64_11 BLN11 dn_64_11 sky130_fd_pr_reram__reram_cell area_ox=0.0676
XMp_64_12 dp_64_12 WL64 SL12 VSS sky130_fd_pr__nfet_g5v0d10v5 w=1 l=0.5
XRp_64_12 BLP12 dp_64_12 sky130_fd_pr_reram__reram_cell area_ox=0.0676
XMz_64_12 dz_64_12 WL64 SL12 VSS sky130_fd_pr__nfet_g5v0d10v5 w=1 l=0.5
XRz_64_12 BLZ12 dz_64_12 sky130_fd_pr_reram__reram_cell area_ox=0.0676
XMn_64_12 dn_64_12 WL64 SL12 VSS sky130_fd_pr__nfet_g5v0d10v5 w=1 l=0.5
XRn_64_12 BLN12 dn_64_12 sky130_fd_pr_reram__reram_cell area_ox=0.0676
XMp_64_13 dp_64_13 WL64 SL13 VSS sky130_fd_pr__nfet_g5v0d10v5 w=1 l=0.5
XRp_64_13 BLP13 dp_64_13 sky130_fd_pr_reram__reram_cell area_ox=0.0676
XMz_64_13 dz_64_13 WL64 SL13 VSS sky130_fd_pr__nfet_g5v0d10v5 w=1 l=0.5
XRz_64_13 BLZ13 dz_64_13 sky130_fd_pr_reram__reram_cell area_ox=0.0676
XMn_64_13 dn_64_13 WL64 SL13 VSS sky130_fd_pr__nfet_g5v0d10v5 w=1 l=0.5
XRn_64_13 BLN13 dn_64_13 sky130_fd_pr_reram__reram_cell area_ox=0.0676
XMp_64_14 dp_64_14 WL64 SL14 VSS sky130_fd_pr__nfet_g5v0d10v5 w=1 l=0.5
XRp_64_14 BLP14 dp_64_14 sky130_fd_pr_reram__reram_cell area_ox=0.0676
XMz_64_14 dz_64_14 WL64 SL14 VSS sky130_fd_pr__nfet_g5v0d10v5 w=1 l=0.5
XRz_64_14 BLZ14 dz_64_14 sky130_fd_pr_reram__reram_cell area_ox=0.0676
XMn_64_14 dn_64_14 WL64 SL14 VSS sky130_fd_pr__nfet_g5v0d10v5 w=1 l=0.5
XRn_64_14 BLN14 dn_64_14 sky130_fd_pr_reram__reram_cell area_ox=0.0676
XMp_64_15 dp_64_15 WL64 SL15 VSS sky130_fd_pr__nfet_g5v0d10v5 w=1 l=0.5
XRp_64_15 BLP15 dp_64_15 sky130_fd_pr_reram__reram_cell area_ox=0.0676
XMz_64_15 dz_64_15 WL64 SL15 VSS sky130_fd_pr__nfet_g5v0d10v5 w=1 l=0.5
XRz_64_15 BLZ15 dz_64_15 sky130_fd_pr_reram__reram_cell area_ox=0.0676
XMn_64_15 dn_64_15 WL64 SL15 VSS sky130_fd_pr__nfet_g5v0d10v5 w=1 l=0.5
XRn_64_15 BLN15 dn_64_15 sky130_fd_pr_reram__reram_cell area_ox=0.0676
XMp_64_16 dp_64_16 WL64 SL16 VSS sky130_fd_pr__nfet_g5v0d10v5 w=1 l=0.5
XRp_64_16 BLP16 dp_64_16 sky130_fd_pr_reram__reram_cell area_ox=0.0676
XMz_64_16 dz_64_16 WL64 SL16 VSS sky130_fd_pr__nfet_g5v0d10v5 w=1 l=0.5
XRz_64_16 BLZ16 dz_64_16 sky130_fd_pr_reram__reram_cell area_ox=0.0676
XMn_64_16 dn_64_16 WL64 SL16 VSS sky130_fd_pr__nfet_g5v0d10v5 w=1 l=0.5
XRn_64_16 BLN16 dn_64_16 sky130_fd_pr_reram__reram_cell area_ox=0.0676
XMp_64_17 dp_64_17 WL64 SL17 VSS sky130_fd_pr__nfet_g5v0d10v5 w=1 l=0.5
XRp_64_17 BLP17 dp_64_17 sky130_fd_pr_reram__reram_cell area_ox=0.0676
XMz_64_17 dz_64_17 WL64 SL17 VSS sky130_fd_pr__nfet_g5v0d10v5 w=1 l=0.5
XRz_64_17 BLZ17 dz_64_17 sky130_fd_pr_reram__reram_cell area_ox=0.0676
XMn_64_17 dn_64_17 WL64 SL17 VSS sky130_fd_pr__nfet_g5v0d10v5 w=1 l=0.5
XRn_64_17 BLN17 dn_64_17 sky130_fd_pr_reram__reram_cell area_ox=0.0676
XMp_64_18 dp_64_18 WL64 SL18 VSS sky130_fd_pr__nfet_g5v0d10v5 w=1 l=0.5
XRp_64_18 BLP18 dp_64_18 sky130_fd_pr_reram__reram_cell area_ox=0.0676
XMz_64_18 dz_64_18 WL64 SL18 VSS sky130_fd_pr__nfet_g5v0d10v5 w=1 l=0.5
XRz_64_18 BLZ18 dz_64_18 sky130_fd_pr_reram__reram_cell area_ox=0.0676
XMn_64_18 dn_64_18 WL64 SL18 VSS sky130_fd_pr__nfet_g5v0d10v5 w=1 l=0.5
XRn_64_18 BLN18 dn_64_18 sky130_fd_pr_reram__reram_cell area_ox=0.0676
XMp_64_19 dp_64_19 WL64 SL19 VSS sky130_fd_pr__nfet_g5v0d10v5 w=1 l=0.5
XRp_64_19 BLP19 dp_64_19 sky130_fd_pr_reram__reram_cell area_ox=0.0676
XMz_64_19 dz_64_19 WL64 SL19 VSS sky130_fd_pr__nfet_g5v0d10v5 w=1 l=0.5
XRz_64_19 BLZ19 dz_64_19 sky130_fd_pr_reram__reram_cell area_ox=0.0676
XMn_64_19 dn_64_19 WL64 SL19 VSS sky130_fd_pr__nfet_g5v0d10v5 w=1 l=0.5
XRn_64_19 BLN19 dn_64_19 sky130_fd_pr_reram__reram_cell area_ox=0.0676
XMp_64_20 dp_64_20 WL64 SL20 VSS sky130_fd_pr__nfet_g5v0d10v5 w=1 l=0.5
XRp_64_20 BLP20 dp_64_20 sky130_fd_pr_reram__reram_cell area_ox=0.0676
XMz_64_20 dz_64_20 WL64 SL20 VSS sky130_fd_pr__nfet_g5v0d10v5 w=1 l=0.5
XRz_64_20 BLZ20 dz_64_20 sky130_fd_pr_reram__reram_cell area_ox=0.0676
XMn_64_20 dn_64_20 WL64 SL20 VSS sky130_fd_pr__nfet_g5v0d10v5 w=1 l=0.5
XRn_64_20 BLN20 dn_64_20 sky130_fd_pr_reram__reram_cell area_ox=0.0676
XMp_64_21 dp_64_21 WL64 SL21 VSS sky130_fd_pr__nfet_g5v0d10v5 w=1 l=0.5
XRp_64_21 BLP21 dp_64_21 sky130_fd_pr_reram__reram_cell area_ox=0.0676
XMz_64_21 dz_64_21 WL64 SL21 VSS sky130_fd_pr__nfet_g5v0d10v5 w=1 l=0.5
XRz_64_21 BLZ21 dz_64_21 sky130_fd_pr_reram__reram_cell area_ox=0.0676
XMn_64_21 dn_64_21 WL64 SL21 VSS sky130_fd_pr__nfet_g5v0d10v5 w=1 l=0.5
XRn_64_21 BLN21 dn_64_21 sky130_fd_pr_reram__reram_cell area_ox=0.0676
XMp_64_22 dp_64_22 WL64 SL22 VSS sky130_fd_pr__nfet_g5v0d10v5 w=1 l=0.5
XRp_64_22 BLP22 dp_64_22 sky130_fd_pr_reram__reram_cell area_ox=0.0676
XMz_64_22 dz_64_22 WL64 SL22 VSS sky130_fd_pr__nfet_g5v0d10v5 w=1 l=0.5
XRz_64_22 BLZ22 dz_64_22 sky130_fd_pr_reram__reram_cell area_ox=0.0676
XMn_64_22 dn_64_22 WL64 SL22 VSS sky130_fd_pr__nfet_g5v0d10v5 w=1 l=0.5
XRn_64_22 BLN22 dn_64_22 sky130_fd_pr_reram__reram_cell area_ox=0.0676
XMp_64_23 dp_64_23 WL64 SL23 VSS sky130_fd_pr__nfet_g5v0d10v5 w=1 l=0.5
XRp_64_23 BLP23 dp_64_23 sky130_fd_pr_reram__reram_cell area_ox=0.0676
XMz_64_23 dz_64_23 WL64 SL23 VSS sky130_fd_pr__nfet_g5v0d10v5 w=1 l=0.5
XRz_64_23 BLZ23 dz_64_23 sky130_fd_pr_reram__reram_cell area_ox=0.0676
XMn_64_23 dn_64_23 WL64 SL23 VSS sky130_fd_pr__nfet_g5v0d10v5 w=1 l=0.5
XRn_64_23 BLN23 dn_64_23 sky130_fd_pr_reram__reram_cell area_ox=0.0676
XMp_65_0 dp_65_0 WL65 SL0 VSS sky130_fd_pr__nfet_g5v0d10v5 w=1 l=0.5
XRp_65_0 BLP0 dp_65_0 sky130_fd_pr_reram__reram_cell area_ox=0.0676
XMz_65_0 dz_65_0 WL65 SL0 VSS sky130_fd_pr__nfet_g5v0d10v5 w=1 l=0.5
XRz_65_0 BLZ0 dz_65_0 sky130_fd_pr_reram__reram_cell area_ox=0.0676
XMn_65_0 dn_65_0 WL65 SL0 VSS sky130_fd_pr__nfet_g5v0d10v5 w=1 l=0.5
XRn_65_0 BLN0 dn_65_0 sky130_fd_pr_reram__reram_cell area_ox=0.0676
XMp_65_1 dp_65_1 WL65 SL1 VSS sky130_fd_pr__nfet_g5v0d10v5 w=1 l=0.5
XRp_65_1 BLP1 dp_65_1 sky130_fd_pr_reram__reram_cell area_ox=0.0676
XMz_65_1 dz_65_1 WL65 SL1 VSS sky130_fd_pr__nfet_g5v0d10v5 w=1 l=0.5
XRz_65_1 BLZ1 dz_65_1 sky130_fd_pr_reram__reram_cell area_ox=0.0676
XMn_65_1 dn_65_1 WL65 SL1 VSS sky130_fd_pr__nfet_g5v0d10v5 w=1 l=0.5
XRn_65_1 BLN1 dn_65_1 sky130_fd_pr_reram__reram_cell area_ox=0.0676
XMp_65_2 dp_65_2 WL65 SL2 VSS sky130_fd_pr__nfet_g5v0d10v5 w=1 l=0.5
XRp_65_2 BLP2 dp_65_2 sky130_fd_pr_reram__reram_cell area_ox=0.0676
XMz_65_2 dz_65_2 WL65 SL2 VSS sky130_fd_pr__nfet_g5v0d10v5 w=1 l=0.5
XRz_65_2 BLZ2 dz_65_2 sky130_fd_pr_reram__reram_cell area_ox=0.0676
XMn_65_2 dn_65_2 WL65 SL2 VSS sky130_fd_pr__nfet_g5v0d10v5 w=1 l=0.5
XRn_65_2 BLN2 dn_65_2 sky130_fd_pr_reram__reram_cell area_ox=0.0676
XMp_65_3 dp_65_3 WL65 SL3 VSS sky130_fd_pr__nfet_g5v0d10v5 w=1 l=0.5
XRp_65_3 BLP3 dp_65_3 sky130_fd_pr_reram__reram_cell area_ox=0.0676
XMz_65_3 dz_65_3 WL65 SL3 VSS sky130_fd_pr__nfet_g5v0d10v5 w=1 l=0.5
XRz_65_3 BLZ3 dz_65_3 sky130_fd_pr_reram__reram_cell area_ox=0.0676
XMn_65_3 dn_65_3 WL65 SL3 VSS sky130_fd_pr__nfet_g5v0d10v5 w=1 l=0.5
XRn_65_3 BLN3 dn_65_3 sky130_fd_pr_reram__reram_cell area_ox=0.0676
XMp_65_4 dp_65_4 WL65 SL4 VSS sky130_fd_pr__nfet_g5v0d10v5 w=1 l=0.5
XRp_65_4 BLP4 dp_65_4 sky130_fd_pr_reram__reram_cell area_ox=0.0676
XMz_65_4 dz_65_4 WL65 SL4 VSS sky130_fd_pr__nfet_g5v0d10v5 w=1 l=0.5
XRz_65_4 BLZ4 dz_65_4 sky130_fd_pr_reram__reram_cell area_ox=0.0676
XMn_65_4 dn_65_4 WL65 SL4 VSS sky130_fd_pr__nfet_g5v0d10v5 w=1 l=0.5
XRn_65_4 BLN4 dn_65_4 sky130_fd_pr_reram__reram_cell area_ox=0.0676
XMp_65_5 dp_65_5 WL65 SL5 VSS sky130_fd_pr__nfet_g5v0d10v5 w=1 l=0.5
XRp_65_5 BLP5 dp_65_5 sky130_fd_pr_reram__reram_cell area_ox=0.0676
XMz_65_5 dz_65_5 WL65 SL5 VSS sky130_fd_pr__nfet_g5v0d10v5 w=1 l=0.5
XRz_65_5 BLZ5 dz_65_5 sky130_fd_pr_reram__reram_cell area_ox=0.0676
XMn_65_5 dn_65_5 WL65 SL5 VSS sky130_fd_pr__nfet_g5v0d10v5 w=1 l=0.5
XRn_65_5 BLN5 dn_65_5 sky130_fd_pr_reram__reram_cell area_ox=0.0676
XMp_65_6 dp_65_6 WL65 SL6 VSS sky130_fd_pr__nfet_g5v0d10v5 w=1 l=0.5
XRp_65_6 BLP6 dp_65_6 sky130_fd_pr_reram__reram_cell area_ox=0.0676
XMz_65_6 dz_65_6 WL65 SL6 VSS sky130_fd_pr__nfet_g5v0d10v5 w=1 l=0.5
XRz_65_6 BLZ6 dz_65_6 sky130_fd_pr_reram__reram_cell area_ox=0.0676
XMn_65_6 dn_65_6 WL65 SL6 VSS sky130_fd_pr__nfet_g5v0d10v5 w=1 l=0.5
XRn_65_6 BLN6 dn_65_6 sky130_fd_pr_reram__reram_cell area_ox=0.0676
XMp_65_7 dp_65_7 WL65 SL7 VSS sky130_fd_pr__nfet_g5v0d10v5 w=1 l=0.5
XRp_65_7 BLP7 dp_65_7 sky130_fd_pr_reram__reram_cell area_ox=0.0676
XMz_65_7 dz_65_7 WL65 SL7 VSS sky130_fd_pr__nfet_g5v0d10v5 w=1 l=0.5
XRz_65_7 BLZ7 dz_65_7 sky130_fd_pr_reram__reram_cell area_ox=0.0676
XMn_65_7 dn_65_7 WL65 SL7 VSS sky130_fd_pr__nfet_g5v0d10v5 w=1 l=0.5
XRn_65_7 BLN7 dn_65_7 sky130_fd_pr_reram__reram_cell area_ox=0.0676
XMp_65_8 dp_65_8 WL65 SL8 VSS sky130_fd_pr__nfet_g5v0d10v5 w=1 l=0.5
XRp_65_8 BLP8 dp_65_8 sky130_fd_pr_reram__reram_cell area_ox=0.0676
XMz_65_8 dz_65_8 WL65 SL8 VSS sky130_fd_pr__nfet_g5v0d10v5 w=1 l=0.5
XRz_65_8 BLZ8 dz_65_8 sky130_fd_pr_reram__reram_cell area_ox=0.0676
XMn_65_8 dn_65_8 WL65 SL8 VSS sky130_fd_pr__nfet_g5v0d10v5 w=1 l=0.5
XRn_65_8 BLN8 dn_65_8 sky130_fd_pr_reram__reram_cell area_ox=0.0676
XMp_65_9 dp_65_9 WL65 SL9 VSS sky130_fd_pr__nfet_g5v0d10v5 w=1 l=0.5
XRp_65_9 BLP9 dp_65_9 sky130_fd_pr_reram__reram_cell area_ox=0.0676
XMz_65_9 dz_65_9 WL65 SL9 VSS sky130_fd_pr__nfet_g5v0d10v5 w=1 l=0.5
XRz_65_9 BLZ9 dz_65_9 sky130_fd_pr_reram__reram_cell area_ox=0.0676
XMn_65_9 dn_65_9 WL65 SL9 VSS sky130_fd_pr__nfet_g5v0d10v5 w=1 l=0.5
XRn_65_9 BLN9 dn_65_9 sky130_fd_pr_reram__reram_cell area_ox=0.0676
XMp_65_10 dp_65_10 WL65 SL10 VSS sky130_fd_pr__nfet_g5v0d10v5 w=1 l=0.5
XRp_65_10 BLP10 dp_65_10 sky130_fd_pr_reram__reram_cell area_ox=0.0676
XMz_65_10 dz_65_10 WL65 SL10 VSS sky130_fd_pr__nfet_g5v0d10v5 w=1 l=0.5
XRz_65_10 BLZ10 dz_65_10 sky130_fd_pr_reram__reram_cell area_ox=0.0676
XMn_65_10 dn_65_10 WL65 SL10 VSS sky130_fd_pr__nfet_g5v0d10v5 w=1 l=0.5
XRn_65_10 BLN10 dn_65_10 sky130_fd_pr_reram__reram_cell area_ox=0.0676
XMp_65_11 dp_65_11 WL65 SL11 VSS sky130_fd_pr__nfet_g5v0d10v5 w=1 l=0.5
XRp_65_11 BLP11 dp_65_11 sky130_fd_pr_reram__reram_cell area_ox=0.0676
XMz_65_11 dz_65_11 WL65 SL11 VSS sky130_fd_pr__nfet_g5v0d10v5 w=1 l=0.5
XRz_65_11 BLZ11 dz_65_11 sky130_fd_pr_reram__reram_cell area_ox=0.0676
XMn_65_11 dn_65_11 WL65 SL11 VSS sky130_fd_pr__nfet_g5v0d10v5 w=1 l=0.5
XRn_65_11 BLN11 dn_65_11 sky130_fd_pr_reram__reram_cell area_ox=0.0676
XMp_65_12 dp_65_12 WL65 SL12 VSS sky130_fd_pr__nfet_g5v0d10v5 w=1 l=0.5
XRp_65_12 BLP12 dp_65_12 sky130_fd_pr_reram__reram_cell area_ox=0.0676
XMz_65_12 dz_65_12 WL65 SL12 VSS sky130_fd_pr__nfet_g5v0d10v5 w=1 l=0.5
XRz_65_12 BLZ12 dz_65_12 sky130_fd_pr_reram__reram_cell area_ox=0.0676
XMn_65_12 dn_65_12 WL65 SL12 VSS sky130_fd_pr__nfet_g5v0d10v5 w=1 l=0.5
XRn_65_12 BLN12 dn_65_12 sky130_fd_pr_reram__reram_cell area_ox=0.0676
XMp_65_13 dp_65_13 WL65 SL13 VSS sky130_fd_pr__nfet_g5v0d10v5 w=1 l=0.5
XRp_65_13 BLP13 dp_65_13 sky130_fd_pr_reram__reram_cell area_ox=0.0676
XMz_65_13 dz_65_13 WL65 SL13 VSS sky130_fd_pr__nfet_g5v0d10v5 w=1 l=0.5
XRz_65_13 BLZ13 dz_65_13 sky130_fd_pr_reram__reram_cell area_ox=0.0676
XMn_65_13 dn_65_13 WL65 SL13 VSS sky130_fd_pr__nfet_g5v0d10v5 w=1 l=0.5
XRn_65_13 BLN13 dn_65_13 sky130_fd_pr_reram__reram_cell area_ox=0.0676
XMp_65_14 dp_65_14 WL65 SL14 VSS sky130_fd_pr__nfet_g5v0d10v5 w=1 l=0.5
XRp_65_14 BLP14 dp_65_14 sky130_fd_pr_reram__reram_cell area_ox=0.0676
XMz_65_14 dz_65_14 WL65 SL14 VSS sky130_fd_pr__nfet_g5v0d10v5 w=1 l=0.5
XRz_65_14 BLZ14 dz_65_14 sky130_fd_pr_reram__reram_cell area_ox=0.0676
XMn_65_14 dn_65_14 WL65 SL14 VSS sky130_fd_pr__nfet_g5v0d10v5 w=1 l=0.5
XRn_65_14 BLN14 dn_65_14 sky130_fd_pr_reram__reram_cell area_ox=0.0676
XMp_65_15 dp_65_15 WL65 SL15 VSS sky130_fd_pr__nfet_g5v0d10v5 w=1 l=0.5
XRp_65_15 BLP15 dp_65_15 sky130_fd_pr_reram__reram_cell area_ox=0.0676
XMz_65_15 dz_65_15 WL65 SL15 VSS sky130_fd_pr__nfet_g5v0d10v5 w=1 l=0.5
XRz_65_15 BLZ15 dz_65_15 sky130_fd_pr_reram__reram_cell area_ox=0.0676
XMn_65_15 dn_65_15 WL65 SL15 VSS sky130_fd_pr__nfet_g5v0d10v5 w=1 l=0.5
XRn_65_15 BLN15 dn_65_15 sky130_fd_pr_reram__reram_cell area_ox=0.0676
XMp_65_16 dp_65_16 WL65 SL16 VSS sky130_fd_pr__nfet_g5v0d10v5 w=1 l=0.5
XRp_65_16 BLP16 dp_65_16 sky130_fd_pr_reram__reram_cell area_ox=0.0676
XMz_65_16 dz_65_16 WL65 SL16 VSS sky130_fd_pr__nfet_g5v0d10v5 w=1 l=0.5
XRz_65_16 BLZ16 dz_65_16 sky130_fd_pr_reram__reram_cell area_ox=0.0676
XMn_65_16 dn_65_16 WL65 SL16 VSS sky130_fd_pr__nfet_g5v0d10v5 w=1 l=0.5
XRn_65_16 BLN16 dn_65_16 sky130_fd_pr_reram__reram_cell area_ox=0.0676
XMp_65_17 dp_65_17 WL65 SL17 VSS sky130_fd_pr__nfet_g5v0d10v5 w=1 l=0.5
XRp_65_17 BLP17 dp_65_17 sky130_fd_pr_reram__reram_cell area_ox=0.0676
XMz_65_17 dz_65_17 WL65 SL17 VSS sky130_fd_pr__nfet_g5v0d10v5 w=1 l=0.5
XRz_65_17 BLZ17 dz_65_17 sky130_fd_pr_reram__reram_cell area_ox=0.0676
XMn_65_17 dn_65_17 WL65 SL17 VSS sky130_fd_pr__nfet_g5v0d10v5 w=1 l=0.5
XRn_65_17 BLN17 dn_65_17 sky130_fd_pr_reram__reram_cell area_ox=0.0676
XMp_65_18 dp_65_18 WL65 SL18 VSS sky130_fd_pr__nfet_g5v0d10v5 w=1 l=0.5
XRp_65_18 BLP18 dp_65_18 sky130_fd_pr_reram__reram_cell area_ox=0.0676
XMz_65_18 dz_65_18 WL65 SL18 VSS sky130_fd_pr__nfet_g5v0d10v5 w=1 l=0.5
XRz_65_18 BLZ18 dz_65_18 sky130_fd_pr_reram__reram_cell area_ox=0.0676
XMn_65_18 dn_65_18 WL65 SL18 VSS sky130_fd_pr__nfet_g5v0d10v5 w=1 l=0.5
XRn_65_18 BLN18 dn_65_18 sky130_fd_pr_reram__reram_cell area_ox=0.0676
XMp_65_19 dp_65_19 WL65 SL19 VSS sky130_fd_pr__nfet_g5v0d10v5 w=1 l=0.5
XRp_65_19 BLP19 dp_65_19 sky130_fd_pr_reram__reram_cell area_ox=0.0676
XMz_65_19 dz_65_19 WL65 SL19 VSS sky130_fd_pr__nfet_g5v0d10v5 w=1 l=0.5
XRz_65_19 BLZ19 dz_65_19 sky130_fd_pr_reram__reram_cell area_ox=0.0676
XMn_65_19 dn_65_19 WL65 SL19 VSS sky130_fd_pr__nfet_g5v0d10v5 w=1 l=0.5
XRn_65_19 BLN19 dn_65_19 sky130_fd_pr_reram__reram_cell area_ox=0.0676
XMp_65_20 dp_65_20 WL65 SL20 VSS sky130_fd_pr__nfet_g5v0d10v5 w=1 l=0.5
XRp_65_20 BLP20 dp_65_20 sky130_fd_pr_reram__reram_cell area_ox=0.0676
XMz_65_20 dz_65_20 WL65 SL20 VSS sky130_fd_pr__nfet_g5v0d10v5 w=1 l=0.5
XRz_65_20 BLZ20 dz_65_20 sky130_fd_pr_reram__reram_cell area_ox=0.0676
XMn_65_20 dn_65_20 WL65 SL20 VSS sky130_fd_pr__nfet_g5v0d10v5 w=1 l=0.5
XRn_65_20 BLN20 dn_65_20 sky130_fd_pr_reram__reram_cell area_ox=0.0676
XMp_65_21 dp_65_21 WL65 SL21 VSS sky130_fd_pr__nfet_g5v0d10v5 w=1 l=0.5
XRp_65_21 BLP21 dp_65_21 sky130_fd_pr_reram__reram_cell area_ox=0.0676
XMz_65_21 dz_65_21 WL65 SL21 VSS sky130_fd_pr__nfet_g5v0d10v5 w=1 l=0.5
XRz_65_21 BLZ21 dz_65_21 sky130_fd_pr_reram__reram_cell area_ox=0.0676
XMn_65_21 dn_65_21 WL65 SL21 VSS sky130_fd_pr__nfet_g5v0d10v5 w=1 l=0.5
XRn_65_21 BLN21 dn_65_21 sky130_fd_pr_reram__reram_cell area_ox=0.0676
XMp_65_22 dp_65_22 WL65 SL22 VSS sky130_fd_pr__nfet_g5v0d10v5 w=1 l=0.5
XRp_65_22 BLP22 dp_65_22 sky130_fd_pr_reram__reram_cell area_ox=0.0676
XMz_65_22 dz_65_22 WL65 SL22 VSS sky130_fd_pr__nfet_g5v0d10v5 w=1 l=0.5
XRz_65_22 BLZ22 dz_65_22 sky130_fd_pr_reram__reram_cell area_ox=0.0676
XMn_65_22 dn_65_22 WL65 SL22 VSS sky130_fd_pr__nfet_g5v0d10v5 w=1 l=0.5
XRn_65_22 BLN22 dn_65_22 sky130_fd_pr_reram__reram_cell area_ox=0.0676
XMp_65_23 dp_65_23 WL65 SL23 VSS sky130_fd_pr__nfet_g5v0d10v5 w=1 l=0.5
XRp_65_23 BLP23 dp_65_23 sky130_fd_pr_reram__reram_cell area_ox=0.0676
XMz_65_23 dz_65_23 WL65 SL23 VSS sky130_fd_pr__nfet_g5v0d10v5 w=1 l=0.5
XRz_65_23 BLZ23 dz_65_23 sky130_fd_pr_reram__reram_cell area_ox=0.0676
XMn_65_23 dn_65_23 WL65 SL23 VSS sky130_fd_pr__nfet_g5v0d10v5 w=1 l=0.5
XRn_65_23 BLN23 dn_65_23 sky130_fd_pr_reram__reram_cell area_ox=0.0676
XMp_66_0 dp_66_0 WL66 SL0 VSS sky130_fd_pr__nfet_g5v0d10v5 w=1 l=0.5
XRp_66_0 BLP0 dp_66_0 sky130_fd_pr_reram__reram_cell area_ox=0.0676
XMz_66_0 dz_66_0 WL66 SL0 VSS sky130_fd_pr__nfet_g5v0d10v5 w=1 l=0.5
XRz_66_0 BLZ0 dz_66_0 sky130_fd_pr_reram__reram_cell area_ox=0.0676
XMn_66_0 dn_66_0 WL66 SL0 VSS sky130_fd_pr__nfet_g5v0d10v5 w=1 l=0.5
XRn_66_0 BLN0 dn_66_0 sky130_fd_pr_reram__reram_cell area_ox=0.0676
XMp_66_1 dp_66_1 WL66 SL1 VSS sky130_fd_pr__nfet_g5v0d10v5 w=1 l=0.5
XRp_66_1 BLP1 dp_66_1 sky130_fd_pr_reram__reram_cell area_ox=0.0676
XMz_66_1 dz_66_1 WL66 SL1 VSS sky130_fd_pr__nfet_g5v0d10v5 w=1 l=0.5
XRz_66_1 BLZ1 dz_66_1 sky130_fd_pr_reram__reram_cell area_ox=0.0676
XMn_66_1 dn_66_1 WL66 SL1 VSS sky130_fd_pr__nfet_g5v0d10v5 w=1 l=0.5
XRn_66_1 BLN1 dn_66_1 sky130_fd_pr_reram__reram_cell area_ox=0.0676
XMp_66_2 dp_66_2 WL66 SL2 VSS sky130_fd_pr__nfet_g5v0d10v5 w=1 l=0.5
XRp_66_2 BLP2 dp_66_2 sky130_fd_pr_reram__reram_cell area_ox=0.0676
XMz_66_2 dz_66_2 WL66 SL2 VSS sky130_fd_pr__nfet_g5v0d10v5 w=1 l=0.5
XRz_66_2 BLZ2 dz_66_2 sky130_fd_pr_reram__reram_cell area_ox=0.0676
XMn_66_2 dn_66_2 WL66 SL2 VSS sky130_fd_pr__nfet_g5v0d10v5 w=1 l=0.5
XRn_66_2 BLN2 dn_66_2 sky130_fd_pr_reram__reram_cell area_ox=0.0676
XMp_66_3 dp_66_3 WL66 SL3 VSS sky130_fd_pr__nfet_g5v0d10v5 w=1 l=0.5
XRp_66_3 BLP3 dp_66_3 sky130_fd_pr_reram__reram_cell area_ox=0.0676
XMz_66_3 dz_66_3 WL66 SL3 VSS sky130_fd_pr__nfet_g5v0d10v5 w=1 l=0.5
XRz_66_3 BLZ3 dz_66_3 sky130_fd_pr_reram__reram_cell area_ox=0.0676
XMn_66_3 dn_66_3 WL66 SL3 VSS sky130_fd_pr__nfet_g5v0d10v5 w=1 l=0.5
XRn_66_3 BLN3 dn_66_3 sky130_fd_pr_reram__reram_cell area_ox=0.0676
XMp_66_4 dp_66_4 WL66 SL4 VSS sky130_fd_pr__nfet_g5v0d10v5 w=1 l=0.5
XRp_66_4 BLP4 dp_66_4 sky130_fd_pr_reram__reram_cell area_ox=0.0676
XMz_66_4 dz_66_4 WL66 SL4 VSS sky130_fd_pr__nfet_g5v0d10v5 w=1 l=0.5
XRz_66_4 BLZ4 dz_66_4 sky130_fd_pr_reram__reram_cell area_ox=0.0676
XMn_66_4 dn_66_4 WL66 SL4 VSS sky130_fd_pr__nfet_g5v0d10v5 w=1 l=0.5
XRn_66_4 BLN4 dn_66_4 sky130_fd_pr_reram__reram_cell area_ox=0.0676
XMp_66_5 dp_66_5 WL66 SL5 VSS sky130_fd_pr__nfet_g5v0d10v5 w=1 l=0.5
XRp_66_5 BLP5 dp_66_5 sky130_fd_pr_reram__reram_cell area_ox=0.0676
XMz_66_5 dz_66_5 WL66 SL5 VSS sky130_fd_pr__nfet_g5v0d10v5 w=1 l=0.5
XRz_66_5 BLZ5 dz_66_5 sky130_fd_pr_reram__reram_cell area_ox=0.0676
XMn_66_5 dn_66_5 WL66 SL5 VSS sky130_fd_pr__nfet_g5v0d10v5 w=1 l=0.5
XRn_66_5 BLN5 dn_66_5 sky130_fd_pr_reram__reram_cell area_ox=0.0676
XMp_66_6 dp_66_6 WL66 SL6 VSS sky130_fd_pr__nfet_g5v0d10v5 w=1 l=0.5
XRp_66_6 BLP6 dp_66_6 sky130_fd_pr_reram__reram_cell area_ox=0.0676
XMz_66_6 dz_66_6 WL66 SL6 VSS sky130_fd_pr__nfet_g5v0d10v5 w=1 l=0.5
XRz_66_6 BLZ6 dz_66_6 sky130_fd_pr_reram__reram_cell area_ox=0.0676
XMn_66_6 dn_66_6 WL66 SL6 VSS sky130_fd_pr__nfet_g5v0d10v5 w=1 l=0.5
XRn_66_6 BLN6 dn_66_6 sky130_fd_pr_reram__reram_cell area_ox=0.0676
XMp_66_7 dp_66_7 WL66 SL7 VSS sky130_fd_pr__nfet_g5v0d10v5 w=1 l=0.5
XRp_66_7 BLP7 dp_66_7 sky130_fd_pr_reram__reram_cell area_ox=0.0676
XMz_66_7 dz_66_7 WL66 SL7 VSS sky130_fd_pr__nfet_g5v0d10v5 w=1 l=0.5
XRz_66_7 BLZ7 dz_66_7 sky130_fd_pr_reram__reram_cell area_ox=0.0676
XMn_66_7 dn_66_7 WL66 SL7 VSS sky130_fd_pr__nfet_g5v0d10v5 w=1 l=0.5
XRn_66_7 BLN7 dn_66_7 sky130_fd_pr_reram__reram_cell area_ox=0.0676
XMp_66_8 dp_66_8 WL66 SL8 VSS sky130_fd_pr__nfet_g5v0d10v5 w=1 l=0.5
XRp_66_8 BLP8 dp_66_8 sky130_fd_pr_reram__reram_cell area_ox=0.0676
XMz_66_8 dz_66_8 WL66 SL8 VSS sky130_fd_pr__nfet_g5v0d10v5 w=1 l=0.5
XRz_66_8 BLZ8 dz_66_8 sky130_fd_pr_reram__reram_cell area_ox=0.0676
XMn_66_8 dn_66_8 WL66 SL8 VSS sky130_fd_pr__nfet_g5v0d10v5 w=1 l=0.5
XRn_66_8 BLN8 dn_66_8 sky130_fd_pr_reram__reram_cell area_ox=0.0676
XMp_66_9 dp_66_9 WL66 SL9 VSS sky130_fd_pr__nfet_g5v0d10v5 w=1 l=0.5
XRp_66_9 BLP9 dp_66_9 sky130_fd_pr_reram__reram_cell area_ox=0.0676
XMz_66_9 dz_66_9 WL66 SL9 VSS sky130_fd_pr__nfet_g5v0d10v5 w=1 l=0.5
XRz_66_9 BLZ9 dz_66_9 sky130_fd_pr_reram__reram_cell area_ox=0.0676
XMn_66_9 dn_66_9 WL66 SL9 VSS sky130_fd_pr__nfet_g5v0d10v5 w=1 l=0.5
XRn_66_9 BLN9 dn_66_9 sky130_fd_pr_reram__reram_cell area_ox=0.0676
XMp_66_10 dp_66_10 WL66 SL10 VSS sky130_fd_pr__nfet_g5v0d10v5 w=1 l=0.5
XRp_66_10 BLP10 dp_66_10 sky130_fd_pr_reram__reram_cell area_ox=0.0676
XMz_66_10 dz_66_10 WL66 SL10 VSS sky130_fd_pr__nfet_g5v0d10v5 w=1 l=0.5
XRz_66_10 BLZ10 dz_66_10 sky130_fd_pr_reram__reram_cell area_ox=0.0676
XMn_66_10 dn_66_10 WL66 SL10 VSS sky130_fd_pr__nfet_g5v0d10v5 w=1 l=0.5
XRn_66_10 BLN10 dn_66_10 sky130_fd_pr_reram__reram_cell area_ox=0.0676
XMp_66_11 dp_66_11 WL66 SL11 VSS sky130_fd_pr__nfet_g5v0d10v5 w=1 l=0.5
XRp_66_11 BLP11 dp_66_11 sky130_fd_pr_reram__reram_cell area_ox=0.0676
XMz_66_11 dz_66_11 WL66 SL11 VSS sky130_fd_pr__nfet_g5v0d10v5 w=1 l=0.5
XRz_66_11 BLZ11 dz_66_11 sky130_fd_pr_reram__reram_cell area_ox=0.0676
XMn_66_11 dn_66_11 WL66 SL11 VSS sky130_fd_pr__nfet_g5v0d10v5 w=1 l=0.5
XRn_66_11 BLN11 dn_66_11 sky130_fd_pr_reram__reram_cell area_ox=0.0676
XMp_66_12 dp_66_12 WL66 SL12 VSS sky130_fd_pr__nfet_g5v0d10v5 w=1 l=0.5
XRp_66_12 BLP12 dp_66_12 sky130_fd_pr_reram__reram_cell area_ox=0.0676
XMz_66_12 dz_66_12 WL66 SL12 VSS sky130_fd_pr__nfet_g5v0d10v5 w=1 l=0.5
XRz_66_12 BLZ12 dz_66_12 sky130_fd_pr_reram__reram_cell area_ox=0.0676
XMn_66_12 dn_66_12 WL66 SL12 VSS sky130_fd_pr__nfet_g5v0d10v5 w=1 l=0.5
XRn_66_12 BLN12 dn_66_12 sky130_fd_pr_reram__reram_cell area_ox=0.0676
XMp_66_13 dp_66_13 WL66 SL13 VSS sky130_fd_pr__nfet_g5v0d10v5 w=1 l=0.5
XRp_66_13 BLP13 dp_66_13 sky130_fd_pr_reram__reram_cell area_ox=0.0676
XMz_66_13 dz_66_13 WL66 SL13 VSS sky130_fd_pr__nfet_g5v0d10v5 w=1 l=0.5
XRz_66_13 BLZ13 dz_66_13 sky130_fd_pr_reram__reram_cell area_ox=0.0676
XMn_66_13 dn_66_13 WL66 SL13 VSS sky130_fd_pr__nfet_g5v0d10v5 w=1 l=0.5
XRn_66_13 BLN13 dn_66_13 sky130_fd_pr_reram__reram_cell area_ox=0.0676
XMp_66_14 dp_66_14 WL66 SL14 VSS sky130_fd_pr__nfet_g5v0d10v5 w=1 l=0.5
XRp_66_14 BLP14 dp_66_14 sky130_fd_pr_reram__reram_cell area_ox=0.0676
XMz_66_14 dz_66_14 WL66 SL14 VSS sky130_fd_pr__nfet_g5v0d10v5 w=1 l=0.5
XRz_66_14 BLZ14 dz_66_14 sky130_fd_pr_reram__reram_cell area_ox=0.0676
XMn_66_14 dn_66_14 WL66 SL14 VSS sky130_fd_pr__nfet_g5v0d10v5 w=1 l=0.5
XRn_66_14 BLN14 dn_66_14 sky130_fd_pr_reram__reram_cell area_ox=0.0676
XMp_66_15 dp_66_15 WL66 SL15 VSS sky130_fd_pr__nfet_g5v0d10v5 w=1 l=0.5
XRp_66_15 BLP15 dp_66_15 sky130_fd_pr_reram__reram_cell area_ox=0.0676
XMz_66_15 dz_66_15 WL66 SL15 VSS sky130_fd_pr__nfet_g5v0d10v5 w=1 l=0.5
XRz_66_15 BLZ15 dz_66_15 sky130_fd_pr_reram__reram_cell area_ox=0.0676
XMn_66_15 dn_66_15 WL66 SL15 VSS sky130_fd_pr__nfet_g5v0d10v5 w=1 l=0.5
XRn_66_15 BLN15 dn_66_15 sky130_fd_pr_reram__reram_cell area_ox=0.0676
XMp_66_16 dp_66_16 WL66 SL16 VSS sky130_fd_pr__nfet_g5v0d10v5 w=1 l=0.5
XRp_66_16 BLP16 dp_66_16 sky130_fd_pr_reram__reram_cell area_ox=0.0676
XMz_66_16 dz_66_16 WL66 SL16 VSS sky130_fd_pr__nfet_g5v0d10v5 w=1 l=0.5
XRz_66_16 BLZ16 dz_66_16 sky130_fd_pr_reram__reram_cell area_ox=0.0676
XMn_66_16 dn_66_16 WL66 SL16 VSS sky130_fd_pr__nfet_g5v0d10v5 w=1 l=0.5
XRn_66_16 BLN16 dn_66_16 sky130_fd_pr_reram__reram_cell area_ox=0.0676
XMp_66_17 dp_66_17 WL66 SL17 VSS sky130_fd_pr__nfet_g5v0d10v5 w=1 l=0.5
XRp_66_17 BLP17 dp_66_17 sky130_fd_pr_reram__reram_cell area_ox=0.0676
XMz_66_17 dz_66_17 WL66 SL17 VSS sky130_fd_pr__nfet_g5v0d10v5 w=1 l=0.5
XRz_66_17 BLZ17 dz_66_17 sky130_fd_pr_reram__reram_cell area_ox=0.0676
XMn_66_17 dn_66_17 WL66 SL17 VSS sky130_fd_pr__nfet_g5v0d10v5 w=1 l=0.5
XRn_66_17 BLN17 dn_66_17 sky130_fd_pr_reram__reram_cell area_ox=0.0676
XMp_66_18 dp_66_18 WL66 SL18 VSS sky130_fd_pr__nfet_g5v0d10v5 w=1 l=0.5
XRp_66_18 BLP18 dp_66_18 sky130_fd_pr_reram__reram_cell area_ox=0.0676
XMz_66_18 dz_66_18 WL66 SL18 VSS sky130_fd_pr__nfet_g5v0d10v5 w=1 l=0.5
XRz_66_18 BLZ18 dz_66_18 sky130_fd_pr_reram__reram_cell area_ox=0.0676
XMn_66_18 dn_66_18 WL66 SL18 VSS sky130_fd_pr__nfet_g5v0d10v5 w=1 l=0.5
XRn_66_18 BLN18 dn_66_18 sky130_fd_pr_reram__reram_cell area_ox=0.0676
XMp_66_19 dp_66_19 WL66 SL19 VSS sky130_fd_pr__nfet_g5v0d10v5 w=1 l=0.5
XRp_66_19 BLP19 dp_66_19 sky130_fd_pr_reram__reram_cell area_ox=0.0676
XMz_66_19 dz_66_19 WL66 SL19 VSS sky130_fd_pr__nfet_g5v0d10v5 w=1 l=0.5
XRz_66_19 BLZ19 dz_66_19 sky130_fd_pr_reram__reram_cell area_ox=0.0676
XMn_66_19 dn_66_19 WL66 SL19 VSS sky130_fd_pr__nfet_g5v0d10v5 w=1 l=0.5
XRn_66_19 BLN19 dn_66_19 sky130_fd_pr_reram__reram_cell area_ox=0.0676
XMp_66_20 dp_66_20 WL66 SL20 VSS sky130_fd_pr__nfet_g5v0d10v5 w=1 l=0.5
XRp_66_20 BLP20 dp_66_20 sky130_fd_pr_reram__reram_cell area_ox=0.0676
XMz_66_20 dz_66_20 WL66 SL20 VSS sky130_fd_pr__nfet_g5v0d10v5 w=1 l=0.5
XRz_66_20 BLZ20 dz_66_20 sky130_fd_pr_reram__reram_cell area_ox=0.0676
XMn_66_20 dn_66_20 WL66 SL20 VSS sky130_fd_pr__nfet_g5v0d10v5 w=1 l=0.5
XRn_66_20 BLN20 dn_66_20 sky130_fd_pr_reram__reram_cell area_ox=0.0676
XMp_66_21 dp_66_21 WL66 SL21 VSS sky130_fd_pr__nfet_g5v0d10v5 w=1 l=0.5
XRp_66_21 BLP21 dp_66_21 sky130_fd_pr_reram__reram_cell area_ox=0.0676
XMz_66_21 dz_66_21 WL66 SL21 VSS sky130_fd_pr__nfet_g5v0d10v5 w=1 l=0.5
XRz_66_21 BLZ21 dz_66_21 sky130_fd_pr_reram__reram_cell area_ox=0.0676
XMn_66_21 dn_66_21 WL66 SL21 VSS sky130_fd_pr__nfet_g5v0d10v5 w=1 l=0.5
XRn_66_21 BLN21 dn_66_21 sky130_fd_pr_reram__reram_cell area_ox=0.0676
XMp_66_22 dp_66_22 WL66 SL22 VSS sky130_fd_pr__nfet_g5v0d10v5 w=1 l=0.5
XRp_66_22 BLP22 dp_66_22 sky130_fd_pr_reram__reram_cell area_ox=0.0676
XMz_66_22 dz_66_22 WL66 SL22 VSS sky130_fd_pr__nfet_g5v0d10v5 w=1 l=0.5
XRz_66_22 BLZ22 dz_66_22 sky130_fd_pr_reram__reram_cell area_ox=0.0676
XMn_66_22 dn_66_22 WL66 SL22 VSS sky130_fd_pr__nfet_g5v0d10v5 w=1 l=0.5
XRn_66_22 BLN22 dn_66_22 sky130_fd_pr_reram__reram_cell area_ox=0.0676
XMp_66_23 dp_66_23 WL66 SL23 VSS sky130_fd_pr__nfet_g5v0d10v5 w=1 l=0.5
XRp_66_23 BLP23 dp_66_23 sky130_fd_pr_reram__reram_cell area_ox=0.0676
XMz_66_23 dz_66_23 WL66 SL23 VSS sky130_fd_pr__nfet_g5v0d10v5 w=1 l=0.5
XRz_66_23 BLZ23 dz_66_23 sky130_fd_pr_reram__reram_cell area_ox=0.0676
XMn_66_23 dn_66_23 WL66 SL23 VSS sky130_fd_pr__nfet_g5v0d10v5 w=1 l=0.5
XRn_66_23 BLN23 dn_66_23 sky130_fd_pr_reram__reram_cell area_ox=0.0676
XMp_67_0 dp_67_0 WL67 SL0 VSS sky130_fd_pr__nfet_g5v0d10v5 w=1 l=0.5
XRp_67_0 BLP0 dp_67_0 sky130_fd_pr_reram__reram_cell area_ox=0.0676
XMz_67_0 dz_67_0 WL67 SL0 VSS sky130_fd_pr__nfet_g5v0d10v5 w=1 l=0.5
XRz_67_0 BLZ0 dz_67_0 sky130_fd_pr_reram__reram_cell area_ox=0.0676
XMn_67_0 dn_67_0 WL67 SL0 VSS sky130_fd_pr__nfet_g5v0d10v5 w=1 l=0.5
XRn_67_0 BLN0 dn_67_0 sky130_fd_pr_reram__reram_cell area_ox=0.0676
XMp_67_1 dp_67_1 WL67 SL1 VSS sky130_fd_pr__nfet_g5v0d10v5 w=1 l=0.5
XRp_67_1 BLP1 dp_67_1 sky130_fd_pr_reram__reram_cell area_ox=0.0676
XMz_67_1 dz_67_1 WL67 SL1 VSS sky130_fd_pr__nfet_g5v0d10v5 w=1 l=0.5
XRz_67_1 BLZ1 dz_67_1 sky130_fd_pr_reram__reram_cell area_ox=0.0676
XMn_67_1 dn_67_1 WL67 SL1 VSS sky130_fd_pr__nfet_g5v0d10v5 w=1 l=0.5
XRn_67_1 BLN1 dn_67_1 sky130_fd_pr_reram__reram_cell area_ox=0.0676
XMp_67_2 dp_67_2 WL67 SL2 VSS sky130_fd_pr__nfet_g5v0d10v5 w=1 l=0.5
XRp_67_2 BLP2 dp_67_2 sky130_fd_pr_reram__reram_cell area_ox=0.0676
XMz_67_2 dz_67_2 WL67 SL2 VSS sky130_fd_pr__nfet_g5v0d10v5 w=1 l=0.5
XRz_67_2 BLZ2 dz_67_2 sky130_fd_pr_reram__reram_cell area_ox=0.0676
XMn_67_2 dn_67_2 WL67 SL2 VSS sky130_fd_pr__nfet_g5v0d10v5 w=1 l=0.5
XRn_67_2 BLN2 dn_67_2 sky130_fd_pr_reram__reram_cell area_ox=0.0676
XMp_67_3 dp_67_3 WL67 SL3 VSS sky130_fd_pr__nfet_g5v0d10v5 w=1 l=0.5
XRp_67_3 BLP3 dp_67_3 sky130_fd_pr_reram__reram_cell area_ox=0.0676
XMz_67_3 dz_67_3 WL67 SL3 VSS sky130_fd_pr__nfet_g5v0d10v5 w=1 l=0.5
XRz_67_3 BLZ3 dz_67_3 sky130_fd_pr_reram__reram_cell area_ox=0.0676
XMn_67_3 dn_67_3 WL67 SL3 VSS sky130_fd_pr__nfet_g5v0d10v5 w=1 l=0.5
XRn_67_3 BLN3 dn_67_3 sky130_fd_pr_reram__reram_cell area_ox=0.0676
XMp_67_4 dp_67_4 WL67 SL4 VSS sky130_fd_pr__nfet_g5v0d10v5 w=1 l=0.5
XRp_67_4 BLP4 dp_67_4 sky130_fd_pr_reram__reram_cell area_ox=0.0676
XMz_67_4 dz_67_4 WL67 SL4 VSS sky130_fd_pr__nfet_g5v0d10v5 w=1 l=0.5
XRz_67_4 BLZ4 dz_67_4 sky130_fd_pr_reram__reram_cell area_ox=0.0676
XMn_67_4 dn_67_4 WL67 SL4 VSS sky130_fd_pr__nfet_g5v0d10v5 w=1 l=0.5
XRn_67_4 BLN4 dn_67_4 sky130_fd_pr_reram__reram_cell area_ox=0.0676
XMp_67_5 dp_67_5 WL67 SL5 VSS sky130_fd_pr__nfet_g5v0d10v5 w=1 l=0.5
XRp_67_5 BLP5 dp_67_5 sky130_fd_pr_reram__reram_cell area_ox=0.0676
XMz_67_5 dz_67_5 WL67 SL5 VSS sky130_fd_pr__nfet_g5v0d10v5 w=1 l=0.5
XRz_67_5 BLZ5 dz_67_5 sky130_fd_pr_reram__reram_cell area_ox=0.0676
XMn_67_5 dn_67_5 WL67 SL5 VSS sky130_fd_pr__nfet_g5v0d10v5 w=1 l=0.5
XRn_67_5 BLN5 dn_67_5 sky130_fd_pr_reram__reram_cell area_ox=0.0676
XMp_67_6 dp_67_6 WL67 SL6 VSS sky130_fd_pr__nfet_g5v0d10v5 w=1 l=0.5
XRp_67_6 BLP6 dp_67_6 sky130_fd_pr_reram__reram_cell area_ox=0.0676
XMz_67_6 dz_67_6 WL67 SL6 VSS sky130_fd_pr__nfet_g5v0d10v5 w=1 l=0.5
XRz_67_6 BLZ6 dz_67_6 sky130_fd_pr_reram__reram_cell area_ox=0.0676
XMn_67_6 dn_67_6 WL67 SL6 VSS sky130_fd_pr__nfet_g5v0d10v5 w=1 l=0.5
XRn_67_6 BLN6 dn_67_6 sky130_fd_pr_reram__reram_cell area_ox=0.0676
XMp_67_7 dp_67_7 WL67 SL7 VSS sky130_fd_pr__nfet_g5v0d10v5 w=1 l=0.5
XRp_67_7 BLP7 dp_67_7 sky130_fd_pr_reram__reram_cell area_ox=0.0676
XMz_67_7 dz_67_7 WL67 SL7 VSS sky130_fd_pr__nfet_g5v0d10v5 w=1 l=0.5
XRz_67_7 BLZ7 dz_67_7 sky130_fd_pr_reram__reram_cell area_ox=0.0676
XMn_67_7 dn_67_7 WL67 SL7 VSS sky130_fd_pr__nfet_g5v0d10v5 w=1 l=0.5
XRn_67_7 BLN7 dn_67_7 sky130_fd_pr_reram__reram_cell area_ox=0.0676
XMp_67_8 dp_67_8 WL67 SL8 VSS sky130_fd_pr__nfet_g5v0d10v5 w=1 l=0.5
XRp_67_8 BLP8 dp_67_8 sky130_fd_pr_reram__reram_cell area_ox=0.0676
XMz_67_8 dz_67_8 WL67 SL8 VSS sky130_fd_pr__nfet_g5v0d10v5 w=1 l=0.5
XRz_67_8 BLZ8 dz_67_8 sky130_fd_pr_reram__reram_cell area_ox=0.0676
XMn_67_8 dn_67_8 WL67 SL8 VSS sky130_fd_pr__nfet_g5v0d10v5 w=1 l=0.5
XRn_67_8 BLN8 dn_67_8 sky130_fd_pr_reram__reram_cell area_ox=0.0676
XMp_67_9 dp_67_9 WL67 SL9 VSS sky130_fd_pr__nfet_g5v0d10v5 w=1 l=0.5
XRp_67_9 BLP9 dp_67_9 sky130_fd_pr_reram__reram_cell area_ox=0.0676
XMz_67_9 dz_67_9 WL67 SL9 VSS sky130_fd_pr__nfet_g5v0d10v5 w=1 l=0.5
XRz_67_9 BLZ9 dz_67_9 sky130_fd_pr_reram__reram_cell area_ox=0.0676
XMn_67_9 dn_67_9 WL67 SL9 VSS sky130_fd_pr__nfet_g5v0d10v5 w=1 l=0.5
XRn_67_9 BLN9 dn_67_9 sky130_fd_pr_reram__reram_cell area_ox=0.0676
XMp_67_10 dp_67_10 WL67 SL10 VSS sky130_fd_pr__nfet_g5v0d10v5 w=1 l=0.5
XRp_67_10 BLP10 dp_67_10 sky130_fd_pr_reram__reram_cell area_ox=0.0676
XMz_67_10 dz_67_10 WL67 SL10 VSS sky130_fd_pr__nfet_g5v0d10v5 w=1 l=0.5
XRz_67_10 BLZ10 dz_67_10 sky130_fd_pr_reram__reram_cell area_ox=0.0676
XMn_67_10 dn_67_10 WL67 SL10 VSS sky130_fd_pr__nfet_g5v0d10v5 w=1 l=0.5
XRn_67_10 BLN10 dn_67_10 sky130_fd_pr_reram__reram_cell area_ox=0.0676
XMp_67_11 dp_67_11 WL67 SL11 VSS sky130_fd_pr__nfet_g5v0d10v5 w=1 l=0.5
XRp_67_11 BLP11 dp_67_11 sky130_fd_pr_reram__reram_cell area_ox=0.0676
XMz_67_11 dz_67_11 WL67 SL11 VSS sky130_fd_pr__nfet_g5v0d10v5 w=1 l=0.5
XRz_67_11 BLZ11 dz_67_11 sky130_fd_pr_reram__reram_cell area_ox=0.0676
XMn_67_11 dn_67_11 WL67 SL11 VSS sky130_fd_pr__nfet_g5v0d10v5 w=1 l=0.5
XRn_67_11 BLN11 dn_67_11 sky130_fd_pr_reram__reram_cell area_ox=0.0676
XMp_67_12 dp_67_12 WL67 SL12 VSS sky130_fd_pr__nfet_g5v0d10v5 w=1 l=0.5
XRp_67_12 BLP12 dp_67_12 sky130_fd_pr_reram__reram_cell area_ox=0.0676
XMz_67_12 dz_67_12 WL67 SL12 VSS sky130_fd_pr__nfet_g5v0d10v5 w=1 l=0.5
XRz_67_12 BLZ12 dz_67_12 sky130_fd_pr_reram__reram_cell area_ox=0.0676
XMn_67_12 dn_67_12 WL67 SL12 VSS sky130_fd_pr__nfet_g5v0d10v5 w=1 l=0.5
XRn_67_12 BLN12 dn_67_12 sky130_fd_pr_reram__reram_cell area_ox=0.0676
XMp_67_13 dp_67_13 WL67 SL13 VSS sky130_fd_pr__nfet_g5v0d10v5 w=1 l=0.5
XRp_67_13 BLP13 dp_67_13 sky130_fd_pr_reram__reram_cell area_ox=0.0676
XMz_67_13 dz_67_13 WL67 SL13 VSS sky130_fd_pr__nfet_g5v0d10v5 w=1 l=0.5
XRz_67_13 BLZ13 dz_67_13 sky130_fd_pr_reram__reram_cell area_ox=0.0676
XMn_67_13 dn_67_13 WL67 SL13 VSS sky130_fd_pr__nfet_g5v0d10v5 w=1 l=0.5
XRn_67_13 BLN13 dn_67_13 sky130_fd_pr_reram__reram_cell area_ox=0.0676
XMp_67_14 dp_67_14 WL67 SL14 VSS sky130_fd_pr__nfet_g5v0d10v5 w=1 l=0.5
XRp_67_14 BLP14 dp_67_14 sky130_fd_pr_reram__reram_cell area_ox=0.0676
XMz_67_14 dz_67_14 WL67 SL14 VSS sky130_fd_pr__nfet_g5v0d10v5 w=1 l=0.5
XRz_67_14 BLZ14 dz_67_14 sky130_fd_pr_reram__reram_cell area_ox=0.0676
XMn_67_14 dn_67_14 WL67 SL14 VSS sky130_fd_pr__nfet_g5v0d10v5 w=1 l=0.5
XRn_67_14 BLN14 dn_67_14 sky130_fd_pr_reram__reram_cell area_ox=0.0676
XMp_67_15 dp_67_15 WL67 SL15 VSS sky130_fd_pr__nfet_g5v0d10v5 w=1 l=0.5
XRp_67_15 BLP15 dp_67_15 sky130_fd_pr_reram__reram_cell area_ox=0.0676
XMz_67_15 dz_67_15 WL67 SL15 VSS sky130_fd_pr__nfet_g5v0d10v5 w=1 l=0.5
XRz_67_15 BLZ15 dz_67_15 sky130_fd_pr_reram__reram_cell area_ox=0.0676
XMn_67_15 dn_67_15 WL67 SL15 VSS sky130_fd_pr__nfet_g5v0d10v5 w=1 l=0.5
XRn_67_15 BLN15 dn_67_15 sky130_fd_pr_reram__reram_cell area_ox=0.0676
XMp_67_16 dp_67_16 WL67 SL16 VSS sky130_fd_pr__nfet_g5v0d10v5 w=1 l=0.5
XRp_67_16 BLP16 dp_67_16 sky130_fd_pr_reram__reram_cell area_ox=0.0676
XMz_67_16 dz_67_16 WL67 SL16 VSS sky130_fd_pr__nfet_g5v0d10v5 w=1 l=0.5
XRz_67_16 BLZ16 dz_67_16 sky130_fd_pr_reram__reram_cell area_ox=0.0676
XMn_67_16 dn_67_16 WL67 SL16 VSS sky130_fd_pr__nfet_g5v0d10v5 w=1 l=0.5
XRn_67_16 BLN16 dn_67_16 sky130_fd_pr_reram__reram_cell area_ox=0.0676
XMp_67_17 dp_67_17 WL67 SL17 VSS sky130_fd_pr__nfet_g5v0d10v5 w=1 l=0.5
XRp_67_17 BLP17 dp_67_17 sky130_fd_pr_reram__reram_cell area_ox=0.0676
XMz_67_17 dz_67_17 WL67 SL17 VSS sky130_fd_pr__nfet_g5v0d10v5 w=1 l=0.5
XRz_67_17 BLZ17 dz_67_17 sky130_fd_pr_reram__reram_cell area_ox=0.0676
XMn_67_17 dn_67_17 WL67 SL17 VSS sky130_fd_pr__nfet_g5v0d10v5 w=1 l=0.5
XRn_67_17 BLN17 dn_67_17 sky130_fd_pr_reram__reram_cell area_ox=0.0676
XMp_67_18 dp_67_18 WL67 SL18 VSS sky130_fd_pr__nfet_g5v0d10v5 w=1 l=0.5
XRp_67_18 BLP18 dp_67_18 sky130_fd_pr_reram__reram_cell area_ox=0.0676
XMz_67_18 dz_67_18 WL67 SL18 VSS sky130_fd_pr__nfet_g5v0d10v5 w=1 l=0.5
XRz_67_18 BLZ18 dz_67_18 sky130_fd_pr_reram__reram_cell area_ox=0.0676
XMn_67_18 dn_67_18 WL67 SL18 VSS sky130_fd_pr__nfet_g5v0d10v5 w=1 l=0.5
XRn_67_18 BLN18 dn_67_18 sky130_fd_pr_reram__reram_cell area_ox=0.0676
XMp_67_19 dp_67_19 WL67 SL19 VSS sky130_fd_pr__nfet_g5v0d10v5 w=1 l=0.5
XRp_67_19 BLP19 dp_67_19 sky130_fd_pr_reram__reram_cell area_ox=0.0676
XMz_67_19 dz_67_19 WL67 SL19 VSS sky130_fd_pr__nfet_g5v0d10v5 w=1 l=0.5
XRz_67_19 BLZ19 dz_67_19 sky130_fd_pr_reram__reram_cell area_ox=0.0676
XMn_67_19 dn_67_19 WL67 SL19 VSS sky130_fd_pr__nfet_g5v0d10v5 w=1 l=0.5
XRn_67_19 BLN19 dn_67_19 sky130_fd_pr_reram__reram_cell area_ox=0.0676
XMp_67_20 dp_67_20 WL67 SL20 VSS sky130_fd_pr__nfet_g5v0d10v5 w=1 l=0.5
XRp_67_20 BLP20 dp_67_20 sky130_fd_pr_reram__reram_cell area_ox=0.0676
XMz_67_20 dz_67_20 WL67 SL20 VSS sky130_fd_pr__nfet_g5v0d10v5 w=1 l=0.5
XRz_67_20 BLZ20 dz_67_20 sky130_fd_pr_reram__reram_cell area_ox=0.0676
XMn_67_20 dn_67_20 WL67 SL20 VSS sky130_fd_pr__nfet_g5v0d10v5 w=1 l=0.5
XRn_67_20 BLN20 dn_67_20 sky130_fd_pr_reram__reram_cell area_ox=0.0676
XMp_67_21 dp_67_21 WL67 SL21 VSS sky130_fd_pr__nfet_g5v0d10v5 w=1 l=0.5
XRp_67_21 BLP21 dp_67_21 sky130_fd_pr_reram__reram_cell area_ox=0.0676
XMz_67_21 dz_67_21 WL67 SL21 VSS sky130_fd_pr__nfet_g5v0d10v5 w=1 l=0.5
XRz_67_21 BLZ21 dz_67_21 sky130_fd_pr_reram__reram_cell area_ox=0.0676
XMn_67_21 dn_67_21 WL67 SL21 VSS sky130_fd_pr__nfet_g5v0d10v5 w=1 l=0.5
XRn_67_21 BLN21 dn_67_21 sky130_fd_pr_reram__reram_cell area_ox=0.0676
XMp_67_22 dp_67_22 WL67 SL22 VSS sky130_fd_pr__nfet_g5v0d10v5 w=1 l=0.5
XRp_67_22 BLP22 dp_67_22 sky130_fd_pr_reram__reram_cell area_ox=0.0676
XMz_67_22 dz_67_22 WL67 SL22 VSS sky130_fd_pr__nfet_g5v0d10v5 w=1 l=0.5
XRz_67_22 BLZ22 dz_67_22 sky130_fd_pr_reram__reram_cell area_ox=0.0676
XMn_67_22 dn_67_22 WL67 SL22 VSS sky130_fd_pr__nfet_g5v0d10v5 w=1 l=0.5
XRn_67_22 BLN22 dn_67_22 sky130_fd_pr_reram__reram_cell area_ox=0.0676
XMp_67_23 dp_67_23 WL67 SL23 VSS sky130_fd_pr__nfet_g5v0d10v5 w=1 l=0.5
XRp_67_23 BLP23 dp_67_23 sky130_fd_pr_reram__reram_cell area_ox=0.0676
XMz_67_23 dz_67_23 WL67 SL23 VSS sky130_fd_pr__nfet_g5v0d10v5 w=1 l=0.5
XRz_67_23 BLZ23 dz_67_23 sky130_fd_pr_reram__reram_cell area_ox=0.0676
XMn_67_23 dn_67_23 WL67 SL23 VSS sky130_fd_pr__nfet_g5v0d10v5 w=1 l=0.5
XRn_67_23 BLN23 dn_67_23 sky130_fd_pr_reram__reram_cell area_ox=0.0676
XMp_68_0 dp_68_0 WL68 SL0 VSS sky130_fd_pr__nfet_g5v0d10v5 w=1 l=0.5
XRp_68_0 BLP0 dp_68_0 sky130_fd_pr_reram__reram_cell area_ox=0.0676
XMz_68_0 dz_68_0 WL68 SL0 VSS sky130_fd_pr__nfet_g5v0d10v5 w=1 l=0.5
XRz_68_0 BLZ0 dz_68_0 sky130_fd_pr_reram__reram_cell area_ox=0.0676
XMn_68_0 dn_68_0 WL68 SL0 VSS sky130_fd_pr__nfet_g5v0d10v5 w=1 l=0.5
XRn_68_0 BLN0 dn_68_0 sky130_fd_pr_reram__reram_cell area_ox=0.0676
XMp_68_1 dp_68_1 WL68 SL1 VSS sky130_fd_pr__nfet_g5v0d10v5 w=1 l=0.5
XRp_68_1 BLP1 dp_68_1 sky130_fd_pr_reram__reram_cell area_ox=0.0676
XMz_68_1 dz_68_1 WL68 SL1 VSS sky130_fd_pr__nfet_g5v0d10v5 w=1 l=0.5
XRz_68_1 BLZ1 dz_68_1 sky130_fd_pr_reram__reram_cell area_ox=0.0676
XMn_68_1 dn_68_1 WL68 SL1 VSS sky130_fd_pr__nfet_g5v0d10v5 w=1 l=0.5
XRn_68_1 BLN1 dn_68_1 sky130_fd_pr_reram__reram_cell area_ox=0.0676
XMp_68_2 dp_68_2 WL68 SL2 VSS sky130_fd_pr__nfet_g5v0d10v5 w=1 l=0.5
XRp_68_2 BLP2 dp_68_2 sky130_fd_pr_reram__reram_cell area_ox=0.0676
XMz_68_2 dz_68_2 WL68 SL2 VSS sky130_fd_pr__nfet_g5v0d10v5 w=1 l=0.5
XRz_68_2 BLZ2 dz_68_2 sky130_fd_pr_reram__reram_cell area_ox=0.0676
XMn_68_2 dn_68_2 WL68 SL2 VSS sky130_fd_pr__nfet_g5v0d10v5 w=1 l=0.5
XRn_68_2 BLN2 dn_68_2 sky130_fd_pr_reram__reram_cell area_ox=0.0676
XMp_68_3 dp_68_3 WL68 SL3 VSS sky130_fd_pr__nfet_g5v0d10v5 w=1 l=0.5
XRp_68_3 BLP3 dp_68_3 sky130_fd_pr_reram__reram_cell area_ox=0.0676
XMz_68_3 dz_68_3 WL68 SL3 VSS sky130_fd_pr__nfet_g5v0d10v5 w=1 l=0.5
XRz_68_3 BLZ3 dz_68_3 sky130_fd_pr_reram__reram_cell area_ox=0.0676
XMn_68_3 dn_68_3 WL68 SL3 VSS sky130_fd_pr__nfet_g5v0d10v5 w=1 l=0.5
XRn_68_3 BLN3 dn_68_3 sky130_fd_pr_reram__reram_cell area_ox=0.0676
XMp_68_4 dp_68_4 WL68 SL4 VSS sky130_fd_pr__nfet_g5v0d10v5 w=1 l=0.5
XRp_68_4 BLP4 dp_68_4 sky130_fd_pr_reram__reram_cell area_ox=0.0676
XMz_68_4 dz_68_4 WL68 SL4 VSS sky130_fd_pr__nfet_g5v0d10v5 w=1 l=0.5
XRz_68_4 BLZ4 dz_68_4 sky130_fd_pr_reram__reram_cell area_ox=0.0676
XMn_68_4 dn_68_4 WL68 SL4 VSS sky130_fd_pr__nfet_g5v0d10v5 w=1 l=0.5
XRn_68_4 BLN4 dn_68_4 sky130_fd_pr_reram__reram_cell area_ox=0.0676
XMp_68_5 dp_68_5 WL68 SL5 VSS sky130_fd_pr__nfet_g5v0d10v5 w=1 l=0.5
XRp_68_5 BLP5 dp_68_5 sky130_fd_pr_reram__reram_cell area_ox=0.0676
XMz_68_5 dz_68_5 WL68 SL5 VSS sky130_fd_pr__nfet_g5v0d10v5 w=1 l=0.5
XRz_68_5 BLZ5 dz_68_5 sky130_fd_pr_reram__reram_cell area_ox=0.0676
XMn_68_5 dn_68_5 WL68 SL5 VSS sky130_fd_pr__nfet_g5v0d10v5 w=1 l=0.5
XRn_68_5 BLN5 dn_68_5 sky130_fd_pr_reram__reram_cell area_ox=0.0676
XMp_68_6 dp_68_6 WL68 SL6 VSS sky130_fd_pr__nfet_g5v0d10v5 w=1 l=0.5
XRp_68_6 BLP6 dp_68_6 sky130_fd_pr_reram__reram_cell area_ox=0.0676
XMz_68_6 dz_68_6 WL68 SL6 VSS sky130_fd_pr__nfet_g5v0d10v5 w=1 l=0.5
XRz_68_6 BLZ6 dz_68_6 sky130_fd_pr_reram__reram_cell area_ox=0.0676
XMn_68_6 dn_68_6 WL68 SL6 VSS sky130_fd_pr__nfet_g5v0d10v5 w=1 l=0.5
XRn_68_6 BLN6 dn_68_6 sky130_fd_pr_reram__reram_cell area_ox=0.0676
XMp_68_7 dp_68_7 WL68 SL7 VSS sky130_fd_pr__nfet_g5v0d10v5 w=1 l=0.5
XRp_68_7 BLP7 dp_68_7 sky130_fd_pr_reram__reram_cell area_ox=0.0676
XMz_68_7 dz_68_7 WL68 SL7 VSS sky130_fd_pr__nfet_g5v0d10v5 w=1 l=0.5
XRz_68_7 BLZ7 dz_68_7 sky130_fd_pr_reram__reram_cell area_ox=0.0676
XMn_68_7 dn_68_7 WL68 SL7 VSS sky130_fd_pr__nfet_g5v0d10v5 w=1 l=0.5
XRn_68_7 BLN7 dn_68_7 sky130_fd_pr_reram__reram_cell area_ox=0.0676
XMp_68_8 dp_68_8 WL68 SL8 VSS sky130_fd_pr__nfet_g5v0d10v5 w=1 l=0.5
XRp_68_8 BLP8 dp_68_8 sky130_fd_pr_reram__reram_cell area_ox=0.0676
XMz_68_8 dz_68_8 WL68 SL8 VSS sky130_fd_pr__nfet_g5v0d10v5 w=1 l=0.5
XRz_68_8 BLZ8 dz_68_8 sky130_fd_pr_reram__reram_cell area_ox=0.0676
XMn_68_8 dn_68_8 WL68 SL8 VSS sky130_fd_pr__nfet_g5v0d10v5 w=1 l=0.5
XRn_68_8 BLN8 dn_68_8 sky130_fd_pr_reram__reram_cell area_ox=0.0676
XMp_68_9 dp_68_9 WL68 SL9 VSS sky130_fd_pr__nfet_g5v0d10v5 w=1 l=0.5
XRp_68_9 BLP9 dp_68_9 sky130_fd_pr_reram__reram_cell area_ox=0.0676
XMz_68_9 dz_68_9 WL68 SL9 VSS sky130_fd_pr__nfet_g5v0d10v5 w=1 l=0.5
XRz_68_9 BLZ9 dz_68_9 sky130_fd_pr_reram__reram_cell area_ox=0.0676
XMn_68_9 dn_68_9 WL68 SL9 VSS sky130_fd_pr__nfet_g5v0d10v5 w=1 l=0.5
XRn_68_9 BLN9 dn_68_9 sky130_fd_pr_reram__reram_cell area_ox=0.0676
XMp_68_10 dp_68_10 WL68 SL10 VSS sky130_fd_pr__nfet_g5v0d10v5 w=1 l=0.5
XRp_68_10 BLP10 dp_68_10 sky130_fd_pr_reram__reram_cell area_ox=0.0676
XMz_68_10 dz_68_10 WL68 SL10 VSS sky130_fd_pr__nfet_g5v0d10v5 w=1 l=0.5
XRz_68_10 BLZ10 dz_68_10 sky130_fd_pr_reram__reram_cell area_ox=0.0676
XMn_68_10 dn_68_10 WL68 SL10 VSS sky130_fd_pr__nfet_g5v0d10v5 w=1 l=0.5
XRn_68_10 BLN10 dn_68_10 sky130_fd_pr_reram__reram_cell area_ox=0.0676
XMp_68_11 dp_68_11 WL68 SL11 VSS sky130_fd_pr__nfet_g5v0d10v5 w=1 l=0.5
XRp_68_11 BLP11 dp_68_11 sky130_fd_pr_reram__reram_cell area_ox=0.0676
XMz_68_11 dz_68_11 WL68 SL11 VSS sky130_fd_pr__nfet_g5v0d10v5 w=1 l=0.5
XRz_68_11 BLZ11 dz_68_11 sky130_fd_pr_reram__reram_cell area_ox=0.0676
XMn_68_11 dn_68_11 WL68 SL11 VSS sky130_fd_pr__nfet_g5v0d10v5 w=1 l=0.5
XRn_68_11 BLN11 dn_68_11 sky130_fd_pr_reram__reram_cell area_ox=0.0676
XMp_68_12 dp_68_12 WL68 SL12 VSS sky130_fd_pr__nfet_g5v0d10v5 w=1 l=0.5
XRp_68_12 BLP12 dp_68_12 sky130_fd_pr_reram__reram_cell area_ox=0.0676
XMz_68_12 dz_68_12 WL68 SL12 VSS sky130_fd_pr__nfet_g5v0d10v5 w=1 l=0.5
XRz_68_12 BLZ12 dz_68_12 sky130_fd_pr_reram__reram_cell area_ox=0.0676
XMn_68_12 dn_68_12 WL68 SL12 VSS sky130_fd_pr__nfet_g5v0d10v5 w=1 l=0.5
XRn_68_12 BLN12 dn_68_12 sky130_fd_pr_reram__reram_cell area_ox=0.0676
XMp_68_13 dp_68_13 WL68 SL13 VSS sky130_fd_pr__nfet_g5v0d10v5 w=1 l=0.5
XRp_68_13 BLP13 dp_68_13 sky130_fd_pr_reram__reram_cell area_ox=0.0676
XMz_68_13 dz_68_13 WL68 SL13 VSS sky130_fd_pr__nfet_g5v0d10v5 w=1 l=0.5
XRz_68_13 BLZ13 dz_68_13 sky130_fd_pr_reram__reram_cell area_ox=0.0676
XMn_68_13 dn_68_13 WL68 SL13 VSS sky130_fd_pr__nfet_g5v0d10v5 w=1 l=0.5
XRn_68_13 BLN13 dn_68_13 sky130_fd_pr_reram__reram_cell area_ox=0.0676
XMp_68_14 dp_68_14 WL68 SL14 VSS sky130_fd_pr__nfet_g5v0d10v5 w=1 l=0.5
XRp_68_14 BLP14 dp_68_14 sky130_fd_pr_reram__reram_cell area_ox=0.0676
XMz_68_14 dz_68_14 WL68 SL14 VSS sky130_fd_pr__nfet_g5v0d10v5 w=1 l=0.5
XRz_68_14 BLZ14 dz_68_14 sky130_fd_pr_reram__reram_cell area_ox=0.0676
XMn_68_14 dn_68_14 WL68 SL14 VSS sky130_fd_pr__nfet_g5v0d10v5 w=1 l=0.5
XRn_68_14 BLN14 dn_68_14 sky130_fd_pr_reram__reram_cell area_ox=0.0676
XMp_68_15 dp_68_15 WL68 SL15 VSS sky130_fd_pr__nfet_g5v0d10v5 w=1 l=0.5
XRp_68_15 BLP15 dp_68_15 sky130_fd_pr_reram__reram_cell area_ox=0.0676
XMz_68_15 dz_68_15 WL68 SL15 VSS sky130_fd_pr__nfet_g5v0d10v5 w=1 l=0.5
XRz_68_15 BLZ15 dz_68_15 sky130_fd_pr_reram__reram_cell area_ox=0.0676
XMn_68_15 dn_68_15 WL68 SL15 VSS sky130_fd_pr__nfet_g5v0d10v5 w=1 l=0.5
XRn_68_15 BLN15 dn_68_15 sky130_fd_pr_reram__reram_cell area_ox=0.0676
XMp_68_16 dp_68_16 WL68 SL16 VSS sky130_fd_pr__nfet_g5v0d10v5 w=1 l=0.5
XRp_68_16 BLP16 dp_68_16 sky130_fd_pr_reram__reram_cell area_ox=0.0676
XMz_68_16 dz_68_16 WL68 SL16 VSS sky130_fd_pr__nfet_g5v0d10v5 w=1 l=0.5
XRz_68_16 BLZ16 dz_68_16 sky130_fd_pr_reram__reram_cell area_ox=0.0676
XMn_68_16 dn_68_16 WL68 SL16 VSS sky130_fd_pr__nfet_g5v0d10v5 w=1 l=0.5
XRn_68_16 BLN16 dn_68_16 sky130_fd_pr_reram__reram_cell area_ox=0.0676
XMp_68_17 dp_68_17 WL68 SL17 VSS sky130_fd_pr__nfet_g5v0d10v5 w=1 l=0.5
XRp_68_17 BLP17 dp_68_17 sky130_fd_pr_reram__reram_cell area_ox=0.0676
XMz_68_17 dz_68_17 WL68 SL17 VSS sky130_fd_pr__nfet_g5v0d10v5 w=1 l=0.5
XRz_68_17 BLZ17 dz_68_17 sky130_fd_pr_reram__reram_cell area_ox=0.0676
XMn_68_17 dn_68_17 WL68 SL17 VSS sky130_fd_pr__nfet_g5v0d10v5 w=1 l=0.5
XRn_68_17 BLN17 dn_68_17 sky130_fd_pr_reram__reram_cell area_ox=0.0676
XMp_68_18 dp_68_18 WL68 SL18 VSS sky130_fd_pr__nfet_g5v0d10v5 w=1 l=0.5
XRp_68_18 BLP18 dp_68_18 sky130_fd_pr_reram__reram_cell area_ox=0.0676
XMz_68_18 dz_68_18 WL68 SL18 VSS sky130_fd_pr__nfet_g5v0d10v5 w=1 l=0.5
XRz_68_18 BLZ18 dz_68_18 sky130_fd_pr_reram__reram_cell area_ox=0.0676
XMn_68_18 dn_68_18 WL68 SL18 VSS sky130_fd_pr__nfet_g5v0d10v5 w=1 l=0.5
XRn_68_18 BLN18 dn_68_18 sky130_fd_pr_reram__reram_cell area_ox=0.0676
XMp_68_19 dp_68_19 WL68 SL19 VSS sky130_fd_pr__nfet_g5v0d10v5 w=1 l=0.5
XRp_68_19 BLP19 dp_68_19 sky130_fd_pr_reram__reram_cell area_ox=0.0676
XMz_68_19 dz_68_19 WL68 SL19 VSS sky130_fd_pr__nfet_g5v0d10v5 w=1 l=0.5
XRz_68_19 BLZ19 dz_68_19 sky130_fd_pr_reram__reram_cell area_ox=0.0676
XMn_68_19 dn_68_19 WL68 SL19 VSS sky130_fd_pr__nfet_g5v0d10v5 w=1 l=0.5
XRn_68_19 BLN19 dn_68_19 sky130_fd_pr_reram__reram_cell area_ox=0.0676
XMp_68_20 dp_68_20 WL68 SL20 VSS sky130_fd_pr__nfet_g5v0d10v5 w=1 l=0.5
XRp_68_20 BLP20 dp_68_20 sky130_fd_pr_reram__reram_cell area_ox=0.0676
XMz_68_20 dz_68_20 WL68 SL20 VSS sky130_fd_pr__nfet_g5v0d10v5 w=1 l=0.5
XRz_68_20 BLZ20 dz_68_20 sky130_fd_pr_reram__reram_cell area_ox=0.0676
XMn_68_20 dn_68_20 WL68 SL20 VSS sky130_fd_pr__nfet_g5v0d10v5 w=1 l=0.5
XRn_68_20 BLN20 dn_68_20 sky130_fd_pr_reram__reram_cell area_ox=0.0676
XMp_68_21 dp_68_21 WL68 SL21 VSS sky130_fd_pr__nfet_g5v0d10v5 w=1 l=0.5
XRp_68_21 BLP21 dp_68_21 sky130_fd_pr_reram__reram_cell area_ox=0.0676
XMz_68_21 dz_68_21 WL68 SL21 VSS sky130_fd_pr__nfet_g5v0d10v5 w=1 l=0.5
XRz_68_21 BLZ21 dz_68_21 sky130_fd_pr_reram__reram_cell area_ox=0.0676
XMn_68_21 dn_68_21 WL68 SL21 VSS sky130_fd_pr__nfet_g5v0d10v5 w=1 l=0.5
XRn_68_21 BLN21 dn_68_21 sky130_fd_pr_reram__reram_cell area_ox=0.0676
XMp_68_22 dp_68_22 WL68 SL22 VSS sky130_fd_pr__nfet_g5v0d10v5 w=1 l=0.5
XRp_68_22 BLP22 dp_68_22 sky130_fd_pr_reram__reram_cell area_ox=0.0676
XMz_68_22 dz_68_22 WL68 SL22 VSS sky130_fd_pr__nfet_g5v0d10v5 w=1 l=0.5
XRz_68_22 BLZ22 dz_68_22 sky130_fd_pr_reram__reram_cell area_ox=0.0676
XMn_68_22 dn_68_22 WL68 SL22 VSS sky130_fd_pr__nfet_g5v0d10v5 w=1 l=0.5
XRn_68_22 BLN22 dn_68_22 sky130_fd_pr_reram__reram_cell area_ox=0.0676
XMp_68_23 dp_68_23 WL68 SL23 VSS sky130_fd_pr__nfet_g5v0d10v5 w=1 l=0.5
XRp_68_23 BLP23 dp_68_23 sky130_fd_pr_reram__reram_cell area_ox=0.0676
XMz_68_23 dz_68_23 WL68 SL23 VSS sky130_fd_pr__nfet_g5v0d10v5 w=1 l=0.5
XRz_68_23 BLZ23 dz_68_23 sky130_fd_pr_reram__reram_cell area_ox=0.0676
XMn_68_23 dn_68_23 WL68 SL23 VSS sky130_fd_pr__nfet_g5v0d10v5 w=1 l=0.5
XRn_68_23 BLN23 dn_68_23 sky130_fd_pr_reram__reram_cell area_ox=0.0676
XMp_69_0 dp_69_0 WL69 SL0 VSS sky130_fd_pr__nfet_g5v0d10v5 w=1 l=0.5
XRp_69_0 BLP0 dp_69_0 sky130_fd_pr_reram__reram_cell area_ox=0.0676
XMz_69_0 dz_69_0 WL69 SL0 VSS sky130_fd_pr__nfet_g5v0d10v5 w=1 l=0.5
XRz_69_0 BLZ0 dz_69_0 sky130_fd_pr_reram__reram_cell area_ox=0.0676
XMn_69_0 dn_69_0 WL69 SL0 VSS sky130_fd_pr__nfet_g5v0d10v5 w=1 l=0.5
XRn_69_0 BLN0 dn_69_0 sky130_fd_pr_reram__reram_cell area_ox=0.0676
XMp_69_1 dp_69_1 WL69 SL1 VSS sky130_fd_pr__nfet_g5v0d10v5 w=1 l=0.5
XRp_69_1 BLP1 dp_69_1 sky130_fd_pr_reram__reram_cell area_ox=0.0676
XMz_69_1 dz_69_1 WL69 SL1 VSS sky130_fd_pr__nfet_g5v0d10v5 w=1 l=0.5
XRz_69_1 BLZ1 dz_69_1 sky130_fd_pr_reram__reram_cell area_ox=0.0676
XMn_69_1 dn_69_1 WL69 SL1 VSS sky130_fd_pr__nfet_g5v0d10v5 w=1 l=0.5
XRn_69_1 BLN1 dn_69_1 sky130_fd_pr_reram__reram_cell area_ox=0.0676
XMp_69_2 dp_69_2 WL69 SL2 VSS sky130_fd_pr__nfet_g5v0d10v5 w=1 l=0.5
XRp_69_2 BLP2 dp_69_2 sky130_fd_pr_reram__reram_cell area_ox=0.0676
XMz_69_2 dz_69_2 WL69 SL2 VSS sky130_fd_pr__nfet_g5v0d10v5 w=1 l=0.5
XRz_69_2 BLZ2 dz_69_2 sky130_fd_pr_reram__reram_cell area_ox=0.0676
XMn_69_2 dn_69_2 WL69 SL2 VSS sky130_fd_pr__nfet_g5v0d10v5 w=1 l=0.5
XRn_69_2 BLN2 dn_69_2 sky130_fd_pr_reram__reram_cell area_ox=0.0676
XMp_69_3 dp_69_3 WL69 SL3 VSS sky130_fd_pr__nfet_g5v0d10v5 w=1 l=0.5
XRp_69_3 BLP3 dp_69_3 sky130_fd_pr_reram__reram_cell area_ox=0.0676
XMz_69_3 dz_69_3 WL69 SL3 VSS sky130_fd_pr__nfet_g5v0d10v5 w=1 l=0.5
XRz_69_3 BLZ3 dz_69_3 sky130_fd_pr_reram__reram_cell area_ox=0.0676
XMn_69_3 dn_69_3 WL69 SL3 VSS sky130_fd_pr__nfet_g5v0d10v5 w=1 l=0.5
XRn_69_3 BLN3 dn_69_3 sky130_fd_pr_reram__reram_cell area_ox=0.0676
XMp_69_4 dp_69_4 WL69 SL4 VSS sky130_fd_pr__nfet_g5v0d10v5 w=1 l=0.5
XRp_69_4 BLP4 dp_69_4 sky130_fd_pr_reram__reram_cell area_ox=0.0676
XMz_69_4 dz_69_4 WL69 SL4 VSS sky130_fd_pr__nfet_g5v0d10v5 w=1 l=0.5
XRz_69_4 BLZ4 dz_69_4 sky130_fd_pr_reram__reram_cell area_ox=0.0676
XMn_69_4 dn_69_4 WL69 SL4 VSS sky130_fd_pr__nfet_g5v0d10v5 w=1 l=0.5
XRn_69_4 BLN4 dn_69_4 sky130_fd_pr_reram__reram_cell area_ox=0.0676
XMp_69_5 dp_69_5 WL69 SL5 VSS sky130_fd_pr__nfet_g5v0d10v5 w=1 l=0.5
XRp_69_5 BLP5 dp_69_5 sky130_fd_pr_reram__reram_cell area_ox=0.0676
XMz_69_5 dz_69_5 WL69 SL5 VSS sky130_fd_pr__nfet_g5v0d10v5 w=1 l=0.5
XRz_69_5 BLZ5 dz_69_5 sky130_fd_pr_reram__reram_cell area_ox=0.0676
XMn_69_5 dn_69_5 WL69 SL5 VSS sky130_fd_pr__nfet_g5v0d10v5 w=1 l=0.5
XRn_69_5 BLN5 dn_69_5 sky130_fd_pr_reram__reram_cell area_ox=0.0676
XMp_69_6 dp_69_6 WL69 SL6 VSS sky130_fd_pr__nfet_g5v0d10v5 w=1 l=0.5
XRp_69_6 BLP6 dp_69_6 sky130_fd_pr_reram__reram_cell area_ox=0.0676
XMz_69_6 dz_69_6 WL69 SL6 VSS sky130_fd_pr__nfet_g5v0d10v5 w=1 l=0.5
XRz_69_6 BLZ6 dz_69_6 sky130_fd_pr_reram__reram_cell area_ox=0.0676
XMn_69_6 dn_69_6 WL69 SL6 VSS sky130_fd_pr__nfet_g5v0d10v5 w=1 l=0.5
XRn_69_6 BLN6 dn_69_6 sky130_fd_pr_reram__reram_cell area_ox=0.0676
XMp_69_7 dp_69_7 WL69 SL7 VSS sky130_fd_pr__nfet_g5v0d10v5 w=1 l=0.5
XRp_69_7 BLP7 dp_69_7 sky130_fd_pr_reram__reram_cell area_ox=0.0676
XMz_69_7 dz_69_7 WL69 SL7 VSS sky130_fd_pr__nfet_g5v0d10v5 w=1 l=0.5
XRz_69_7 BLZ7 dz_69_7 sky130_fd_pr_reram__reram_cell area_ox=0.0676
XMn_69_7 dn_69_7 WL69 SL7 VSS sky130_fd_pr__nfet_g5v0d10v5 w=1 l=0.5
XRn_69_7 BLN7 dn_69_7 sky130_fd_pr_reram__reram_cell area_ox=0.0676
XMp_69_8 dp_69_8 WL69 SL8 VSS sky130_fd_pr__nfet_g5v0d10v5 w=1 l=0.5
XRp_69_8 BLP8 dp_69_8 sky130_fd_pr_reram__reram_cell area_ox=0.0676
XMz_69_8 dz_69_8 WL69 SL8 VSS sky130_fd_pr__nfet_g5v0d10v5 w=1 l=0.5
XRz_69_8 BLZ8 dz_69_8 sky130_fd_pr_reram__reram_cell area_ox=0.0676
XMn_69_8 dn_69_8 WL69 SL8 VSS sky130_fd_pr__nfet_g5v0d10v5 w=1 l=0.5
XRn_69_8 BLN8 dn_69_8 sky130_fd_pr_reram__reram_cell area_ox=0.0676
XMp_69_9 dp_69_9 WL69 SL9 VSS sky130_fd_pr__nfet_g5v0d10v5 w=1 l=0.5
XRp_69_9 BLP9 dp_69_9 sky130_fd_pr_reram__reram_cell area_ox=0.0676
XMz_69_9 dz_69_9 WL69 SL9 VSS sky130_fd_pr__nfet_g5v0d10v5 w=1 l=0.5
XRz_69_9 BLZ9 dz_69_9 sky130_fd_pr_reram__reram_cell area_ox=0.0676
XMn_69_9 dn_69_9 WL69 SL9 VSS sky130_fd_pr__nfet_g5v0d10v5 w=1 l=0.5
XRn_69_9 BLN9 dn_69_9 sky130_fd_pr_reram__reram_cell area_ox=0.0676
XMp_69_10 dp_69_10 WL69 SL10 VSS sky130_fd_pr__nfet_g5v0d10v5 w=1 l=0.5
XRp_69_10 BLP10 dp_69_10 sky130_fd_pr_reram__reram_cell area_ox=0.0676
XMz_69_10 dz_69_10 WL69 SL10 VSS sky130_fd_pr__nfet_g5v0d10v5 w=1 l=0.5
XRz_69_10 BLZ10 dz_69_10 sky130_fd_pr_reram__reram_cell area_ox=0.0676
XMn_69_10 dn_69_10 WL69 SL10 VSS sky130_fd_pr__nfet_g5v0d10v5 w=1 l=0.5
XRn_69_10 BLN10 dn_69_10 sky130_fd_pr_reram__reram_cell area_ox=0.0676
XMp_69_11 dp_69_11 WL69 SL11 VSS sky130_fd_pr__nfet_g5v0d10v5 w=1 l=0.5
XRp_69_11 BLP11 dp_69_11 sky130_fd_pr_reram__reram_cell area_ox=0.0676
XMz_69_11 dz_69_11 WL69 SL11 VSS sky130_fd_pr__nfet_g5v0d10v5 w=1 l=0.5
XRz_69_11 BLZ11 dz_69_11 sky130_fd_pr_reram__reram_cell area_ox=0.0676
XMn_69_11 dn_69_11 WL69 SL11 VSS sky130_fd_pr__nfet_g5v0d10v5 w=1 l=0.5
XRn_69_11 BLN11 dn_69_11 sky130_fd_pr_reram__reram_cell area_ox=0.0676
XMp_69_12 dp_69_12 WL69 SL12 VSS sky130_fd_pr__nfet_g5v0d10v5 w=1 l=0.5
XRp_69_12 BLP12 dp_69_12 sky130_fd_pr_reram__reram_cell area_ox=0.0676
XMz_69_12 dz_69_12 WL69 SL12 VSS sky130_fd_pr__nfet_g5v0d10v5 w=1 l=0.5
XRz_69_12 BLZ12 dz_69_12 sky130_fd_pr_reram__reram_cell area_ox=0.0676
XMn_69_12 dn_69_12 WL69 SL12 VSS sky130_fd_pr__nfet_g5v0d10v5 w=1 l=0.5
XRn_69_12 BLN12 dn_69_12 sky130_fd_pr_reram__reram_cell area_ox=0.0676
XMp_69_13 dp_69_13 WL69 SL13 VSS sky130_fd_pr__nfet_g5v0d10v5 w=1 l=0.5
XRp_69_13 BLP13 dp_69_13 sky130_fd_pr_reram__reram_cell area_ox=0.0676
XMz_69_13 dz_69_13 WL69 SL13 VSS sky130_fd_pr__nfet_g5v0d10v5 w=1 l=0.5
XRz_69_13 BLZ13 dz_69_13 sky130_fd_pr_reram__reram_cell area_ox=0.0676
XMn_69_13 dn_69_13 WL69 SL13 VSS sky130_fd_pr__nfet_g5v0d10v5 w=1 l=0.5
XRn_69_13 BLN13 dn_69_13 sky130_fd_pr_reram__reram_cell area_ox=0.0676
XMp_69_14 dp_69_14 WL69 SL14 VSS sky130_fd_pr__nfet_g5v0d10v5 w=1 l=0.5
XRp_69_14 BLP14 dp_69_14 sky130_fd_pr_reram__reram_cell area_ox=0.0676
XMz_69_14 dz_69_14 WL69 SL14 VSS sky130_fd_pr__nfet_g5v0d10v5 w=1 l=0.5
XRz_69_14 BLZ14 dz_69_14 sky130_fd_pr_reram__reram_cell area_ox=0.0676
XMn_69_14 dn_69_14 WL69 SL14 VSS sky130_fd_pr__nfet_g5v0d10v5 w=1 l=0.5
XRn_69_14 BLN14 dn_69_14 sky130_fd_pr_reram__reram_cell area_ox=0.0676
XMp_69_15 dp_69_15 WL69 SL15 VSS sky130_fd_pr__nfet_g5v0d10v5 w=1 l=0.5
XRp_69_15 BLP15 dp_69_15 sky130_fd_pr_reram__reram_cell area_ox=0.0676
XMz_69_15 dz_69_15 WL69 SL15 VSS sky130_fd_pr__nfet_g5v0d10v5 w=1 l=0.5
XRz_69_15 BLZ15 dz_69_15 sky130_fd_pr_reram__reram_cell area_ox=0.0676
XMn_69_15 dn_69_15 WL69 SL15 VSS sky130_fd_pr__nfet_g5v0d10v5 w=1 l=0.5
XRn_69_15 BLN15 dn_69_15 sky130_fd_pr_reram__reram_cell area_ox=0.0676
XMp_69_16 dp_69_16 WL69 SL16 VSS sky130_fd_pr__nfet_g5v0d10v5 w=1 l=0.5
XRp_69_16 BLP16 dp_69_16 sky130_fd_pr_reram__reram_cell area_ox=0.0676
XMz_69_16 dz_69_16 WL69 SL16 VSS sky130_fd_pr__nfet_g5v0d10v5 w=1 l=0.5
XRz_69_16 BLZ16 dz_69_16 sky130_fd_pr_reram__reram_cell area_ox=0.0676
XMn_69_16 dn_69_16 WL69 SL16 VSS sky130_fd_pr__nfet_g5v0d10v5 w=1 l=0.5
XRn_69_16 BLN16 dn_69_16 sky130_fd_pr_reram__reram_cell area_ox=0.0676
XMp_69_17 dp_69_17 WL69 SL17 VSS sky130_fd_pr__nfet_g5v0d10v5 w=1 l=0.5
XRp_69_17 BLP17 dp_69_17 sky130_fd_pr_reram__reram_cell area_ox=0.0676
XMz_69_17 dz_69_17 WL69 SL17 VSS sky130_fd_pr__nfet_g5v0d10v5 w=1 l=0.5
XRz_69_17 BLZ17 dz_69_17 sky130_fd_pr_reram__reram_cell area_ox=0.0676
XMn_69_17 dn_69_17 WL69 SL17 VSS sky130_fd_pr__nfet_g5v0d10v5 w=1 l=0.5
XRn_69_17 BLN17 dn_69_17 sky130_fd_pr_reram__reram_cell area_ox=0.0676
XMp_69_18 dp_69_18 WL69 SL18 VSS sky130_fd_pr__nfet_g5v0d10v5 w=1 l=0.5
XRp_69_18 BLP18 dp_69_18 sky130_fd_pr_reram__reram_cell area_ox=0.0676
XMz_69_18 dz_69_18 WL69 SL18 VSS sky130_fd_pr__nfet_g5v0d10v5 w=1 l=0.5
XRz_69_18 BLZ18 dz_69_18 sky130_fd_pr_reram__reram_cell area_ox=0.0676
XMn_69_18 dn_69_18 WL69 SL18 VSS sky130_fd_pr__nfet_g5v0d10v5 w=1 l=0.5
XRn_69_18 BLN18 dn_69_18 sky130_fd_pr_reram__reram_cell area_ox=0.0676
XMp_69_19 dp_69_19 WL69 SL19 VSS sky130_fd_pr__nfet_g5v0d10v5 w=1 l=0.5
XRp_69_19 BLP19 dp_69_19 sky130_fd_pr_reram__reram_cell area_ox=0.0676
XMz_69_19 dz_69_19 WL69 SL19 VSS sky130_fd_pr__nfet_g5v0d10v5 w=1 l=0.5
XRz_69_19 BLZ19 dz_69_19 sky130_fd_pr_reram__reram_cell area_ox=0.0676
XMn_69_19 dn_69_19 WL69 SL19 VSS sky130_fd_pr__nfet_g5v0d10v5 w=1 l=0.5
XRn_69_19 BLN19 dn_69_19 sky130_fd_pr_reram__reram_cell area_ox=0.0676
XMp_69_20 dp_69_20 WL69 SL20 VSS sky130_fd_pr__nfet_g5v0d10v5 w=1 l=0.5
XRp_69_20 BLP20 dp_69_20 sky130_fd_pr_reram__reram_cell area_ox=0.0676
XMz_69_20 dz_69_20 WL69 SL20 VSS sky130_fd_pr__nfet_g5v0d10v5 w=1 l=0.5
XRz_69_20 BLZ20 dz_69_20 sky130_fd_pr_reram__reram_cell area_ox=0.0676
XMn_69_20 dn_69_20 WL69 SL20 VSS sky130_fd_pr__nfet_g5v0d10v5 w=1 l=0.5
XRn_69_20 BLN20 dn_69_20 sky130_fd_pr_reram__reram_cell area_ox=0.0676
XMp_69_21 dp_69_21 WL69 SL21 VSS sky130_fd_pr__nfet_g5v0d10v5 w=1 l=0.5
XRp_69_21 BLP21 dp_69_21 sky130_fd_pr_reram__reram_cell area_ox=0.0676
XMz_69_21 dz_69_21 WL69 SL21 VSS sky130_fd_pr__nfet_g5v0d10v5 w=1 l=0.5
XRz_69_21 BLZ21 dz_69_21 sky130_fd_pr_reram__reram_cell area_ox=0.0676
XMn_69_21 dn_69_21 WL69 SL21 VSS sky130_fd_pr__nfet_g5v0d10v5 w=1 l=0.5
XRn_69_21 BLN21 dn_69_21 sky130_fd_pr_reram__reram_cell area_ox=0.0676
XMp_69_22 dp_69_22 WL69 SL22 VSS sky130_fd_pr__nfet_g5v0d10v5 w=1 l=0.5
XRp_69_22 BLP22 dp_69_22 sky130_fd_pr_reram__reram_cell area_ox=0.0676
XMz_69_22 dz_69_22 WL69 SL22 VSS sky130_fd_pr__nfet_g5v0d10v5 w=1 l=0.5
XRz_69_22 BLZ22 dz_69_22 sky130_fd_pr_reram__reram_cell area_ox=0.0676
XMn_69_22 dn_69_22 WL69 SL22 VSS sky130_fd_pr__nfet_g5v0d10v5 w=1 l=0.5
XRn_69_22 BLN22 dn_69_22 sky130_fd_pr_reram__reram_cell area_ox=0.0676
XMp_69_23 dp_69_23 WL69 SL23 VSS sky130_fd_pr__nfet_g5v0d10v5 w=1 l=0.5
XRp_69_23 BLP23 dp_69_23 sky130_fd_pr_reram__reram_cell area_ox=0.0676
XMz_69_23 dz_69_23 WL69 SL23 VSS sky130_fd_pr__nfet_g5v0d10v5 w=1 l=0.5
XRz_69_23 BLZ23 dz_69_23 sky130_fd_pr_reram__reram_cell area_ox=0.0676
XMn_69_23 dn_69_23 WL69 SL23 VSS sky130_fd_pr__nfet_g5v0d10v5 w=1 l=0.5
XRn_69_23 BLN23 dn_69_23 sky130_fd_pr_reram__reram_cell area_ox=0.0676
XMp_70_0 dp_70_0 WL70 SL0 VSS sky130_fd_pr__nfet_g5v0d10v5 w=1 l=0.5
XRp_70_0 BLP0 dp_70_0 sky130_fd_pr_reram__reram_cell area_ox=0.0676
XMz_70_0 dz_70_0 WL70 SL0 VSS sky130_fd_pr__nfet_g5v0d10v5 w=1 l=0.5
XRz_70_0 BLZ0 dz_70_0 sky130_fd_pr_reram__reram_cell area_ox=0.0676
XMn_70_0 dn_70_0 WL70 SL0 VSS sky130_fd_pr__nfet_g5v0d10v5 w=1 l=0.5
XRn_70_0 BLN0 dn_70_0 sky130_fd_pr_reram__reram_cell area_ox=0.0676
XMp_70_1 dp_70_1 WL70 SL1 VSS sky130_fd_pr__nfet_g5v0d10v5 w=1 l=0.5
XRp_70_1 BLP1 dp_70_1 sky130_fd_pr_reram__reram_cell area_ox=0.0676
XMz_70_1 dz_70_1 WL70 SL1 VSS sky130_fd_pr__nfet_g5v0d10v5 w=1 l=0.5
XRz_70_1 BLZ1 dz_70_1 sky130_fd_pr_reram__reram_cell area_ox=0.0676
XMn_70_1 dn_70_1 WL70 SL1 VSS sky130_fd_pr__nfet_g5v0d10v5 w=1 l=0.5
XRn_70_1 BLN1 dn_70_1 sky130_fd_pr_reram__reram_cell area_ox=0.0676
XMp_70_2 dp_70_2 WL70 SL2 VSS sky130_fd_pr__nfet_g5v0d10v5 w=1 l=0.5
XRp_70_2 BLP2 dp_70_2 sky130_fd_pr_reram__reram_cell area_ox=0.0676
XMz_70_2 dz_70_2 WL70 SL2 VSS sky130_fd_pr__nfet_g5v0d10v5 w=1 l=0.5
XRz_70_2 BLZ2 dz_70_2 sky130_fd_pr_reram__reram_cell area_ox=0.0676
XMn_70_2 dn_70_2 WL70 SL2 VSS sky130_fd_pr__nfet_g5v0d10v5 w=1 l=0.5
XRn_70_2 BLN2 dn_70_2 sky130_fd_pr_reram__reram_cell area_ox=0.0676
XMp_70_3 dp_70_3 WL70 SL3 VSS sky130_fd_pr__nfet_g5v0d10v5 w=1 l=0.5
XRp_70_3 BLP3 dp_70_3 sky130_fd_pr_reram__reram_cell area_ox=0.0676
XMz_70_3 dz_70_3 WL70 SL3 VSS sky130_fd_pr__nfet_g5v0d10v5 w=1 l=0.5
XRz_70_3 BLZ3 dz_70_3 sky130_fd_pr_reram__reram_cell area_ox=0.0676
XMn_70_3 dn_70_3 WL70 SL3 VSS sky130_fd_pr__nfet_g5v0d10v5 w=1 l=0.5
XRn_70_3 BLN3 dn_70_3 sky130_fd_pr_reram__reram_cell area_ox=0.0676
XMp_70_4 dp_70_4 WL70 SL4 VSS sky130_fd_pr__nfet_g5v0d10v5 w=1 l=0.5
XRp_70_4 BLP4 dp_70_4 sky130_fd_pr_reram__reram_cell area_ox=0.0676
XMz_70_4 dz_70_4 WL70 SL4 VSS sky130_fd_pr__nfet_g5v0d10v5 w=1 l=0.5
XRz_70_4 BLZ4 dz_70_4 sky130_fd_pr_reram__reram_cell area_ox=0.0676
XMn_70_4 dn_70_4 WL70 SL4 VSS sky130_fd_pr__nfet_g5v0d10v5 w=1 l=0.5
XRn_70_4 BLN4 dn_70_4 sky130_fd_pr_reram__reram_cell area_ox=0.0676
XMp_70_5 dp_70_5 WL70 SL5 VSS sky130_fd_pr__nfet_g5v0d10v5 w=1 l=0.5
XRp_70_5 BLP5 dp_70_5 sky130_fd_pr_reram__reram_cell area_ox=0.0676
XMz_70_5 dz_70_5 WL70 SL5 VSS sky130_fd_pr__nfet_g5v0d10v5 w=1 l=0.5
XRz_70_5 BLZ5 dz_70_5 sky130_fd_pr_reram__reram_cell area_ox=0.0676
XMn_70_5 dn_70_5 WL70 SL5 VSS sky130_fd_pr__nfet_g5v0d10v5 w=1 l=0.5
XRn_70_5 BLN5 dn_70_5 sky130_fd_pr_reram__reram_cell area_ox=0.0676
XMp_70_6 dp_70_6 WL70 SL6 VSS sky130_fd_pr__nfet_g5v0d10v5 w=1 l=0.5
XRp_70_6 BLP6 dp_70_6 sky130_fd_pr_reram__reram_cell area_ox=0.0676
XMz_70_6 dz_70_6 WL70 SL6 VSS sky130_fd_pr__nfet_g5v0d10v5 w=1 l=0.5
XRz_70_6 BLZ6 dz_70_6 sky130_fd_pr_reram__reram_cell area_ox=0.0676
XMn_70_6 dn_70_6 WL70 SL6 VSS sky130_fd_pr__nfet_g5v0d10v5 w=1 l=0.5
XRn_70_6 BLN6 dn_70_6 sky130_fd_pr_reram__reram_cell area_ox=0.0676
XMp_70_7 dp_70_7 WL70 SL7 VSS sky130_fd_pr__nfet_g5v0d10v5 w=1 l=0.5
XRp_70_7 BLP7 dp_70_7 sky130_fd_pr_reram__reram_cell area_ox=0.0676
XMz_70_7 dz_70_7 WL70 SL7 VSS sky130_fd_pr__nfet_g5v0d10v5 w=1 l=0.5
XRz_70_7 BLZ7 dz_70_7 sky130_fd_pr_reram__reram_cell area_ox=0.0676
XMn_70_7 dn_70_7 WL70 SL7 VSS sky130_fd_pr__nfet_g5v0d10v5 w=1 l=0.5
XRn_70_7 BLN7 dn_70_7 sky130_fd_pr_reram__reram_cell area_ox=0.0676
XMp_70_8 dp_70_8 WL70 SL8 VSS sky130_fd_pr__nfet_g5v0d10v5 w=1 l=0.5
XRp_70_8 BLP8 dp_70_8 sky130_fd_pr_reram__reram_cell area_ox=0.0676
XMz_70_8 dz_70_8 WL70 SL8 VSS sky130_fd_pr__nfet_g5v0d10v5 w=1 l=0.5
XRz_70_8 BLZ8 dz_70_8 sky130_fd_pr_reram__reram_cell area_ox=0.0676
XMn_70_8 dn_70_8 WL70 SL8 VSS sky130_fd_pr__nfet_g5v0d10v5 w=1 l=0.5
XRn_70_8 BLN8 dn_70_8 sky130_fd_pr_reram__reram_cell area_ox=0.0676
XMp_70_9 dp_70_9 WL70 SL9 VSS sky130_fd_pr__nfet_g5v0d10v5 w=1 l=0.5
XRp_70_9 BLP9 dp_70_9 sky130_fd_pr_reram__reram_cell area_ox=0.0676
XMz_70_9 dz_70_9 WL70 SL9 VSS sky130_fd_pr__nfet_g5v0d10v5 w=1 l=0.5
XRz_70_9 BLZ9 dz_70_9 sky130_fd_pr_reram__reram_cell area_ox=0.0676
XMn_70_9 dn_70_9 WL70 SL9 VSS sky130_fd_pr__nfet_g5v0d10v5 w=1 l=0.5
XRn_70_9 BLN9 dn_70_9 sky130_fd_pr_reram__reram_cell area_ox=0.0676
XMp_70_10 dp_70_10 WL70 SL10 VSS sky130_fd_pr__nfet_g5v0d10v5 w=1 l=0.5
XRp_70_10 BLP10 dp_70_10 sky130_fd_pr_reram__reram_cell area_ox=0.0676
XMz_70_10 dz_70_10 WL70 SL10 VSS sky130_fd_pr__nfet_g5v0d10v5 w=1 l=0.5
XRz_70_10 BLZ10 dz_70_10 sky130_fd_pr_reram__reram_cell area_ox=0.0676
XMn_70_10 dn_70_10 WL70 SL10 VSS sky130_fd_pr__nfet_g5v0d10v5 w=1 l=0.5
XRn_70_10 BLN10 dn_70_10 sky130_fd_pr_reram__reram_cell area_ox=0.0676
XMp_70_11 dp_70_11 WL70 SL11 VSS sky130_fd_pr__nfet_g5v0d10v5 w=1 l=0.5
XRp_70_11 BLP11 dp_70_11 sky130_fd_pr_reram__reram_cell area_ox=0.0676
XMz_70_11 dz_70_11 WL70 SL11 VSS sky130_fd_pr__nfet_g5v0d10v5 w=1 l=0.5
XRz_70_11 BLZ11 dz_70_11 sky130_fd_pr_reram__reram_cell area_ox=0.0676
XMn_70_11 dn_70_11 WL70 SL11 VSS sky130_fd_pr__nfet_g5v0d10v5 w=1 l=0.5
XRn_70_11 BLN11 dn_70_11 sky130_fd_pr_reram__reram_cell area_ox=0.0676
XMp_70_12 dp_70_12 WL70 SL12 VSS sky130_fd_pr__nfet_g5v0d10v5 w=1 l=0.5
XRp_70_12 BLP12 dp_70_12 sky130_fd_pr_reram__reram_cell area_ox=0.0676
XMz_70_12 dz_70_12 WL70 SL12 VSS sky130_fd_pr__nfet_g5v0d10v5 w=1 l=0.5
XRz_70_12 BLZ12 dz_70_12 sky130_fd_pr_reram__reram_cell area_ox=0.0676
XMn_70_12 dn_70_12 WL70 SL12 VSS sky130_fd_pr__nfet_g5v0d10v5 w=1 l=0.5
XRn_70_12 BLN12 dn_70_12 sky130_fd_pr_reram__reram_cell area_ox=0.0676
XMp_70_13 dp_70_13 WL70 SL13 VSS sky130_fd_pr__nfet_g5v0d10v5 w=1 l=0.5
XRp_70_13 BLP13 dp_70_13 sky130_fd_pr_reram__reram_cell area_ox=0.0676
XMz_70_13 dz_70_13 WL70 SL13 VSS sky130_fd_pr__nfet_g5v0d10v5 w=1 l=0.5
XRz_70_13 BLZ13 dz_70_13 sky130_fd_pr_reram__reram_cell area_ox=0.0676
XMn_70_13 dn_70_13 WL70 SL13 VSS sky130_fd_pr__nfet_g5v0d10v5 w=1 l=0.5
XRn_70_13 BLN13 dn_70_13 sky130_fd_pr_reram__reram_cell area_ox=0.0676
XMp_70_14 dp_70_14 WL70 SL14 VSS sky130_fd_pr__nfet_g5v0d10v5 w=1 l=0.5
XRp_70_14 BLP14 dp_70_14 sky130_fd_pr_reram__reram_cell area_ox=0.0676
XMz_70_14 dz_70_14 WL70 SL14 VSS sky130_fd_pr__nfet_g5v0d10v5 w=1 l=0.5
XRz_70_14 BLZ14 dz_70_14 sky130_fd_pr_reram__reram_cell area_ox=0.0676
XMn_70_14 dn_70_14 WL70 SL14 VSS sky130_fd_pr__nfet_g5v0d10v5 w=1 l=0.5
XRn_70_14 BLN14 dn_70_14 sky130_fd_pr_reram__reram_cell area_ox=0.0676
XMp_70_15 dp_70_15 WL70 SL15 VSS sky130_fd_pr__nfet_g5v0d10v5 w=1 l=0.5
XRp_70_15 BLP15 dp_70_15 sky130_fd_pr_reram__reram_cell area_ox=0.0676
XMz_70_15 dz_70_15 WL70 SL15 VSS sky130_fd_pr__nfet_g5v0d10v5 w=1 l=0.5
XRz_70_15 BLZ15 dz_70_15 sky130_fd_pr_reram__reram_cell area_ox=0.0676
XMn_70_15 dn_70_15 WL70 SL15 VSS sky130_fd_pr__nfet_g5v0d10v5 w=1 l=0.5
XRn_70_15 BLN15 dn_70_15 sky130_fd_pr_reram__reram_cell area_ox=0.0676
XMp_70_16 dp_70_16 WL70 SL16 VSS sky130_fd_pr__nfet_g5v0d10v5 w=1 l=0.5
XRp_70_16 BLP16 dp_70_16 sky130_fd_pr_reram__reram_cell area_ox=0.0676
XMz_70_16 dz_70_16 WL70 SL16 VSS sky130_fd_pr__nfet_g5v0d10v5 w=1 l=0.5
XRz_70_16 BLZ16 dz_70_16 sky130_fd_pr_reram__reram_cell area_ox=0.0676
XMn_70_16 dn_70_16 WL70 SL16 VSS sky130_fd_pr__nfet_g5v0d10v5 w=1 l=0.5
XRn_70_16 BLN16 dn_70_16 sky130_fd_pr_reram__reram_cell area_ox=0.0676
XMp_70_17 dp_70_17 WL70 SL17 VSS sky130_fd_pr__nfet_g5v0d10v5 w=1 l=0.5
XRp_70_17 BLP17 dp_70_17 sky130_fd_pr_reram__reram_cell area_ox=0.0676
XMz_70_17 dz_70_17 WL70 SL17 VSS sky130_fd_pr__nfet_g5v0d10v5 w=1 l=0.5
XRz_70_17 BLZ17 dz_70_17 sky130_fd_pr_reram__reram_cell area_ox=0.0676
XMn_70_17 dn_70_17 WL70 SL17 VSS sky130_fd_pr__nfet_g5v0d10v5 w=1 l=0.5
XRn_70_17 BLN17 dn_70_17 sky130_fd_pr_reram__reram_cell area_ox=0.0676
XMp_70_18 dp_70_18 WL70 SL18 VSS sky130_fd_pr__nfet_g5v0d10v5 w=1 l=0.5
XRp_70_18 BLP18 dp_70_18 sky130_fd_pr_reram__reram_cell area_ox=0.0676
XMz_70_18 dz_70_18 WL70 SL18 VSS sky130_fd_pr__nfet_g5v0d10v5 w=1 l=0.5
XRz_70_18 BLZ18 dz_70_18 sky130_fd_pr_reram__reram_cell area_ox=0.0676
XMn_70_18 dn_70_18 WL70 SL18 VSS sky130_fd_pr__nfet_g5v0d10v5 w=1 l=0.5
XRn_70_18 BLN18 dn_70_18 sky130_fd_pr_reram__reram_cell area_ox=0.0676
XMp_70_19 dp_70_19 WL70 SL19 VSS sky130_fd_pr__nfet_g5v0d10v5 w=1 l=0.5
XRp_70_19 BLP19 dp_70_19 sky130_fd_pr_reram__reram_cell area_ox=0.0676
XMz_70_19 dz_70_19 WL70 SL19 VSS sky130_fd_pr__nfet_g5v0d10v5 w=1 l=0.5
XRz_70_19 BLZ19 dz_70_19 sky130_fd_pr_reram__reram_cell area_ox=0.0676
XMn_70_19 dn_70_19 WL70 SL19 VSS sky130_fd_pr__nfet_g5v0d10v5 w=1 l=0.5
XRn_70_19 BLN19 dn_70_19 sky130_fd_pr_reram__reram_cell area_ox=0.0676
XMp_70_20 dp_70_20 WL70 SL20 VSS sky130_fd_pr__nfet_g5v0d10v5 w=1 l=0.5
XRp_70_20 BLP20 dp_70_20 sky130_fd_pr_reram__reram_cell area_ox=0.0676
XMz_70_20 dz_70_20 WL70 SL20 VSS sky130_fd_pr__nfet_g5v0d10v5 w=1 l=0.5
XRz_70_20 BLZ20 dz_70_20 sky130_fd_pr_reram__reram_cell area_ox=0.0676
XMn_70_20 dn_70_20 WL70 SL20 VSS sky130_fd_pr__nfet_g5v0d10v5 w=1 l=0.5
XRn_70_20 BLN20 dn_70_20 sky130_fd_pr_reram__reram_cell area_ox=0.0676
XMp_70_21 dp_70_21 WL70 SL21 VSS sky130_fd_pr__nfet_g5v0d10v5 w=1 l=0.5
XRp_70_21 BLP21 dp_70_21 sky130_fd_pr_reram__reram_cell area_ox=0.0676
XMz_70_21 dz_70_21 WL70 SL21 VSS sky130_fd_pr__nfet_g5v0d10v5 w=1 l=0.5
XRz_70_21 BLZ21 dz_70_21 sky130_fd_pr_reram__reram_cell area_ox=0.0676
XMn_70_21 dn_70_21 WL70 SL21 VSS sky130_fd_pr__nfet_g5v0d10v5 w=1 l=0.5
XRn_70_21 BLN21 dn_70_21 sky130_fd_pr_reram__reram_cell area_ox=0.0676
XMp_70_22 dp_70_22 WL70 SL22 VSS sky130_fd_pr__nfet_g5v0d10v5 w=1 l=0.5
XRp_70_22 BLP22 dp_70_22 sky130_fd_pr_reram__reram_cell area_ox=0.0676
XMz_70_22 dz_70_22 WL70 SL22 VSS sky130_fd_pr__nfet_g5v0d10v5 w=1 l=0.5
XRz_70_22 BLZ22 dz_70_22 sky130_fd_pr_reram__reram_cell area_ox=0.0676
XMn_70_22 dn_70_22 WL70 SL22 VSS sky130_fd_pr__nfet_g5v0d10v5 w=1 l=0.5
XRn_70_22 BLN22 dn_70_22 sky130_fd_pr_reram__reram_cell area_ox=0.0676
XMp_70_23 dp_70_23 WL70 SL23 VSS sky130_fd_pr__nfet_g5v0d10v5 w=1 l=0.5
XRp_70_23 BLP23 dp_70_23 sky130_fd_pr_reram__reram_cell area_ox=0.0676
XMz_70_23 dz_70_23 WL70 SL23 VSS sky130_fd_pr__nfet_g5v0d10v5 w=1 l=0.5
XRz_70_23 BLZ23 dz_70_23 sky130_fd_pr_reram__reram_cell area_ox=0.0676
XMn_70_23 dn_70_23 WL70 SL23 VSS sky130_fd_pr__nfet_g5v0d10v5 w=1 l=0.5
XRn_70_23 BLN23 dn_70_23 sky130_fd_pr_reram__reram_cell area_ox=0.0676
XMp_71_0 dp_71_0 WL71 SL0 VSS sky130_fd_pr__nfet_g5v0d10v5 w=1 l=0.5
XRp_71_0 BLP0 dp_71_0 sky130_fd_pr_reram__reram_cell area_ox=0.0676
XMz_71_0 dz_71_0 WL71 SL0 VSS sky130_fd_pr__nfet_g5v0d10v5 w=1 l=0.5
XRz_71_0 BLZ0 dz_71_0 sky130_fd_pr_reram__reram_cell area_ox=0.0676
XMn_71_0 dn_71_0 WL71 SL0 VSS sky130_fd_pr__nfet_g5v0d10v5 w=1 l=0.5
XRn_71_0 BLN0 dn_71_0 sky130_fd_pr_reram__reram_cell area_ox=0.0676
XMp_71_1 dp_71_1 WL71 SL1 VSS sky130_fd_pr__nfet_g5v0d10v5 w=1 l=0.5
XRp_71_1 BLP1 dp_71_1 sky130_fd_pr_reram__reram_cell area_ox=0.0676
XMz_71_1 dz_71_1 WL71 SL1 VSS sky130_fd_pr__nfet_g5v0d10v5 w=1 l=0.5
XRz_71_1 BLZ1 dz_71_1 sky130_fd_pr_reram__reram_cell area_ox=0.0676
XMn_71_1 dn_71_1 WL71 SL1 VSS sky130_fd_pr__nfet_g5v0d10v5 w=1 l=0.5
XRn_71_1 BLN1 dn_71_1 sky130_fd_pr_reram__reram_cell area_ox=0.0676
XMp_71_2 dp_71_2 WL71 SL2 VSS sky130_fd_pr__nfet_g5v0d10v5 w=1 l=0.5
XRp_71_2 BLP2 dp_71_2 sky130_fd_pr_reram__reram_cell area_ox=0.0676
XMz_71_2 dz_71_2 WL71 SL2 VSS sky130_fd_pr__nfet_g5v0d10v5 w=1 l=0.5
XRz_71_2 BLZ2 dz_71_2 sky130_fd_pr_reram__reram_cell area_ox=0.0676
XMn_71_2 dn_71_2 WL71 SL2 VSS sky130_fd_pr__nfet_g5v0d10v5 w=1 l=0.5
XRn_71_2 BLN2 dn_71_2 sky130_fd_pr_reram__reram_cell area_ox=0.0676
XMp_71_3 dp_71_3 WL71 SL3 VSS sky130_fd_pr__nfet_g5v0d10v5 w=1 l=0.5
XRp_71_3 BLP3 dp_71_3 sky130_fd_pr_reram__reram_cell area_ox=0.0676
XMz_71_3 dz_71_3 WL71 SL3 VSS sky130_fd_pr__nfet_g5v0d10v5 w=1 l=0.5
XRz_71_3 BLZ3 dz_71_3 sky130_fd_pr_reram__reram_cell area_ox=0.0676
XMn_71_3 dn_71_3 WL71 SL3 VSS sky130_fd_pr__nfet_g5v0d10v5 w=1 l=0.5
XRn_71_3 BLN3 dn_71_3 sky130_fd_pr_reram__reram_cell area_ox=0.0676
XMp_71_4 dp_71_4 WL71 SL4 VSS sky130_fd_pr__nfet_g5v0d10v5 w=1 l=0.5
XRp_71_4 BLP4 dp_71_4 sky130_fd_pr_reram__reram_cell area_ox=0.0676
XMz_71_4 dz_71_4 WL71 SL4 VSS sky130_fd_pr__nfet_g5v0d10v5 w=1 l=0.5
XRz_71_4 BLZ4 dz_71_4 sky130_fd_pr_reram__reram_cell area_ox=0.0676
XMn_71_4 dn_71_4 WL71 SL4 VSS sky130_fd_pr__nfet_g5v0d10v5 w=1 l=0.5
XRn_71_4 BLN4 dn_71_4 sky130_fd_pr_reram__reram_cell area_ox=0.0676
XMp_71_5 dp_71_5 WL71 SL5 VSS sky130_fd_pr__nfet_g5v0d10v5 w=1 l=0.5
XRp_71_5 BLP5 dp_71_5 sky130_fd_pr_reram__reram_cell area_ox=0.0676
XMz_71_5 dz_71_5 WL71 SL5 VSS sky130_fd_pr__nfet_g5v0d10v5 w=1 l=0.5
XRz_71_5 BLZ5 dz_71_5 sky130_fd_pr_reram__reram_cell area_ox=0.0676
XMn_71_5 dn_71_5 WL71 SL5 VSS sky130_fd_pr__nfet_g5v0d10v5 w=1 l=0.5
XRn_71_5 BLN5 dn_71_5 sky130_fd_pr_reram__reram_cell area_ox=0.0676
XMp_71_6 dp_71_6 WL71 SL6 VSS sky130_fd_pr__nfet_g5v0d10v5 w=1 l=0.5
XRp_71_6 BLP6 dp_71_6 sky130_fd_pr_reram__reram_cell area_ox=0.0676
XMz_71_6 dz_71_6 WL71 SL6 VSS sky130_fd_pr__nfet_g5v0d10v5 w=1 l=0.5
XRz_71_6 BLZ6 dz_71_6 sky130_fd_pr_reram__reram_cell area_ox=0.0676
XMn_71_6 dn_71_6 WL71 SL6 VSS sky130_fd_pr__nfet_g5v0d10v5 w=1 l=0.5
XRn_71_6 BLN6 dn_71_6 sky130_fd_pr_reram__reram_cell area_ox=0.0676
XMp_71_7 dp_71_7 WL71 SL7 VSS sky130_fd_pr__nfet_g5v0d10v5 w=1 l=0.5
XRp_71_7 BLP7 dp_71_7 sky130_fd_pr_reram__reram_cell area_ox=0.0676
XMz_71_7 dz_71_7 WL71 SL7 VSS sky130_fd_pr__nfet_g5v0d10v5 w=1 l=0.5
XRz_71_7 BLZ7 dz_71_7 sky130_fd_pr_reram__reram_cell area_ox=0.0676
XMn_71_7 dn_71_7 WL71 SL7 VSS sky130_fd_pr__nfet_g5v0d10v5 w=1 l=0.5
XRn_71_7 BLN7 dn_71_7 sky130_fd_pr_reram__reram_cell area_ox=0.0676
XMp_71_8 dp_71_8 WL71 SL8 VSS sky130_fd_pr__nfet_g5v0d10v5 w=1 l=0.5
XRp_71_8 BLP8 dp_71_8 sky130_fd_pr_reram__reram_cell area_ox=0.0676
XMz_71_8 dz_71_8 WL71 SL8 VSS sky130_fd_pr__nfet_g5v0d10v5 w=1 l=0.5
XRz_71_8 BLZ8 dz_71_8 sky130_fd_pr_reram__reram_cell area_ox=0.0676
XMn_71_8 dn_71_8 WL71 SL8 VSS sky130_fd_pr__nfet_g5v0d10v5 w=1 l=0.5
XRn_71_8 BLN8 dn_71_8 sky130_fd_pr_reram__reram_cell area_ox=0.0676
XMp_71_9 dp_71_9 WL71 SL9 VSS sky130_fd_pr__nfet_g5v0d10v5 w=1 l=0.5
XRp_71_9 BLP9 dp_71_9 sky130_fd_pr_reram__reram_cell area_ox=0.0676
XMz_71_9 dz_71_9 WL71 SL9 VSS sky130_fd_pr__nfet_g5v0d10v5 w=1 l=0.5
XRz_71_9 BLZ9 dz_71_9 sky130_fd_pr_reram__reram_cell area_ox=0.0676
XMn_71_9 dn_71_9 WL71 SL9 VSS sky130_fd_pr__nfet_g5v0d10v5 w=1 l=0.5
XRn_71_9 BLN9 dn_71_9 sky130_fd_pr_reram__reram_cell area_ox=0.0676
XMp_71_10 dp_71_10 WL71 SL10 VSS sky130_fd_pr__nfet_g5v0d10v5 w=1 l=0.5
XRp_71_10 BLP10 dp_71_10 sky130_fd_pr_reram__reram_cell area_ox=0.0676
XMz_71_10 dz_71_10 WL71 SL10 VSS sky130_fd_pr__nfet_g5v0d10v5 w=1 l=0.5
XRz_71_10 BLZ10 dz_71_10 sky130_fd_pr_reram__reram_cell area_ox=0.0676
XMn_71_10 dn_71_10 WL71 SL10 VSS sky130_fd_pr__nfet_g5v0d10v5 w=1 l=0.5
XRn_71_10 BLN10 dn_71_10 sky130_fd_pr_reram__reram_cell area_ox=0.0676
XMp_71_11 dp_71_11 WL71 SL11 VSS sky130_fd_pr__nfet_g5v0d10v5 w=1 l=0.5
XRp_71_11 BLP11 dp_71_11 sky130_fd_pr_reram__reram_cell area_ox=0.0676
XMz_71_11 dz_71_11 WL71 SL11 VSS sky130_fd_pr__nfet_g5v0d10v5 w=1 l=0.5
XRz_71_11 BLZ11 dz_71_11 sky130_fd_pr_reram__reram_cell area_ox=0.0676
XMn_71_11 dn_71_11 WL71 SL11 VSS sky130_fd_pr__nfet_g5v0d10v5 w=1 l=0.5
XRn_71_11 BLN11 dn_71_11 sky130_fd_pr_reram__reram_cell area_ox=0.0676
XMp_71_12 dp_71_12 WL71 SL12 VSS sky130_fd_pr__nfet_g5v0d10v5 w=1 l=0.5
XRp_71_12 BLP12 dp_71_12 sky130_fd_pr_reram__reram_cell area_ox=0.0676
XMz_71_12 dz_71_12 WL71 SL12 VSS sky130_fd_pr__nfet_g5v0d10v5 w=1 l=0.5
XRz_71_12 BLZ12 dz_71_12 sky130_fd_pr_reram__reram_cell area_ox=0.0676
XMn_71_12 dn_71_12 WL71 SL12 VSS sky130_fd_pr__nfet_g5v0d10v5 w=1 l=0.5
XRn_71_12 BLN12 dn_71_12 sky130_fd_pr_reram__reram_cell area_ox=0.0676
XMp_71_13 dp_71_13 WL71 SL13 VSS sky130_fd_pr__nfet_g5v0d10v5 w=1 l=0.5
XRp_71_13 BLP13 dp_71_13 sky130_fd_pr_reram__reram_cell area_ox=0.0676
XMz_71_13 dz_71_13 WL71 SL13 VSS sky130_fd_pr__nfet_g5v0d10v5 w=1 l=0.5
XRz_71_13 BLZ13 dz_71_13 sky130_fd_pr_reram__reram_cell area_ox=0.0676
XMn_71_13 dn_71_13 WL71 SL13 VSS sky130_fd_pr__nfet_g5v0d10v5 w=1 l=0.5
XRn_71_13 BLN13 dn_71_13 sky130_fd_pr_reram__reram_cell area_ox=0.0676
XMp_71_14 dp_71_14 WL71 SL14 VSS sky130_fd_pr__nfet_g5v0d10v5 w=1 l=0.5
XRp_71_14 BLP14 dp_71_14 sky130_fd_pr_reram__reram_cell area_ox=0.0676
XMz_71_14 dz_71_14 WL71 SL14 VSS sky130_fd_pr__nfet_g5v0d10v5 w=1 l=0.5
XRz_71_14 BLZ14 dz_71_14 sky130_fd_pr_reram__reram_cell area_ox=0.0676
XMn_71_14 dn_71_14 WL71 SL14 VSS sky130_fd_pr__nfet_g5v0d10v5 w=1 l=0.5
XRn_71_14 BLN14 dn_71_14 sky130_fd_pr_reram__reram_cell area_ox=0.0676
XMp_71_15 dp_71_15 WL71 SL15 VSS sky130_fd_pr__nfet_g5v0d10v5 w=1 l=0.5
XRp_71_15 BLP15 dp_71_15 sky130_fd_pr_reram__reram_cell area_ox=0.0676
XMz_71_15 dz_71_15 WL71 SL15 VSS sky130_fd_pr__nfet_g5v0d10v5 w=1 l=0.5
XRz_71_15 BLZ15 dz_71_15 sky130_fd_pr_reram__reram_cell area_ox=0.0676
XMn_71_15 dn_71_15 WL71 SL15 VSS sky130_fd_pr__nfet_g5v0d10v5 w=1 l=0.5
XRn_71_15 BLN15 dn_71_15 sky130_fd_pr_reram__reram_cell area_ox=0.0676
XMp_71_16 dp_71_16 WL71 SL16 VSS sky130_fd_pr__nfet_g5v0d10v5 w=1 l=0.5
XRp_71_16 BLP16 dp_71_16 sky130_fd_pr_reram__reram_cell area_ox=0.0676
XMz_71_16 dz_71_16 WL71 SL16 VSS sky130_fd_pr__nfet_g5v0d10v5 w=1 l=0.5
XRz_71_16 BLZ16 dz_71_16 sky130_fd_pr_reram__reram_cell area_ox=0.0676
XMn_71_16 dn_71_16 WL71 SL16 VSS sky130_fd_pr__nfet_g5v0d10v5 w=1 l=0.5
XRn_71_16 BLN16 dn_71_16 sky130_fd_pr_reram__reram_cell area_ox=0.0676
XMp_71_17 dp_71_17 WL71 SL17 VSS sky130_fd_pr__nfet_g5v0d10v5 w=1 l=0.5
XRp_71_17 BLP17 dp_71_17 sky130_fd_pr_reram__reram_cell area_ox=0.0676
XMz_71_17 dz_71_17 WL71 SL17 VSS sky130_fd_pr__nfet_g5v0d10v5 w=1 l=0.5
XRz_71_17 BLZ17 dz_71_17 sky130_fd_pr_reram__reram_cell area_ox=0.0676
XMn_71_17 dn_71_17 WL71 SL17 VSS sky130_fd_pr__nfet_g5v0d10v5 w=1 l=0.5
XRn_71_17 BLN17 dn_71_17 sky130_fd_pr_reram__reram_cell area_ox=0.0676
XMp_71_18 dp_71_18 WL71 SL18 VSS sky130_fd_pr__nfet_g5v0d10v5 w=1 l=0.5
XRp_71_18 BLP18 dp_71_18 sky130_fd_pr_reram__reram_cell area_ox=0.0676
XMz_71_18 dz_71_18 WL71 SL18 VSS sky130_fd_pr__nfet_g5v0d10v5 w=1 l=0.5
XRz_71_18 BLZ18 dz_71_18 sky130_fd_pr_reram__reram_cell area_ox=0.0676
XMn_71_18 dn_71_18 WL71 SL18 VSS sky130_fd_pr__nfet_g5v0d10v5 w=1 l=0.5
XRn_71_18 BLN18 dn_71_18 sky130_fd_pr_reram__reram_cell area_ox=0.0676
XMp_71_19 dp_71_19 WL71 SL19 VSS sky130_fd_pr__nfet_g5v0d10v5 w=1 l=0.5
XRp_71_19 BLP19 dp_71_19 sky130_fd_pr_reram__reram_cell area_ox=0.0676
XMz_71_19 dz_71_19 WL71 SL19 VSS sky130_fd_pr__nfet_g5v0d10v5 w=1 l=0.5
XRz_71_19 BLZ19 dz_71_19 sky130_fd_pr_reram__reram_cell area_ox=0.0676
XMn_71_19 dn_71_19 WL71 SL19 VSS sky130_fd_pr__nfet_g5v0d10v5 w=1 l=0.5
XRn_71_19 BLN19 dn_71_19 sky130_fd_pr_reram__reram_cell area_ox=0.0676
XMp_71_20 dp_71_20 WL71 SL20 VSS sky130_fd_pr__nfet_g5v0d10v5 w=1 l=0.5
XRp_71_20 BLP20 dp_71_20 sky130_fd_pr_reram__reram_cell area_ox=0.0676
XMz_71_20 dz_71_20 WL71 SL20 VSS sky130_fd_pr__nfet_g5v0d10v5 w=1 l=0.5
XRz_71_20 BLZ20 dz_71_20 sky130_fd_pr_reram__reram_cell area_ox=0.0676
XMn_71_20 dn_71_20 WL71 SL20 VSS sky130_fd_pr__nfet_g5v0d10v5 w=1 l=0.5
XRn_71_20 BLN20 dn_71_20 sky130_fd_pr_reram__reram_cell area_ox=0.0676
XMp_71_21 dp_71_21 WL71 SL21 VSS sky130_fd_pr__nfet_g5v0d10v5 w=1 l=0.5
XRp_71_21 BLP21 dp_71_21 sky130_fd_pr_reram__reram_cell area_ox=0.0676
XMz_71_21 dz_71_21 WL71 SL21 VSS sky130_fd_pr__nfet_g5v0d10v5 w=1 l=0.5
XRz_71_21 BLZ21 dz_71_21 sky130_fd_pr_reram__reram_cell area_ox=0.0676
XMn_71_21 dn_71_21 WL71 SL21 VSS sky130_fd_pr__nfet_g5v0d10v5 w=1 l=0.5
XRn_71_21 BLN21 dn_71_21 sky130_fd_pr_reram__reram_cell area_ox=0.0676
XMp_71_22 dp_71_22 WL71 SL22 VSS sky130_fd_pr__nfet_g5v0d10v5 w=1 l=0.5
XRp_71_22 BLP22 dp_71_22 sky130_fd_pr_reram__reram_cell area_ox=0.0676
XMz_71_22 dz_71_22 WL71 SL22 VSS sky130_fd_pr__nfet_g5v0d10v5 w=1 l=0.5
XRz_71_22 BLZ22 dz_71_22 sky130_fd_pr_reram__reram_cell area_ox=0.0676
XMn_71_22 dn_71_22 WL71 SL22 VSS sky130_fd_pr__nfet_g5v0d10v5 w=1 l=0.5
XRn_71_22 BLN22 dn_71_22 sky130_fd_pr_reram__reram_cell area_ox=0.0676
XMp_71_23 dp_71_23 WL71 SL23 VSS sky130_fd_pr__nfet_g5v0d10v5 w=1 l=0.5
XRp_71_23 BLP23 dp_71_23 sky130_fd_pr_reram__reram_cell area_ox=0.0676
XMz_71_23 dz_71_23 WL71 SL23 VSS sky130_fd_pr__nfet_g5v0d10v5 w=1 l=0.5
XRz_71_23 BLZ23 dz_71_23 sky130_fd_pr_reram__reram_cell area_ox=0.0676
XMn_71_23 dn_71_23 WL71 SL23 VSS sky130_fd_pr__nfet_g5v0d10v5 w=1 l=0.5
XRn_71_23 BLN23 dn_71_23 sky130_fd_pr_reram__reram_cell area_ox=0.0676
.ends
