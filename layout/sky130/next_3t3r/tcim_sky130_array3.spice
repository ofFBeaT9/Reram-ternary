* NGSPICE file created from tcim_sky130_array3.ext - technology: sky130B

.subckt tcim_sky130_array3 WL0 WL1 WL2 WL3 WL4 WL5 WL6 WL7 WL8 WL9 WL10 WL11 WL12
+ WL13 WL14 WL15 WL16 WL17 WL18 WL19 WL20 WL21 WL22 WL23 WL24 WL25 WL26 WL27 WL28
+ WL29 WL30 WL31 WL32 WL33 WL34 WL35 WL36 WL37 WL38 WL39 WL40 WL41 WL42 WL43 WL44
+ WL45 WL46 WL47 WL48 WL49 WL50 WL51 WL52 WL53 WL54 WL55 WL56 WL57 WL58 WL59 WL60
+ WL61 WL62 WL63 WL64 WL65 WL66 WL67 WL68 WL69 WL70 WL71 BLP0 BLP1 BLP2 BLP3 BLP4
+ BLP5 BLP6 BLP7 BLP8 BLP9 BLP10 BLP11 BLP12 BLP13 BLP14 BLP15 BLP16 BLP17 BLP18 BLP19
+ BLP20 BLP21 BLP22 BLP23 BLZ0 BLZ1 BLZ2 BLZ3 BLZ4 BLZ5 BLZ6 BLZ7 BLZ8 BLZ9 BLZ10
+ BLZ11 BLZ12 BLZ13 BLZ14 BLZ15 BLZ16 BLZ17 BLZ18 BLZ19 BLZ20 BLZ21 BLZ22 BLZ23 BLN0
+ BLN1 BLN2 BLN3 BLN4 BLN5 BLN6 BLN7 BLN8 BLN9 BLN10 BLN11 BLN12 BLN13 BLN14 BLN15
+ BLN16 BLN17 BLN18 BLN19 BLN20 BLN21 BLN22 BLN23 SL0 SL1 SL2 SL3 SL4 SL5 SL6 SL7
+ SL8 SL9 SL10 SL11 SL12 SL13 SL14 SL15 SL16 SL17 SL18 SL19 SL20 SL21 SL22 SL23 VSS
X0 BLP0 rr3t3r_0[0|0]/a_60_290# sky130_fd_pr_reram__reram_cell area_ox=0.0676
X1 BLZ0 rr3t3r_0[0|0]/a_460_290# sky130_fd_pr_reram__reram_cell area_ox=0.0676
X2 rr3t3r_0[0|0]/a_460_290# WL0 SL0 VSS sky130_fd_pr__nfet_g5v0d10v5 ad=0.65 pd=3.3 as=0.75 ps=3.5 w=1 l=0.5
X3 BLN0 rr3t3r_0[0|0]/a_860_290# sky130_fd_pr_reram__reram_cell area_ox=0.0676
X4 rr3t3r_0[0|0]/a_60_290# WL0 SL0 VSS sky130_fd_pr__nfet_g5v0d10v5 ad=0.65 pd=3.3 as=0.75 ps=3.5 w=1 l=0.5
X5 rr3t3r_0[0|0]/a_860_290# WL0 SL0 VSS sky130_fd_pr__nfet_g5v0d10v5 ad=0.65 pd=3.3 as=0.75 ps=3.5 w=1 l=0.5
X6 BLP0 rr3t3r_0[1|0]/a_60_290# sky130_fd_pr_reram__reram_cell area_ox=0.0676
X7 BLZ0 rr3t3r_0[1|0]/a_460_290# sky130_fd_pr_reram__reram_cell area_ox=0.0676
X8 rr3t3r_0[1|0]/a_460_290# WL1 SL0 VSS sky130_fd_pr__nfet_g5v0d10v5 ad=0.65 pd=3.3 as=162 ps=756 w=1 l=0.5
X9 BLN0 rr3t3r_0[1|0]/a_860_290# sky130_fd_pr_reram__reram_cell area_ox=0.0676
X10 rr3t3r_0[1|0]/a_60_290# WL1 SL0 VSS sky130_fd_pr__nfet_g5v0d10v5 ad=0.65 pd=3.3 as=0 ps=0 w=1 l=0.5
X11 rr3t3r_0[1|0]/a_860_290# WL1 SL0 VSS sky130_fd_pr__nfet_g5v0d10v5 ad=0.65 pd=3.3 as=0 ps=0 w=1 l=0.5
X12 BLP0 rr3t3r_0[2|0]/a_60_290# sky130_fd_pr_reram__reram_cell area_ox=0.0676
X13 BLZ0 rr3t3r_0[2|0]/a_460_290# sky130_fd_pr_reram__reram_cell area_ox=0.0676
X14 rr3t3r_0[2|0]/a_460_290# WL2 SL0 VSS sky130_fd_pr__nfet_g5v0d10v5 ad=0.65 pd=3.3 as=0 ps=0 w=1 l=0.5
X15 BLN0 rr3t3r_0[2|0]/a_860_290# sky130_fd_pr_reram__reram_cell area_ox=0.0676
X16 rr3t3r_0[2|0]/a_60_290# WL2 SL0 VSS sky130_fd_pr__nfet_g5v0d10v5 ad=0.65 pd=3.3 as=0 ps=0 w=1 l=0.5
X17 rr3t3r_0[2|0]/a_860_290# WL2 SL0 VSS sky130_fd_pr__nfet_g5v0d10v5 ad=0.65 pd=3.3 as=0 ps=0 w=1 l=0.5
X18 BLP0 rr3t3r_0[3|0]/a_60_290# sky130_fd_pr_reram__reram_cell area_ox=0.0676
X19 BLZ0 rr3t3r_0[3|0]/a_460_290# sky130_fd_pr_reram__reram_cell area_ox=0.0676
X20 rr3t3r_0[3|0]/a_460_290# WL3 SL0 VSS sky130_fd_pr__nfet_g5v0d10v5 ad=0.65 pd=3.3 as=0 ps=0 w=1 l=0.5
X21 BLN0 rr3t3r_0[3|0]/a_860_290# sky130_fd_pr_reram__reram_cell area_ox=0.0676
X22 rr3t3r_0[3|0]/a_60_290# WL3 SL0 VSS sky130_fd_pr__nfet_g5v0d10v5 ad=0.65 pd=3.3 as=0 ps=0 w=1 l=0.5
X23 rr3t3r_0[3|0]/a_860_290# WL3 SL0 VSS sky130_fd_pr__nfet_g5v0d10v5 ad=0.65 pd=3.3 as=0 ps=0 w=1 l=0.5
X24 BLP0 rr3t3r_0[4|0]/a_60_290# sky130_fd_pr_reram__reram_cell area_ox=0.0676
X25 BLZ0 rr3t3r_0[4|0]/a_460_290# sky130_fd_pr_reram__reram_cell area_ox=0.0676
X26 rr3t3r_0[4|0]/a_460_290# WL4 SL0 VSS sky130_fd_pr__nfet_g5v0d10v5 ad=0.65 pd=3.3 as=0 ps=0 w=1 l=0.5
X27 BLN0 rr3t3r_0[4|0]/a_860_290# sky130_fd_pr_reram__reram_cell area_ox=0.0676
X28 rr3t3r_0[4|0]/a_60_290# WL4 SL0 VSS sky130_fd_pr__nfet_g5v0d10v5 ad=0.65 pd=3.3 as=0 ps=0 w=1 l=0.5
X29 rr3t3r_0[4|0]/a_860_290# WL4 SL0 VSS sky130_fd_pr__nfet_g5v0d10v5 ad=0.65 pd=3.3 as=0 ps=0 w=1 l=0.5
X30 BLP0 rr3t3r_0[5|0]/a_60_290# sky130_fd_pr_reram__reram_cell area_ox=0.0676
X31 BLZ0 rr3t3r_0[5|0]/a_460_290# sky130_fd_pr_reram__reram_cell area_ox=0.0676
X32 rr3t3r_0[5|0]/a_460_290# WL5 SL0 VSS sky130_fd_pr__nfet_g5v0d10v5 ad=0.65 pd=3.3 as=0 ps=0 w=1 l=0.5
X33 BLN0 rr3t3r_0[5|0]/a_860_290# sky130_fd_pr_reram__reram_cell area_ox=0.0676
X34 rr3t3r_0[5|0]/a_60_290# WL5 SL0 VSS sky130_fd_pr__nfet_g5v0d10v5 ad=0.65 pd=3.3 as=0 ps=0 w=1 l=0.5
X35 rr3t3r_0[5|0]/a_860_290# WL5 SL0 VSS sky130_fd_pr__nfet_g5v0d10v5 ad=0.65 pd=3.3 as=0 ps=0 w=1 l=0.5
X36 BLP0 rr3t3r_0[6|0]/a_60_290# sky130_fd_pr_reram__reram_cell area_ox=0.0676
X37 BLZ0 rr3t3r_0[6|0]/a_460_290# sky130_fd_pr_reram__reram_cell area_ox=0.0676
X38 rr3t3r_0[6|0]/a_460_290# WL6 SL0 VSS sky130_fd_pr__nfet_g5v0d10v5 ad=0.65 pd=3.3 as=0 ps=0 w=1 l=0.5
X39 BLN0 rr3t3r_0[6|0]/a_860_290# sky130_fd_pr_reram__reram_cell area_ox=0.0676
X40 rr3t3r_0[6|0]/a_60_290# WL6 SL0 VSS sky130_fd_pr__nfet_g5v0d10v5 ad=0.65 pd=3.3 as=0 ps=0 w=1 l=0.5
X41 rr3t3r_0[6|0]/a_860_290# WL6 SL0 VSS sky130_fd_pr__nfet_g5v0d10v5 ad=0.65 pd=3.3 as=0 ps=0 w=1 l=0.5
X42 BLP0 rr3t3r_0[7|0]/a_60_290# sky130_fd_pr_reram__reram_cell area_ox=0.0676
X43 BLZ0 rr3t3r_0[7|0]/a_460_290# sky130_fd_pr_reram__reram_cell area_ox=0.0676
X44 rr3t3r_0[7|0]/a_460_290# WL7 SL0 VSS sky130_fd_pr__nfet_g5v0d10v5 ad=0.65 pd=3.3 as=0 ps=0 w=1 l=0.5
X45 BLN0 rr3t3r_0[7|0]/a_860_290# sky130_fd_pr_reram__reram_cell area_ox=0.0676
X46 rr3t3r_0[7|0]/a_60_290# WL7 SL0 VSS sky130_fd_pr__nfet_g5v0d10v5 ad=0.65 pd=3.3 as=0 ps=0 w=1 l=0.5
X47 rr3t3r_0[7|0]/a_860_290# WL7 SL0 VSS sky130_fd_pr__nfet_g5v0d10v5 ad=0.65 pd=3.3 as=0 ps=0 w=1 l=0.5
X48 BLP0 rr3t3r_0[8|0]/a_60_290# sky130_fd_pr_reram__reram_cell area_ox=0.0676
X49 BLZ0 rr3t3r_0[8|0]/a_460_290# sky130_fd_pr_reram__reram_cell area_ox=0.0676
X50 rr3t3r_0[8|0]/a_460_290# WL8 SL0 VSS sky130_fd_pr__nfet_g5v0d10v5 ad=0.65 pd=3.3 as=0 ps=0 w=1 l=0.5
X51 BLN0 rr3t3r_0[8|0]/a_860_290# sky130_fd_pr_reram__reram_cell area_ox=0.0676
X52 rr3t3r_0[8|0]/a_60_290# WL8 SL0 VSS sky130_fd_pr__nfet_g5v0d10v5 ad=0.65 pd=3.3 as=0 ps=0 w=1 l=0.5
X53 rr3t3r_0[8|0]/a_860_290# WL8 SL0 VSS sky130_fd_pr__nfet_g5v0d10v5 ad=0.65 pd=3.3 as=0 ps=0 w=1 l=0.5
X54 BLP0 rr3t3r_0[9|0]/a_60_290# sky130_fd_pr_reram__reram_cell area_ox=0.0676
X55 BLZ0 rr3t3r_0[9|0]/a_460_290# sky130_fd_pr_reram__reram_cell area_ox=0.0676
X56 rr3t3r_0[9|0]/a_460_290# WL9 SL0 VSS sky130_fd_pr__nfet_g5v0d10v5 ad=0.65 pd=3.3 as=0 ps=0 w=1 l=0.5
X57 BLN0 rr3t3r_0[9|0]/a_860_290# sky130_fd_pr_reram__reram_cell area_ox=0.0676
X58 rr3t3r_0[9|0]/a_60_290# WL9 SL0 VSS sky130_fd_pr__nfet_g5v0d10v5 ad=0.65 pd=3.3 as=0 ps=0 w=1 l=0.5
X59 rr3t3r_0[9|0]/a_860_290# WL9 SL0 VSS sky130_fd_pr__nfet_g5v0d10v5 ad=0.65 pd=3.3 as=0 ps=0 w=1 l=0.5
X60 BLP0 rr3t3r_0[10|0]/a_60_290# sky130_fd_pr_reram__reram_cell area_ox=0.0676
X61 BLZ0 rr3t3r_0[10|0]/a_460_290# sky130_fd_pr_reram__reram_cell area_ox=0.0676
X62 rr3t3r_0[10|0]/a_460_290# WL10 SL0 VSS sky130_fd_pr__nfet_g5v0d10v5 ad=0.65 pd=3.3 as=0 ps=0 w=1 l=0.5
X63 BLN0 rr3t3r_0[10|0]/a_860_290# sky130_fd_pr_reram__reram_cell area_ox=0.0676
X64 rr3t3r_0[10|0]/a_60_290# WL10 SL0 VSS sky130_fd_pr__nfet_g5v0d10v5 ad=0.65 pd=3.3 as=0 ps=0 w=1 l=0.5
X65 rr3t3r_0[10|0]/a_860_290# WL10 SL0 VSS sky130_fd_pr__nfet_g5v0d10v5 ad=0.65 pd=3.3 as=0 ps=0 w=1 l=0.5
X66 BLP0 rr3t3r_0[11|0]/a_60_290# sky130_fd_pr_reram__reram_cell area_ox=0.0676
X67 BLZ0 rr3t3r_0[11|0]/a_460_290# sky130_fd_pr_reram__reram_cell area_ox=0.0676
X68 rr3t3r_0[11|0]/a_460_290# WL11 SL0 VSS sky130_fd_pr__nfet_g5v0d10v5 ad=0.65 pd=3.3 as=0 ps=0 w=1 l=0.5
X69 BLN0 rr3t3r_0[11|0]/a_860_290# sky130_fd_pr_reram__reram_cell area_ox=0.0676
X70 rr3t3r_0[11|0]/a_60_290# WL11 SL0 VSS sky130_fd_pr__nfet_g5v0d10v5 ad=0.65 pd=3.3 as=0 ps=0 w=1 l=0.5
X71 rr3t3r_0[11|0]/a_860_290# WL11 SL0 VSS sky130_fd_pr__nfet_g5v0d10v5 ad=0.65 pd=3.3 as=0 ps=0 w=1 l=0.5
X72 BLP0 rr3t3r_0[12|0]/a_60_290# sky130_fd_pr_reram__reram_cell area_ox=0.0676
X73 BLZ0 rr3t3r_0[12|0]/a_460_290# sky130_fd_pr_reram__reram_cell area_ox=0.0676
X74 rr3t3r_0[12|0]/a_460_290# WL12 SL0 VSS sky130_fd_pr__nfet_g5v0d10v5 ad=0.65 pd=3.3 as=0 ps=0 w=1 l=0.5
X75 BLN0 rr3t3r_0[12|0]/a_860_290# sky130_fd_pr_reram__reram_cell area_ox=0.0676
X76 rr3t3r_0[12|0]/a_60_290# WL12 SL0 VSS sky130_fd_pr__nfet_g5v0d10v5 ad=0.65 pd=3.3 as=0 ps=0 w=1 l=0.5
X77 rr3t3r_0[12|0]/a_860_290# WL12 SL0 VSS sky130_fd_pr__nfet_g5v0d10v5 ad=0.65 pd=3.3 as=0 ps=0 w=1 l=0.5
X78 BLP0 rr3t3r_0[13|0]/a_60_290# sky130_fd_pr_reram__reram_cell area_ox=0.0676
X79 BLZ0 rr3t3r_0[13|0]/a_460_290# sky130_fd_pr_reram__reram_cell area_ox=0.0676
X80 rr3t3r_0[13|0]/a_460_290# WL13 SL0 VSS sky130_fd_pr__nfet_g5v0d10v5 ad=0.65 pd=3.3 as=0 ps=0 w=1 l=0.5
X81 BLN0 rr3t3r_0[13|0]/a_860_290# sky130_fd_pr_reram__reram_cell area_ox=0.0676
X82 rr3t3r_0[13|0]/a_60_290# WL13 SL0 VSS sky130_fd_pr__nfet_g5v0d10v5 ad=0.65 pd=3.3 as=0 ps=0 w=1 l=0.5
X83 rr3t3r_0[13|0]/a_860_290# WL13 SL0 VSS sky130_fd_pr__nfet_g5v0d10v5 ad=0.65 pd=3.3 as=0 ps=0 w=1 l=0.5
X84 BLP0 rr3t3r_0[14|0]/a_60_290# sky130_fd_pr_reram__reram_cell area_ox=0.0676
X85 BLZ0 rr3t3r_0[14|0]/a_460_290# sky130_fd_pr_reram__reram_cell area_ox=0.0676
X86 rr3t3r_0[14|0]/a_460_290# WL14 SL0 VSS sky130_fd_pr__nfet_g5v0d10v5 ad=0.65 pd=3.3 as=0 ps=0 w=1 l=0.5
X87 BLN0 rr3t3r_0[14|0]/a_860_290# sky130_fd_pr_reram__reram_cell area_ox=0.0676
X88 rr3t3r_0[14|0]/a_60_290# WL14 SL0 VSS sky130_fd_pr__nfet_g5v0d10v5 ad=0.65 pd=3.3 as=0 ps=0 w=1 l=0.5
X89 rr3t3r_0[14|0]/a_860_290# WL14 SL0 VSS sky130_fd_pr__nfet_g5v0d10v5 ad=0.65 pd=3.3 as=0 ps=0 w=1 l=0.5
X90 BLP0 rr3t3r_0[15|0]/a_60_290# sky130_fd_pr_reram__reram_cell area_ox=0.0676
X91 BLZ0 rr3t3r_0[15|0]/a_460_290# sky130_fd_pr_reram__reram_cell area_ox=0.0676
X92 rr3t3r_0[15|0]/a_460_290# WL15 SL0 VSS sky130_fd_pr__nfet_g5v0d10v5 ad=0.65 pd=3.3 as=0 ps=0 w=1 l=0.5
X93 BLN0 rr3t3r_0[15|0]/a_860_290# sky130_fd_pr_reram__reram_cell area_ox=0.0676
X94 rr3t3r_0[15|0]/a_60_290# WL15 SL0 VSS sky130_fd_pr__nfet_g5v0d10v5 ad=0.65 pd=3.3 as=0 ps=0 w=1 l=0.5
X95 rr3t3r_0[15|0]/a_860_290# WL15 SL0 VSS sky130_fd_pr__nfet_g5v0d10v5 ad=0.65 pd=3.3 as=0 ps=0 w=1 l=0.5
X96 BLP0 rr3t3r_0[16|0]/a_60_290# sky130_fd_pr_reram__reram_cell area_ox=0.0676
X97 BLZ0 rr3t3r_0[16|0]/a_460_290# sky130_fd_pr_reram__reram_cell area_ox=0.0676
X98 rr3t3r_0[16|0]/a_460_290# WL16 SL0 VSS sky130_fd_pr__nfet_g5v0d10v5 ad=0.65 pd=3.3 as=0 ps=0 w=1 l=0.5
X99 BLN0 rr3t3r_0[16|0]/a_860_290# sky130_fd_pr_reram__reram_cell area_ox=0.0676
X100 rr3t3r_0[16|0]/a_60_290# WL16 SL0 VSS sky130_fd_pr__nfet_g5v0d10v5 ad=0.65 pd=3.3 as=0 ps=0 w=1 l=0.5
X101 rr3t3r_0[16|0]/a_860_290# WL16 SL0 VSS sky130_fd_pr__nfet_g5v0d10v5 ad=0.65 pd=3.3 as=0 ps=0 w=1 l=0.5
X102 BLP0 rr3t3r_0[17|0]/a_60_290# sky130_fd_pr_reram__reram_cell area_ox=0.0676
X103 BLZ0 rr3t3r_0[17|0]/a_460_290# sky130_fd_pr_reram__reram_cell area_ox=0.0676
X104 rr3t3r_0[17|0]/a_460_290# WL17 SL0 VSS sky130_fd_pr__nfet_g5v0d10v5 ad=0.65 pd=3.3 as=0 ps=0 w=1 l=0.5
X105 BLN0 rr3t3r_0[17|0]/a_860_290# sky130_fd_pr_reram__reram_cell area_ox=0.0676
X106 rr3t3r_0[17|0]/a_60_290# WL17 SL0 VSS sky130_fd_pr__nfet_g5v0d10v5 ad=0.65 pd=3.3 as=0 ps=0 w=1 l=0.5
X107 rr3t3r_0[17|0]/a_860_290# WL17 SL0 VSS sky130_fd_pr__nfet_g5v0d10v5 ad=0.65 pd=3.3 as=0 ps=0 w=1 l=0.5
X108 BLP0 rr3t3r_0[18|0]/a_60_290# sky130_fd_pr_reram__reram_cell area_ox=0.0676
X109 BLZ0 rr3t3r_0[18|0]/a_460_290# sky130_fd_pr_reram__reram_cell area_ox=0.0676
X110 rr3t3r_0[18|0]/a_460_290# WL18 SL0 VSS sky130_fd_pr__nfet_g5v0d10v5 ad=0.65 pd=3.3 as=0 ps=0 w=1 l=0.5
X111 BLN0 rr3t3r_0[18|0]/a_860_290# sky130_fd_pr_reram__reram_cell area_ox=0.0676
X112 rr3t3r_0[18|0]/a_60_290# WL18 SL0 VSS sky130_fd_pr__nfet_g5v0d10v5 ad=0.65 pd=3.3 as=0 ps=0 w=1 l=0.5
X113 rr3t3r_0[18|0]/a_860_290# WL18 SL0 VSS sky130_fd_pr__nfet_g5v0d10v5 ad=0.65 pd=3.3 as=0 ps=0 w=1 l=0.5
X114 BLP0 rr3t3r_0[19|0]/a_60_290# sky130_fd_pr_reram__reram_cell area_ox=0.0676
X115 BLZ0 rr3t3r_0[19|0]/a_460_290# sky130_fd_pr_reram__reram_cell area_ox=0.0676
X116 rr3t3r_0[19|0]/a_460_290# WL19 SL0 VSS sky130_fd_pr__nfet_g5v0d10v5 ad=0.65 pd=3.3 as=0 ps=0 w=1 l=0.5
X117 BLN0 rr3t3r_0[19|0]/a_860_290# sky130_fd_pr_reram__reram_cell area_ox=0.0676
X118 rr3t3r_0[19|0]/a_60_290# WL19 SL0 VSS sky130_fd_pr__nfet_g5v0d10v5 ad=0.65 pd=3.3 as=0 ps=0 w=1 l=0.5
X119 rr3t3r_0[19|0]/a_860_290# WL19 SL0 VSS sky130_fd_pr__nfet_g5v0d10v5 ad=0.65 pd=3.3 as=0 ps=0 w=1 l=0.5
X120 BLP0 rr3t3r_0[20|0]/a_60_290# sky130_fd_pr_reram__reram_cell area_ox=0.0676
X121 BLZ0 rr3t3r_0[20|0]/a_460_290# sky130_fd_pr_reram__reram_cell area_ox=0.0676
X122 rr3t3r_0[20|0]/a_460_290# WL20 SL0 VSS sky130_fd_pr__nfet_g5v0d10v5 ad=0.65 pd=3.3 as=0 ps=0 w=1 l=0.5
X123 BLN0 rr3t3r_0[20|0]/a_860_290# sky130_fd_pr_reram__reram_cell area_ox=0.0676
X124 rr3t3r_0[20|0]/a_60_290# WL20 SL0 VSS sky130_fd_pr__nfet_g5v0d10v5 ad=0.65 pd=3.3 as=0 ps=0 w=1 l=0.5
X125 rr3t3r_0[20|0]/a_860_290# WL20 SL0 VSS sky130_fd_pr__nfet_g5v0d10v5 ad=0.65 pd=3.3 as=0 ps=0 w=1 l=0.5
X126 BLP0 rr3t3r_0[21|0]/a_60_290# sky130_fd_pr_reram__reram_cell area_ox=0.0676
X127 BLZ0 rr3t3r_0[21|0]/a_460_290# sky130_fd_pr_reram__reram_cell area_ox=0.0676
X128 rr3t3r_0[21|0]/a_460_290# WL21 SL0 VSS sky130_fd_pr__nfet_g5v0d10v5 ad=0.65 pd=3.3 as=0 ps=0 w=1 l=0.5
X129 BLN0 rr3t3r_0[21|0]/a_860_290# sky130_fd_pr_reram__reram_cell area_ox=0.0676
X130 rr3t3r_0[21|0]/a_60_290# WL21 SL0 VSS sky130_fd_pr__nfet_g5v0d10v5 ad=0.65 pd=3.3 as=0 ps=0 w=1 l=0.5
X131 rr3t3r_0[21|0]/a_860_290# WL21 SL0 VSS sky130_fd_pr__nfet_g5v0d10v5 ad=0.65 pd=3.3 as=0 ps=0 w=1 l=0.5
X132 BLP0 rr3t3r_0[22|0]/a_60_290# sky130_fd_pr_reram__reram_cell area_ox=0.0676
X133 BLZ0 rr3t3r_0[22|0]/a_460_290# sky130_fd_pr_reram__reram_cell area_ox=0.0676
X134 rr3t3r_0[22|0]/a_460_290# WL22 SL0 VSS sky130_fd_pr__nfet_g5v0d10v5 ad=0.65 pd=3.3 as=0 ps=0 w=1 l=0.5
X135 BLN0 rr3t3r_0[22|0]/a_860_290# sky130_fd_pr_reram__reram_cell area_ox=0.0676
X136 rr3t3r_0[22|0]/a_60_290# WL22 SL0 VSS sky130_fd_pr__nfet_g5v0d10v5 ad=0.65 pd=3.3 as=0 ps=0 w=1 l=0.5
X137 rr3t3r_0[22|0]/a_860_290# WL22 SL0 VSS sky130_fd_pr__nfet_g5v0d10v5 ad=0.65 pd=3.3 as=0 ps=0 w=1 l=0.5
X138 BLP0 rr3t3r_0[23|0]/a_60_290# sky130_fd_pr_reram__reram_cell area_ox=0.0676
X139 BLZ0 rr3t3r_0[23|0]/a_460_290# sky130_fd_pr_reram__reram_cell area_ox=0.0676
X140 rr3t3r_0[23|0]/a_460_290# WL23 SL0 VSS sky130_fd_pr__nfet_g5v0d10v5 ad=0.65 pd=3.3 as=0 ps=0 w=1 l=0.5
X141 BLN0 rr3t3r_0[23|0]/a_860_290# sky130_fd_pr_reram__reram_cell area_ox=0.0676
X142 rr3t3r_0[23|0]/a_60_290# WL23 SL0 VSS sky130_fd_pr__nfet_g5v0d10v5 ad=0.65 pd=3.3 as=0 ps=0 w=1 l=0.5
X143 rr3t3r_0[23|0]/a_860_290# WL23 SL0 VSS sky130_fd_pr__nfet_g5v0d10v5 ad=0.65 pd=3.3 as=0 ps=0 w=1 l=0.5
X144 BLP0 rr3t3r_0[24|0]/a_60_290# sky130_fd_pr_reram__reram_cell area_ox=0.0676
X145 BLZ0 rr3t3r_0[24|0]/a_460_290# sky130_fd_pr_reram__reram_cell area_ox=0.0676
X146 rr3t3r_0[24|0]/a_460_290# WL24 SL0 VSS sky130_fd_pr__nfet_g5v0d10v5 ad=0.65 pd=3.3 as=0 ps=0 w=1 l=0.5
X147 BLN0 rr3t3r_0[24|0]/a_860_290# sky130_fd_pr_reram__reram_cell area_ox=0.0676
X148 rr3t3r_0[24|0]/a_60_290# WL24 SL0 VSS sky130_fd_pr__nfet_g5v0d10v5 ad=0.65 pd=3.3 as=0 ps=0 w=1 l=0.5
X149 rr3t3r_0[24|0]/a_860_290# WL24 SL0 VSS sky130_fd_pr__nfet_g5v0d10v5 ad=0.65 pd=3.3 as=0 ps=0 w=1 l=0.5
X150 BLP0 rr3t3r_0[25|0]/a_60_290# sky130_fd_pr_reram__reram_cell area_ox=0.0676
X151 BLZ0 rr3t3r_0[25|0]/a_460_290# sky130_fd_pr_reram__reram_cell area_ox=0.0676
X152 rr3t3r_0[25|0]/a_460_290# WL25 SL0 VSS sky130_fd_pr__nfet_g5v0d10v5 ad=0.65 pd=3.3 as=0 ps=0 w=1 l=0.5
X153 BLN0 rr3t3r_0[25|0]/a_860_290# sky130_fd_pr_reram__reram_cell area_ox=0.0676
X154 rr3t3r_0[25|0]/a_60_290# WL25 SL0 VSS sky130_fd_pr__nfet_g5v0d10v5 ad=0.65 pd=3.3 as=0 ps=0 w=1 l=0.5
X155 rr3t3r_0[25|0]/a_860_290# WL25 SL0 VSS sky130_fd_pr__nfet_g5v0d10v5 ad=0.65 pd=3.3 as=0 ps=0 w=1 l=0.5
X156 BLP0 rr3t3r_0[26|0]/a_60_290# sky130_fd_pr_reram__reram_cell area_ox=0.0676
X157 BLZ0 rr3t3r_0[26|0]/a_460_290# sky130_fd_pr_reram__reram_cell area_ox=0.0676
X158 rr3t3r_0[26|0]/a_460_290# WL26 SL0 VSS sky130_fd_pr__nfet_g5v0d10v5 ad=0.65 pd=3.3 as=0 ps=0 w=1 l=0.5
X159 BLN0 rr3t3r_0[26|0]/a_860_290# sky130_fd_pr_reram__reram_cell area_ox=0.0676
X160 rr3t3r_0[26|0]/a_60_290# WL26 SL0 VSS sky130_fd_pr__nfet_g5v0d10v5 ad=0.65 pd=3.3 as=0 ps=0 w=1 l=0.5
X161 rr3t3r_0[26|0]/a_860_290# WL26 SL0 VSS sky130_fd_pr__nfet_g5v0d10v5 ad=0.65 pd=3.3 as=0 ps=0 w=1 l=0.5
X162 BLP0 rr3t3r_0[27|0]/a_60_290# sky130_fd_pr_reram__reram_cell area_ox=0.0676
X163 BLZ0 rr3t3r_0[27|0]/a_460_290# sky130_fd_pr_reram__reram_cell area_ox=0.0676
X164 rr3t3r_0[27|0]/a_460_290# WL27 SL0 VSS sky130_fd_pr__nfet_g5v0d10v5 ad=0.65 pd=3.3 as=0 ps=0 w=1 l=0.5
X165 BLN0 rr3t3r_0[27|0]/a_860_290# sky130_fd_pr_reram__reram_cell area_ox=0.0676
X166 rr3t3r_0[27|0]/a_60_290# WL27 SL0 VSS sky130_fd_pr__nfet_g5v0d10v5 ad=0.65 pd=3.3 as=0 ps=0 w=1 l=0.5
X167 rr3t3r_0[27|0]/a_860_290# WL27 SL0 VSS sky130_fd_pr__nfet_g5v0d10v5 ad=0.65 pd=3.3 as=0 ps=0 w=1 l=0.5
X168 BLP0 rr3t3r_0[28|0]/a_60_290# sky130_fd_pr_reram__reram_cell area_ox=0.0676
X169 BLZ0 rr3t3r_0[28|0]/a_460_290# sky130_fd_pr_reram__reram_cell area_ox=0.0676
X170 rr3t3r_0[28|0]/a_460_290# WL28 SL0 VSS sky130_fd_pr__nfet_g5v0d10v5 ad=0.65 pd=3.3 as=0 ps=0 w=1 l=0.5
X171 BLN0 rr3t3r_0[28|0]/a_860_290# sky130_fd_pr_reram__reram_cell area_ox=0.0676
X172 rr3t3r_0[28|0]/a_60_290# WL28 SL0 VSS sky130_fd_pr__nfet_g5v0d10v5 ad=0.65 pd=3.3 as=0 ps=0 w=1 l=0.5
X173 rr3t3r_0[28|0]/a_860_290# WL28 SL0 VSS sky130_fd_pr__nfet_g5v0d10v5 ad=0.65 pd=3.3 as=0 ps=0 w=1 l=0.5
X174 BLP0 rr3t3r_0[29|0]/a_60_290# sky130_fd_pr_reram__reram_cell area_ox=0.0676
X175 BLZ0 rr3t3r_0[29|0]/a_460_290# sky130_fd_pr_reram__reram_cell area_ox=0.0676
X176 rr3t3r_0[29|0]/a_460_290# WL29 SL0 VSS sky130_fd_pr__nfet_g5v0d10v5 ad=0.65 pd=3.3 as=0 ps=0 w=1 l=0.5
X177 BLN0 rr3t3r_0[29|0]/a_860_290# sky130_fd_pr_reram__reram_cell area_ox=0.0676
X178 rr3t3r_0[29|0]/a_60_290# WL29 SL0 VSS sky130_fd_pr__nfet_g5v0d10v5 ad=0.65 pd=3.3 as=0 ps=0 w=1 l=0.5
X179 rr3t3r_0[29|0]/a_860_290# WL29 SL0 VSS sky130_fd_pr__nfet_g5v0d10v5 ad=0.65 pd=3.3 as=0 ps=0 w=1 l=0.5
X180 BLP0 rr3t3r_0[30|0]/a_60_290# sky130_fd_pr_reram__reram_cell area_ox=0.0676
X181 BLZ0 rr3t3r_0[30|0]/a_460_290# sky130_fd_pr_reram__reram_cell area_ox=0.0676
X182 rr3t3r_0[30|0]/a_460_290# WL30 SL0 VSS sky130_fd_pr__nfet_g5v0d10v5 ad=0.65 pd=3.3 as=0 ps=0 w=1 l=0.5
X183 BLN0 rr3t3r_0[30|0]/a_860_290# sky130_fd_pr_reram__reram_cell area_ox=0.0676
X184 rr3t3r_0[30|0]/a_60_290# WL30 SL0 VSS sky130_fd_pr__nfet_g5v0d10v5 ad=0.65 pd=3.3 as=0 ps=0 w=1 l=0.5
X185 rr3t3r_0[30|0]/a_860_290# WL30 SL0 VSS sky130_fd_pr__nfet_g5v0d10v5 ad=0.65 pd=3.3 as=0 ps=0 w=1 l=0.5
X186 BLP0 rr3t3r_0[31|0]/a_60_290# sky130_fd_pr_reram__reram_cell area_ox=0.0676
X187 BLZ0 rr3t3r_0[31|0]/a_460_290# sky130_fd_pr_reram__reram_cell area_ox=0.0676
X188 rr3t3r_0[31|0]/a_460_290# WL31 SL0 VSS sky130_fd_pr__nfet_g5v0d10v5 ad=0.65 pd=3.3 as=0 ps=0 w=1 l=0.5
X189 BLN0 rr3t3r_0[31|0]/a_860_290# sky130_fd_pr_reram__reram_cell area_ox=0.0676
X190 rr3t3r_0[31|0]/a_60_290# WL31 SL0 VSS sky130_fd_pr__nfet_g5v0d10v5 ad=0.65 pd=3.3 as=0 ps=0 w=1 l=0.5
X191 rr3t3r_0[31|0]/a_860_290# WL31 SL0 VSS sky130_fd_pr__nfet_g5v0d10v5 ad=0.65 pd=3.3 as=0 ps=0 w=1 l=0.5
X192 BLP0 rr3t3r_0[32|0]/a_60_290# sky130_fd_pr_reram__reram_cell area_ox=0.0676
X193 BLZ0 rr3t3r_0[32|0]/a_460_290# sky130_fd_pr_reram__reram_cell area_ox=0.0676
X194 rr3t3r_0[32|0]/a_460_290# WL32 SL0 VSS sky130_fd_pr__nfet_g5v0d10v5 ad=0.65 pd=3.3 as=0 ps=0 w=1 l=0.5
X195 BLN0 rr3t3r_0[32|0]/a_860_290# sky130_fd_pr_reram__reram_cell area_ox=0.0676
X196 rr3t3r_0[32|0]/a_60_290# WL32 SL0 VSS sky130_fd_pr__nfet_g5v0d10v5 ad=0.65 pd=3.3 as=0 ps=0 w=1 l=0.5
X197 rr3t3r_0[32|0]/a_860_290# WL32 SL0 VSS sky130_fd_pr__nfet_g5v0d10v5 ad=0.65 pd=3.3 as=0 ps=0 w=1 l=0.5
X198 BLP0 rr3t3r_0[33|0]/a_60_290# sky130_fd_pr_reram__reram_cell area_ox=0.0676
X199 BLZ0 rr3t3r_0[33|0]/a_460_290# sky130_fd_pr_reram__reram_cell area_ox=0.0676
X200 rr3t3r_0[33|0]/a_460_290# WL33 SL0 VSS sky130_fd_pr__nfet_g5v0d10v5 ad=0.65 pd=3.3 as=0 ps=0 w=1 l=0.5
X201 BLN0 rr3t3r_0[33|0]/a_860_290# sky130_fd_pr_reram__reram_cell area_ox=0.0676
X202 rr3t3r_0[33|0]/a_60_290# WL33 SL0 VSS sky130_fd_pr__nfet_g5v0d10v5 ad=0.65 pd=3.3 as=0 ps=0 w=1 l=0.5
X203 rr3t3r_0[33|0]/a_860_290# WL33 SL0 VSS sky130_fd_pr__nfet_g5v0d10v5 ad=0.65 pd=3.3 as=0 ps=0 w=1 l=0.5
X204 BLP0 rr3t3r_0[34|0]/a_60_290# sky130_fd_pr_reram__reram_cell area_ox=0.0676
X205 BLZ0 rr3t3r_0[34|0]/a_460_290# sky130_fd_pr_reram__reram_cell area_ox=0.0676
X206 rr3t3r_0[34|0]/a_460_290# WL34 SL0 VSS sky130_fd_pr__nfet_g5v0d10v5 ad=0.65 pd=3.3 as=0 ps=0 w=1 l=0.5
X207 BLN0 rr3t3r_0[34|0]/a_860_290# sky130_fd_pr_reram__reram_cell area_ox=0.0676
X208 rr3t3r_0[34|0]/a_60_290# WL34 SL0 VSS sky130_fd_pr__nfet_g5v0d10v5 ad=0.65 pd=3.3 as=0 ps=0 w=1 l=0.5
X209 rr3t3r_0[34|0]/a_860_290# WL34 SL0 VSS sky130_fd_pr__nfet_g5v0d10v5 ad=0.65 pd=3.3 as=0 ps=0 w=1 l=0.5
X210 BLP0 rr3t3r_0[35|0]/a_60_290# sky130_fd_pr_reram__reram_cell area_ox=0.0676
X211 BLZ0 rr3t3r_0[35|0]/a_460_290# sky130_fd_pr_reram__reram_cell area_ox=0.0676
X212 rr3t3r_0[35|0]/a_460_290# WL35 SL0 VSS sky130_fd_pr__nfet_g5v0d10v5 ad=0.65 pd=3.3 as=0 ps=0 w=1 l=0.5
X213 BLN0 rr3t3r_0[35|0]/a_860_290# sky130_fd_pr_reram__reram_cell area_ox=0.0676
X214 rr3t3r_0[35|0]/a_60_290# WL35 SL0 VSS sky130_fd_pr__nfet_g5v0d10v5 ad=0.65 pd=3.3 as=0 ps=0 w=1 l=0.5
X215 rr3t3r_0[35|0]/a_860_290# WL35 SL0 VSS sky130_fd_pr__nfet_g5v0d10v5 ad=0.65 pd=3.3 as=0 ps=0 w=1 l=0.5
X216 BLP0 rr3t3r_0[36|0]/a_60_290# sky130_fd_pr_reram__reram_cell area_ox=0.0676
X217 BLZ0 rr3t3r_0[36|0]/a_460_290# sky130_fd_pr_reram__reram_cell area_ox=0.0676
X218 rr3t3r_0[36|0]/a_460_290# WL36 SL0 VSS sky130_fd_pr__nfet_g5v0d10v5 ad=0.65 pd=3.3 as=0 ps=0 w=1 l=0.5
X219 BLN0 rr3t3r_0[36|0]/a_860_290# sky130_fd_pr_reram__reram_cell area_ox=0.0676
X220 rr3t3r_0[36|0]/a_60_290# WL36 SL0 VSS sky130_fd_pr__nfet_g5v0d10v5 ad=0.65 pd=3.3 as=0 ps=0 w=1 l=0.5
X221 rr3t3r_0[36|0]/a_860_290# WL36 SL0 VSS sky130_fd_pr__nfet_g5v0d10v5 ad=0.65 pd=3.3 as=0 ps=0 w=1 l=0.5
X222 BLP0 rr3t3r_0[37|0]/a_60_290# sky130_fd_pr_reram__reram_cell area_ox=0.0676
X223 BLZ0 rr3t3r_0[37|0]/a_460_290# sky130_fd_pr_reram__reram_cell area_ox=0.0676
X224 rr3t3r_0[37|0]/a_460_290# WL37 SL0 VSS sky130_fd_pr__nfet_g5v0d10v5 ad=0.65 pd=3.3 as=0 ps=0 w=1 l=0.5
X225 BLN0 rr3t3r_0[37|0]/a_860_290# sky130_fd_pr_reram__reram_cell area_ox=0.0676
X226 rr3t3r_0[37|0]/a_60_290# WL37 SL0 VSS sky130_fd_pr__nfet_g5v0d10v5 ad=0.65 pd=3.3 as=0 ps=0 w=1 l=0.5
X227 rr3t3r_0[37|0]/a_860_290# WL37 SL0 VSS sky130_fd_pr__nfet_g5v0d10v5 ad=0.65 pd=3.3 as=0 ps=0 w=1 l=0.5
X228 BLP0 rr3t3r_0[38|0]/a_60_290# sky130_fd_pr_reram__reram_cell area_ox=0.0676
X229 BLZ0 rr3t3r_0[38|0]/a_460_290# sky130_fd_pr_reram__reram_cell area_ox=0.0676
X230 rr3t3r_0[38|0]/a_460_290# WL38 SL0 VSS sky130_fd_pr__nfet_g5v0d10v5 ad=0.65 pd=3.3 as=0 ps=0 w=1 l=0.5
X231 BLN0 rr3t3r_0[38|0]/a_860_290# sky130_fd_pr_reram__reram_cell area_ox=0.0676
X232 rr3t3r_0[38|0]/a_60_290# WL38 SL0 VSS sky130_fd_pr__nfet_g5v0d10v5 ad=0.65 pd=3.3 as=0 ps=0 w=1 l=0.5
X233 rr3t3r_0[38|0]/a_860_290# WL38 SL0 VSS sky130_fd_pr__nfet_g5v0d10v5 ad=0.65 pd=3.3 as=0 ps=0 w=1 l=0.5
X234 BLP0 rr3t3r_0[39|0]/a_60_290# sky130_fd_pr_reram__reram_cell area_ox=0.0676
X235 BLZ0 rr3t3r_0[39|0]/a_460_290# sky130_fd_pr_reram__reram_cell area_ox=0.0676
X236 rr3t3r_0[39|0]/a_460_290# WL39 SL0 VSS sky130_fd_pr__nfet_g5v0d10v5 ad=0.65 pd=3.3 as=0 ps=0 w=1 l=0.5
X237 BLN0 rr3t3r_0[39|0]/a_860_290# sky130_fd_pr_reram__reram_cell area_ox=0.0676
X238 rr3t3r_0[39|0]/a_60_290# WL39 SL0 VSS sky130_fd_pr__nfet_g5v0d10v5 ad=0.65 pd=3.3 as=0 ps=0 w=1 l=0.5
X239 rr3t3r_0[39|0]/a_860_290# WL39 SL0 VSS sky130_fd_pr__nfet_g5v0d10v5 ad=0.65 pd=3.3 as=0 ps=0 w=1 l=0.5
X240 BLP0 rr3t3r_0[40|0]/a_60_290# sky130_fd_pr_reram__reram_cell area_ox=0.0676
X241 BLZ0 rr3t3r_0[40|0]/a_460_290# sky130_fd_pr_reram__reram_cell area_ox=0.0676
X242 rr3t3r_0[40|0]/a_460_290# WL40 SL0 VSS sky130_fd_pr__nfet_g5v0d10v5 ad=0.65 pd=3.3 as=0 ps=0 w=1 l=0.5
X243 BLN0 rr3t3r_0[40|0]/a_860_290# sky130_fd_pr_reram__reram_cell area_ox=0.0676
X244 rr3t3r_0[40|0]/a_60_290# WL40 SL0 VSS sky130_fd_pr__nfet_g5v0d10v5 ad=0.65 pd=3.3 as=0 ps=0 w=1 l=0.5
X245 rr3t3r_0[40|0]/a_860_290# WL40 SL0 VSS sky130_fd_pr__nfet_g5v0d10v5 ad=0.65 pd=3.3 as=0 ps=0 w=1 l=0.5
X246 BLP0 rr3t3r_0[41|0]/a_60_290# sky130_fd_pr_reram__reram_cell area_ox=0.0676
X247 BLZ0 rr3t3r_0[41|0]/a_460_290# sky130_fd_pr_reram__reram_cell area_ox=0.0676
X248 rr3t3r_0[41|0]/a_460_290# WL41 SL0 VSS sky130_fd_pr__nfet_g5v0d10v5 ad=0.65 pd=3.3 as=0 ps=0 w=1 l=0.5
X249 BLN0 rr3t3r_0[41|0]/a_860_290# sky130_fd_pr_reram__reram_cell area_ox=0.0676
X250 rr3t3r_0[41|0]/a_60_290# WL41 SL0 VSS sky130_fd_pr__nfet_g5v0d10v5 ad=0.65 pd=3.3 as=0 ps=0 w=1 l=0.5
X251 rr3t3r_0[41|0]/a_860_290# WL41 SL0 VSS sky130_fd_pr__nfet_g5v0d10v5 ad=0.65 pd=3.3 as=0 ps=0 w=1 l=0.5
X252 BLP0 rr3t3r_0[42|0]/a_60_290# sky130_fd_pr_reram__reram_cell area_ox=0.0676
X253 BLZ0 rr3t3r_0[42|0]/a_460_290# sky130_fd_pr_reram__reram_cell area_ox=0.0676
X254 rr3t3r_0[42|0]/a_460_290# WL42 SL0 VSS sky130_fd_pr__nfet_g5v0d10v5 ad=0.65 pd=3.3 as=0 ps=0 w=1 l=0.5
X255 BLN0 rr3t3r_0[42|0]/a_860_290# sky130_fd_pr_reram__reram_cell area_ox=0.0676
X256 rr3t3r_0[42|0]/a_60_290# WL42 SL0 VSS sky130_fd_pr__nfet_g5v0d10v5 ad=0.65 pd=3.3 as=0 ps=0 w=1 l=0.5
X257 rr3t3r_0[42|0]/a_860_290# WL42 SL0 VSS sky130_fd_pr__nfet_g5v0d10v5 ad=0.65 pd=3.3 as=0 ps=0 w=1 l=0.5
X258 BLP0 rr3t3r_0[43|0]/a_60_290# sky130_fd_pr_reram__reram_cell area_ox=0.0676
X259 BLZ0 rr3t3r_0[43|0]/a_460_290# sky130_fd_pr_reram__reram_cell area_ox=0.0676
X260 rr3t3r_0[43|0]/a_460_290# WL43 SL0 VSS sky130_fd_pr__nfet_g5v0d10v5 ad=0.65 pd=3.3 as=0 ps=0 w=1 l=0.5
X261 BLN0 rr3t3r_0[43|0]/a_860_290# sky130_fd_pr_reram__reram_cell area_ox=0.0676
X262 rr3t3r_0[43|0]/a_60_290# WL43 SL0 VSS sky130_fd_pr__nfet_g5v0d10v5 ad=0.65 pd=3.3 as=0 ps=0 w=1 l=0.5
X263 rr3t3r_0[43|0]/a_860_290# WL43 SL0 VSS sky130_fd_pr__nfet_g5v0d10v5 ad=0.65 pd=3.3 as=0 ps=0 w=1 l=0.5
X264 BLP0 rr3t3r_0[44|0]/a_60_290# sky130_fd_pr_reram__reram_cell area_ox=0.0676
X265 BLZ0 rr3t3r_0[44|0]/a_460_290# sky130_fd_pr_reram__reram_cell area_ox=0.0676
X266 rr3t3r_0[44|0]/a_460_290# WL44 SL0 VSS sky130_fd_pr__nfet_g5v0d10v5 ad=0.65 pd=3.3 as=0 ps=0 w=1 l=0.5
X267 BLN0 rr3t3r_0[44|0]/a_860_290# sky130_fd_pr_reram__reram_cell area_ox=0.0676
X268 rr3t3r_0[44|0]/a_60_290# WL44 SL0 VSS sky130_fd_pr__nfet_g5v0d10v5 ad=0.65 pd=3.3 as=0 ps=0 w=1 l=0.5
X269 rr3t3r_0[44|0]/a_860_290# WL44 SL0 VSS sky130_fd_pr__nfet_g5v0d10v5 ad=0.65 pd=3.3 as=0 ps=0 w=1 l=0.5
X270 BLP0 rr3t3r_0[45|0]/a_60_290# sky130_fd_pr_reram__reram_cell area_ox=0.0676
X271 BLZ0 rr3t3r_0[45|0]/a_460_290# sky130_fd_pr_reram__reram_cell area_ox=0.0676
X272 rr3t3r_0[45|0]/a_460_290# WL45 SL0 VSS sky130_fd_pr__nfet_g5v0d10v5 ad=0.65 pd=3.3 as=0 ps=0 w=1 l=0.5
X273 BLN0 rr3t3r_0[45|0]/a_860_290# sky130_fd_pr_reram__reram_cell area_ox=0.0676
X274 rr3t3r_0[45|0]/a_60_290# WL45 SL0 VSS sky130_fd_pr__nfet_g5v0d10v5 ad=0.65 pd=3.3 as=0 ps=0 w=1 l=0.5
X275 rr3t3r_0[45|0]/a_860_290# WL45 SL0 VSS sky130_fd_pr__nfet_g5v0d10v5 ad=0.65 pd=3.3 as=0 ps=0 w=1 l=0.5
X276 BLP0 rr3t3r_0[46|0]/a_60_290# sky130_fd_pr_reram__reram_cell area_ox=0.0676
X277 BLZ0 rr3t3r_0[46|0]/a_460_290# sky130_fd_pr_reram__reram_cell area_ox=0.0676
X278 rr3t3r_0[46|0]/a_460_290# WL46 SL0 VSS sky130_fd_pr__nfet_g5v0d10v5 ad=0.65 pd=3.3 as=0 ps=0 w=1 l=0.5
X279 BLN0 rr3t3r_0[46|0]/a_860_290# sky130_fd_pr_reram__reram_cell area_ox=0.0676
X280 rr3t3r_0[46|0]/a_60_290# WL46 SL0 VSS sky130_fd_pr__nfet_g5v0d10v5 ad=0.65 pd=3.3 as=0 ps=0 w=1 l=0.5
X281 rr3t3r_0[46|0]/a_860_290# WL46 SL0 VSS sky130_fd_pr__nfet_g5v0d10v5 ad=0.65 pd=3.3 as=0 ps=0 w=1 l=0.5
X282 BLP0 rr3t3r_0[47|0]/a_60_290# sky130_fd_pr_reram__reram_cell area_ox=0.0676
X283 BLZ0 rr3t3r_0[47|0]/a_460_290# sky130_fd_pr_reram__reram_cell area_ox=0.0676
X284 rr3t3r_0[47|0]/a_460_290# WL47 SL0 VSS sky130_fd_pr__nfet_g5v0d10v5 ad=0.65 pd=3.3 as=0 ps=0 w=1 l=0.5
X285 BLN0 rr3t3r_0[47|0]/a_860_290# sky130_fd_pr_reram__reram_cell area_ox=0.0676
X286 rr3t3r_0[47|0]/a_60_290# WL47 SL0 VSS sky130_fd_pr__nfet_g5v0d10v5 ad=0.65 pd=3.3 as=0 ps=0 w=1 l=0.5
X287 rr3t3r_0[47|0]/a_860_290# WL47 SL0 VSS sky130_fd_pr__nfet_g5v0d10v5 ad=0.65 pd=3.3 as=0 ps=0 w=1 l=0.5
X288 BLP0 rr3t3r_0[48|0]/a_60_290# sky130_fd_pr_reram__reram_cell area_ox=0.0676
X289 BLZ0 rr3t3r_0[48|0]/a_460_290# sky130_fd_pr_reram__reram_cell area_ox=0.0676
X290 rr3t3r_0[48|0]/a_460_290# WL48 SL0 VSS sky130_fd_pr__nfet_g5v0d10v5 ad=0.65 pd=3.3 as=0 ps=0 w=1 l=0.5
X291 BLN0 rr3t3r_0[48|0]/a_860_290# sky130_fd_pr_reram__reram_cell area_ox=0.0676
X292 rr3t3r_0[48|0]/a_60_290# WL48 SL0 VSS sky130_fd_pr__nfet_g5v0d10v5 ad=0.65 pd=3.3 as=0 ps=0 w=1 l=0.5
X293 rr3t3r_0[48|0]/a_860_290# WL48 SL0 VSS sky130_fd_pr__nfet_g5v0d10v5 ad=0.65 pd=3.3 as=0 ps=0 w=1 l=0.5
X294 BLP0 rr3t3r_0[49|0]/a_60_290# sky130_fd_pr_reram__reram_cell area_ox=0.0676
X295 BLZ0 rr3t3r_0[49|0]/a_460_290# sky130_fd_pr_reram__reram_cell area_ox=0.0676
X296 rr3t3r_0[49|0]/a_460_290# WL49 SL0 VSS sky130_fd_pr__nfet_g5v0d10v5 ad=0.65 pd=3.3 as=0 ps=0 w=1 l=0.5
X297 BLN0 rr3t3r_0[49|0]/a_860_290# sky130_fd_pr_reram__reram_cell area_ox=0.0676
X298 rr3t3r_0[49|0]/a_60_290# WL49 SL0 VSS sky130_fd_pr__nfet_g5v0d10v5 ad=0.65 pd=3.3 as=0 ps=0 w=1 l=0.5
X299 rr3t3r_0[49|0]/a_860_290# WL49 SL0 VSS sky130_fd_pr__nfet_g5v0d10v5 ad=0.65 pd=3.3 as=0 ps=0 w=1 l=0.5
X300 BLP0 rr3t3r_0[50|0]/a_60_290# sky130_fd_pr_reram__reram_cell area_ox=0.0676
X301 BLZ0 rr3t3r_0[50|0]/a_460_290# sky130_fd_pr_reram__reram_cell area_ox=0.0676
X302 rr3t3r_0[50|0]/a_460_290# WL50 SL0 VSS sky130_fd_pr__nfet_g5v0d10v5 ad=0.65 pd=3.3 as=0 ps=0 w=1 l=0.5
X303 BLN0 rr3t3r_0[50|0]/a_860_290# sky130_fd_pr_reram__reram_cell area_ox=0.0676
X304 rr3t3r_0[50|0]/a_60_290# WL50 SL0 VSS sky130_fd_pr__nfet_g5v0d10v5 ad=0.65 pd=3.3 as=0 ps=0 w=1 l=0.5
X305 rr3t3r_0[50|0]/a_860_290# WL50 SL0 VSS sky130_fd_pr__nfet_g5v0d10v5 ad=0.65 pd=3.3 as=0 ps=0 w=1 l=0.5
X306 BLP0 rr3t3r_0[51|0]/a_60_290# sky130_fd_pr_reram__reram_cell area_ox=0.0676
X307 BLZ0 rr3t3r_0[51|0]/a_460_290# sky130_fd_pr_reram__reram_cell area_ox=0.0676
X308 rr3t3r_0[51|0]/a_460_290# WL51 SL0 VSS sky130_fd_pr__nfet_g5v0d10v5 ad=0.65 pd=3.3 as=0 ps=0 w=1 l=0.5
X309 BLN0 rr3t3r_0[51|0]/a_860_290# sky130_fd_pr_reram__reram_cell area_ox=0.0676
X310 rr3t3r_0[51|0]/a_60_290# WL51 SL0 VSS sky130_fd_pr__nfet_g5v0d10v5 ad=0.65 pd=3.3 as=0 ps=0 w=1 l=0.5
X311 rr3t3r_0[51|0]/a_860_290# WL51 SL0 VSS sky130_fd_pr__nfet_g5v0d10v5 ad=0.65 pd=3.3 as=0 ps=0 w=1 l=0.5
X312 BLP0 rr3t3r_0[52|0]/a_60_290# sky130_fd_pr_reram__reram_cell area_ox=0.0676
X313 BLZ0 rr3t3r_0[52|0]/a_460_290# sky130_fd_pr_reram__reram_cell area_ox=0.0676
X314 rr3t3r_0[52|0]/a_460_290# WL52 SL0 VSS sky130_fd_pr__nfet_g5v0d10v5 ad=0.65 pd=3.3 as=0 ps=0 w=1 l=0.5
X315 BLN0 rr3t3r_0[52|0]/a_860_290# sky130_fd_pr_reram__reram_cell area_ox=0.0676
X316 rr3t3r_0[52|0]/a_60_290# WL52 SL0 VSS sky130_fd_pr__nfet_g5v0d10v5 ad=0.65 pd=3.3 as=0 ps=0 w=1 l=0.5
X317 rr3t3r_0[52|0]/a_860_290# WL52 SL0 VSS sky130_fd_pr__nfet_g5v0d10v5 ad=0.65 pd=3.3 as=0 ps=0 w=1 l=0.5
X318 BLP0 rr3t3r_0[53|0]/a_60_290# sky130_fd_pr_reram__reram_cell area_ox=0.0676
X319 BLZ0 rr3t3r_0[53|0]/a_460_290# sky130_fd_pr_reram__reram_cell area_ox=0.0676
X320 rr3t3r_0[53|0]/a_460_290# WL53 SL0 VSS sky130_fd_pr__nfet_g5v0d10v5 ad=0.65 pd=3.3 as=0 ps=0 w=1 l=0.5
X321 BLN0 rr3t3r_0[53|0]/a_860_290# sky130_fd_pr_reram__reram_cell area_ox=0.0676
X322 rr3t3r_0[53|0]/a_60_290# WL53 SL0 VSS sky130_fd_pr__nfet_g5v0d10v5 ad=0.65 pd=3.3 as=0 ps=0 w=1 l=0.5
X323 rr3t3r_0[53|0]/a_860_290# WL53 SL0 VSS sky130_fd_pr__nfet_g5v0d10v5 ad=0.65 pd=3.3 as=0 ps=0 w=1 l=0.5
X324 BLP0 rr3t3r_0[54|0]/a_60_290# sky130_fd_pr_reram__reram_cell area_ox=0.0676
X325 BLZ0 rr3t3r_0[54|0]/a_460_290# sky130_fd_pr_reram__reram_cell area_ox=0.0676
X326 rr3t3r_0[54|0]/a_460_290# WL54 SL0 VSS sky130_fd_pr__nfet_g5v0d10v5 ad=0.65 pd=3.3 as=0 ps=0 w=1 l=0.5
X327 BLN0 rr3t3r_0[54|0]/a_860_290# sky130_fd_pr_reram__reram_cell area_ox=0.0676
X328 rr3t3r_0[54|0]/a_60_290# WL54 SL0 VSS sky130_fd_pr__nfet_g5v0d10v5 ad=0.65 pd=3.3 as=0 ps=0 w=1 l=0.5
X329 rr3t3r_0[54|0]/a_860_290# WL54 SL0 VSS sky130_fd_pr__nfet_g5v0d10v5 ad=0.65 pd=3.3 as=0 ps=0 w=1 l=0.5
X330 BLP0 rr3t3r_0[55|0]/a_60_290# sky130_fd_pr_reram__reram_cell area_ox=0.0676
X331 BLZ0 rr3t3r_0[55|0]/a_460_290# sky130_fd_pr_reram__reram_cell area_ox=0.0676
X332 rr3t3r_0[55|0]/a_460_290# WL55 SL0 VSS sky130_fd_pr__nfet_g5v0d10v5 ad=0.65 pd=3.3 as=0 ps=0 w=1 l=0.5
X333 BLN0 rr3t3r_0[55|0]/a_860_290# sky130_fd_pr_reram__reram_cell area_ox=0.0676
X334 rr3t3r_0[55|0]/a_60_290# WL55 SL0 VSS sky130_fd_pr__nfet_g5v0d10v5 ad=0.65 pd=3.3 as=0 ps=0 w=1 l=0.5
X335 rr3t3r_0[55|0]/a_860_290# WL55 SL0 VSS sky130_fd_pr__nfet_g5v0d10v5 ad=0.65 pd=3.3 as=0 ps=0 w=1 l=0.5
X336 BLP0 rr3t3r_0[56|0]/a_60_290# sky130_fd_pr_reram__reram_cell area_ox=0.0676
X337 BLZ0 rr3t3r_0[56|0]/a_460_290# sky130_fd_pr_reram__reram_cell area_ox=0.0676
X338 rr3t3r_0[56|0]/a_460_290# WL56 SL0 VSS sky130_fd_pr__nfet_g5v0d10v5 ad=0.65 pd=3.3 as=0 ps=0 w=1 l=0.5
X339 BLN0 rr3t3r_0[56|0]/a_860_290# sky130_fd_pr_reram__reram_cell area_ox=0.0676
X340 rr3t3r_0[56|0]/a_60_290# WL56 SL0 VSS sky130_fd_pr__nfet_g5v0d10v5 ad=0.65 pd=3.3 as=0 ps=0 w=1 l=0.5
X341 rr3t3r_0[56|0]/a_860_290# WL56 SL0 VSS sky130_fd_pr__nfet_g5v0d10v5 ad=0.65 pd=3.3 as=0 ps=0 w=1 l=0.5
X342 BLP0 rr3t3r_0[57|0]/a_60_290# sky130_fd_pr_reram__reram_cell area_ox=0.0676
X343 BLZ0 rr3t3r_0[57|0]/a_460_290# sky130_fd_pr_reram__reram_cell area_ox=0.0676
X344 rr3t3r_0[57|0]/a_460_290# WL57 SL0 VSS sky130_fd_pr__nfet_g5v0d10v5 ad=0.65 pd=3.3 as=0 ps=0 w=1 l=0.5
X345 BLN0 rr3t3r_0[57|0]/a_860_290# sky130_fd_pr_reram__reram_cell area_ox=0.0676
X346 rr3t3r_0[57|0]/a_60_290# WL57 SL0 VSS sky130_fd_pr__nfet_g5v0d10v5 ad=0.65 pd=3.3 as=0 ps=0 w=1 l=0.5
X347 rr3t3r_0[57|0]/a_860_290# WL57 SL0 VSS sky130_fd_pr__nfet_g5v0d10v5 ad=0.65 pd=3.3 as=0 ps=0 w=1 l=0.5
X348 BLP0 rr3t3r_0[58|0]/a_60_290# sky130_fd_pr_reram__reram_cell area_ox=0.0676
X349 BLZ0 rr3t3r_0[58|0]/a_460_290# sky130_fd_pr_reram__reram_cell area_ox=0.0676
X350 rr3t3r_0[58|0]/a_460_290# WL58 SL0 VSS sky130_fd_pr__nfet_g5v0d10v5 ad=0.65 pd=3.3 as=0 ps=0 w=1 l=0.5
X351 BLN0 rr3t3r_0[58|0]/a_860_290# sky130_fd_pr_reram__reram_cell area_ox=0.0676
X352 rr3t3r_0[58|0]/a_60_290# WL58 SL0 VSS sky130_fd_pr__nfet_g5v0d10v5 ad=0.65 pd=3.3 as=0 ps=0 w=1 l=0.5
X353 rr3t3r_0[58|0]/a_860_290# WL58 SL0 VSS sky130_fd_pr__nfet_g5v0d10v5 ad=0.65 pd=3.3 as=0 ps=0 w=1 l=0.5
X354 BLP0 rr3t3r_0[59|0]/a_60_290# sky130_fd_pr_reram__reram_cell area_ox=0.0676
X355 BLZ0 rr3t3r_0[59|0]/a_460_290# sky130_fd_pr_reram__reram_cell area_ox=0.0676
X356 rr3t3r_0[59|0]/a_460_290# WL59 SL0 VSS sky130_fd_pr__nfet_g5v0d10v5 ad=0.65 pd=3.3 as=0 ps=0 w=1 l=0.5
X357 BLN0 rr3t3r_0[59|0]/a_860_290# sky130_fd_pr_reram__reram_cell area_ox=0.0676
X358 rr3t3r_0[59|0]/a_60_290# WL59 SL0 VSS sky130_fd_pr__nfet_g5v0d10v5 ad=0.65 pd=3.3 as=0 ps=0 w=1 l=0.5
X359 rr3t3r_0[59|0]/a_860_290# WL59 SL0 VSS sky130_fd_pr__nfet_g5v0d10v5 ad=0.65 pd=3.3 as=0 ps=0 w=1 l=0.5
X360 BLP0 rr3t3r_0[60|0]/a_60_290# sky130_fd_pr_reram__reram_cell area_ox=0.0676
X361 BLZ0 rr3t3r_0[60|0]/a_460_290# sky130_fd_pr_reram__reram_cell area_ox=0.0676
X362 rr3t3r_0[60|0]/a_460_290# WL60 SL0 VSS sky130_fd_pr__nfet_g5v0d10v5 ad=0.65 pd=3.3 as=0 ps=0 w=1 l=0.5
X363 BLN0 rr3t3r_0[60|0]/a_860_290# sky130_fd_pr_reram__reram_cell area_ox=0.0676
X364 rr3t3r_0[60|0]/a_60_290# WL60 SL0 VSS sky130_fd_pr__nfet_g5v0d10v5 ad=0.65 pd=3.3 as=0 ps=0 w=1 l=0.5
X365 rr3t3r_0[60|0]/a_860_290# WL60 SL0 VSS sky130_fd_pr__nfet_g5v0d10v5 ad=0.65 pd=3.3 as=0 ps=0 w=1 l=0.5
X366 BLP0 rr3t3r_0[61|0]/a_60_290# sky130_fd_pr_reram__reram_cell area_ox=0.0676
X367 BLZ0 rr3t3r_0[61|0]/a_460_290# sky130_fd_pr_reram__reram_cell area_ox=0.0676
X368 rr3t3r_0[61|0]/a_460_290# WL61 SL0 VSS sky130_fd_pr__nfet_g5v0d10v5 ad=0.65 pd=3.3 as=0 ps=0 w=1 l=0.5
X369 BLN0 rr3t3r_0[61|0]/a_860_290# sky130_fd_pr_reram__reram_cell area_ox=0.0676
X370 rr3t3r_0[61|0]/a_60_290# WL61 SL0 VSS sky130_fd_pr__nfet_g5v0d10v5 ad=0.65 pd=3.3 as=0 ps=0 w=1 l=0.5
X371 rr3t3r_0[61|0]/a_860_290# WL61 SL0 VSS sky130_fd_pr__nfet_g5v0d10v5 ad=0.65 pd=3.3 as=0 ps=0 w=1 l=0.5
X372 BLP0 rr3t3r_0[62|0]/a_60_290# sky130_fd_pr_reram__reram_cell area_ox=0.0676
X373 BLZ0 rr3t3r_0[62|0]/a_460_290# sky130_fd_pr_reram__reram_cell area_ox=0.0676
X374 rr3t3r_0[62|0]/a_460_290# WL62 SL0 VSS sky130_fd_pr__nfet_g5v0d10v5 ad=0.65 pd=3.3 as=0 ps=0 w=1 l=0.5
X375 BLN0 rr3t3r_0[62|0]/a_860_290# sky130_fd_pr_reram__reram_cell area_ox=0.0676
X376 rr3t3r_0[62|0]/a_60_290# WL62 SL0 VSS sky130_fd_pr__nfet_g5v0d10v5 ad=0.65 pd=3.3 as=0 ps=0 w=1 l=0.5
X377 rr3t3r_0[62|0]/a_860_290# WL62 SL0 VSS sky130_fd_pr__nfet_g5v0d10v5 ad=0.65 pd=3.3 as=0 ps=0 w=1 l=0.5
X378 BLP0 rr3t3r_0[63|0]/a_60_290# sky130_fd_pr_reram__reram_cell area_ox=0.0676
X379 BLZ0 rr3t3r_0[63|0]/a_460_290# sky130_fd_pr_reram__reram_cell area_ox=0.0676
X380 rr3t3r_0[63|0]/a_460_290# WL63 SL0 VSS sky130_fd_pr__nfet_g5v0d10v5 ad=0.65 pd=3.3 as=0 ps=0 w=1 l=0.5
X381 BLN0 rr3t3r_0[63|0]/a_860_290# sky130_fd_pr_reram__reram_cell area_ox=0.0676
X382 rr3t3r_0[63|0]/a_60_290# WL63 SL0 VSS sky130_fd_pr__nfet_g5v0d10v5 ad=0.65 pd=3.3 as=0 ps=0 w=1 l=0.5
X383 rr3t3r_0[63|0]/a_860_290# WL63 SL0 VSS sky130_fd_pr__nfet_g5v0d10v5 ad=0.65 pd=3.3 as=0 ps=0 w=1 l=0.5
X384 BLP0 rr3t3r_0[64|0]/a_60_290# sky130_fd_pr_reram__reram_cell area_ox=0.0676
X385 BLZ0 rr3t3r_0[64|0]/a_460_290# sky130_fd_pr_reram__reram_cell area_ox=0.0676
X386 rr3t3r_0[64|0]/a_460_290# WL64 SL0 VSS sky130_fd_pr__nfet_g5v0d10v5 ad=0.65 pd=3.3 as=0 ps=0 w=1 l=0.5
X387 BLN0 rr3t3r_0[64|0]/a_860_290# sky130_fd_pr_reram__reram_cell area_ox=0.0676
X388 rr3t3r_0[64|0]/a_60_290# WL64 SL0 VSS sky130_fd_pr__nfet_g5v0d10v5 ad=0.65 pd=3.3 as=0 ps=0 w=1 l=0.5
X389 rr3t3r_0[64|0]/a_860_290# WL64 SL0 VSS sky130_fd_pr__nfet_g5v0d10v5 ad=0.65 pd=3.3 as=0 ps=0 w=1 l=0.5
X390 BLP0 rr3t3r_0[65|0]/a_60_290# sky130_fd_pr_reram__reram_cell area_ox=0.0676
X391 BLZ0 rr3t3r_0[65|0]/a_460_290# sky130_fd_pr_reram__reram_cell area_ox=0.0676
X392 rr3t3r_0[65|0]/a_460_290# WL65 SL0 VSS sky130_fd_pr__nfet_g5v0d10v5 ad=0.65 pd=3.3 as=0 ps=0 w=1 l=0.5
X393 BLN0 rr3t3r_0[65|0]/a_860_290# sky130_fd_pr_reram__reram_cell area_ox=0.0676
X394 rr3t3r_0[65|0]/a_60_290# WL65 SL0 VSS sky130_fd_pr__nfet_g5v0d10v5 ad=0.65 pd=3.3 as=0 ps=0 w=1 l=0.5
X395 rr3t3r_0[65|0]/a_860_290# WL65 SL0 VSS sky130_fd_pr__nfet_g5v0d10v5 ad=0.65 pd=3.3 as=0 ps=0 w=1 l=0.5
X396 BLP0 rr3t3r_0[66|0]/a_60_290# sky130_fd_pr_reram__reram_cell area_ox=0.0676
X397 BLZ0 rr3t3r_0[66|0]/a_460_290# sky130_fd_pr_reram__reram_cell area_ox=0.0676
X398 rr3t3r_0[66|0]/a_460_290# WL66 SL0 VSS sky130_fd_pr__nfet_g5v0d10v5 ad=0.65 pd=3.3 as=0 ps=0 w=1 l=0.5
X399 BLN0 rr3t3r_0[66|0]/a_860_290# sky130_fd_pr_reram__reram_cell area_ox=0.0676
X400 rr3t3r_0[66|0]/a_60_290# WL66 SL0 VSS sky130_fd_pr__nfet_g5v0d10v5 ad=0.65 pd=3.3 as=0 ps=0 w=1 l=0.5
X401 rr3t3r_0[66|0]/a_860_290# WL66 SL0 VSS sky130_fd_pr__nfet_g5v0d10v5 ad=0.65 pd=3.3 as=0 ps=0 w=1 l=0.5
X402 BLP0 rr3t3r_0[67|0]/a_60_290# sky130_fd_pr_reram__reram_cell area_ox=0.0676
X403 BLZ0 rr3t3r_0[67|0]/a_460_290# sky130_fd_pr_reram__reram_cell area_ox=0.0676
X404 rr3t3r_0[67|0]/a_460_290# WL67 SL0 VSS sky130_fd_pr__nfet_g5v0d10v5 ad=0.65 pd=3.3 as=0 ps=0 w=1 l=0.5
X405 BLN0 rr3t3r_0[67|0]/a_860_290# sky130_fd_pr_reram__reram_cell area_ox=0.0676
X406 rr3t3r_0[67|0]/a_60_290# WL67 SL0 VSS sky130_fd_pr__nfet_g5v0d10v5 ad=0.65 pd=3.3 as=0 ps=0 w=1 l=0.5
X407 rr3t3r_0[67|0]/a_860_290# WL67 SL0 VSS sky130_fd_pr__nfet_g5v0d10v5 ad=0.65 pd=3.3 as=0 ps=0 w=1 l=0.5
X408 BLP0 rr3t3r_0[68|0]/a_60_290# sky130_fd_pr_reram__reram_cell area_ox=0.0676
X409 BLZ0 rr3t3r_0[68|0]/a_460_290# sky130_fd_pr_reram__reram_cell area_ox=0.0676
X410 rr3t3r_0[68|0]/a_460_290# WL68 SL0 VSS sky130_fd_pr__nfet_g5v0d10v5 ad=0.65 pd=3.3 as=0 ps=0 w=1 l=0.5
X411 BLN0 rr3t3r_0[68|0]/a_860_290# sky130_fd_pr_reram__reram_cell area_ox=0.0676
X412 rr3t3r_0[68|0]/a_60_290# WL68 SL0 VSS sky130_fd_pr__nfet_g5v0d10v5 ad=0.65 pd=3.3 as=0 ps=0 w=1 l=0.5
X413 rr3t3r_0[68|0]/a_860_290# WL68 SL0 VSS sky130_fd_pr__nfet_g5v0d10v5 ad=0.65 pd=3.3 as=0 ps=0 w=1 l=0.5
X414 BLP0 rr3t3r_0[69|0]/a_60_290# sky130_fd_pr_reram__reram_cell area_ox=0.0676
X415 BLZ0 rr3t3r_0[69|0]/a_460_290# sky130_fd_pr_reram__reram_cell area_ox=0.0676
X416 rr3t3r_0[69|0]/a_460_290# WL69 SL0 VSS sky130_fd_pr__nfet_g5v0d10v5 ad=0.65 pd=3.3 as=0 ps=0 w=1 l=0.5
X417 BLN0 rr3t3r_0[69|0]/a_860_290# sky130_fd_pr_reram__reram_cell area_ox=0.0676
X418 rr3t3r_0[69|0]/a_60_290# WL69 SL0 VSS sky130_fd_pr__nfet_g5v0d10v5 ad=0.65 pd=3.3 as=0 ps=0 w=1 l=0.5
X419 rr3t3r_0[69|0]/a_860_290# WL69 SL0 VSS sky130_fd_pr__nfet_g5v0d10v5 ad=0.65 pd=3.3 as=0 ps=0 w=1 l=0.5
X420 BLP0 rr3t3r_0[70|0]/a_60_290# sky130_fd_pr_reram__reram_cell area_ox=0.0676
X421 BLZ0 rr3t3r_0[70|0]/a_460_290# sky130_fd_pr_reram__reram_cell area_ox=0.0676
X422 rr3t3r_0[70|0]/a_460_290# WL70 SL0 VSS sky130_fd_pr__nfet_g5v0d10v5 ad=0.65 pd=3.3 as=0 ps=0 w=1 l=0.5
X423 BLN0 rr3t3r_0[70|0]/a_860_290# sky130_fd_pr_reram__reram_cell area_ox=0.0676
X424 rr3t3r_0[70|0]/a_60_290# WL70 SL0 VSS sky130_fd_pr__nfet_g5v0d10v5 ad=0.65 pd=3.3 as=0 ps=0 w=1 l=0.5
X425 rr3t3r_0[70|0]/a_860_290# WL70 SL0 VSS sky130_fd_pr__nfet_g5v0d10v5 ad=0.65 pd=3.3 as=0 ps=0 w=1 l=0.5
X426 BLP0 rr3t3r_0[71|0]/a_60_290# sky130_fd_pr_reram__reram_cell area_ox=0.0676
X427 BLZ0 rr3t3r_0[71|0]/a_460_290# sky130_fd_pr_reram__reram_cell area_ox=0.0676
X428 rr3t3r_0[71|0]/a_460_290# WL71 SL0 VSS sky130_fd_pr__nfet_g5v0d10v5 ad=0.65 pd=3.3 as=0 ps=0 w=1 l=0.5
X429 BLN0 rr3t3r_0[71|0]/a_860_290# sky130_fd_pr_reram__reram_cell area_ox=0.0676
X430 rr3t3r_0[71|0]/a_60_290# WL71 SL0 VSS sky130_fd_pr__nfet_g5v0d10v5 ad=0.65 pd=3.3 as=0 ps=0 w=1 l=0.5
X431 rr3t3r_0[71|0]/a_860_290# WL71 SL0 VSS sky130_fd_pr__nfet_g5v0d10v5 ad=0.65 pd=3.3 as=0 ps=0 w=1 l=0.5
X432 BLP1 rr3t3r_0[0|1]/a_60_290# sky130_fd_pr_reram__reram_cell area_ox=0.0676
X433 BLZ1 rr3t3r_0[0|1]/a_460_290# sky130_fd_pr_reram__reram_cell area_ox=0.0676
X434 rr3t3r_0[0|1]/a_460_290# WL0 SL1 VSS sky130_fd_pr__nfet_g5v0d10v5 ad=0.65 pd=3.3 as=162 ps=756 w=1 l=0.5
X435 BLN1 rr3t3r_0[0|1]/a_860_290# sky130_fd_pr_reram__reram_cell area_ox=0.0676
X436 rr3t3r_0[0|1]/a_60_290# WL0 SL1 VSS sky130_fd_pr__nfet_g5v0d10v5 ad=0.65 pd=3.3 as=0 ps=0 w=1 l=0.5
X437 rr3t3r_0[0|1]/a_860_290# WL0 SL1 VSS sky130_fd_pr__nfet_g5v0d10v5 ad=0.65 pd=3.3 as=0 ps=0 w=1 l=0.5
X438 BLP1 rr3t3r_0[1|1]/a_60_290# sky130_fd_pr_reram__reram_cell area_ox=0.0676
X439 BLZ1 rr3t3r_0[1|1]/a_460_290# sky130_fd_pr_reram__reram_cell area_ox=0.0676
X440 rr3t3r_0[1|1]/a_460_290# WL1 SL1 VSS sky130_fd_pr__nfet_g5v0d10v5 ad=0.65 pd=3.3 as=0 ps=0 w=1 l=0.5
X441 BLN1 rr3t3r_0[1|1]/a_860_290# sky130_fd_pr_reram__reram_cell area_ox=0.0676
X442 rr3t3r_0[1|1]/a_60_290# WL1 SL1 VSS sky130_fd_pr__nfet_g5v0d10v5 ad=0.65 pd=3.3 as=0 ps=0 w=1 l=0.5
X443 rr3t3r_0[1|1]/a_860_290# WL1 SL1 VSS sky130_fd_pr__nfet_g5v0d10v5 ad=0.65 pd=3.3 as=0 ps=0 w=1 l=0.5
X444 BLP1 rr3t3r_0[2|1]/a_60_290# sky130_fd_pr_reram__reram_cell area_ox=0.0676
X445 BLZ1 rr3t3r_0[2|1]/a_460_290# sky130_fd_pr_reram__reram_cell area_ox=0.0676
X446 rr3t3r_0[2|1]/a_460_290# WL2 SL1 VSS sky130_fd_pr__nfet_g5v0d10v5 ad=0.65 pd=3.3 as=0 ps=0 w=1 l=0.5
X447 BLN1 rr3t3r_0[2|1]/a_860_290# sky130_fd_pr_reram__reram_cell area_ox=0.0676
X448 rr3t3r_0[2|1]/a_60_290# WL2 SL1 VSS sky130_fd_pr__nfet_g5v0d10v5 ad=0.65 pd=3.3 as=0 ps=0 w=1 l=0.5
X449 rr3t3r_0[2|1]/a_860_290# WL2 SL1 VSS sky130_fd_pr__nfet_g5v0d10v5 ad=0.65 pd=3.3 as=0 ps=0 w=1 l=0.5
X450 BLP1 rr3t3r_0[3|1]/a_60_290# sky130_fd_pr_reram__reram_cell area_ox=0.0676
X451 BLZ1 rr3t3r_0[3|1]/a_460_290# sky130_fd_pr_reram__reram_cell area_ox=0.0676
X452 rr3t3r_0[3|1]/a_460_290# WL3 SL1 VSS sky130_fd_pr__nfet_g5v0d10v5 ad=0.65 pd=3.3 as=0 ps=0 w=1 l=0.5
X453 BLN1 rr3t3r_0[3|1]/a_860_290# sky130_fd_pr_reram__reram_cell area_ox=0.0676
X454 rr3t3r_0[3|1]/a_60_290# WL3 SL1 VSS sky130_fd_pr__nfet_g5v0d10v5 ad=0.65 pd=3.3 as=0 ps=0 w=1 l=0.5
X455 rr3t3r_0[3|1]/a_860_290# WL3 SL1 VSS sky130_fd_pr__nfet_g5v0d10v5 ad=0.65 pd=3.3 as=0 ps=0 w=1 l=0.5
X456 BLP1 rr3t3r_0[4|1]/a_60_290# sky130_fd_pr_reram__reram_cell area_ox=0.0676
X457 BLZ1 rr3t3r_0[4|1]/a_460_290# sky130_fd_pr_reram__reram_cell area_ox=0.0676
X458 rr3t3r_0[4|1]/a_460_290# WL4 SL1 VSS sky130_fd_pr__nfet_g5v0d10v5 ad=0.65 pd=3.3 as=0 ps=0 w=1 l=0.5
X459 BLN1 rr3t3r_0[4|1]/a_860_290# sky130_fd_pr_reram__reram_cell area_ox=0.0676
X460 rr3t3r_0[4|1]/a_60_290# WL4 SL1 VSS sky130_fd_pr__nfet_g5v0d10v5 ad=0.65 pd=3.3 as=0 ps=0 w=1 l=0.5
X461 rr3t3r_0[4|1]/a_860_290# WL4 SL1 VSS sky130_fd_pr__nfet_g5v0d10v5 ad=0.65 pd=3.3 as=0 ps=0 w=1 l=0.5
X462 BLP1 rr3t3r_0[5|1]/a_60_290# sky130_fd_pr_reram__reram_cell area_ox=0.0676
X463 BLZ1 rr3t3r_0[5|1]/a_460_290# sky130_fd_pr_reram__reram_cell area_ox=0.0676
X464 rr3t3r_0[5|1]/a_460_290# WL5 SL1 VSS sky130_fd_pr__nfet_g5v0d10v5 ad=0.65 pd=3.3 as=0 ps=0 w=1 l=0.5
X465 BLN1 rr3t3r_0[5|1]/a_860_290# sky130_fd_pr_reram__reram_cell area_ox=0.0676
X466 rr3t3r_0[5|1]/a_60_290# WL5 SL1 VSS sky130_fd_pr__nfet_g5v0d10v5 ad=0.65 pd=3.3 as=0 ps=0 w=1 l=0.5
X467 rr3t3r_0[5|1]/a_860_290# WL5 SL1 VSS sky130_fd_pr__nfet_g5v0d10v5 ad=0.65 pd=3.3 as=0 ps=0 w=1 l=0.5
X468 BLP1 rr3t3r_0[6|1]/a_60_290# sky130_fd_pr_reram__reram_cell area_ox=0.0676
X469 BLZ1 rr3t3r_0[6|1]/a_460_290# sky130_fd_pr_reram__reram_cell area_ox=0.0676
X470 rr3t3r_0[6|1]/a_460_290# WL6 SL1 VSS sky130_fd_pr__nfet_g5v0d10v5 ad=0.65 pd=3.3 as=0 ps=0 w=1 l=0.5
X471 BLN1 rr3t3r_0[6|1]/a_860_290# sky130_fd_pr_reram__reram_cell area_ox=0.0676
X472 rr3t3r_0[6|1]/a_60_290# WL6 SL1 VSS sky130_fd_pr__nfet_g5v0d10v5 ad=0.65 pd=3.3 as=0 ps=0 w=1 l=0.5
X473 rr3t3r_0[6|1]/a_860_290# WL6 SL1 VSS sky130_fd_pr__nfet_g5v0d10v5 ad=0.65 pd=3.3 as=0 ps=0 w=1 l=0.5
X474 BLP1 rr3t3r_0[7|1]/a_60_290# sky130_fd_pr_reram__reram_cell area_ox=0.0676
X475 BLZ1 rr3t3r_0[7|1]/a_460_290# sky130_fd_pr_reram__reram_cell area_ox=0.0676
X476 rr3t3r_0[7|1]/a_460_290# WL7 SL1 VSS sky130_fd_pr__nfet_g5v0d10v5 ad=0.65 pd=3.3 as=0 ps=0 w=1 l=0.5
X477 BLN1 rr3t3r_0[7|1]/a_860_290# sky130_fd_pr_reram__reram_cell area_ox=0.0676
X478 rr3t3r_0[7|1]/a_60_290# WL7 SL1 VSS sky130_fd_pr__nfet_g5v0d10v5 ad=0.65 pd=3.3 as=0 ps=0 w=1 l=0.5
X479 rr3t3r_0[7|1]/a_860_290# WL7 SL1 VSS sky130_fd_pr__nfet_g5v0d10v5 ad=0.65 pd=3.3 as=0 ps=0 w=1 l=0.5
X480 BLP1 rr3t3r_0[8|1]/a_60_290# sky130_fd_pr_reram__reram_cell area_ox=0.0676
X481 BLZ1 rr3t3r_0[8|1]/a_460_290# sky130_fd_pr_reram__reram_cell area_ox=0.0676
X482 rr3t3r_0[8|1]/a_460_290# WL8 SL1 VSS sky130_fd_pr__nfet_g5v0d10v5 ad=0.65 pd=3.3 as=0 ps=0 w=1 l=0.5
X483 BLN1 rr3t3r_0[8|1]/a_860_290# sky130_fd_pr_reram__reram_cell area_ox=0.0676
X484 rr3t3r_0[8|1]/a_60_290# WL8 SL1 VSS sky130_fd_pr__nfet_g5v0d10v5 ad=0.65 pd=3.3 as=0 ps=0 w=1 l=0.5
X485 rr3t3r_0[8|1]/a_860_290# WL8 SL1 VSS sky130_fd_pr__nfet_g5v0d10v5 ad=0.65 pd=3.3 as=0 ps=0 w=1 l=0.5
X486 BLP1 rr3t3r_0[9|1]/a_60_290# sky130_fd_pr_reram__reram_cell area_ox=0.0676
X487 BLZ1 rr3t3r_0[9|1]/a_460_290# sky130_fd_pr_reram__reram_cell area_ox=0.0676
X488 rr3t3r_0[9|1]/a_460_290# WL9 SL1 VSS sky130_fd_pr__nfet_g5v0d10v5 ad=0.65 pd=3.3 as=0 ps=0 w=1 l=0.5
X489 BLN1 rr3t3r_0[9|1]/a_860_290# sky130_fd_pr_reram__reram_cell area_ox=0.0676
X490 rr3t3r_0[9|1]/a_60_290# WL9 SL1 VSS sky130_fd_pr__nfet_g5v0d10v5 ad=0.65 pd=3.3 as=0 ps=0 w=1 l=0.5
X491 rr3t3r_0[9|1]/a_860_290# WL9 SL1 VSS sky130_fd_pr__nfet_g5v0d10v5 ad=0.65 pd=3.3 as=0 ps=0 w=1 l=0.5
X492 BLP1 rr3t3r_0[10|1]/a_60_290# sky130_fd_pr_reram__reram_cell area_ox=0.0676
X493 BLZ1 rr3t3r_0[10|1]/a_460_290# sky130_fd_pr_reram__reram_cell area_ox=0.0676
X494 rr3t3r_0[10|1]/a_460_290# WL10 SL1 VSS sky130_fd_pr__nfet_g5v0d10v5 ad=0.65 pd=3.3 as=0 ps=0 w=1 l=0.5
X495 BLN1 rr3t3r_0[10|1]/a_860_290# sky130_fd_pr_reram__reram_cell area_ox=0.0676
X496 rr3t3r_0[10|1]/a_60_290# WL10 SL1 VSS sky130_fd_pr__nfet_g5v0d10v5 ad=0.65 pd=3.3 as=0 ps=0 w=1 l=0.5
X497 rr3t3r_0[10|1]/a_860_290# WL10 SL1 VSS sky130_fd_pr__nfet_g5v0d10v5 ad=0.65 pd=3.3 as=0 ps=0 w=1 l=0.5
X498 BLP1 rr3t3r_0[11|1]/a_60_290# sky130_fd_pr_reram__reram_cell area_ox=0.0676
X499 BLZ1 rr3t3r_0[11|1]/a_460_290# sky130_fd_pr_reram__reram_cell area_ox=0.0676
X500 rr3t3r_0[11|1]/a_460_290# WL11 SL1 VSS sky130_fd_pr__nfet_g5v0d10v5 ad=0.65 pd=3.3 as=0 ps=0 w=1 l=0.5
X501 BLN1 rr3t3r_0[11|1]/a_860_290# sky130_fd_pr_reram__reram_cell area_ox=0.0676
X502 rr3t3r_0[11|1]/a_60_290# WL11 SL1 VSS sky130_fd_pr__nfet_g5v0d10v5 ad=0.65 pd=3.3 as=0 ps=0 w=1 l=0.5
X503 rr3t3r_0[11|1]/a_860_290# WL11 SL1 VSS sky130_fd_pr__nfet_g5v0d10v5 ad=0.65 pd=3.3 as=0 ps=0 w=1 l=0.5
X504 BLP1 rr3t3r_0[12|1]/a_60_290# sky130_fd_pr_reram__reram_cell area_ox=0.0676
X505 BLZ1 rr3t3r_0[12|1]/a_460_290# sky130_fd_pr_reram__reram_cell area_ox=0.0676
X506 rr3t3r_0[12|1]/a_460_290# WL12 SL1 VSS sky130_fd_pr__nfet_g5v0d10v5 ad=0.65 pd=3.3 as=0 ps=0 w=1 l=0.5
X507 BLN1 rr3t3r_0[12|1]/a_860_290# sky130_fd_pr_reram__reram_cell area_ox=0.0676
X508 rr3t3r_0[12|1]/a_60_290# WL12 SL1 VSS sky130_fd_pr__nfet_g5v0d10v5 ad=0.65 pd=3.3 as=0 ps=0 w=1 l=0.5
X509 rr3t3r_0[12|1]/a_860_290# WL12 SL1 VSS sky130_fd_pr__nfet_g5v0d10v5 ad=0.65 pd=3.3 as=0 ps=0 w=1 l=0.5
X510 BLP1 rr3t3r_0[13|1]/a_60_290# sky130_fd_pr_reram__reram_cell area_ox=0.0676
X511 BLZ1 rr3t3r_0[13|1]/a_460_290# sky130_fd_pr_reram__reram_cell area_ox=0.0676
X512 rr3t3r_0[13|1]/a_460_290# WL13 SL1 VSS sky130_fd_pr__nfet_g5v0d10v5 ad=0.65 pd=3.3 as=0 ps=0 w=1 l=0.5
X513 BLN1 rr3t3r_0[13|1]/a_860_290# sky130_fd_pr_reram__reram_cell area_ox=0.0676
X514 rr3t3r_0[13|1]/a_60_290# WL13 SL1 VSS sky130_fd_pr__nfet_g5v0d10v5 ad=0.65 pd=3.3 as=0 ps=0 w=1 l=0.5
X515 rr3t3r_0[13|1]/a_860_290# WL13 SL1 VSS sky130_fd_pr__nfet_g5v0d10v5 ad=0.65 pd=3.3 as=0 ps=0 w=1 l=0.5
X516 BLP1 rr3t3r_0[14|1]/a_60_290# sky130_fd_pr_reram__reram_cell area_ox=0.0676
X517 BLZ1 rr3t3r_0[14|1]/a_460_290# sky130_fd_pr_reram__reram_cell area_ox=0.0676
X518 rr3t3r_0[14|1]/a_460_290# WL14 SL1 VSS sky130_fd_pr__nfet_g5v0d10v5 ad=0.65 pd=3.3 as=0 ps=0 w=1 l=0.5
X519 BLN1 rr3t3r_0[14|1]/a_860_290# sky130_fd_pr_reram__reram_cell area_ox=0.0676
X520 rr3t3r_0[14|1]/a_60_290# WL14 SL1 VSS sky130_fd_pr__nfet_g5v0d10v5 ad=0.65 pd=3.3 as=0 ps=0 w=1 l=0.5
X521 rr3t3r_0[14|1]/a_860_290# WL14 SL1 VSS sky130_fd_pr__nfet_g5v0d10v5 ad=0.65 pd=3.3 as=0 ps=0 w=1 l=0.5
X522 BLP1 rr3t3r_0[15|1]/a_60_290# sky130_fd_pr_reram__reram_cell area_ox=0.0676
X523 BLZ1 rr3t3r_0[15|1]/a_460_290# sky130_fd_pr_reram__reram_cell area_ox=0.0676
X524 rr3t3r_0[15|1]/a_460_290# WL15 SL1 VSS sky130_fd_pr__nfet_g5v0d10v5 ad=0.65 pd=3.3 as=0 ps=0 w=1 l=0.5
X525 BLN1 rr3t3r_0[15|1]/a_860_290# sky130_fd_pr_reram__reram_cell area_ox=0.0676
X526 rr3t3r_0[15|1]/a_60_290# WL15 SL1 VSS sky130_fd_pr__nfet_g5v0d10v5 ad=0.65 pd=3.3 as=0 ps=0 w=1 l=0.5
X527 rr3t3r_0[15|1]/a_860_290# WL15 SL1 VSS sky130_fd_pr__nfet_g5v0d10v5 ad=0.65 pd=3.3 as=0 ps=0 w=1 l=0.5
X528 BLP1 rr3t3r_0[16|1]/a_60_290# sky130_fd_pr_reram__reram_cell area_ox=0.0676
X529 BLZ1 rr3t3r_0[16|1]/a_460_290# sky130_fd_pr_reram__reram_cell area_ox=0.0676
X530 rr3t3r_0[16|1]/a_460_290# WL16 SL1 VSS sky130_fd_pr__nfet_g5v0d10v5 ad=0.65 pd=3.3 as=0 ps=0 w=1 l=0.5
X531 BLN1 rr3t3r_0[16|1]/a_860_290# sky130_fd_pr_reram__reram_cell area_ox=0.0676
X532 rr3t3r_0[16|1]/a_60_290# WL16 SL1 VSS sky130_fd_pr__nfet_g5v0d10v5 ad=0.65 pd=3.3 as=0 ps=0 w=1 l=0.5
X533 rr3t3r_0[16|1]/a_860_290# WL16 SL1 VSS sky130_fd_pr__nfet_g5v0d10v5 ad=0.65 pd=3.3 as=0 ps=0 w=1 l=0.5
X534 BLP1 rr3t3r_0[17|1]/a_60_290# sky130_fd_pr_reram__reram_cell area_ox=0.0676
X535 BLZ1 rr3t3r_0[17|1]/a_460_290# sky130_fd_pr_reram__reram_cell area_ox=0.0676
X536 rr3t3r_0[17|1]/a_460_290# WL17 SL1 VSS sky130_fd_pr__nfet_g5v0d10v5 ad=0.65 pd=3.3 as=0 ps=0 w=1 l=0.5
X537 BLN1 rr3t3r_0[17|1]/a_860_290# sky130_fd_pr_reram__reram_cell area_ox=0.0676
X538 rr3t3r_0[17|1]/a_60_290# WL17 SL1 VSS sky130_fd_pr__nfet_g5v0d10v5 ad=0.65 pd=3.3 as=0 ps=0 w=1 l=0.5
X539 rr3t3r_0[17|1]/a_860_290# WL17 SL1 VSS sky130_fd_pr__nfet_g5v0d10v5 ad=0.65 pd=3.3 as=0 ps=0 w=1 l=0.5
X540 BLP1 rr3t3r_0[18|1]/a_60_290# sky130_fd_pr_reram__reram_cell area_ox=0.0676
X541 BLZ1 rr3t3r_0[18|1]/a_460_290# sky130_fd_pr_reram__reram_cell area_ox=0.0676
X542 rr3t3r_0[18|1]/a_460_290# WL18 SL1 VSS sky130_fd_pr__nfet_g5v0d10v5 ad=0.65 pd=3.3 as=0 ps=0 w=1 l=0.5
X543 BLN1 rr3t3r_0[18|1]/a_860_290# sky130_fd_pr_reram__reram_cell area_ox=0.0676
X544 rr3t3r_0[18|1]/a_60_290# WL18 SL1 VSS sky130_fd_pr__nfet_g5v0d10v5 ad=0.65 pd=3.3 as=0 ps=0 w=1 l=0.5
X545 rr3t3r_0[18|1]/a_860_290# WL18 SL1 VSS sky130_fd_pr__nfet_g5v0d10v5 ad=0.65 pd=3.3 as=0 ps=0 w=1 l=0.5
X546 BLP1 rr3t3r_0[19|1]/a_60_290# sky130_fd_pr_reram__reram_cell area_ox=0.0676
X547 BLZ1 rr3t3r_0[19|1]/a_460_290# sky130_fd_pr_reram__reram_cell area_ox=0.0676
X548 rr3t3r_0[19|1]/a_460_290# WL19 SL1 VSS sky130_fd_pr__nfet_g5v0d10v5 ad=0.65 pd=3.3 as=0 ps=0 w=1 l=0.5
X549 BLN1 rr3t3r_0[19|1]/a_860_290# sky130_fd_pr_reram__reram_cell area_ox=0.0676
X550 rr3t3r_0[19|1]/a_60_290# WL19 SL1 VSS sky130_fd_pr__nfet_g5v0d10v5 ad=0.65 pd=3.3 as=0 ps=0 w=1 l=0.5
X551 rr3t3r_0[19|1]/a_860_290# WL19 SL1 VSS sky130_fd_pr__nfet_g5v0d10v5 ad=0.65 pd=3.3 as=0 ps=0 w=1 l=0.5
X552 BLP1 rr3t3r_0[20|1]/a_60_290# sky130_fd_pr_reram__reram_cell area_ox=0.0676
X553 BLZ1 rr3t3r_0[20|1]/a_460_290# sky130_fd_pr_reram__reram_cell area_ox=0.0676
X554 rr3t3r_0[20|1]/a_460_290# WL20 SL1 VSS sky130_fd_pr__nfet_g5v0d10v5 ad=0.65 pd=3.3 as=0 ps=0 w=1 l=0.5
X555 BLN1 rr3t3r_0[20|1]/a_860_290# sky130_fd_pr_reram__reram_cell area_ox=0.0676
X556 rr3t3r_0[20|1]/a_60_290# WL20 SL1 VSS sky130_fd_pr__nfet_g5v0d10v5 ad=0.65 pd=3.3 as=0 ps=0 w=1 l=0.5
X557 rr3t3r_0[20|1]/a_860_290# WL20 SL1 VSS sky130_fd_pr__nfet_g5v0d10v5 ad=0.65 pd=3.3 as=0 ps=0 w=1 l=0.5
X558 BLP1 rr3t3r_0[21|1]/a_60_290# sky130_fd_pr_reram__reram_cell area_ox=0.0676
X559 BLZ1 rr3t3r_0[21|1]/a_460_290# sky130_fd_pr_reram__reram_cell area_ox=0.0676
X560 rr3t3r_0[21|1]/a_460_290# WL21 SL1 VSS sky130_fd_pr__nfet_g5v0d10v5 ad=0.65 pd=3.3 as=0 ps=0 w=1 l=0.5
X561 BLN1 rr3t3r_0[21|1]/a_860_290# sky130_fd_pr_reram__reram_cell area_ox=0.0676
X562 rr3t3r_0[21|1]/a_60_290# WL21 SL1 VSS sky130_fd_pr__nfet_g5v0d10v5 ad=0.65 pd=3.3 as=0 ps=0 w=1 l=0.5
X563 rr3t3r_0[21|1]/a_860_290# WL21 SL1 VSS sky130_fd_pr__nfet_g5v0d10v5 ad=0.65 pd=3.3 as=0 ps=0 w=1 l=0.5
X564 BLP1 rr3t3r_0[22|1]/a_60_290# sky130_fd_pr_reram__reram_cell area_ox=0.0676
X565 BLZ1 rr3t3r_0[22|1]/a_460_290# sky130_fd_pr_reram__reram_cell area_ox=0.0676
X566 rr3t3r_0[22|1]/a_460_290# WL22 SL1 VSS sky130_fd_pr__nfet_g5v0d10v5 ad=0.65 pd=3.3 as=0 ps=0 w=1 l=0.5
X567 BLN1 rr3t3r_0[22|1]/a_860_290# sky130_fd_pr_reram__reram_cell area_ox=0.0676
X568 rr3t3r_0[22|1]/a_60_290# WL22 SL1 VSS sky130_fd_pr__nfet_g5v0d10v5 ad=0.65 pd=3.3 as=0 ps=0 w=1 l=0.5
X569 rr3t3r_0[22|1]/a_860_290# WL22 SL1 VSS sky130_fd_pr__nfet_g5v0d10v5 ad=0.65 pd=3.3 as=0 ps=0 w=1 l=0.5
X570 BLP1 rr3t3r_0[23|1]/a_60_290# sky130_fd_pr_reram__reram_cell area_ox=0.0676
X571 BLZ1 rr3t3r_0[23|1]/a_460_290# sky130_fd_pr_reram__reram_cell area_ox=0.0676
X572 rr3t3r_0[23|1]/a_460_290# WL23 SL1 VSS sky130_fd_pr__nfet_g5v0d10v5 ad=0.65 pd=3.3 as=0 ps=0 w=1 l=0.5
X573 BLN1 rr3t3r_0[23|1]/a_860_290# sky130_fd_pr_reram__reram_cell area_ox=0.0676
X574 rr3t3r_0[23|1]/a_60_290# WL23 SL1 VSS sky130_fd_pr__nfet_g5v0d10v5 ad=0.65 pd=3.3 as=0 ps=0 w=1 l=0.5
X575 rr3t3r_0[23|1]/a_860_290# WL23 SL1 VSS sky130_fd_pr__nfet_g5v0d10v5 ad=0.65 pd=3.3 as=0 ps=0 w=1 l=0.5
X576 BLP1 rr3t3r_0[24|1]/a_60_290# sky130_fd_pr_reram__reram_cell area_ox=0.0676
X577 BLZ1 rr3t3r_0[24|1]/a_460_290# sky130_fd_pr_reram__reram_cell area_ox=0.0676
X578 rr3t3r_0[24|1]/a_460_290# WL24 SL1 VSS sky130_fd_pr__nfet_g5v0d10v5 ad=0.65 pd=3.3 as=0 ps=0 w=1 l=0.5
X579 BLN1 rr3t3r_0[24|1]/a_860_290# sky130_fd_pr_reram__reram_cell area_ox=0.0676
X580 rr3t3r_0[24|1]/a_60_290# WL24 SL1 VSS sky130_fd_pr__nfet_g5v0d10v5 ad=0.65 pd=3.3 as=0 ps=0 w=1 l=0.5
X581 rr3t3r_0[24|1]/a_860_290# WL24 SL1 VSS sky130_fd_pr__nfet_g5v0d10v5 ad=0.65 pd=3.3 as=0 ps=0 w=1 l=0.5
X582 BLP1 rr3t3r_0[25|1]/a_60_290# sky130_fd_pr_reram__reram_cell area_ox=0.0676
X583 BLZ1 rr3t3r_0[25|1]/a_460_290# sky130_fd_pr_reram__reram_cell area_ox=0.0676
X584 rr3t3r_0[25|1]/a_460_290# WL25 SL1 VSS sky130_fd_pr__nfet_g5v0d10v5 ad=0.65 pd=3.3 as=0 ps=0 w=1 l=0.5
X585 BLN1 rr3t3r_0[25|1]/a_860_290# sky130_fd_pr_reram__reram_cell area_ox=0.0676
X586 rr3t3r_0[25|1]/a_60_290# WL25 SL1 VSS sky130_fd_pr__nfet_g5v0d10v5 ad=0.65 pd=3.3 as=0 ps=0 w=1 l=0.5
X587 rr3t3r_0[25|1]/a_860_290# WL25 SL1 VSS sky130_fd_pr__nfet_g5v0d10v5 ad=0.65 pd=3.3 as=0 ps=0 w=1 l=0.5
X588 BLP1 rr3t3r_0[26|1]/a_60_290# sky130_fd_pr_reram__reram_cell area_ox=0.0676
X589 BLZ1 rr3t3r_0[26|1]/a_460_290# sky130_fd_pr_reram__reram_cell area_ox=0.0676
X590 rr3t3r_0[26|1]/a_460_290# WL26 SL1 VSS sky130_fd_pr__nfet_g5v0d10v5 ad=0.65 pd=3.3 as=0 ps=0 w=1 l=0.5
X591 BLN1 rr3t3r_0[26|1]/a_860_290# sky130_fd_pr_reram__reram_cell area_ox=0.0676
X592 rr3t3r_0[26|1]/a_60_290# WL26 SL1 VSS sky130_fd_pr__nfet_g5v0d10v5 ad=0.65 pd=3.3 as=0 ps=0 w=1 l=0.5
X593 rr3t3r_0[26|1]/a_860_290# WL26 SL1 VSS sky130_fd_pr__nfet_g5v0d10v5 ad=0.65 pd=3.3 as=0 ps=0 w=1 l=0.5
X594 BLP1 rr3t3r_0[27|1]/a_60_290# sky130_fd_pr_reram__reram_cell area_ox=0.0676
X595 BLZ1 rr3t3r_0[27|1]/a_460_290# sky130_fd_pr_reram__reram_cell area_ox=0.0676
X596 rr3t3r_0[27|1]/a_460_290# WL27 SL1 VSS sky130_fd_pr__nfet_g5v0d10v5 ad=0.65 pd=3.3 as=0 ps=0 w=1 l=0.5
X597 BLN1 rr3t3r_0[27|1]/a_860_290# sky130_fd_pr_reram__reram_cell area_ox=0.0676
X598 rr3t3r_0[27|1]/a_60_290# WL27 SL1 VSS sky130_fd_pr__nfet_g5v0d10v5 ad=0.65 pd=3.3 as=0 ps=0 w=1 l=0.5
X599 rr3t3r_0[27|1]/a_860_290# WL27 SL1 VSS sky130_fd_pr__nfet_g5v0d10v5 ad=0.65 pd=3.3 as=0 ps=0 w=1 l=0.5
X600 BLP1 rr3t3r_0[28|1]/a_60_290# sky130_fd_pr_reram__reram_cell area_ox=0.0676
X601 BLZ1 rr3t3r_0[28|1]/a_460_290# sky130_fd_pr_reram__reram_cell area_ox=0.0676
X602 rr3t3r_0[28|1]/a_460_290# WL28 SL1 VSS sky130_fd_pr__nfet_g5v0d10v5 ad=0.65 pd=3.3 as=0 ps=0 w=1 l=0.5
X603 BLN1 rr3t3r_0[28|1]/a_860_290# sky130_fd_pr_reram__reram_cell area_ox=0.0676
X604 rr3t3r_0[28|1]/a_60_290# WL28 SL1 VSS sky130_fd_pr__nfet_g5v0d10v5 ad=0.65 pd=3.3 as=0 ps=0 w=1 l=0.5
X605 rr3t3r_0[28|1]/a_860_290# WL28 SL1 VSS sky130_fd_pr__nfet_g5v0d10v5 ad=0.65 pd=3.3 as=0 ps=0 w=1 l=0.5
X606 BLP1 rr3t3r_0[29|1]/a_60_290# sky130_fd_pr_reram__reram_cell area_ox=0.0676
X607 BLZ1 rr3t3r_0[29|1]/a_460_290# sky130_fd_pr_reram__reram_cell area_ox=0.0676
X608 rr3t3r_0[29|1]/a_460_290# WL29 SL1 VSS sky130_fd_pr__nfet_g5v0d10v5 ad=0.65 pd=3.3 as=0 ps=0 w=1 l=0.5
X609 BLN1 rr3t3r_0[29|1]/a_860_290# sky130_fd_pr_reram__reram_cell area_ox=0.0676
X610 rr3t3r_0[29|1]/a_60_290# WL29 SL1 VSS sky130_fd_pr__nfet_g5v0d10v5 ad=0.65 pd=3.3 as=0 ps=0 w=1 l=0.5
X611 rr3t3r_0[29|1]/a_860_290# WL29 SL1 VSS sky130_fd_pr__nfet_g5v0d10v5 ad=0.65 pd=3.3 as=0 ps=0 w=1 l=0.5
X612 BLP1 rr3t3r_0[30|1]/a_60_290# sky130_fd_pr_reram__reram_cell area_ox=0.0676
X613 BLZ1 rr3t3r_0[30|1]/a_460_290# sky130_fd_pr_reram__reram_cell area_ox=0.0676
X614 rr3t3r_0[30|1]/a_460_290# WL30 SL1 VSS sky130_fd_pr__nfet_g5v0d10v5 ad=0.65 pd=3.3 as=0 ps=0 w=1 l=0.5
X615 BLN1 rr3t3r_0[30|1]/a_860_290# sky130_fd_pr_reram__reram_cell area_ox=0.0676
X616 rr3t3r_0[30|1]/a_60_290# WL30 SL1 VSS sky130_fd_pr__nfet_g5v0d10v5 ad=0.65 pd=3.3 as=0 ps=0 w=1 l=0.5
X617 rr3t3r_0[30|1]/a_860_290# WL30 SL1 VSS sky130_fd_pr__nfet_g5v0d10v5 ad=0.65 pd=3.3 as=0 ps=0 w=1 l=0.5
X618 BLP1 rr3t3r_0[31|1]/a_60_290# sky130_fd_pr_reram__reram_cell area_ox=0.0676
X619 BLZ1 rr3t3r_0[31|1]/a_460_290# sky130_fd_pr_reram__reram_cell area_ox=0.0676
X620 rr3t3r_0[31|1]/a_460_290# WL31 SL1 VSS sky130_fd_pr__nfet_g5v0d10v5 ad=0.65 pd=3.3 as=0 ps=0 w=1 l=0.5
X621 BLN1 rr3t3r_0[31|1]/a_860_290# sky130_fd_pr_reram__reram_cell area_ox=0.0676
X622 rr3t3r_0[31|1]/a_60_290# WL31 SL1 VSS sky130_fd_pr__nfet_g5v0d10v5 ad=0.65 pd=3.3 as=0 ps=0 w=1 l=0.5
X623 rr3t3r_0[31|1]/a_860_290# WL31 SL1 VSS sky130_fd_pr__nfet_g5v0d10v5 ad=0.65 pd=3.3 as=0 ps=0 w=1 l=0.5
X624 BLP1 rr3t3r_0[32|1]/a_60_290# sky130_fd_pr_reram__reram_cell area_ox=0.0676
X625 BLZ1 rr3t3r_0[32|1]/a_460_290# sky130_fd_pr_reram__reram_cell area_ox=0.0676
X626 rr3t3r_0[32|1]/a_460_290# WL32 SL1 VSS sky130_fd_pr__nfet_g5v0d10v5 ad=0.65 pd=3.3 as=0 ps=0 w=1 l=0.5
X627 BLN1 rr3t3r_0[32|1]/a_860_290# sky130_fd_pr_reram__reram_cell area_ox=0.0676
X628 rr3t3r_0[32|1]/a_60_290# WL32 SL1 VSS sky130_fd_pr__nfet_g5v0d10v5 ad=0.65 pd=3.3 as=0 ps=0 w=1 l=0.5
X629 rr3t3r_0[32|1]/a_860_290# WL32 SL1 VSS sky130_fd_pr__nfet_g5v0d10v5 ad=0.65 pd=3.3 as=0 ps=0 w=1 l=0.5
X630 BLP1 rr3t3r_0[33|1]/a_60_290# sky130_fd_pr_reram__reram_cell area_ox=0.0676
X631 BLZ1 rr3t3r_0[33|1]/a_460_290# sky130_fd_pr_reram__reram_cell area_ox=0.0676
X632 rr3t3r_0[33|1]/a_460_290# WL33 SL1 VSS sky130_fd_pr__nfet_g5v0d10v5 ad=0.65 pd=3.3 as=0 ps=0 w=1 l=0.5
X633 BLN1 rr3t3r_0[33|1]/a_860_290# sky130_fd_pr_reram__reram_cell area_ox=0.0676
X634 rr3t3r_0[33|1]/a_60_290# WL33 SL1 VSS sky130_fd_pr__nfet_g5v0d10v5 ad=0.65 pd=3.3 as=0 ps=0 w=1 l=0.5
X635 rr3t3r_0[33|1]/a_860_290# WL33 SL1 VSS sky130_fd_pr__nfet_g5v0d10v5 ad=0.65 pd=3.3 as=0 ps=0 w=1 l=0.5
X636 BLP1 rr3t3r_0[34|1]/a_60_290# sky130_fd_pr_reram__reram_cell area_ox=0.0676
X637 BLZ1 rr3t3r_0[34|1]/a_460_290# sky130_fd_pr_reram__reram_cell area_ox=0.0676
X638 rr3t3r_0[34|1]/a_460_290# WL34 SL1 VSS sky130_fd_pr__nfet_g5v0d10v5 ad=0.65 pd=3.3 as=0 ps=0 w=1 l=0.5
X639 BLN1 rr3t3r_0[34|1]/a_860_290# sky130_fd_pr_reram__reram_cell area_ox=0.0676
X640 rr3t3r_0[34|1]/a_60_290# WL34 SL1 VSS sky130_fd_pr__nfet_g5v0d10v5 ad=0.65 pd=3.3 as=0 ps=0 w=1 l=0.5
X641 rr3t3r_0[34|1]/a_860_290# WL34 SL1 VSS sky130_fd_pr__nfet_g5v0d10v5 ad=0.65 pd=3.3 as=0 ps=0 w=1 l=0.5
X642 BLP1 rr3t3r_0[35|1]/a_60_290# sky130_fd_pr_reram__reram_cell area_ox=0.0676
X643 BLZ1 rr3t3r_0[35|1]/a_460_290# sky130_fd_pr_reram__reram_cell area_ox=0.0676
X644 rr3t3r_0[35|1]/a_460_290# WL35 SL1 VSS sky130_fd_pr__nfet_g5v0d10v5 ad=0.65 pd=3.3 as=0 ps=0 w=1 l=0.5
X645 BLN1 rr3t3r_0[35|1]/a_860_290# sky130_fd_pr_reram__reram_cell area_ox=0.0676
X646 rr3t3r_0[35|1]/a_60_290# WL35 SL1 VSS sky130_fd_pr__nfet_g5v0d10v5 ad=0.65 pd=3.3 as=0 ps=0 w=1 l=0.5
X647 rr3t3r_0[35|1]/a_860_290# WL35 SL1 VSS sky130_fd_pr__nfet_g5v0d10v5 ad=0.65 pd=3.3 as=0 ps=0 w=1 l=0.5
X648 BLP1 rr3t3r_0[36|1]/a_60_290# sky130_fd_pr_reram__reram_cell area_ox=0.0676
X649 BLZ1 rr3t3r_0[36|1]/a_460_290# sky130_fd_pr_reram__reram_cell area_ox=0.0676
X650 rr3t3r_0[36|1]/a_460_290# WL36 SL1 VSS sky130_fd_pr__nfet_g5v0d10v5 ad=0.65 pd=3.3 as=0 ps=0 w=1 l=0.5
X651 BLN1 rr3t3r_0[36|1]/a_860_290# sky130_fd_pr_reram__reram_cell area_ox=0.0676
X652 rr3t3r_0[36|1]/a_60_290# WL36 SL1 VSS sky130_fd_pr__nfet_g5v0d10v5 ad=0.65 pd=3.3 as=0 ps=0 w=1 l=0.5
X653 rr3t3r_0[36|1]/a_860_290# WL36 SL1 VSS sky130_fd_pr__nfet_g5v0d10v5 ad=0.65 pd=3.3 as=0 ps=0 w=1 l=0.5
X654 BLP1 rr3t3r_0[37|1]/a_60_290# sky130_fd_pr_reram__reram_cell area_ox=0.0676
X655 BLZ1 rr3t3r_0[37|1]/a_460_290# sky130_fd_pr_reram__reram_cell area_ox=0.0676
X656 rr3t3r_0[37|1]/a_460_290# WL37 SL1 VSS sky130_fd_pr__nfet_g5v0d10v5 ad=0.65 pd=3.3 as=0 ps=0 w=1 l=0.5
X657 BLN1 rr3t3r_0[37|1]/a_860_290# sky130_fd_pr_reram__reram_cell area_ox=0.0676
X658 rr3t3r_0[37|1]/a_60_290# WL37 SL1 VSS sky130_fd_pr__nfet_g5v0d10v5 ad=0.65 pd=3.3 as=0 ps=0 w=1 l=0.5
X659 rr3t3r_0[37|1]/a_860_290# WL37 SL1 VSS sky130_fd_pr__nfet_g5v0d10v5 ad=0.65 pd=3.3 as=0 ps=0 w=1 l=0.5
X660 BLP1 rr3t3r_0[38|1]/a_60_290# sky130_fd_pr_reram__reram_cell area_ox=0.0676
X661 BLZ1 rr3t3r_0[38|1]/a_460_290# sky130_fd_pr_reram__reram_cell area_ox=0.0676
X662 rr3t3r_0[38|1]/a_460_290# WL38 SL1 VSS sky130_fd_pr__nfet_g5v0d10v5 ad=0.65 pd=3.3 as=0 ps=0 w=1 l=0.5
X663 BLN1 rr3t3r_0[38|1]/a_860_290# sky130_fd_pr_reram__reram_cell area_ox=0.0676
X664 rr3t3r_0[38|1]/a_60_290# WL38 SL1 VSS sky130_fd_pr__nfet_g5v0d10v5 ad=0.65 pd=3.3 as=0 ps=0 w=1 l=0.5
X665 rr3t3r_0[38|1]/a_860_290# WL38 SL1 VSS sky130_fd_pr__nfet_g5v0d10v5 ad=0.65 pd=3.3 as=0 ps=0 w=1 l=0.5
X666 BLP1 rr3t3r_0[39|1]/a_60_290# sky130_fd_pr_reram__reram_cell area_ox=0.0676
X667 BLZ1 rr3t3r_0[39|1]/a_460_290# sky130_fd_pr_reram__reram_cell area_ox=0.0676
X668 rr3t3r_0[39|1]/a_460_290# WL39 SL1 VSS sky130_fd_pr__nfet_g5v0d10v5 ad=0.65 pd=3.3 as=0 ps=0 w=1 l=0.5
X669 BLN1 rr3t3r_0[39|1]/a_860_290# sky130_fd_pr_reram__reram_cell area_ox=0.0676
X670 rr3t3r_0[39|1]/a_60_290# WL39 SL1 VSS sky130_fd_pr__nfet_g5v0d10v5 ad=0.65 pd=3.3 as=0 ps=0 w=1 l=0.5
X671 rr3t3r_0[39|1]/a_860_290# WL39 SL1 VSS sky130_fd_pr__nfet_g5v0d10v5 ad=0.65 pd=3.3 as=0 ps=0 w=1 l=0.5
X672 BLP1 rr3t3r_0[40|1]/a_60_290# sky130_fd_pr_reram__reram_cell area_ox=0.0676
X673 BLZ1 rr3t3r_0[40|1]/a_460_290# sky130_fd_pr_reram__reram_cell area_ox=0.0676
X674 rr3t3r_0[40|1]/a_460_290# WL40 SL1 VSS sky130_fd_pr__nfet_g5v0d10v5 ad=0.65 pd=3.3 as=0 ps=0 w=1 l=0.5
X675 BLN1 rr3t3r_0[40|1]/a_860_290# sky130_fd_pr_reram__reram_cell area_ox=0.0676
X676 rr3t3r_0[40|1]/a_60_290# WL40 SL1 VSS sky130_fd_pr__nfet_g5v0d10v5 ad=0.65 pd=3.3 as=0 ps=0 w=1 l=0.5
X677 rr3t3r_0[40|1]/a_860_290# WL40 SL1 VSS sky130_fd_pr__nfet_g5v0d10v5 ad=0.65 pd=3.3 as=0 ps=0 w=1 l=0.5
X678 BLP1 rr3t3r_0[41|1]/a_60_290# sky130_fd_pr_reram__reram_cell area_ox=0.0676
X679 BLZ1 rr3t3r_0[41|1]/a_460_290# sky130_fd_pr_reram__reram_cell area_ox=0.0676
X680 rr3t3r_0[41|1]/a_460_290# WL41 SL1 VSS sky130_fd_pr__nfet_g5v0d10v5 ad=0.65 pd=3.3 as=0 ps=0 w=1 l=0.5
X681 BLN1 rr3t3r_0[41|1]/a_860_290# sky130_fd_pr_reram__reram_cell area_ox=0.0676
X682 rr3t3r_0[41|1]/a_60_290# WL41 SL1 VSS sky130_fd_pr__nfet_g5v0d10v5 ad=0.65 pd=3.3 as=0 ps=0 w=1 l=0.5
X683 rr3t3r_0[41|1]/a_860_290# WL41 SL1 VSS sky130_fd_pr__nfet_g5v0d10v5 ad=0.65 pd=3.3 as=0 ps=0 w=1 l=0.5
X684 BLP1 rr3t3r_0[42|1]/a_60_290# sky130_fd_pr_reram__reram_cell area_ox=0.0676
X685 BLZ1 rr3t3r_0[42|1]/a_460_290# sky130_fd_pr_reram__reram_cell area_ox=0.0676
X686 rr3t3r_0[42|1]/a_460_290# WL42 SL1 VSS sky130_fd_pr__nfet_g5v0d10v5 ad=0.65 pd=3.3 as=0 ps=0 w=1 l=0.5
X687 BLN1 rr3t3r_0[42|1]/a_860_290# sky130_fd_pr_reram__reram_cell area_ox=0.0676
X688 rr3t3r_0[42|1]/a_60_290# WL42 SL1 VSS sky130_fd_pr__nfet_g5v0d10v5 ad=0.65 pd=3.3 as=0 ps=0 w=1 l=0.5
X689 rr3t3r_0[42|1]/a_860_290# WL42 SL1 VSS sky130_fd_pr__nfet_g5v0d10v5 ad=0.65 pd=3.3 as=0 ps=0 w=1 l=0.5
X690 BLP1 rr3t3r_0[43|1]/a_60_290# sky130_fd_pr_reram__reram_cell area_ox=0.0676
X691 BLZ1 rr3t3r_0[43|1]/a_460_290# sky130_fd_pr_reram__reram_cell area_ox=0.0676
X692 rr3t3r_0[43|1]/a_460_290# WL43 SL1 VSS sky130_fd_pr__nfet_g5v0d10v5 ad=0.65 pd=3.3 as=0 ps=0 w=1 l=0.5
X693 BLN1 rr3t3r_0[43|1]/a_860_290# sky130_fd_pr_reram__reram_cell area_ox=0.0676
X694 rr3t3r_0[43|1]/a_60_290# WL43 SL1 VSS sky130_fd_pr__nfet_g5v0d10v5 ad=0.65 pd=3.3 as=0 ps=0 w=1 l=0.5
X695 rr3t3r_0[43|1]/a_860_290# WL43 SL1 VSS sky130_fd_pr__nfet_g5v0d10v5 ad=0.65 pd=3.3 as=0 ps=0 w=1 l=0.5
X696 BLP1 rr3t3r_0[44|1]/a_60_290# sky130_fd_pr_reram__reram_cell area_ox=0.0676
X697 BLZ1 rr3t3r_0[44|1]/a_460_290# sky130_fd_pr_reram__reram_cell area_ox=0.0676
X698 rr3t3r_0[44|1]/a_460_290# WL44 SL1 VSS sky130_fd_pr__nfet_g5v0d10v5 ad=0.65 pd=3.3 as=0 ps=0 w=1 l=0.5
X699 BLN1 rr3t3r_0[44|1]/a_860_290# sky130_fd_pr_reram__reram_cell area_ox=0.0676
X700 rr3t3r_0[44|1]/a_60_290# WL44 SL1 VSS sky130_fd_pr__nfet_g5v0d10v5 ad=0.65 pd=3.3 as=0 ps=0 w=1 l=0.5
X701 rr3t3r_0[44|1]/a_860_290# WL44 SL1 VSS sky130_fd_pr__nfet_g5v0d10v5 ad=0.65 pd=3.3 as=0 ps=0 w=1 l=0.5
X702 BLP1 rr3t3r_0[45|1]/a_60_290# sky130_fd_pr_reram__reram_cell area_ox=0.0676
X703 BLZ1 rr3t3r_0[45|1]/a_460_290# sky130_fd_pr_reram__reram_cell area_ox=0.0676
X704 rr3t3r_0[45|1]/a_460_290# WL45 SL1 VSS sky130_fd_pr__nfet_g5v0d10v5 ad=0.65 pd=3.3 as=0 ps=0 w=1 l=0.5
X705 BLN1 rr3t3r_0[45|1]/a_860_290# sky130_fd_pr_reram__reram_cell area_ox=0.0676
X706 rr3t3r_0[45|1]/a_60_290# WL45 SL1 VSS sky130_fd_pr__nfet_g5v0d10v5 ad=0.65 pd=3.3 as=0 ps=0 w=1 l=0.5
X707 rr3t3r_0[45|1]/a_860_290# WL45 SL1 VSS sky130_fd_pr__nfet_g5v0d10v5 ad=0.65 pd=3.3 as=0 ps=0 w=1 l=0.5
X708 BLP1 rr3t3r_0[46|1]/a_60_290# sky130_fd_pr_reram__reram_cell area_ox=0.0676
X709 BLZ1 rr3t3r_0[46|1]/a_460_290# sky130_fd_pr_reram__reram_cell area_ox=0.0676
X710 rr3t3r_0[46|1]/a_460_290# WL46 SL1 VSS sky130_fd_pr__nfet_g5v0d10v5 ad=0.65 pd=3.3 as=0 ps=0 w=1 l=0.5
X711 BLN1 rr3t3r_0[46|1]/a_860_290# sky130_fd_pr_reram__reram_cell area_ox=0.0676
X712 rr3t3r_0[46|1]/a_60_290# WL46 SL1 VSS sky130_fd_pr__nfet_g5v0d10v5 ad=0.65 pd=3.3 as=0 ps=0 w=1 l=0.5
X713 rr3t3r_0[46|1]/a_860_290# WL46 SL1 VSS sky130_fd_pr__nfet_g5v0d10v5 ad=0.65 pd=3.3 as=0 ps=0 w=1 l=0.5
X714 BLP1 rr3t3r_0[47|1]/a_60_290# sky130_fd_pr_reram__reram_cell area_ox=0.0676
X715 BLZ1 rr3t3r_0[47|1]/a_460_290# sky130_fd_pr_reram__reram_cell area_ox=0.0676
X716 rr3t3r_0[47|1]/a_460_290# WL47 SL1 VSS sky130_fd_pr__nfet_g5v0d10v5 ad=0.65 pd=3.3 as=0 ps=0 w=1 l=0.5
X717 BLN1 rr3t3r_0[47|1]/a_860_290# sky130_fd_pr_reram__reram_cell area_ox=0.0676
X718 rr3t3r_0[47|1]/a_60_290# WL47 SL1 VSS sky130_fd_pr__nfet_g5v0d10v5 ad=0.65 pd=3.3 as=0 ps=0 w=1 l=0.5
X719 rr3t3r_0[47|1]/a_860_290# WL47 SL1 VSS sky130_fd_pr__nfet_g5v0d10v5 ad=0.65 pd=3.3 as=0 ps=0 w=1 l=0.5
X720 BLP1 rr3t3r_0[48|1]/a_60_290# sky130_fd_pr_reram__reram_cell area_ox=0.0676
X721 BLZ1 rr3t3r_0[48|1]/a_460_290# sky130_fd_pr_reram__reram_cell area_ox=0.0676
X722 rr3t3r_0[48|1]/a_460_290# WL48 SL1 VSS sky130_fd_pr__nfet_g5v0d10v5 ad=0.65 pd=3.3 as=0 ps=0 w=1 l=0.5
X723 BLN1 rr3t3r_0[48|1]/a_860_290# sky130_fd_pr_reram__reram_cell area_ox=0.0676
X724 rr3t3r_0[48|1]/a_60_290# WL48 SL1 VSS sky130_fd_pr__nfet_g5v0d10v5 ad=0.65 pd=3.3 as=0 ps=0 w=1 l=0.5
X725 rr3t3r_0[48|1]/a_860_290# WL48 SL1 VSS sky130_fd_pr__nfet_g5v0d10v5 ad=0.65 pd=3.3 as=0 ps=0 w=1 l=0.5
X726 BLP1 rr3t3r_0[49|1]/a_60_290# sky130_fd_pr_reram__reram_cell area_ox=0.0676
X727 BLZ1 rr3t3r_0[49|1]/a_460_290# sky130_fd_pr_reram__reram_cell area_ox=0.0676
X728 rr3t3r_0[49|1]/a_460_290# WL49 SL1 VSS sky130_fd_pr__nfet_g5v0d10v5 ad=0.65 pd=3.3 as=0 ps=0 w=1 l=0.5
X729 BLN1 rr3t3r_0[49|1]/a_860_290# sky130_fd_pr_reram__reram_cell area_ox=0.0676
X730 rr3t3r_0[49|1]/a_60_290# WL49 SL1 VSS sky130_fd_pr__nfet_g5v0d10v5 ad=0.65 pd=3.3 as=0 ps=0 w=1 l=0.5
X731 rr3t3r_0[49|1]/a_860_290# WL49 SL1 VSS sky130_fd_pr__nfet_g5v0d10v5 ad=0.65 pd=3.3 as=0 ps=0 w=1 l=0.5
X732 BLP1 rr3t3r_0[50|1]/a_60_290# sky130_fd_pr_reram__reram_cell area_ox=0.0676
X733 BLZ1 rr3t3r_0[50|1]/a_460_290# sky130_fd_pr_reram__reram_cell area_ox=0.0676
X734 rr3t3r_0[50|1]/a_460_290# WL50 SL1 VSS sky130_fd_pr__nfet_g5v0d10v5 ad=0.65 pd=3.3 as=0 ps=0 w=1 l=0.5
X735 BLN1 rr3t3r_0[50|1]/a_860_290# sky130_fd_pr_reram__reram_cell area_ox=0.0676
X736 rr3t3r_0[50|1]/a_60_290# WL50 SL1 VSS sky130_fd_pr__nfet_g5v0d10v5 ad=0.65 pd=3.3 as=0 ps=0 w=1 l=0.5
X737 rr3t3r_0[50|1]/a_860_290# WL50 SL1 VSS sky130_fd_pr__nfet_g5v0d10v5 ad=0.65 pd=3.3 as=0 ps=0 w=1 l=0.5
X738 BLP1 rr3t3r_0[51|1]/a_60_290# sky130_fd_pr_reram__reram_cell area_ox=0.0676
X739 BLZ1 rr3t3r_0[51|1]/a_460_290# sky130_fd_pr_reram__reram_cell area_ox=0.0676
X740 rr3t3r_0[51|1]/a_460_290# WL51 SL1 VSS sky130_fd_pr__nfet_g5v0d10v5 ad=0.65 pd=3.3 as=0 ps=0 w=1 l=0.5
X741 BLN1 rr3t3r_0[51|1]/a_860_290# sky130_fd_pr_reram__reram_cell area_ox=0.0676
X742 rr3t3r_0[51|1]/a_60_290# WL51 SL1 VSS sky130_fd_pr__nfet_g5v0d10v5 ad=0.65 pd=3.3 as=0 ps=0 w=1 l=0.5
X743 rr3t3r_0[51|1]/a_860_290# WL51 SL1 VSS sky130_fd_pr__nfet_g5v0d10v5 ad=0.65 pd=3.3 as=0 ps=0 w=1 l=0.5
X744 BLP1 rr3t3r_0[52|1]/a_60_290# sky130_fd_pr_reram__reram_cell area_ox=0.0676
X745 BLZ1 rr3t3r_0[52|1]/a_460_290# sky130_fd_pr_reram__reram_cell area_ox=0.0676
X746 rr3t3r_0[52|1]/a_460_290# WL52 SL1 VSS sky130_fd_pr__nfet_g5v0d10v5 ad=0.65 pd=3.3 as=0 ps=0 w=1 l=0.5
X747 BLN1 rr3t3r_0[52|1]/a_860_290# sky130_fd_pr_reram__reram_cell area_ox=0.0676
X748 rr3t3r_0[52|1]/a_60_290# WL52 SL1 VSS sky130_fd_pr__nfet_g5v0d10v5 ad=0.65 pd=3.3 as=0 ps=0 w=1 l=0.5
X749 rr3t3r_0[52|1]/a_860_290# WL52 SL1 VSS sky130_fd_pr__nfet_g5v0d10v5 ad=0.65 pd=3.3 as=0 ps=0 w=1 l=0.5
X750 BLP1 rr3t3r_0[53|1]/a_60_290# sky130_fd_pr_reram__reram_cell area_ox=0.0676
X751 BLZ1 rr3t3r_0[53|1]/a_460_290# sky130_fd_pr_reram__reram_cell area_ox=0.0676
X752 rr3t3r_0[53|1]/a_460_290# WL53 SL1 VSS sky130_fd_pr__nfet_g5v0d10v5 ad=0.65 pd=3.3 as=0 ps=0 w=1 l=0.5
X753 BLN1 rr3t3r_0[53|1]/a_860_290# sky130_fd_pr_reram__reram_cell area_ox=0.0676
X754 rr3t3r_0[53|1]/a_60_290# WL53 SL1 VSS sky130_fd_pr__nfet_g5v0d10v5 ad=0.65 pd=3.3 as=0 ps=0 w=1 l=0.5
X755 rr3t3r_0[53|1]/a_860_290# WL53 SL1 VSS sky130_fd_pr__nfet_g5v0d10v5 ad=0.65 pd=3.3 as=0 ps=0 w=1 l=0.5
X756 BLP1 rr3t3r_0[54|1]/a_60_290# sky130_fd_pr_reram__reram_cell area_ox=0.0676
X757 BLZ1 rr3t3r_0[54|1]/a_460_290# sky130_fd_pr_reram__reram_cell area_ox=0.0676
X758 rr3t3r_0[54|1]/a_460_290# WL54 SL1 VSS sky130_fd_pr__nfet_g5v0d10v5 ad=0.65 pd=3.3 as=0 ps=0 w=1 l=0.5
X759 BLN1 rr3t3r_0[54|1]/a_860_290# sky130_fd_pr_reram__reram_cell area_ox=0.0676
X760 rr3t3r_0[54|1]/a_60_290# WL54 SL1 VSS sky130_fd_pr__nfet_g5v0d10v5 ad=0.65 pd=3.3 as=0 ps=0 w=1 l=0.5
X761 rr3t3r_0[54|1]/a_860_290# WL54 SL1 VSS sky130_fd_pr__nfet_g5v0d10v5 ad=0.65 pd=3.3 as=0 ps=0 w=1 l=0.5
X762 BLP1 rr3t3r_0[55|1]/a_60_290# sky130_fd_pr_reram__reram_cell area_ox=0.0676
X763 BLZ1 rr3t3r_0[55|1]/a_460_290# sky130_fd_pr_reram__reram_cell area_ox=0.0676
X764 rr3t3r_0[55|1]/a_460_290# WL55 SL1 VSS sky130_fd_pr__nfet_g5v0d10v5 ad=0.65 pd=3.3 as=0 ps=0 w=1 l=0.5
X765 BLN1 rr3t3r_0[55|1]/a_860_290# sky130_fd_pr_reram__reram_cell area_ox=0.0676
X766 rr3t3r_0[55|1]/a_60_290# WL55 SL1 VSS sky130_fd_pr__nfet_g5v0d10v5 ad=0.65 pd=3.3 as=0 ps=0 w=1 l=0.5
X767 rr3t3r_0[55|1]/a_860_290# WL55 SL1 VSS sky130_fd_pr__nfet_g5v0d10v5 ad=0.65 pd=3.3 as=0 ps=0 w=1 l=0.5
X768 BLP1 rr3t3r_0[56|1]/a_60_290# sky130_fd_pr_reram__reram_cell area_ox=0.0676
X769 BLZ1 rr3t3r_0[56|1]/a_460_290# sky130_fd_pr_reram__reram_cell area_ox=0.0676
X770 rr3t3r_0[56|1]/a_460_290# WL56 SL1 VSS sky130_fd_pr__nfet_g5v0d10v5 ad=0.65 pd=3.3 as=0 ps=0 w=1 l=0.5
X771 BLN1 rr3t3r_0[56|1]/a_860_290# sky130_fd_pr_reram__reram_cell area_ox=0.0676
X772 rr3t3r_0[56|1]/a_60_290# WL56 SL1 VSS sky130_fd_pr__nfet_g5v0d10v5 ad=0.65 pd=3.3 as=0 ps=0 w=1 l=0.5
X773 rr3t3r_0[56|1]/a_860_290# WL56 SL1 VSS sky130_fd_pr__nfet_g5v0d10v5 ad=0.65 pd=3.3 as=0 ps=0 w=1 l=0.5
X774 BLP1 rr3t3r_0[57|1]/a_60_290# sky130_fd_pr_reram__reram_cell area_ox=0.0676
X775 BLZ1 rr3t3r_0[57|1]/a_460_290# sky130_fd_pr_reram__reram_cell area_ox=0.0676
X776 rr3t3r_0[57|1]/a_460_290# WL57 SL1 VSS sky130_fd_pr__nfet_g5v0d10v5 ad=0.65 pd=3.3 as=0 ps=0 w=1 l=0.5
X777 BLN1 rr3t3r_0[57|1]/a_860_290# sky130_fd_pr_reram__reram_cell area_ox=0.0676
X778 rr3t3r_0[57|1]/a_60_290# WL57 SL1 VSS sky130_fd_pr__nfet_g5v0d10v5 ad=0.65 pd=3.3 as=0 ps=0 w=1 l=0.5
X779 rr3t3r_0[57|1]/a_860_290# WL57 SL1 VSS sky130_fd_pr__nfet_g5v0d10v5 ad=0.65 pd=3.3 as=0 ps=0 w=1 l=0.5
X780 BLP1 rr3t3r_0[58|1]/a_60_290# sky130_fd_pr_reram__reram_cell area_ox=0.0676
X781 BLZ1 rr3t3r_0[58|1]/a_460_290# sky130_fd_pr_reram__reram_cell area_ox=0.0676
X782 rr3t3r_0[58|1]/a_460_290# WL58 SL1 VSS sky130_fd_pr__nfet_g5v0d10v5 ad=0.65 pd=3.3 as=0 ps=0 w=1 l=0.5
X783 BLN1 rr3t3r_0[58|1]/a_860_290# sky130_fd_pr_reram__reram_cell area_ox=0.0676
X784 rr3t3r_0[58|1]/a_60_290# WL58 SL1 VSS sky130_fd_pr__nfet_g5v0d10v5 ad=0.65 pd=3.3 as=0 ps=0 w=1 l=0.5
X785 rr3t3r_0[58|1]/a_860_290# WL58 SL1 VSS sky130_fd_pr__nfet_g5v0d10v5 ad=0.65 pd=3.3 as=0 ps=0 w=1 l=0.5
X786 BLP1 rr3t3r_0[59|1]/a_60_290# sky130_fd_pr_reram__reram_cell area_ox=0.0676
X787 BLZ1 rr3t3r_0[59|1]/a_460_290# sky130_fd_pr_reram__reram_cell area_ox=0.0676
X788 rr3t3r_0[59|1]/a_460_290# WL59 SL1 VSS sky130_fd_pr__nfet_g5v0d10v5 ad=0.65 pd=3.3 as=0 ps=0 w=1 l=0.5
X789 BLN1 rr3t3r_0[59|1]/a_860_290# sky130_fd_pr_reram__reram_cell area_ox=0.0676
X790 rr3t3r_0[59|1]/a_60_290# WL59 SL1 VSS sky130_fd_pr__nfet_g5v0d10v5 ad=0.65 pd=3.3 as=0 ps=0 w=1 l=0.5
X791 rr3t3r_0[59|1]/a_860_290# WL59 SL1 VSS sky130_fd_pr__nfet_g5v0d10v5 ad=0.65 pd=3.3 as=0 ps=0 w=1 l=0.5
X792 BLP1 rr3t3r_0[60|1]/a_60_290# sky130_fd_pr_reram__reram_cell area_ox=0.0676
X793 BLZ1 rr3t3r_0[60|1]/a_460_290# sky130_fd_pr_reram__reram_cell area_ox=0.0676
X794 rr3t3r_0[60|1]/a_460_290# WL60 SL1 VSS sky130_fd_pr__nfet_g5v0d10v5 ad=0.65 pd=3.3 as=0 ps=0 w=1 l=0.5
X795 BLN1 rr3t3r_0[60|1]/a_860_290# sky130_fd_pr_reram__reram_cell area_ox=0.0676
X796 rr3t3r_0[60|1]/a_60_290# WL60 SL1 VSS sky130_fd_pr__nfet_g5v0d10v5 ad=0.65 pd=3.3 as=0 ps=0 w=1 l=0.5
X797 rr3t3r_0[60|1]/a_860_290# WL60 SL1 VSS sky130_fd_pr__nfet_g5v0d10v5 ad=0.65 pd=3.3 as=0 ps=0 w=1 l=0.5
X798 BLP1 rr3t3r_0[61|1]/a_60_290# sky130_fd_pr_reram__reram_cell area_ox=0.0676
X799 BLZ1 rr3t3r_0[61|1]/a_460_290# sky130_fd_pr_reram__reram_cell area_ox=0.0676
X800 rr3t3r_0[61|1]/a_460_290# WL61 SL1 VSS sky130_fd_pr__nfet_g5v0d10v5 ad=0.65 pd=3.3 as=0 ps=0 w=1 l=0.5
X801 BLN1 rr3t3r_0[61|1]/a_860_290# sky130_fd_pr_reram__reram_cell area_ox=0.0676
X802 rr3t3r_0[61|1]/a_60_290# WL61 SL1 VSS sky130_fd_pr__nfet_g5v0d10v5 ad=0.65 pd=3.3 as=0 ps=0 w=1 l=0.5
X803 rr3t3r_0[61|1]/a_860_290# WL61 SL1 VSS sky130_fd_pr__nfet_g5v0d10v5 ad=0.65 pd=3.3 as=0 ps=0 w=1 l=0.5
X804 BLP1 rr3t3r_0[62|1]/a_60_290# sky130_fd_pr_reram__reram_cell area_ox=0.0676
X805 BLZ1 rr3t3r_0[62|1]/a_460_290# sky130_fd_pr_reram__reram_cell area_ox=0.0676
X806 rr3t3r_0[62|1]/a_460_290# WL62 SL1 VSS sky130_fd_pr__nfet_g5v0d10v5 ad=0.65 pd=3.3 as=0 ps=0 w=1 l=0.5
X807 BLN1 rr3t3r_0[62|1]/a_860_290# sky130_fd_pr_reram__reram_cell area_ox=0.0676
X808 rr3t3r_0[62|1]/a_60_290# WL62 SL1 VSS sky130_fd_pr__nfet_g5v0d10v5 ad=0.65 pd=3.3 as=0 ps=0 w=1 l=0.5
X809 rr3t3r_0[62|1]/a_860_290# WL62 SL1 VSS sky130_fd_pr__nfet_g5v0d10v5 ad=0.65 pd=3.3 as=0 ps=0 w=1 l=0.5
X810 BLP1 rr3t3r_0[63|1]/a_60_290# sky130_fd_pr_reram__reram_cell area_ox=0.0676
X811 BLZ1 rr3t3r_0[63|1]/a_460_290# sky130_fd_pr_reram__reram_cell area_ox=0.0676
X812 rr3t3r_0[63|1]/a_460_290# WL63 SL1 VSS sky130_fd_pr__nfet_g5v0d10v5 ad=0.65 pd=3.3 as=0 ps=0 w=1 l=0.5
X813 BLN1 rr3t3r_0[63|1]/a_860_290# sky130_fd_pr_reram__reram_cell area_ox=0.0676
X814 rr3t3r_0[63|1]/a_60_290# WL63 SL1 VSS sky130_fd_pr__nfet_g5v0d10v5 ad=0.65 pd=3.3 as=0 ps=0 w=1 l=0.5
X815 rr3t3r_0[63|1]/a_860_290# WL63 SL1 VSS sky130_fd_pr__nfet_g5v0d10v5 ad=0.65 pd=3.3 as=0 ps=0 w=1 l=0.5
X816 BLP1 rr3t3r_0[64|1]/a_60_290# sky130_fd_pr_reram__reram_cell area_ox=0.0676
X817 BLZ1 rr3t3r_0[64|1]/a_460_290# sky130_fd_pr_reram__reram_cell area_ox=0.0676
X818 rr3t3r_0[64|1]/a_460_290# WL64 SL1 VSS sky130_fd_pr__nfet_g5v0d10v5 ad=0.65 pd=3.3 as=0 ps=0 w=1 l=0.5
X819 BLN1 rr3t3r_0[64|1]/a_860_290# sky130_fd_pr_reram__reram_cell area_ox=0.0676
X820 rr3t3r_0[64|1]/a_60_290# WL64 SL1 VSS sky130_fd_pr__nfet_g5v0d10v5 ad=0.65 pd=3.3 as=0 ps=0 w=1 l=0.5
X821 rr3t3r_0[64|1]/a_860_290# WL64 SL1 VSS sky130_fd_pr__nfet_g5v0d10v5 ad=0.65 pd=3.3 as=0 ps=0 w=1 l=0.5
X822 BLP1 rr3t3r_0[65|1]/a_60_290# sky130_fd_pr_reram__reram_cell area_ox=0.0676
X823 BLZ1 rr3t3r_0[65|1]/a_460_290# sky130_fd_pr_reram__reram_cell area_ox=0.0676
X824 rr3t3r_0[65|1]/a_460_290# WL65 SL1 VSS sky130_fd_pr__nfet_g5v0d10v5 ad=0.65 pd=3.3 as=0 ps=0 w=1 l=0.5
X825 BLN1 rr3t3r_0[65|1]/a_860_290# sky130_fd_pr_reram__reram_cell area_ox=0.0676
X826 rr3t3r_0[65|1]/a_60_290# WL65 SL1 VSS sky130_fd_pr__nfet_g5v0d10v5 ad=0.65 pd=3.3 as=0 ps=0 w=1 l=0.5
X827 rr3t3r_0[65|1]/a_860_290# WL65 SL1 VSS sky130_fd_pr__nfet_g5v0d10v5 ad=0.65 pd=3.3 as=0 ps=0 w=1 l=0.5
X828 BLP1 rr3t3r_0[66|1]/a_60_290# sky130_fd_pr_reram__reram_cell area_ox=0.0676
X829 BLZ1 rr3t3r_0[66|1]/a_460_290# sky130_fd_pr_reram__reram_cell area_ox=0.0676
X830 rr3t3r_0[66|1]/a_460_290# WL66 SL1 VSS sky130_fd_pr__nfet_g5v0d10v5 ad=0.65 pd=3.3 as=0 ps=0 w=1 l=0.5
X831 BLN1 rr3t3r_0[66|1]/a_860_290# sky130_fd_pr_reram__reram_cell area_ox=0.0676
X832 rr3t3r_0[66|1]/a_60_290# WL66 SL1 VSS sky130_fd_pr__nfet_g5v0d10v5 ad=0.65 pd=3.3 as=0 ps=0 w=1 l=0.5
X833 rr3t3r_0[66|1]/a_860_290# WL66 SL1 VSS sky130_fd_pr__nfet_g5v0d10v5 ad=0.65 pd=3.3 as=0 ps=0 w=1 l=0.5
X834 BLP1 rr3t3r_0[67|1]/a_60_290# sky130_fd_pr_reram__reram_cell area_ox=0.0676
X835 BLZ1 rr3t3r_0[67|1]/a_460_290# sky130_fd_pr_reram__reram_cell area_ox=0.0676
X836 rr3t3r_0[67|1]/a_460_290# WL67 SL1 VSS sky130_fd_pr__nfet_g5v0d10v5 ad=0.65 pd=3.3 as=0 ps=0 w=1 l=0.5
X837 BLN1 rr3t3r_0[67|1]/a_860_290# sky130_fd_pr_reram__reram_cell area_ox=0.0676
X838 rr3t3r_0[67|1]/a_60_290# WL67 SL1 VSS sky130_fd_pr__nfet_g5v0d10v5 ad=0.65 pd=3.3 as=0 ps=0 w=1 l=0.5
X839 rr3t3r_0[67|1]/a_860_290# WL67 SL1 VSS sky130_fd_pr__nfet_g5v0d10v5 ad=0.65 pd=3.3 as=0 ps=0 w=1 l=0.5
X840 BLP1 rr3t3r_0[68|1]/a_60_290# sky130_fd_pr_reram__reram_cell area_ox=0.0676
X841 BLZ1 rr3t3r_0[68|1]/a_460_290# sky130_fd_pr_reram__reram_cell area_ox=0.0676
X842 rr3t3r_0[68|1]/a_460_290# WL68 SL1 VSS sky130_fd_pr__nfet_g5v0d10v5 ad=0.65 pd=3.3 as=0 ps=0 w=1 l=0.5
X843 BLN1 rr3t3r_0[68|1]/a_860_290# sky130_fd_pr_reram__reram_cell area_ox=0.0676
X844 rr3t3r_0[68|1]/a_60_290# WL68 SL1 VSS sky130_fd_pr__nfet_g5v0d10v5 ad=0.65 pd=3.3 as=0 ps=0 w=1 l=0.5
X845 rr3t3r_0[68|1]/a_860_290# WL68 SL1 VSS sky130_fd_pr__nfet_g5v0d10v5 ad=0.65 pd=3.3 as=0 ps=0 w=1 l=0.5
X846 BLP1 rr3t3r_0[69|1]/a_60_290# sky130_fd_pr_reram__reram_cell area_ox=0.0676
X847 BLZ1 rr3t3r_0[69|1]/a_460_290# sky130_fd_pr_reram__reram_cell area_ox=0.0676
X848 rr3t3r_0[69|1]/a_460_290# WL69 SL1 VSS sky130_fd_pr__nfet_g5v0d10v5 ad=0.65 pd=3.3 as=0 ps=0 w=1 l=0.5
X849 BLN1 rr3t3r_0[69|1]/a_860_290# sky130_fd_pr_reram__reram_cell area_ox=0.0676
X850 rr3t3r_0[69|1]/a_60_290# WL69 SL1 VSS sky130_fd_pr__nfet_g5v0d10v5 ad=0.65 pd=3.3 as=0 ps=0 w=1 l=0.5
X851 rr3t3r_0[69|1]/a_860_290# WL69 SL1 VSS sky130_fd_pr__nfet_g5v0d10v5 ad=0.65 pd=3.3 as=0 ps=0 w=1 l=0.5
X852 BLP1 rr3t3r_0[70|1]/a_60_290# sky130_fd_pr_reram__reram_cell area_ox=0.0676
X853 BLZ1 rr3t3r_0[70|1]/a_460_290# sky130_fd_pr_reram__reram_cell area_ox=0.0676
X854 rr3t3r_0[70|1]/a_460_290# WL70 SL1 VSS sky130_fd_pr__nfet_g5v0d10v5 ad=0.65 pd=3.3 as=0 ps=0 w=1 l=0.5
X855 BLN1 rr3t3r_0[70|1]/a_860_290# sky130_fd_pr_reram__reram_cell area_ox=0.0676
X856 rr3t3r_0[70|1]/a_60_290# WL70 SL1 VSS sky130_fd_pr__nfet_g5v0d10v5 ad=0.65 pd=3.3 as=0 ps=0 w=1 l=0.5
X857 rr3t3r_0[70|1]/a_860_290# WL70 SL1 VSS sky130_fd_pr__nfet_g5v0d10v5 ad=0.65 pd=3.3 as=0 ps=0 w=1 l=0.5
X858 BLP1 rr3t3r_0[71|1]/a_60_290# sky130_fd_pr_reram__reram_cell area_ox=0.0676
X859 BLZ1 rr3t3r_0[71|1]/a_460_290# sky130_fd_pr_reram__reram_cell area_ox=0.0676
X860 rr3t3r_0[71|1]/a_460_290# WL71 SL1 VSS sky130_fd_pr__nfet_g5v0d10v5 ad=0.65 pd=3.3 as=0 ps=0 w=1 l=0.5
X861 BLN1 rr3t3r_0[71|1]/a_860_290# sky130_fd_pr_reram__reram_cell area_ox=0.0676
X862 rr3t3r_0[71|1]/a_60_290# WL71 SL1 VSS sky130_fd_pr__nfet_g5v0d10v5 ad=0.65 pd=3.3 as=0 ps=0 w=1 l=0.5
X863 rr3t3r_0[71|1]/a_860_290# WL71 SL1 VSS sky130_fd_pr__nfet_g5v0d10v5 ad=0.65 pd=3.3 as=0 ps=0 w=1 l=0.5
X864 BLP2 rr3t3r_0[0|2]/a_60_290# sky130_fd_pr_reram__reram_cell area_ox=0.0676
X865 BLZ2 rr3t3r_0[0|2]/a_460_290# sky130_fd_pr_reram__reram_cell area_ox=0.0676
X866 rr3t3r_0[0|2]/a_460_290# WL0 SL2 VSS sky130_fd_pr__nfet_g5v0d10v5 ad=0.65 pd=3.3 as=162 ps=756 w=1 l=0.5
X867 BLN2 rr3t3r_0[0|2]/a_860_290# sky130_fd_pr_reram__reram_cell area_ox=0.0676
X868 rr3t3r_0[0|2]/a_60_290# WL0 SL2 VSS sky130_fd_pr__nfet_g5v0d10v5 ad=0.65 pd=3.3 as=0 ps=0 w=1 l=0.5
X869 rr3t3r_0[0|2]/a_860_290# WL0 SL2 VSS sky130_fd_pr__nfet_g5v0d10v5 ad=0.65 pd=3.3 as=0 ps=0 w=1 l=0.5
X870 BLP2 rr3t3r_0[1|2]/a_60_290# sky130_fd_pr_reram__reram_cell area_ox=0.0676
X871 BLZ2 rr3t3r_0[1|2]/a_460_290# sky130_fd_pr_reram__reram_cell area_ox=0.0676
X872 rr3t3r_0[1|2]/a_460_290# WL1 SL2 VSS sky130_fd_pr__nfet_g5v0d10v5 ad=0.65 pd=3.3 as=0 ps=0 w=1 l=0.5
X873 BLN2 rr3t3r_0[1|2]/a_860_290# sky130_fd_pr_reram__reram_cell area_ox=0.0676
X874 rr3t3r_0[1|2]/a_60_290# WL1 SL2 VSS sky130_fd_pr__nfet_g5v0d10v5 ad=0.65 pd=3.3 as=0 ps=0 w=1 l=0.5
X875 rr3t3r_0[1|2]/a_860_290# WL1 SL2 VSS sky130_fd_pr__nfet_g5v0d10v5 ad=0.65 pd=3.3 as=0 ps=0 w=1 l=0.5
X876 BLP2 rr3t3r_0[2|2]/a_60_290# sky130_fd_pr_reram__reram_cell area_ox=0.0676
X877 BLZ2 rr3t3r_0[2|2]/a_460_290# sky130_fd_pr_reram__reram_cell area_ox=0.0676
X878 rr3t3r_0[2|2]/a_460_290# WL2 SL2 VSS sky130_fd_pr__nfet_g5v0d10v5 ad=0.65 pd=3.3 as=0 ps=0 w=1 l=0.5
X879 BLN2 rr3t3r_0[2|2]/a_860_290# sky130_fd_pr_reram__reram_cell area_ox=0.0676
X880 rr3t3r_0[2|2]/a_60_290# WL2 SL2 VSS sky130_fd_pr__nfet_g5v0d10v5 ad=0.65 pd=3.3 as=0 ps=0 w=1 l=0.5
X881 rr3t3r_0[2|2]/a_860_290# WL2 SL2 VSS sky130_fd_pr__nfet_g5v0d10v5 ad=0.65 pd=3.3 as=0 ps=0 w=1 l=0.5
X882 BLP2 rr3t3r_0[3|2]/a_60_290# sky130_fd_pr_reram__reram_cell area_ox=0.0676
X883 BLZ2 rr3t3r_0[3|2]/a_460_290# sky130_fd_pr_reram__reram_cell area_ox=0.0676
X884 rr3t3r_0[3|2]/a_460_290# WL3 SL2 VSS sky130_fd_pr__nfet_g5v0d10v5 ad=0.65 pd=3.3 as=0 ps=0 w=1 l=0.5
X885 BLN2 rr3t3r_0[3|2]/a_860_290# sky130_fd_pr_reram__reram_cell area_ox=0.0676
X886 rr3t3r_0[3|2]/a_60_290# WL3 SL2 VSS sky130_fd_pr__nfet_g5v0d10v5 ad=0.65 pd=3.3 as=0 ps=0 w=1 l=0.5
X887 rr3t3r_0[3|2]/a_860_290# WL3 SL2 VSS sky130_fd_pr__nfet_g5v0d10v5 ad=0.65 pd=3.3 as=0 ps=0 w=1 l=0.5
X888 BLP2 rr3t3r_0[4|2]/a_60_290# sky130_fd_pr_reram__reram_cell area_ox=0.0676
X889 BLZ2 rr3t3r_0[4|2]/a_460_290# sky130_fd_pr_reram__reram_cell area_ox=0.0676
X890 rr3t3r_0[4|2]/a_460_290# WL4 SL2 VSS sky130_fd_pr__nfet_g5v0d10v5 ad=0.65 pd=3.3 as=0 ps=0 w=1 l=0.5
X891 BLN2 rr3t3r_0[4|2]/a_860_290# sky130_fd_pr_reram__reram_cell area_ox=0.0676
X892 rr3t3r_0[4|2]/a_60_290# WL4 SL2 VSS sky130_fd_pr__nfet_g5v0d10v5 ad=0.65 pd=3.3 as=0 ps=0 w=1 l=0.5
X893 rr3t3r_0[4|2]/a_860_290# WL4 SL2 VSS sky130_fd_pr__nfet_g5v0d10v5 ad=0.65 pd=3.3 as=0 ps=0 w=1 l=0.5
X894 BLP2 rr3t3r_0[5|2]/a_60_290# sky130_fd_pr_reram__reram_cell area_ox=0.0676
X895 BLZ2 rr3t3r_0[5|2]/a_460_290# sky130_fd_pr_reram__reram_cell area_ox=0.0676
X896 rr3t3r_0[5|2]/a_460_290# WL5 SL2 VSS sky130_fd_pr__nfet_g5v0d10v5 ad=0.65 pd=3.3 as=0 ps=0 w=1 l=0.5
X897 BLN2 rr3t3r_0[5|2]/a_860_290# sky130_fd_pr_reram__reram_cell area_ox=0.0676
X898 rr3t3r_0[5|2]/a_60_290# WL5 SL2 VSS sky130_fd_pr__nfet_g5v0d10v5 ad=0.65 pd=3.3 as=0 ps=0 w=1 l=0.5
X899 rr3t3r_0[5|2]/a_860_290# WL5 SL2 VSS sky130_fd_pr__nfet_g5v0d10v5 ad=0.65 pd=3.3 as=0 ps=0 w=1 l=0.5
X900 BLP2 rr3t3r_0[6|2]/a_60_290# sky130_fd_pr_reram__reram_cell area_ox=0.0676
X901 BLZ2 rr3t3r_0[6|2]/a_460_290# sky130_fd_pr_reram__reram_cell area_ox=0.0676
X902 rr3t3r_0[6|2]/a_460_290# WL6 SL2 VSS sky130_fd_pr__nfet_g5v0d10v5 ad=0.65 pd=3.3 as=0 ps=0 w=1 l=0.5
X903 BLN2 rr3t3r_0[6|2]/a_860_290# sky130_fd_pr_reram__reram_cell area_ox=0.0676
X904 rr3t3r_0[6|2]/a_60_290# WL6 SL2 VSS sky130_fd_pr__nfet_g5v0d10v5 ad=0.65 pd=3.3 as=0 ps=0 w=1 l=0.5
X905 rr3t3r_0[6|2]/a_860_290# WL6 SL2 VSS sky130_fd_pr__nfet_g5v0d10v5 ad=0.65 pd=3.3 as=0 ps=0 w=1 l=0.5
X906 BLP2 rr3t3r_0[7|2]/a_60_290# sky130_fd_pr_reram__reram_cell area_ox=0.0676
X907 BLZ2 rr3t3r_0[7|2]/a_460_290# sky130_fd_pr_reram__reram_cell area_ox=0.0676
X908 rr3t3r_0[7|2]/a_460_290# WL7 SL2 VSS sky130_fd_pr__nfet_g5v0d10v5 ad=0.65 pd=3.3 as=0 ps=0 w=1 l=0.5
X909 BLN2 rr3t3r_0[7|2]/a_860_290# sky130_fd_pr_reram__reram_cell area_ox=0.0676
X910 rr3t3r_0[7|2]/a_60_290# WL7 SL2 VSS sky130_fd_pr__nfet_g5v0d10v5 ad=0.65 pd=3.3 as=0 ps=0 w=1 l=0.5
X911 rr3t3r_0[7|2]/a_860_290# WL7 SL2 VSS sky130_fd_pr__nfet_g5v0d10v5 ad=0.65 pd=3.3 as=0 ps=0 w=1 l=0.5
X912 BLP2 rr3t3r_0[8|2]/a_60_290# sky130_fd_pr_reram__reram_cell area_ox=0.0676
X913 BLZ2 rr3t3r_0[8|2]/a_460_290# sky130_fd_pr_reram__reram_cell area_ox=0.0676
X914 rr3t3r_0[8|2]/a_460_290# WL8 SL2 VSS sky130_fd_pr__nfet_g5v0d10v5 ad=0.65 pd=3.3 as=0 ps=0 w=1 l=0.5
X915 BLN2 rr3t3r_0[8|2]/a_860_290# sky130_fd_pr_reram__reram_cell area_ox=0.0676
X916 rr3t3r_0[8|2]/a_60_290# WL8 SL2 VSS sky130_fd_pr__nfet_g5v0d10v5 ad=0.65 pd=3.3 as=0 ps=0 w=1 l=0.5
X917 rr3t3r_0[8|2]/a_860_290# WL8 SL2 VSS sky130_fd_pr__nfet_g5v0d10v5 ad=0.65 pd=3.3 as=0 ps=0 w=1 l=0.5
X918 BLP2 rr3t3r_0[9|2]/a_60_290# sky130_fd_pr_reram__reram_cell area_ox=0.0676
X919 BLZ2 rr3t3r_0[9|2]/a_460_290# sky130_fd_pr_reram__reram_cell area_ox=0.0676
X920 rr3t3r_0[9|2]/a_460_290# WL9 SL2 VSS sky130_fd_pr__nfet_g5v0d10v5 ad=0.65 pd=3.3 as=0 ps=0 w=1 l=0.5
X921 BLN2 rr3t3r_0[9|2]/a_860_290# sky130_fd_pr_reram__reram_cell area_ox=0.0676
X922 rr3t3r_0[9|2]/a_60_290# WL9 SL2 VSS sky130_fd_pr__nfet_g5v0d10v5 ad=0.65 pd=3.3 as=0 ps=0 w=1 l=0.5
X923 rr3t3r_0[9|2]/a_860_290# WL9 SL2 VSS sky130_fd_pr__nfet_g5v0d10v5 ad=0.65 pd=3.3 as=0 ps=0 w=1 l=0.5
X924 BLP2 rr3t3r_0[10|2]/a_60_290# sky130_fd_pr_reram__reram_cell area_ox=0.0676
X925 BLZ2 rr3t3r_0[10|2]/a_460_290# sky130_fd_pr_reram__reram_cell area_ox=0.0676
X926 rr3t3r_0[10|2]/a_460_290# WL10 SL2 VSS sky130_fd_pr__nfet_g5v0d10v5 ad=0.65 pd=3.3 as=0 ps=0 w=1 l=0.5
X927 BLN2 rr3t3r_0[10|2]/a_860_290# sky130_fd_pr_reram__reram_cell area_ox=0.0676
X928 rr3t3r_0[10|2]/a_60_290# WL10 SL2 VSS sky130_fd_pr__nfet_g5v0d10v5 ad=0.65 pd=3.3 as=0 ps=0 w=1 l=0.5
X929 rr3t3r_0[10|2]/a_860_290# WL10 SL2 VSS sky130_fd_pr__nfet_g5v0d10v5 ad=0.65 pd=3.3 as=0 ps=0 w=1 l=0.5
X930 BLP2 rr3t3r_0[11|2]/a_60_290# sky130_fd_pr_reram__reram_cell area_ox=0.0676
X931 BLZ2 rr3t3r_0[11|2]/a_460_290# sky130_fd_pr_reram__reram_cell area_ox=0.0676
X932 rr3t3r_0[11|2]/a_460_290# WL11 SL2 VSS sky130_fd_pr__nfet_g5v0d10v5 ad=0.65 pd=3.3 as=0 ps=0 w=1 l=0.5
X933 BLN2 rr3t3r_0[11|2]/a_860_290# sky130_fd_pr_reram__reram_cell area_ox=0.0676
X934 rr3t3r_0[11|2]/a_60_290# WL11 SL2 VSS sky130_fd_pr__nfet_g5v0d10v5 ad=0.65 pd=3.3 as=0 ps=0 w=1 l=0.5
X935 rr3t3r_0[11|2]/a_860_290# WL11 SL2 VSS sky130_fd_pr__nfet_g5v0d10v5 ad=0.65 pd=3.3 as=0 ps=0 w=1 l=0.5
X936 BLP2 rr3t3r_0[12|2]/a_60_290# sky130_fd_pr_reram__reram_cell area_ox=0.0676
X937 BLZ2 rr3t3r_0[12|2]/a_460_290# sky130_fd_pr_reram__reram_cell area_ox=0.0676
X938 rr3t3r_0[12|2]/a_460_290# WL12 SL2 VSS sky130_fd_pr__nfet_g5v0d10v5 ad=0.65 pd=3.3 as=0 ps=0 w=1 l=0.5
X939 BLN2 rr3t3r_0[12|2]/a_860_290# sky130_fd_pr_reram__reram_cell area_ox=0.0676
X940 rr3t3r_0[12|2]/a_60_290# WL12 SL2 VSS sky130_fd_pr__nfet_g5v0d10v5 ad=0.65 pd=3.3 as=0 ps=0 w=1 l=0.5
X941 rr3t3r_0[12|2]/a_860_290# WL12 SL2 VSS sky130_fd_pr__nfet_g5v0d10v5 ad=0.65 pd=3.3 as=0 ps=0 w=1 l=0.5
X942 BLP2 rr3t3r_0[13|2]/a_60_290# sky130_fd_pr_reram__reram_cell area_ox=0.0676
X943 BLZ2 rr3t3r_0[13|2]/a_460_290# sky130_fd_pr_reram__reram_cell area_ox=0.0676
X944 rr3t3r_0[13|2]/a_460_290# WL13 SL2 VSS sky130_fd_pr__nfet_g5v0d10v5 ad=0.65 pd=3.3 as=0 ps=0 w=1 l=0.5
X945 BLN2 rr3t3r_0[13|2]/a_860_290# sky130_fd_pr_reram__reram_cell area_ox=0.0676
X946 rr3t3r_0[13|2]/a_60_290# WL13 SL2 VSS sky130_fd_pr__nfet_g5v0d10v5 ad=0.65 pd=3.3 as=0 ps=0 w=1 l=0.5
X947 rr3t3r_0[13|2]/a_860_290# WL13 SL2 VSS sky130_fd_pr__nfet_g5v0d10v5 ad=0.65 pd=3.3 as=0 ps=0 w=1 l=0.5
X948 BLP2 rr3t3r_0[14|2]/a_60_290# sky130_fd_pr_reram__reram_cell area_ox=0.0676
X949 BLZ2 rr3t3r_0[14|2]/a_460_290# sky130_fd_pr_reram__reram_cell area_ox=0.0676
X950 rr3t3r_0[14|2]/a_460_290# WL14 SL2 VSS sky130_fd_pr__nfet_g5v0d10v5 ad=0.65 pd=3.3 as=0 ps=0 w=1 l=0.5
X951 BLN2 rr3t3r_0[14|2]/a_860_290# sky130_fd_pr_reram__reram_cell area_ox=0.0676
X952 rr3t3r_0[14|2]/a_60_290# WL14 SL2 VSS sky130_fd_pr__nfet_g5v0d10v5 ad=0.65 pd=3.3 as=0 ps=0 w=1 l=0.5
X953 rr3t3r_0[14|2]/a_860_290# WL14 SL2 VSS sky130_fd_pr__nfet_g5v0d10v5 ad=0.65 pd=3.3 as=0 ps=0 w=1 l=0.5
X954 BLP2 rr3t3r_0[15|2]/a_60_290# sky130_fd_pr_reram__reram_cell area_ox=0.0676
X955 BLZ2 rr3t3r_0[15|2]/a_460_290# sky130_fd_pr_reram__reram_cell area_ox=0.0676
X956 rr3t3r_0[15|2]/a_460_290# WL15 SL2 VSS sky130_fd_pr__nfet_g5v0d10v5 ad=0.65 pd=3.3 as=0 ps=0 w=1 l=0.5
X957 BLN2 rr3t3r_0[15|2]/a_860_290# sky130_fd_pr_reram__reram_cell area_ox=0.0676
X958 rr3t3r_0[15|2]/a_60_290# WL15 SL2 VSS sky130_fd_pr__nfet_g5v0d10v5 ad=0.65 pd=3.3 as=0 ps=0 w=1 l=0.5
X959 rr3t3r_0[15|2]/a_860_290# WL15 SL2 VSS sky130_fd_pr__nfet_g5v0d10v5 ad=0.65 pd=3.3 as=0 ps=0 w=1 l=0.5
X960 BLP2 rr3t3r_0[16|2]/a_60_290# sky130_fd_pr_reram__reram_cell area_ox=0.0676
X961 BLZ2 rr3t3r_0[16|2]/a_460_290# sky130_fd_pr_reram__reram_cell area_ox=0.0676
X962 rr3t3r_0[16|2]/a_460_290# WL16 SL2 VSS sky130_fd_pr__nfet_g5v0d10v5 ad=0.65 pd=3.3 as=0 ps=0 w=1 l=0.5
X963 BLN2 rr3t3r_0[16|2]/a_860_290# sky130_fd_pr_reram__reram_cell area_ox=0.0676
X964 rr3t3r_0[16|2]/a_60_290# WL16 SL2 VSS sky130_fd_pr__nfet_g5v0d10v5 ad=0.65 pd=3.3 as=0 ps=0 w=1 l=0.5
X965 rr3t3r_0[16|2]/a_860_290# WL16 SL2 VSS sky130_fd_pr__nfet_g5v0d10v5 ad=0.65 pd=3.3 as=0 ps=0 w=1 l=0.5
X966 BLP2 rr3t3r_0[17|2]/a_60_290# sky130_fd_pr_reram__reram_cell area_ox=0.0676
X967 BLZ2 rr3t3r_0[17|2]/a_460_290# sky130_fd_pr_reram__reram_cell area_ox=0.0676
X968 rr3t3r_0[17|2]/a_460_290# WL17 SL2 VSS sky130_fd_pr__nfet_g5v0d10v5 ad=0.65 pd=3.3 as=0 ps=0 w=1 l=0.5
X969 BLN2 rr3t3r_0[17|2]/a_860_290# sky130_fd_pr_reram__reram_cell area_ox=0.0676
X970 rr3t3r_0[17|2]/a_60_290# WL17 SL2 VSS sky130_fd_pr__nfet_g5v0d10v5 ad=0.65 pd=3.3 as=0 ps=0 w=1 l=0.5
X971 rr3t3r_0[17|2]/a_860_290# WL17 SL2 VSS sky130_fd_pr__nfet_g5v0d10v5 ad=0.65 pd=3.3 as=0 ps=0 w=1 l=0.5
X972 BLP2 rr3t3r_0[18|2]/a_60_290# sky130_fd_pr_reram__reram_cell area_ox=0.0676
X973 BLZ2 rr3t3r_0[18|2]/a_460_290# sky130_fd_pr_reram__reram_cell area_ox=0.0676
X974 rr3t3r_0[18|2]/a_460_290# WL18 SL2 VSS sky130_fd_pr__nfet_g5v0d10v5 ad=0.65 pd=3.3 as=0 ps=0 w=1 l=0.5
X975 BLN2 rr3t3r_0[18|2]/a_860_290# sky130_fd_pr_reram__reram_cell area_ox=0.0676
X976 rr3t3r_0[18|2]/a_60_290# WL18 SL2 VSS sky130_fd_pr__nfet_g5v0d10v5 ad=0.65 pd=3.3 as=0 ps=0 w=1 l=0.5
X977 rr3t3r_0[18|2]/a_860_290# WL18 SL2 VSS sky130_fd_pr__nfet_g5v0d10v5 ad=0.65 pd=3.3 as=0 ps=0 w=1 l=0.5
X978 BLP2 rr3t3r_0[19|2]/a_60_290# sky130_fd_pr_reram__reram_cell area_ox=0.0676
X979 BLZ2 rr3t3r_0[19|2]/a_460_290# sky130_fd_pr_reram__reram_cell area_ox=0.0676
X980 rr3t3r_0[19|2]/a_460_290# WL19 SL2 VSS sky130_fd_pr__nfet_g5v0d10v5 ad=0.65 pd=3.3 as=0 ps=0 w=1 l=0.5
X981 BLN2 rr3t3r_0[19|2]/a_860_290# sky130_fd_pr_reram__reram_cell area_ox=0.0676
X982 rr3t3r_0[19|2]/a_60_290# WL19 SL2 VSS sky130_fd_pr__nfet_g5v0d10v5 ad=0.65 pd=3.3 as=0 ps=0 w=1 l=0.5
X983 rr3t3r_0[19|2]/a_860_290# WL19 SL2 VSS sky130_fd_pr__nfet_g5v0d10v5 ad=0.65 pd=3.3 as=0 ps=0 w=1 l=0.5
X984 BLP2 rr3t3r_0[20|2]/a_60_290# sky130_fd_pr_reram__reram_cell area_ox=0.0676
X985 BLZ2 rr3t3r_0[20|2]/a_460_290# sky130_fd_pr_reram__reram_cell area_ox=0.0676
X986 rr3t3r_0[20|2]/a_460_290# WL20 SL2 VSS sky130_fd_pr__nfet_g5v0d10v5 ad=0.65 pd=3.3 as=0 ps=0 w=1 l=0.5
X987 BLN2 rr3t3r_0[20|2]/a_860_290# sky130_fd_pr_reram__reram_cell area_ox=0.0676
X988 rr3t3r_0[20|2]/a_60_290# WL20 SL2 VSS sky130_fd_pr__nfet_g5v0d10v5 ad=0.65 pd=3.3 as=0 ps=0 w=1 l=0.5
X989 rr3t3r_0[20|2]/a_860_290# WL20 SL2 VSS sky130_fd_pr__nfet_g5v0d10v5 ad=0.65 pd=3.3 as=0 ps=0 w=1 l=0.5
X990 BLP2 rr3t3r_0[21|2]/a_60_290# sky130_fd_pr_reram__reram_cell area_ox=0.0676
X991 BLZ2 rr3t3r_0[21|2]/a_460_290# sky130_fd_pr_reram__reram_cell area_ox=0.0676
X992 rr3t3r_0[21|2]/a_460_290# WL21 SL2 VSS sky130_fd_pr__nfet_g5v0d10v5 ad=0.65 pd=3.3 as=0 ps=0 w=1 l=0.5
X993 BLN2 rr3t3r_0[21|2]/a_860_290# sky130_fd_pr_reram__reram_cell area_ox=0.0676
X994 rr3t3r_0[21|2]/a_60_290# WL21 SL2 VSS sky130_fd_pr__nfet_g5v0d10v5 ad=0.65 pd=3.3 as=0 ps=0 w=1 l=0.5
X995 rr3t3r_0[21|2]/a_860_290# WL21 SL2 VSS sky130_fd_pr__nfet_g5v0d10v5 ad=0.65 pd=3.3 as=0 ps=0 w=1 l=0.5
X996 BLP2 rr3t3r_0[22|2]/a_60_290# sky130_fd_pr_reram__reram_cell area_ox=0.0676
X997 BLZ2 rr3t3r_0[22|2]/a_460_290# sky130_fd_pr_reram__reram_cell area_ox=0.0676
X998 rr3t3r_0[22|2]/a_460_290# WL22 SL2 VSS sky130_fd_pr__nfet_g5v0d10v5 ad=0.65 pd=3.3 as=0 ps=0 w=1 l=0.5
X999 BLN2 rr3t3r_0[22|2]/a_860_290# sky130_fd_pr_reram__reram_cell area_ox=0.0676
X1000 rr3t3r_0[22|2]/a_60_290# WL22 SL2 VSS sky130_fd_pr__nfet_g5v0d10v5 ad=0.65 pd=3.3 as=0 ps=0 w=1 l=0.5
X1001 rr3t3r_0[22|2]/a_860_290# WL22 SL2 VSS sky130_fd_pr__nfet_g5v0d10v5 ad=0.65 pd=3.3 as=0 ps=0 w=1 l=0.5
X1002 BLP2 rr3t3r_0[23|2]/a_60_290# sky130_fd_pr_reram__reram_cell area_ox=0.0676
X1003 BLZ2 rr3t3r_0[23|2]/a_460_290# sky130_fd_pr_reram__reram_cell area_ox=0.0676
X1004 rr3t3r_0[23|2]/a_460_290# WL23 SL2 VSS sky130_fd_pr__nfet_g5v0d10v5 ad=0.65 pd=3.3 as=0 ps=0 w=1 l=0.5
X1005 BLN2 rr3t3r_0[23|2]/a_860_290# sky130_fd_pr_reram__reram_cell area_ox=0.0676
X1006 rr3t3r_0[23|2]/a_60_290# WL23 SL2 VSS sky130_fd_pr__nfet_g5v0d10v5 ad=0.65 pd=3.3 as=0 ps=0 w=1 l=0.5
X1007 rr3t3r_0[23|2]/a_860_290# WL23 SL2 VSS sky130_fd_pr__nfet_g5v0d10v5 ad=0.65 pd=3.3 as=0 ps=0 w=1 l=0.5
X1008 BLP2 rr3t3r_0[24|2]/a_60_290# sky130_fd_pr_reram__reram_cell area_ox=0.0676
X1009 BLZ2 rr3t3r_0[24|2]/a_460_290# sky130_fd_pr_reram__reram_cell area_ox=0.0676
X1010 rr3t3r_0[24|2]/a_460_290# WL24 SL2 VSS sky130_fd_pr__nfet_g5v0d10v5 ad=0.65 pd=3.3 as=0 ps=0 w=1 l=0.5
X1011 BLN2 rr3t3r_0[24|2]/a_860_290# sky130_fd_pr_reram__reram_cell area_ox=0.0676
X1012 rr3t3r_0[24|2]/a_60_290# WL24 SL2 VSS sky130_fd_pr__nfet_g5v0d10v5 ad=0.65 pd=3.3 as=0 ps=0 w=1 l=0.5
X1013 rr3t3r_0[24|2]/a_860_290# WL24 SL2 VSS sky130_fd_pr__nfet_g5v0d10v5 ad=0.65 pd=3.3 as=0 ps=0 w=1 l=0.5
X1014 BLP2 rr3t3r_0[25|2]/a_60_290# sky130_fd_pr_reram__reram_cell area_ox=0.0676
X1015 BLZ2 rr3t3r_0[25|2]/a_460_290# sky130_fd_pr_reram__reram_cell area_ox=0.0676
X1016 rr3t3r_0[25|2]/a_460_290# WL25 SL2 VSS sky130_fd_pr__nfet_g5v0d10v5 ad=0.65 pd=3.3 as=0 ps=0 w=1 l=0.5
X1017 BLN2 rr3t3r_0[25|2]/a_860_290# sky130_fd_pr_reram__reram_cell area_ox=0.0676
X1018 rr3t3r_0[25|2]/a_60_290# WL25 SL2 VSS sky130_fd_pr__nfet_g5v0d10v5 ad=0.65 pd=3.3 as=0 ps=0 w=1 l=0.5
X1019 rr3t3r_0[25|2]/a_860_290# WL25 SL2 VSS sky130_fd_pr__nfet_g5v0d10v5 ad=0.65 pd=3.3 as=0 ps=0 w=1 l=0.5
X1020 BLP2 rr3t3r_0[26|2]/a_60_290# sky130_fd_pr_reram__reram_cell area_ox=0.0676
X1021 BLZ2 rr3t3r_0[26|2]/a_460_290# sky130_fd_pr_reram__reram_cell area_ox=0.0676
X1022 rr3t3r_0[26|2]/a_460_290# WL26 SL2 VSS sky130_fd_pr__nfet_g5v0d10v5 ad=0.65 pd=3.3 as=0 ps=0 w=1 l=0.5
X1023 BLN2 rr3t3r_0[26|2]/a_860_290# sky130_fd_pr_reram__reram_cell area_ox=0.0676
X1024 rr3t3r_0[26|2]/a_60_290# WL26 SL2 VSS sky130_fd_pr__nfet_g5v0d10v5 ad=0.65 pd=3.3 as=0 ps=0 w=1 l=0.5
X1025 rr3t3r_0[26|2]/a_860_290# WL26 SL2 VSS sky130_fd_pr__nfet_g5v0d10v5 ad=0.65 pd=3.3 as=0 ps=0 w=1 l=0.5
X1026 BLP2 rr3t3r_0[27|2]/a_60_290# sky130_fd_pr_reram__reram_cell area_ox=0.0676
X1027 BLZ2 rr3t3r_0[27|2]/a_460_290# sky130_fd_pr_reram__reram_cell area_ox=0.0676
X1028 rr3t3r_0[27|2]/a_460_290# WL27 SL2 VSS sky130_fd_pr__nfet_g5v0d10v5 ad=0.65 pd=3.3 as=0 ps=0 w=1 l=0.5
X1029 BLN2 rr3t3r_0[27|2]/a_860_290# sky130_fd_pr_reram__reram_cell area_ox=0.0676
X1030 rr3t3r_0[27|2]/a_60_290# WL27 SL2 VSS sky130_fd_pr__nfet_g5v0d10v5 ad=0.65 pd=3.3 as=0 ps=0 w=1 l=0.5
X1031 rr3t3r_0[27|2]/a_860_290# WL27 SL2 VSS sky130_fd_pr__nfet_g5v0d10v5 ad=0.65 pd=3.3 as=0 ps=0 w=1 l=0.5
X1032 BLP2 rr3t3r_0[28|2]/a_60_290# sky130_fd_pr_reram__reram_cell area_ox=0.0676
X1033 BLZ2 rr3t3r_0[28|2]/a_460_290# sky130_fd_pr_reram__reram_cell area_ox=0.0676
X1034 rr3t3r_0[28|2]/a_460_290# WL28 SL2 VSS sky130_fd_pr__nfet_g5v0d10v5 ad=0.65 pd=3.3 as=0 ps=0 w=1 l=0.5
X1035 BLN2 rr3t3r_0[28|2]/a_860_290# sky130_fd_pr_reram__reram_cell area_ox=0.0676
X1036 rr3t3r_0[28|2]/a_60_290# WL28 SL2 VSS sky130_fd_pr__nfet_g5v0d10v5 ad=0.65 pd=3.3 as=0 ps=0 w=1 l=0.5
X1037 rr3t3r_0[28|2]/a_860_290# WL28 SL2 VSS sky130_fd_pr__nfet_g5v0d10v5 ad=0.65 pd=3.3 as=0 ps=0 w=1 l=0.5
X1038 BLP2 rr3t3r_0[29|2]/a_60_290# sky130_fd_pr_reram__reram_cell area_ox=0.0676
X1039 BLZ2 rr3t3r_0[29|2]/a_460_290# sky130_fd_pr_reram__reram_cell area_ox=0.0676
X1040 rr3t3r_0[29|2]/a_460_290# WL29 SL2 VSS sky130_fd_pr__nfet_g5v0d10v5 ad=0.65 pd=3.3 as=0 ps=0 w=1 l=0.5
X1041 BLN2 rr3t3r_0[29|2]/a_860_290# sky130_fd_pr_reram__reram_cell area_ox=0.0676
X1042 rr3t3r_0[29|2]/a_60_290# WL29 SL2 VSS sky130_fd_pr__nfet_g5v0d10v5 ad=0.65 pd=3.3 as=0 ps=0 w=1 l=0.5
X1043 rr3t3r_0[29|2]/a_860_290# WL29 SL2 VSS sky130_fd_pr__nfet_g5v0d10v5 ad=0.65 pd=3.3 as=0 ps=0 w=1 l=0.5
X1044 BLP2 rr3t3r_0[30|2]/a_60_290# sky130_fd_pr_reram__reram_cell area_ox=0.0676
X1045 BLZ2 rr3t3r_0[30|2]/a_460_290# sky130_fd_pr_reram__reram_cell area_ox=0.0676
X1046 rr3t3r_0[30|2]/a_460_290# WL30 SL2 VSS sky130_fd_pr__nfet_g5v0d10v5 ad=0.65 pd=3.3 as=0 ps=0 w=1 l=0.5
X1047 BLN2 rr3t3r_0[30|2]/a_860_290# sky130_fd_pr_reram__reram_cell area_ox=0.0676
X1048 rr3t3r_0[30|2]/a_60_290# WL30 SL2 VSS sky130_fd_pr__nfet_g5v0d10v5 ad=0.65 pd=3.3 as=0 ps=0 w=1 l=0.5
X1049 rr3t3r_0[30|2]/a_860_290# WL30 SL2 VSS sky130_fd_pr__nfet_g5v0d10v5 ad=0.65 pd=3.3 as=0 ps=0 w=1 l=0.5
X1050 BLP2 rr3t3r_0[31|2]/a_60_290# sky130_fd_pr_reram__reram_cell area_ox=0.0676
X1051 BLZ2 rr3t3r_0[31|2]/a_460_290# sky130_fd_pr_reram__reram_cell area_ox=0.0676
X1052 rr3t3r_0[31|2]/a_460_290# WL31 SL2 VSS sky130_fd_pr__nfet_g5v0d10v5 ad=0.65 pd=3.3 as=0 ps=0 w=1 l=0.5
X1053 BLN2 rr3t3r_0[31|2]/a_860_290# sky130_fd_pr_reram__reram_cell area_ox=0.0676
X1054 rr3t3r_0[31|2]/a_60_290# WL31 SL2 VSS sky130_fd_pr__nfet_g5v0d10v5 ad=0.65 pd=3.3 as=0 ps=0 w=1 l=0.5
X1055 rr3t3r_0[31|2]/a_860_290# WL31 SL2 VSS sky130_fd_pr__nfet_g5v0d10v5 ad=0.65 pd=3.3 as=0 ps=0 w=1 l=0.5
X1056 BLP2 rr3t3r_0[32|2]/a_60_290# sky130_fd_pr_reram__reram_cell area_ox=0.0676
X1057 BLZ2 rr3t3r_0[32|2]/a_460_290# sky130_fd_pr_reram__reram_cell area_ox=0.0676
X1058 rr3t3r_0[32|2]/a_460_290# WL32 SL2 VSS sky130_fd_pr__nfet_g5v0d10v5 ad=0.65 pd=3.3 as=0 ps=0 w=1 l=0.5
X1059 BLN2 rr3t3r_0[32|2]/a_860_290# sky130_fd_pr_reram__reram_cell area_ox=0.0676
X1060 rr3t3r_0[32|2]/a_60_290# WL32 SL2 VSS sky130_fd_pr__nfet_g5v0d10v5 ad=0.65 pd=3.3 as=0 ps=0 w=1 l=0.5
X1061 rr3t3r_0[32|2]/a_860_290# WL32 SL2 VSS sky130_fd_pr__nfet_g5v0d10v5 ad=0.65 pd=3.3 as=0 ps=0 w=1 l=0.5
X1062 BLP2 rr3t3r_0[33|2]/a_60_290# sky130_fd_pr_reram__reram_cell area_ox=0.0676
X1063 BLZ2 rr3t3r_0[33|2]/a_460_290# sky130_fd_pr_reram__reram_cell area_ox=0.0676
X1064 rr3t3r_0[33|2]/a_460_290# WL33 SL2 VSS sky130_fd_pr__nfet_g5v0d10v5 ad=0.65 pd=3.3 as=0 ps=0 w=1 l=0.5
X1065 BLN2 rr3t3r_0[33|2]/a_860_290# sky130_fd_pr_reram__reram_cell area_ox=0.0676
X1066 rr3t3r_0[33|2]/a_60_290# WL33 SL2 VSS sky130_fd_pr__nfet_g5v0d10v5 ad=0.65 pd=3.3 as=0 ps=0 w=1 l=0.5
X1067 rr3t3r_0[33|2]/a_860_290# WL33 SL2 VSS sky130_fd_pr__nfet_g5v0d10v5 ad=0.65 pd=3.3 as=0 ps=0 w=1 l=0.5
X1068 BLP2 rr3t3r_0[34|2]/a_60_290# sky130_fd_pr_reram__reram_cell area_ox=0.0676
X1069 BLZ2 rr3t3r_0[34|2]/a_460_290# sky130_fd_pr_reram__reram_cell area_ox=0.0676
X1070 rr3t3r_0[34|2]/a_460_290# WL34 SL2 VSS sky130_fd_pr__nfet_g5v0d10v5 ad=0.65 pd=3.3 as=0 ps=0 w=1 l=0.5
X1071 BLN2 rr3t3r_0[34|2]/a_860_290# sky130_fd_pr_reram__reram_cell area_ox=0.0676
X1072 rr3t3r_0[34|2]/a_60_290# WL34 SL2 VSS sky130_fd_pr__nfet_g5v0d10v5 ad=0.65 pd=3.3 as=0 ps=0 w=1 l=0.5
X1073 rr3t3r_0[34|2]/a_860_290# WL34 SL2 VSS sky130_fd_pr__nfet_g5v0d10v5 ad=0.65 pd=3.3 as=0 ps=0 w=1 l=0.5
X1074 BLP2 rr3t3r_0[35|2]/a_60_290# sky130_fd_pr_reram__reram_cell area_ox=0.0676
X1075 BLZ2 rr3t3r_0[35|2]/a_460_290# sky130_fd_pr_reram__reram_cell area_ox=0.0676
X1076 rr3t3r_0[35|2]/a_460_290# WL35 SL2 VSS sky130_fd_pr__nfet_g5v0d10v5 ad=0.65 pd=3.3 as=0 ps=0 w=1 l=0.5
X1077 BLN2 rr3t3r_0[35|2]/a_860_290# sky130_fd_pr_reram__reram_cell area_ox=0.0676
X1078 rr3t3r_0[35|2]/a_60_290# WL35 SL2 VSS sky130_fd_pr__nfet_g5v0d10v5 ad=0.65 pd=3.3 as=0 ps=0 w=1 l=0.5
X1079 rr3t3r_0[35|2]/a_860_290# WL35 SL2 VSS sky130_fd_pr__nfet_g5v0d10v5 ad=0.65 pd=3.3 as=0 ps=0 w=1 l=0.5
X1080 BLP2 rr3t3r_0[36|2]/a_60_290# sky130_fd_pr_reram__reram_cell area_ox=0.0676
X1081 BLZ2 rr3t3r_0[36|2]/a_460_290# sky130_fd_pr_reram__reram_cell area_ox=0.0676
X1082 rr3t3r_0[36|2]/a_460_290# WL36 SL2 VSS sky130_fd_pr__nfet_g5v0d10v5 ad=0.65 pd=3.3 as=0 ps=0 w=1 l=0.5
X1083 BLN2 rr3t3r_0[36|2]/a_860_290# sky130_fd_pr_reram__reram_cell area_ox=0.0676
X1084 rr3t3r_0[36|2]/a_60_290# WL36 SL2 VSS sky130_fd_pr__nfet_g5v0d10v5 ad=0.65 pd=3.3 as=0 ps=0 w=1 l=0.5
X1085 rr3t3r_0[36|2]/a_860_290# WL36 SL2 VSS sky130_fd_pr__nfet_g5v0d10v5 ad=0.65 pd=3.3 as=0 ps=0 w=1 l=0.5
X1086 BLP2 rr3t3r_0[37|2]/a_60_290# sky130_fd_pr_reram__reram_cell area_ox=0.0676
X1087 BLZ2 rr3t3r_0[37|2]/a_460_290# sky130_fd_pr_reram__reram_cell area_ox=0.0676
X1088 rr3t3r_0[37|2]/a_460_290# WL37 SL2 VSS sky130_fd_pr__nfet_g5v0d10v5 ad=0.65 pd=3.3 as=0 ps=0 w=1 l=0.5
X1089 BLN2 rr3t3r_0[37|2]/a_860_290# sky130_fd_pr_reram__reram_cell area_ox=0.0676
X1090 rr3t3r_0[37|2]/a_60_290# WL37 SL2 VSS sky130_fd_pr__nfet_g5v0d10v5 ad=0.65 pd=3.3 as=0 ps=0 w=1 l=0.5
X1091 rr3t3r_0[37|2]/a_860_290# WL37 SL2 VSS sky130_fd_pr__nfet_g5v0d10v5 ad=0.65 pd=3.3 as=0 ps=0 w=1 l=0.5
X1092 BLP2 rr3t3r_0[38|2]/a_60_290# sky130_fd_pr_reram__reram_cell area_ox=0.0676
X1093 BLZ2 rr3t3r_0[38|2]/a_460_290# sky130_fd_pr_reram__reram_cell area_ox=0.0676
X1094 rr3t3r_0[38|2]/a_460_290# WL38 SL2 VSS sky130_fd_pr__nfet_g5v0d10v5 ad=0.65 pd=3.3 as=0 ps=0 w=1 l=0.5
X1095 BLN2 rr3t3r_0[38|2]/a_860_290# sky130_fd_pr_reram__reram_cell area_ox=0.0676
X1096 rr3t3r_0[38|2]/a_60_290# WL38 SL2 VSS sky130_fd_pr__nfet_g5v0d10v5 ad=0.65 pd=3.3 as=0 ps=0 w=1 l=0.5
X1097 rr3t3r_0[38|2]/a_860_290# WL38 SL2 VSS sky130_fd_pr__nfet_g5v0d10v5 ad=0.65 pd=3.3 as=0 ps=0 w=1 l=0.5
X1098 BLP2 rr3t3r_0[39|2]/a_60_290# sky130_fd_pr_reram__reram_cell area_ox=0.0676
X1099 BLZ2 rr3t3r_0[39|2]/a_460_290# sky130_fd_pr_reram__reram_cell area_ox=0.0676
X1100 rr3t3r_0[39|2]/a_460_290# WL39 SL2 VSS sky130_fd_pr__nfet_g5v0d10v5 ad=0.65 pd=3.3 as=0 ps=0 w=1 l=0.5
X1101 BLN2 rr3t3r_0[39|2]/a_860_290# sky130_fd_pr_reram__reram_cell area_ox=0.0676
X1102 rr3t3r_0[39|2]/a_60_290# WL39 SL2 VSS sky130_fd_pr__nfet_g5v0d10v5 ad=0.65 pd=3.3 as=0 ps=0 w=1 l=0.5
X1103 rr3t3r_0[39|2]/a_860_290# WL39 SL2 VSS sky130_fd_pr__nfet_g5v0d10v5 ad=0.65 pd=3.3 as=0 ps=0 w=1 l=0.5
X1104 BLP2 rr3t3r_0[40|2]/a_60_290# sky130_fd_pr_reram__reram_cell area_ox=0.0676
X1105 BLZ2 rr3t3r_0[40|2]/a_460_290# sky130_fd_pr_reram__reram_cell area_ox=0.0676
X1106 rr3t3r_0[40|2]/a_460_290# WL40 SL2 VSS sky130_fd_pr__nfet_g5v0d10v5 ad=0.65 pd=3.3 as=0 ps=0 w=1 l=0.5
X1107 BLN2 rr3t3r_0[40|2]/a_860_290# sky130_fd_pr_reram__reram_cell area_ox=0.0676
X1108 rr3t3r_0[40|2]/a_60_290# WL40 SL2 VSS sky130_fd_pr__nfet_g5v0d10v5 ad=0.65 pd=3.3 as=0 ps=0 w=1 l=0.5
X1109 rr3t3r_0[40|2]/a_860_290# WL40 SL2 VSS sky130_fd_pr__nfet_g5v0d10v5 ad=0.65 pd=3.3 as=0 ps=0 w=1 l=0.5
X1110 BLP2 rr3t3r_0[41|2]/a_60_290# sky130_fd_pr_reram__reram_cell area_ox=0.0676
X1111 BLZ2 rr3t3r_0[41|2]/a_460_290# sky130_fd_pr_reram__reram_cell area_ox=0.0676
X1112 rr3t3r_0[41|2]/a_460_290# WL41 SL2 VSS sky130_fd_pr__nfet_g5v0d10v5 ad=0.65 pd=3.3 as=0 ps=0 w=1 l=0.5
X1113 BLN2 rr3t3r_0[41|2]/a_860_290# sky130_fd_pr_reram__reram_cell area_ox=0.0676
X1114 rr3t3r_0[41|2]/a_60_290# WL41 SL2 VSS sky130_fd_pr__nfet_g5v0d10v5 ad=0.65 pd=3.3 as=0 ps=0 w=1 l=0.5
X1115 rr3t3r_0[41|2]/a_860_290# WL41 SL2 VSS sky130_fd_pr__nfet_g5v0d10v5 ad=0.65 pd=3.3 as=0 ps=0 w=1 l=0.5
X1116 BLP2 rr3t3r_0[42|2]/a_60_290# sky130_fd_pr_reram__reram_cell area_ox=0.0676
X1117 BLZ2 rr3t3r_0[42|2]/a_460_290# sky130_fd_pr_reram__reram_cell area_ox=0.0676
X1118 rr3t3r_0[42|2]/a_460_290# WL42 SL2 VSS sky130_fd_pr__nfet_g5v0d10v5 ad=0.65 pd=3.3 as=0 ps=0 w=1 l=0.5
X1119 BLN2 rr3t3r_0[42|2]/a_860_290# sky130_fd_pr_reram__reram_cell area_ox=0.0676
X1120 rr3t3r_0[42|2]/a_60_290# WL42 SL2 VSS sky130_fd_pr__nfet_g5v0d10v5 ad=0.65 pd=3.3 as=0 ps=0 w=1 l=0.5
X1121 rr3t3r_0[42|2]/a_860_290# WL42 SL2 VSS sky130_fd_pr__nfet_g5v0d10v5 ad=0.65 pd=3.3 as=0 ps=0 w=1 l=0.5
X1122 BLP2 rr3t3r_0[43|2]/a_60_290# sky130_fd_pr_reram__reram_cell area_ox=0.0676
X1123 BLZ2 rr3t3r_0[43|2]/a_460_290# sky130_fd_pr_reram__reram_cell area_ox=0.0676
X1124 rr3t3r_0[43|2]/a_460_290# WL43 SL2 VSS sky130_fd_pr__nfet_g5v0d10v5 ad=0.65 pd=3.3 as=0 ps=0 w=1 l=0.5
X1125 BLN2 rr3t3r_0[43|2]/a_860_290# sky130_fd_pr_reram__reram_cell area_ox=0.0676
X1126 rr3t3r_0[43|2]/a_60_290# WL43 SL2 VSS sky130_fd_pr__nfet_g5v0d10v5 ad=0.65 pd=3.3 as=0 ps=0 w=1 l=0.5
X1127 rr3t3r_0[43|2]/a_860_290# WL43 SL2 VSS sky130_fd_pr__nfet_g5v0d10v5 ad=0.65 pd=3.3 as=0 ps=0 w=1 l=0.5
X1128 BLP2 rr3t3r_0[44|2]/a_60_290# sky130_fd_pr_reram__reram_cell area_ox=0.0676
X1129 BLZ2 rr3t3r_0[44|2]/a_460_290# sky130_fd_pr_reram__reram_cell area_ox=0.0676
X1130 rr3t3r_0[44|2]/a_460_290# WL44 SL2 VSS sky130_fd_pr__nfet_g5v0d10v5 ad=0.65 pd=3.3 as=0 ps=0 w=1 l=0.5
X1131 BLN2 rr3t3r_0[44|2]/a_860_290# sky130_fd_pr_reram__reram_cell area_ox=0.0676
X1132 rr3t3r_0[44|2]/a_60_290# WL44 SL2 VSS sky130_fd_pr__nfet_g5v0d10v5 ad=0.65 pd=3.3 as=0 ps=0 w=1 l=0.5
X1133 rr3t3r_0[44|2]/a_860_290# WL44 SL2 VSS sky130_fd_pr__nfet_g5v0d10v5 ad=0.65 pd=3.3 as=0 ps=0 w=1 l=0.5
X1134 BLP2 rr3t3r_0[45|2]/a_60_290# sky130_fd_pr_reram__reram_cell area_ox=0.0676
X1135 BLZ2 rr3t3r_0[45|2]/a_460_290# sky130_fd_pr_reram__reram_cell area_ox=0.0676
X1136 rr3t3r_0[45|2]/a_460_290# WL45 SL2 VSS sky130_fd_pr__nfet_g5v0d10v5 ad=0.65 pd=3.3 as=0 ps=0 w=1 l=0.5
X1137 BLN2 rr3t3r_0[45|2]/a_860_290# sky130_fd_pr_reram__reram_cell area_ox=0.0676
X1138 rr3t3r_0[45|2]/a_60_290# WL45 SL2 VSS sky130_fd_pr__nfet_g5v0d10v5 ad=0.65 pd=3.3 as=0 ps=0 w=1 l=0.5
X1139 rr3t3r_0[45|2]/a_860_290# WL45 SL2 VSS sky130_fd_pr__nfet_g5v0d10v5 ad=0.65 pd=3.3 as=0 ps=0 w=1 l=0.5
X1140 BLP2 rr3t3r_0[46|2]/a_60_290# sky130_fd_pr_reram__reram_cell area_ox=0.0676
X1141 BLZ2 rr3t3r_0[46|2]/a_460_290# sky130_fd_pr_reram__reram_cell area_ox=0.0676
X1142 rr3t3r_0[46|2]/a_460_290# WL46 SL2 VSS sky130_fd_pr__nfet_g5v0d10v5 ad=0.65 pd=3.3 as=0 ps=0 w=1 l=0.5
X1143 BLN2 rr3t3r_0[46|2]/a_860_290# sky130_fd_pr_reram__reram_cell area_ox=0.0676
X1144 rr3t3r_0[46|2]/a_60_290# WL46 SL2 VSS sky130_fd_pr__nfet_g5v0d10v5 ad=0.65 pd=3.3 as=0 ps=0 w=1 l=0.5
X1145 rr3t3r_0[46|2]/a_860_290# WL46 SL2 VSS sky130_fd_pr__nfet_g5v0d10v5 ad=0.65 pd=3.3 as=0 ps=0 w=1 l=0.5
X1146 BLP2 rr3t3r_0[47|2]/a_60_290# sky130_fd_pr_reram__reram_cell area_ox=0.0676
X1147 BLZ2 rr3t3r_0[47|2]/a_460_290# sky130_fd_pr_reram__reram_cell area_ox=0.0676
X1148 rr3t3r_0[47|2]/a_460_290# WL47 SL2 VSS sky130_fd_pr__nfet_g5v0d10v5 ad=0.65 pd=3.3 as=0 ps=0 w=1 l=0.5
X1149 BLN2 rr3t3r_0[47|2]/a_860_290# sky130_fd_pr_reram__reram_cell area_ox=0.0676
X1150 rr3t3r_0[47|2]/a_60_290# WL47 SL2 VSS sky130_fd_pr__nfet_g5v0d10v5 ad=0.65 pd=3.3 as=0 ps=0 w=1 l=0.5
X1151 rr3t3r_0[47|2]/a_860_290# WL47 SL2 VSS sky130_fd_pr__nfet_g5v0d10v5 ad=0.65 pd=3.3 as=0 ps=0 w=1 l=0.5
X1152 BLP2 rr3t3r_0[48|2]/a_60_290# sky130_fd_pr_reram__reram_cell area_ox=0.0676
X1153 BLZ2 rr3t3r_0[48|2]/a_460_290# sky130_fd_pr_reram__reram_cell area_ox=0.0676
X1154 rr3t3r_0[48|2]/a_460_290# WL48 SL2 VSS sky130_fd_pr__nfet_g5v0d10v5 ad=0.65 pd=3.3 as=0 ps=0 w=1 l=0.5
X1155 BLN2 rr3t3r_0[48|2]/a_860_290# sky130_fd_pr_reram__reram_cell area_ox=0.0676
X1156 rr3t3r_0[48|2]/a_60_290# WL48 SL2 VSS sky130_fd_pr__nfet_g5v0d10v5 ad=0.65 pd=3.3 as=0 ps=0 w=1 l=0.5
X1157 rr3t3r_0[48|2]/a_860_290# WL48 SL2 VSS sky130_fd_pr__nfet_g5v0d10v5 ad=0.65 pd=3.3 as=0 ps=0 w=1 l=0.5
X1158 BLP2 rr3t3r_0[49|2]/a_60_290# sky130_fd_pr_reram__reram_cell area_ox=0.0676
X1159 BLZ2 rr3t3r_0[49|2]/a_460_290# sky130_fd_pr_reram__reram_cell area_ox=0.0676
X1160 rr3t3r_0[49|2]/a_460_290# WL49 SL2 VSS sky130_fd_pr__nfet_g5v0d10v5 ad=0.65 pd=3.3 as=0 ps=0 w=1 l=0.5
X1161 BLN2 rr3t3r_0[49|2]/a_860_290# sky130_fd_pr_reram__reram_cell area_ox=0.0676
X1162 rr3t3r_0[49|2]/a_60_290# WL49 SL2 VSS sky130_fd_pr__nfet_g5v0d10v5 ad=0.65 pd=3.3 as=0 ps=0 w=1 l=0.5
X1163 rr3t3r_0[49|2]/a_860_290# WL49 SL2 VSS sky130_fd_pr__nfet_g5v0d10v5 ad=0.65 pd=3.3 as=0 ps=0 w=1 l=0.5
X1164 BLP2 rr3t3r_0[50|2]/a_60_290# sky130_fd_pr_reram__reram_cell area_ox=0.0676
X1165 BLZ2 rr3t3r_0[50|2]/a_460_290# sky130_fd_pr_reram__reram_cell area_ox=0.0676
X1166 rr3t3r_0[50|2]/a_460_290# WL50 SL2 VSS sky130_fd_pr__nfet_g5v0d10v5 ad=0.65 pd=3.3 as=0 ps=0 w=1 l=0.5
X1167 BLN2 rr3t3r_0[50|2]/a_860_290# sky130_fd_pr_reram__reram_cell area_ox=0.0676
X1168 rr3t3r_0[50|2]/a_60_290# WL50 SL2 VSS sky130_fd_pr__nfet_g5v0d10v5 ad=0.65 pd=3.3 as=0 ps=0 w=1 l=0.5
X1169 rr3t3r_0[50|2]/a_860_290# WL50 SL2 VSS sky130_fd_pr__nfet_g5v0d10v5 ad=0.65 pd=3.3 as=0 ps=0 w=1 l=0.5
X1170 BLP2 rr3t3r_0[51|2]/a_60_290# sky130_fd_pr_reram__reram_cell area_ox=0.0676
X1171 BLZ2 rr3t3r_0[51|2]/a_460_290# sky130_fd_pr_reram__reram_cell area_ox=0.0676
X1172 rr3t3r_0[51|2]/a_460_290# WL51 SL2 VSS sky130_fd_pr__nfet_g5v0d10v5 ad=0.65 pd=3.3 as=0 ps=0 w=1 l=0.5
X1173 BLN2 rr3t3r_0[51|2]/a_860_290# sky130_fd_pr_reram__reram_cell area_ox=0.0676
X1174 rr3t3r_0[51|2]/a_60_290# WL51 SL2 VSS sky130_fd_pr__nfet_g5v0d10v5 ad=0.65 pd=3.3 as=0 ps=0 w=1 l=0.5
X1175 rr3t3r_0[51|2]/a_860_290# WL51 SL2 VSS sky130_fd_pr__nfet_g5v0d10v5 ad=0.65 pd=3.3 as=0 ps=0 w=1 l=0.5
X1176 BLP2 rr3t3r_0[52|2]/a_60_290# sky130_fd_pr_reram__reram_cell area_ox=0.0676
X1177 BLZ2 rr3t3r_0[52|2]/a_460_290# sky130_fd_pr_reram__reram_cell area_ox=0.0676
X1178 rr3t3r_0[52|2]/a_460_290# WL52 SL2 VSS sky130_fd_pr__nfet_g5v0d10v5 ad=0.65 pd=3.3 as=0 ps=0 w=1 l=0.5
X1179 BLN2 rr3t3r_0[52|2]/a_860_290# sky130_fd_pr_reram__reram_cell area_ox=0.0676
X1180 rr3t3r_0[52|2]/a_60_290# WL52 SL2 VSS sky130_fd_pr__nfet_g5v0d10v5 ad=0.65 pd=3.3 as=0 ps=0 w=1 l=0.5
X1181 rr3t3r_0[52|2]/a_860_290# WL52 SL2 VSS sky130_fd_pr__nfet_g5v0d10v5 ad=0.65 pd=3.3 as=0 ps=0 w=1 l=0.5
X1182 BLP2 rr3t3r_0[53|2]/a_60_290# sky130_fd_pr_reram__reram_cell area_ox=0.0676
X1183 BLZ2 rr3t3r_0[53|2]/a_460_290# sky130_fd_pr_reram__reram_cell area_ox=0.0676
X1184 rr3t3r_0[53|2]/a_460_290# WL53 SL2 VSS sky130_fd_pr__nfet_g5v0d10v5 ad=0.65 pd=3.3 as=0 ps=0 w=1 l=0.5
X1185 BLN2 rr3t3r_0[53|2]/a_860_290# sky130_fd_pr_reram__reram_cell area_ox=0.0676
X1186 rr3t3r_0[53|2]/a_60_290# WL53 SL2 VSS sky130_fd_pr__nfet_g5v0d10v5 ad=0.65 pd=3.3 as=0 ps=0 w=1 l=0.5
X1187 rr3t3r_0[53|2]/a_860_290# WL53 SL2 VSS sky130_fd_pr__nfet_g5v0d10v5 ad=0.65 pd=3.3 as=0 ps=0 w=1 l=0.5
X1188 BLP2 rr3t3r_0[54|2]/a_60_290# sky130_fd_pr_reram__reram_cell area_ox=0.0676
X1189 BLZ2 rr3t3r_0[54|2]/a_460_290# sky130_fd_pr_reram__reram_cell area_ox=0.0676
X1190 rr3t3r_0[54|2]/a_460_290# WL54 SL2 VSS sky130_fd_pr__nfet_g5v0d10v5 ad=0.65 pd=3.3 as=0 ps=0 w=1 l=0.5
X1191 BLN2 rr3t3r_0[54|2]/a_860_290# sky130_fd_pr_reram__reram_cell area_ox=0.0676
X1192 rr3t3r_0[54|2]/a_60_290# WL54 SL2 VSS sky130_fd_pr__nfet_g5v0d10v5 ad=0.65 pd=3.3 as=0 ps=0 w=1 l=0.5
X1193 rr3t3r_0[54|2]/a_860_290# WL54 SL2 VSS sky130_fd_pr__nfet_g5v0d10v5 ad=0.65 pd=3.3 as=0 ps=0 w=1 l=0.5
X1194 BLP2 rr3t3r_0[55|2]/a_60_290# sky130_fd_pr_reram__reram_cell area_ox=0.0676
X1195 BLZ2 rr3t3r_0[55|2]/a_460_290# sky130_fd_pr_reram__reram_cell area_ox=0.0676
X1196 rr3t3r_0[55|2]/a_460_290# WL55 SL2 VSS sky130_fd_pr__nfet_g5v0d10v5 ad=0.65 pd=3.3 as=0 ps=0 w=1 l=0.5
X1197 BLN2 rr3t3r_0[55|2]/a_860_290# sky130_fd_pr_reram__reram_cell area_ox=0.0676
X1198 rr3t3r_0[55|2]/a_60_290# WL55 SL2 VSS sky130_fd_pr__nfet_g5v0d10v5 ad=0.65 pd=3.3 as=0 ps=0 w=1 l=0.5
X1199 rr3t3r_0[55|2]/a_860_290# WL55 SL2 VSS sky130_fd_pr__nfet_g5v0d10v5 ad=0.65 pd=3.3 as=0 ps=0 w=1 l=0.5
X1200 BLP2 rr3t3r_0[56|2]/a_60_290# sky130_fd_pr_reram__reram_cell area_ox=0.0676
X1201 BLZ2 rr3t3r_0[56|2]/a_460_290# sky130_fd_pr_reram__reram_cell area_ox=0.0676
X1202 rr3t3r_0[56|2]/a_460_290# WL56 SL2 VSS sky130_fd_pr__nfet_g5v0d10v5 ad=0.65 pd=3.3 as=0 ps=0 w=1 l=0.5
X1203 BLN2 rr3t3r_0[56|2]/a_860_290# sky130_fd_pr_reram__reram_cell area_ox=0.0676
X1204 rr3t3r_0[56|2]/a_60_290# WL56 SL2 VSS sky130_fd_pr__nfet_g5v0d10v5 ad=0.65 pd=3.3 as=0 ps=0 w=1 l=0.5
X1205 rr3t3r_0[56|2]/a_860_290# WL56 SL2 VSS sky130_fd_pr__nfet_g5v0d10v5 ad=0.65 pd=3.3 as=0 ps=0 w=1 l=0.5
X1206 BLP2 rr3t3r_0[57|2]/a_60_290# sky130_fd_pr_reram__reram_cell area_ox=0.0676
X1207 BLZ2 rr3t3r_0[57|2]/a_460_290# sky130_fd_pr_reram__reram_cell area_ox=0.0676
X1208 rr3t3r_0[57|2]/a_460_290# WL57 SL2 VSS sky130_fd_pr__nfet_g5v0d10v5 ad=0.65 pd=3.3 as=0 ps=0 w=1 l=0.5
X1209 BLN2 rr3t3r_0[57|2]/a_860_290# sky130_fd_pr_reram__reram_cell area_ox=0.0676
X1210 rr3t3r_0[57|2]/a_60_290# WL57 SL2 VSS sky130_fd_pr__nfet_g5v0d10v5 ad=0.65 pd=3.3 as=0 ps=0 w=1 l=0.5
X1211 rr3t3r_0[57|2]/a_860_290# WL57 SL2 VSS sky130_fd_pr__nfet_g5v0d10v5 ad=0.65 pd=3.3 as=0 ps=0 w=1 l=0.5
X1212 BLP2 rr3t3r_0[58|2]/a_60_290# sky130_fd_pr_reram__reram_cell area_ox=0.0676
X1213 BLZ2 rr3t3r_0[58|2]/a_460_290# sky130_fd_pr_reram__reram_cell area_ox=0.0676
X1214 rr3t3r_0[58|2]/a_460_290# WL58 SL2 VSS sky130_fd_pr__nfet_g5v0d10v5 ad=0.65 pd=3.3 as=0 ps=0 w=1 l=0.5
X1215 BLN2 rr3t3r_0[58|2]/a_860_290# sky130_fd_pr_reram__reram_cell area_ox=0.0676
X1216 rr3t3r_0[58|2]/a_60_290# WL58 SL2 VSS sky130_fd_pr__nfet_g5v0d10v5 ad=0.65 pd=3.3 as=0 ps=0 w=1 l=0.5
X1217 rr3t3r_0[58|2]/a_860_290# WL58 SL2 VSS sky130_fd_pr__nfet_g5v0d10v5 ad=0.65 pd=3.3 as=0 ps=0 w=1 l=0.5
X1218 BLP2 rr3t3r_0[59|2]/a_60_290# sky130_fd_pr_reram__reram_cell area_ox=0.0676
X1219 BLZ2 rr3t3r_0[59|2]/a_460_290# sky130_fd_pr_reram__reram_cell area_ox=0.0676
X1220 rr3t3r_0[59|2]/a_460_290# WL59 SL2 VSS sky130_fd_pr__nfet_g5v0d10v5 ad=0.65 pd=3.3 as=0 ps=0 w=1 l=0.5
X1221 BLN2 rr3t3r_0[59|2]/a_860_290# sky130_fd_pr_reram__reram_cell area_ox=0.0676
X1222 rr3t3r_0[59|2]/a_60_290# WL59 SL2 VSS sky130_fd_pr__nfet_g5v0d10v5 ad=0.65 pd=3.3 as=0 ps=0 w=1 l=0.5
X1223 rr3t3r_0[59|2]/a_860_290# WL59 SL2 VSS sky130_fd_pr__nfet_g5v0d10v5 ad=0.65 pd=3.3 as=0 ps=0 w=1 l=0.5
X1224 BLP2 rr3t3r_0[60|2]/a_60_290# sky130_fd_pr_reram__reram_cell area_ox=0.0676
X1225 BLZ2 rr3t3r_0[60|2]/a_460_290# sky130_fd_pr_reram__reram_cell area_ox=0.0676
X1226 rr3t3r_0[60|2]/a_460_290# WL60 SL2 VSS sky130_fd_pr__nfet_g5v0d10v5 ad=0.65 pd=3.3 as=0 ps=0 w=1 l=0.5
X1227 BLN2 rr3t3r_0[60|2]/a_860_290# sky130_fd_pr_reram__reram_cell area_ox=0.0676
X1228 rr3t3r_0[60|2]/a_60_290# WL60 SL2 VSS sky130_fd_pr__nfet_g5v0d10v5 ad=0.65 pd=3.3 as=0 ps=0 w=1 l=0.5
X1229 rr3t3r_0[60|2]/a_860_290# WL60 SL2 VSS sky130_fd_pr__nfet_g5v0d10v5 ad=0.65 pd=3.3 as=0 ps=0 w=1 l=0.5
X1230 BLP2 rr3t3r_0[61|2]/a_60_290# sky130_fd_pr_reram__reram_cell area_ox=0.0676
X1231 BLZ2 rr3t3r_0[61|2]/a_460_290# sky130_fd_pr_reram__reram_cell area_ox=0.0676
X1232 rr3t3r_0[61|2]/a_460_290# WL61 SL2 VSS sky130_fd_pr__nfet_g5v0d10v5 ad=0.65 pd=3.3 as=0 ps=0 w=1 l=0.5
X1233 BLN2 rr3t3r_0[61|2]/a_860_290# sky130_fd_pr_reram__reram_cell area_ox=0.0676
X1234 rr3t3r_0[61|2]/a_60_290# WL61 SL2 VSS sky130_fd_pr__nfet_g5v0d10v5 ad=0.65 pd=3.3 as=0 ps=0 w=1 l=0.5
X1235 rr3t3r_0[61|2]/a_860_290# WL61 SL2 VSS sky130_fd_pr__nfet_g5v0d10v5 ad=0.65 pd=3.3 as=0 ps=0 w=1 l=0.5
X1236 BLP2 rr3t3r_0[62|2]/a_60_290# sky130_fd_pr_reram__reram_cell area_ox=0.0676
X1237 BLZ2 rr3t3r_0[62|2]/a_460_290# sky130_fd_pr_reram__reram_cell area_ox=0.0676
X1238 rr3t3r_0[62|2]/a_460_290# WL62 SL2 VSS sky130_fd_pr__nfet_g5v0d10v5 ad=0.65 pd=3.3 as=0 ps=0 w=1 l=0.5
X1239 BLN2 rr3t3r_0[62|2]/a_860_290# sky130_fd_pr_reram__reram_cell area_ox=0.0676
X1240 rr3t3r_0[62|2]/a_60_290# WL62 SL2 VSS sky130_fd_pr__nfet_g5v0d10v5 ad=0.65 pd=3.3 as=0 ps=0 w=1 l=0.5
X1241 rr3t3r_0[62|2]/a_860_290# WL62 SL2 VSS sky130_fd_pr__nfet_g5v0d10v5 ad=0.65 pd=3.3 as=0 ps=0 w=1 l=0.5
X1242 BLP2 rr3t3r_0[63|2]/a_60_290# sky130_fd_pr_reram__reram_cell area_ox=0.0676
X1243 BLZ2 rr3t3r_0[63|2]/a_460_290# sky130_fd_pr_reram__reram_cell area_ox=0.0676
X1244 rr3t3r_0[63|2]/a_460_290# WL63 SL2 VSS sky130_fd_pr__nfet_g5v0d10v5 ad=0.65 pd=3.3 as=0 ps=0 w=1 l=0.5
X1245 BLN2 rr3t3r_0[63|2]/a_860_290# sky130_fd_pr_reram__reram_cell area_ox=0.0676
X1246 rr3t3r_0[63|2]/a_60_290# WL63 SL2 VSS sky130_fd_pr__nfet_g5v0d10v5 ad=0.65 pd=3.3 as=0 ps=0 w=1 l=0.5
X1247 rr3t3r_0[63|2]/a_860_290# WL63 SL2 VSS sky130_fd_pr__nfet_g5v0d10v5 ad=0.65 pd=3.3 as=0 ps=0 w=1 l=0.5
X1248 BLP2 rr3t3r_0[64|2]/a_60_290# sky130_fd_pr_reram__reram_cell area_ox=0.0676
X1249 BLZ2 rr3t3r_0[64|2]/a_460_290# sky130_fd_pr_reram__reram_cell area_ox=0.0676
X1250 rr3t3r_0[64|2]/a_460_290# WL64 SL2 VSS sky130_fd_pr__nfet_g5v0d10v5 ad=0.65 pd=3.3 as=0 ps=0 w=1 l=0.5
X1251 BLN2 rr3t3r_0[64|2]/a_860_290# sky130_fd_pr_reram__reram_cell area_ox=0.0676
X1252 rr3t3r_0[64|2]/a_60_290# WL64 SL2 VSS sky130_fd_pr__nfet_g5v0d10v5 ad=0.65 pd=3.3 as=0 ps=0 w=1 l=0.5
X1253 rr3t3r_0[64|2]/a_860_290# WL64 SL2 VSS sky130_fd_pr__nfet_g5v0d10v5 ad=0.65 pd=3.3 as=0 ps=0 w=1 l=0.5
X1254 BLP2 rr3t3r_0[65|2]/a_60_290# sky130_fd_pr_reram__reram_cell area_ox=0.0676
X1255 BLZ2 rr3t3r_0[65|2]/a_460_290# sky130_fd_pr_reram__reram_cell area_ox=0.0676
X1256 rr3t3r_0[65|2]/a_460_290# WL65 SL2 VSS sky130_fd_pr__nfet_g5v0d10v5 ad=0.65 pd=3.3 as=0 ps=0 w=1 l=0.5
X1257 BLN2 rr3t3r_0[65|2]/a_860_290# sky130_fd_pr_reram__reram_cell area_ox=0.0676
X1258 rr3t3r_0[65|2]/a_60_290# WL65 SL2 VSS sky130_fd_pr__nfet_g5v0d10v5 ad=0.65 pd=3.3 as=0 ps=0 w=1 l=0.5
X1259 rr3t3r_0[65|2]/a_860_290# WL65 SL2 VSS sky130_fd_pr__nfet_g5v0d10v5 ad=0.65 pd=3.3 as=0 ps=0 w=1 l=0.5
X1260 BLP2 rr3t3r_0[66|2]/a_60_290# sky130_fd_pr_reram__reram_cell area_ox=0.0676
X1261 BLZ2 rr3t3r_0[66|2]/a_460_290# sky130_fd_pr_reram__reram_cell area_ox=0.0676
X1262 rr3t3r_0[66|2]/a_460_290# WL66 SL2 VSS sky130_fd_pr__nfet_g5v0d10v5 ad=0.65 pd=3.3 as=0 ps=0 w=1 l=0.5
X1263 BLN2 rr3t3r_0[66|2]/a_860_290# sky130_fd_pr_reram__reram_cell area_ox=0.0676
X1264 rr3t3r_0[66|2]/a_60_290# WL66 SL2 VSS sky130_fd_pr__nfet_g5v0d10v5 ad=0.65 pd=3.3 as=0 ps=0 w=1 l=0.5
X1265 rr3t3r_0[66|2]/a_860_290# WL66 SL2 VSS sky130_fd_pr__nfet_g5v0d10v5 ad=0.65 pd=3.3 as=0 ps=0 w=1 l=0.5
X1266 BLP2 rr3t3r_0[67|2]/a_60_290# sky130_fd_pr_reram__reram_cell area_ox=0.0676
X1267 BLZ2 rr3t3r_0[67|2]/a_460_290# sky130_fd_pr_reram__reram_cell area_ox=0.0676
X1268 rr3t3r_0[67|2]/a_460_290# WL67 SL2 VSS sky130_fd_pr__nfet_g5v0d10v5 ad=0.65 pd=3.3 as=0 ps=0 w=1 l=0.5
X1269 BLN2 rr3t3r_0[67|2]/a_860_290# sky130_fd_pr_reram__reram_cell area_ox=0.0676
X1270 rr3t3r_0[67|2]/a_60_290# WL67 SL2 VSS sky130_fd_pr__nfet_g5v0d10v5 ad=0.65 pd=3.3 as=0 ps=0 w=1 l=0.5
X1271 rr3t3r_0[67|2]/a_860_290# WL67 SL2 VSS sky130_fd_pr__nfet_g5v0d10v5 ad=0.65 pd=3.3 as=0 ps=0 w=1 l=0.5
X1272 BLP2 rr3t3r_0[68|2]/a_60_290# sky130_fd_pr_reram__reram_cell area_ox=0.0676
X1273 BLZ2 rr3t3r_0[68|2]/a_460_290# sky130_fd_pr_reram__reram_cell area_ox=0.0676
X1274 rr3t3r_0[68|2]/a_460_290# WL68 SL2 VSS sky130_fd_pr__nfet_g5v0d10v5 ad=0.65 pd=3.3 as=0 ps=0 w=1 l=0.5
X1275 BLN2 rr3t3r_0[68|2]/a_860_290# sky130_fd_pr_reram__reram_cell area_ox=0.0676
X1276 rr3t3r_0[68|2]/a_60_290# WL68 SL2 VSS sky130_fd_pr__nfet_g5v0d10v5 ad=0.65 pd=3.3 as=0 ps=0 w=1 l=0.5
X1277 rr3t3r_0[68|2]/a_860_290# WL68 SL2 VSS sky130_fd_pr__nfet_g5v0d10v5 ad=0.65 pd=3.3 as=0 ps=0 w=1 l=0.5
X1278 BLP2 rr3t3r_0[69|2]/a_60_290# sky130_fd_pr_reram__reram_cell area_ox=0.0676
X1279 BLZ2 rr3t3r_0[69|2]/a_460_290# sky130_fd_pr_reram__reram_cell area_ox=0.0676
X1280 rr3t3r_0[69|2]/a_460_290# WL69 SL2 VSS sky130_fd_pr__nfet_g5v0d10v5 ad=0.65 pd=3.3 as=0 ps=0 w=1 l=0.5
X1281 BLN2 rr3t3r_0[69|2]/a_860_290# sky130_fd_pr_reram__reram_cell area_ox=0.0676
X1282 rr3t3r_0[69|2]/a_60_290# WL69 SL2 VSS sky130_fd_pr__nfet_g5v0d10v5 ad=0.65 pd=3.3 as=0 ps=0 w=1 l=0.5
X1283 rr3t3r_0[69|2]/a_860_290# WL69 SL2 VSS sky130_fd_pr__nfet_g5v0d10v5 ad=0.65 pd=3.3 as=0 ps=0 w=1 l=0.5
X1284 BLP2 rr3t3r_0[70|2]/a_60_290# sky130_fd_pr_reram__reram_cell area_ox=0.0676
X1285 BLZ2 rr3t3r_0[70|2]/a_460_290# sky130_fd_pr_reram__reram_cell area_ox=0.0676
X1286 rr3t3r_0[70|2]/a_460_290# WL70 SL2 VSS sky130_fd_pr__nfet_g5v0d10v5 ad=0.65 pd=3.3 as=0 ps=0 w=1 l=0.5
X1287 BLN2 rr3t3r_0[70|2]/a_860_290# sky130_fd_pr_reram__reram_cell area_ox=0.0676
X1288 rr3t3r_0[70|2]/a_60_290# WL70 SL2 VSS sky130_fd_pr__nfet_g5v0d10v5 ad=0.65 pd=3.3 as=0 ps=0 w=1 l=0.5
X1289 rr3t3r_0[70|2]/a_860_290# WL70 SL2 VSS sky130_fd_pr__nfet_g5v0d10v5 ad=0.65 pd=3.3 as=0 ps=0 w=1 l=0.5
X1290 BLP2 rr3t3r_0[71|2]/a_60_290# sky130_fd_pr_reram__reram_cell area_ox=0.0676
X1291 BLZ2 rr3t3r_0[71|2]/a_460_290# sky130_fd_pr_reram__reram_cell area_ox=0.0676
X1292 rr3t3r_0[71|2]/a_460_290# WL71 SL2 VSS sky130_fd_pr__nfet_g5v0d10v5 ad=0.65 pd=3.3 as=0 ps=0 w=1 l=0.5
X1293 BLN2 rr3t3r_0[71|2]/a_860_290# sky130_fd_pr_reram__reram_cell area_ox=0.0676
X1294 rr3t3r_0[71|2]/a_60_290# WL71 SL2 VSS sky130_fd_pr__nfet_g5v0d10v5 ad=0.65 pd=3.3 as=0 ps=0 w=1 l=0.5
X1295 rr3t3r_0[71|2]/a_860_290# WL71 SL2 VSS sky130_fd_pr__nfet_g5v0d10v5 ad=0.65 pd=3.3 as=0 ps=0 w=1 l=0.5
X1296 BLP3 rr3t3r_0[0|3]/a_60_290# sky130_fd_pr_reram__reram_cell area_ox=0.0676
X1297 BLZ3 rr3t3r_0[0|3]/a_460_290# sky130_fd_pr_reram__reram_cell area_ox=0.0676
X1298 rr3t3r_0[0|3]/a_460_290# WL0 SL3 VSS sky130_fd_pr__nfet_g5v0d10v5 ad=0.65 pd=3.3 as=162 ps=756 w=1 l=0.5
X1299 BLN3 rr3t3r_0[0|3]/a_860_290# sky130_fd_pr_reram__reram_cell area_ox=0.0676
X1300 rr3t3r_0[0|3]/a_60_290# WL0 SL3 VSS sky130_fd_pr__nfet_g5v0d10v5 ad=0.65 pd=3.3 as=0 ps=0 w=1 l=0.5
X1301 rr3t3r_0[0|3]/a_860_290# WL0 SL3 VSS sky130_fd_pr__nfet_g5v0d10v5 ad=0.65 pd=3.3 as=0 ps=0 w=1 l=0.5
X1302 BLP3 rr3t3r_0[1|3]/a_60_290# sky130_fd_pr_reram__reram_cell area_ox=0.0676
X1303 BLZ3 rr3t3r_0[1|3]/a_460_290# sky130_fd_pr_reram__reram_cell area_ox=0.0676
X1304 rr3t3r_0[1|3]/a_460_290# WL1 SL3 VSS sky130_fd_pr__nfet_g5v0d10v5 ad=0.65 pd=3.3 as=0 ps=0 w=1 l=0.5
X1305 BLN3 rr3t3r_0[1|3]/a_860_290# sky130_fd_pr_reram__reram_cell area_ox=0.0676
X1306 rr3t3r_0[1|3]/a_60_290# WL1 SL3 VSS sky130_fd_pr__nfet_g5v0d10v5 ad=0.65 pd=3.3 as=0 ps=0 w=1 l=0.5
X1307 rr3t3r_0[1|3]/a_860_290# WL1 SL3 VSS sky130_fd_pr__nfet_g5v0d10v5 ad=0.65 pd=3.3 as=0 ps=0 w=1 l=0.5
X1308 BLP3 rr3t3r_0[2|3]/a_60_290# sky130_fd_pr_reram__reram_cell area_ox=0.0676
X1309 BLZ3 rr3t3r_0[2|3]/a_460_290# sky130_fd_pr_reram__reram_cell area_ox=0.0676
X1310 rr3t3r_0[2|3]/a_460_290# WL2 SL3 VSS sky130_fd_pr__nfet_g5v0d10v5 ad=0.65 pd=3.3 as=0 ps=0 w=1 l=0.5
X1311 BLN3 rr3t3r_0[2|3]/a_860_290# sky130_fd_pr_reram__reram_cell area_ox=0.0676
X1312 rr3t3r_0[2|3]/a_60_290# WL2 SL3 VSS sky130_fd_pr__nfet_g5v0d10v5 ad=0.65 pd=3.3 as=0 ps=0 w=1 l=0.5
X1313 rr3t3r_0[2|3]/a_860_290# WL2 SL3 VSS sky130_fd_pr__nfet_g5v0d10v5 ad=0.65 pd=3.3 as=0 ps=0 w=1 l=0.5
X1314 BLP3 rr3t3r_0[3|3]/a_60_290# sky130_fd_pr_reram__reram_cell area_ox=0.0676
X1315 BLZ3 rr3t3r_0[3|3]/a_460_290# sky130_fd_pr_reram__reram_cell area_ox=0.0676
X1316 rr3t3r_0[3|3]/a_460_290# WL3 SL3 VSS sky130_fd_pr__nfet_g5v0d10v5 ad=0.65 pd=3.3 as=0 ps=0 w=1 l=0.5
X1317 BLN3 rr3t3r_0[3|3]/a_860_290# sky130_fd_pr_reram__reram_cell area_ox=0.0676
X1318 rr3t3r_0[3|3]/a_60_290# WL3 SL3 VSS sky130_fd_pr__nfet_g5v0d10v5 ad=0.65 pd=3.3 as=0 ps=0 w=1 l=0.5
X1319 rr3t3r_0[3|3]/a_860_290# WL3 SL3 VSS sky130_fd_pr__nfet_g5v0d10v5 ad=0.65 pd=3.3 as=0 ps=0 w=1 l=0.5
X1320 BLP3 rr3t3r_0[4|3]/a_60_290# sky130_fd_pr_reram__reram_cell area_ox=0.0676
X1321 BLZ3 rr3t3r_0[4|3]/a_460_290# sky130_fd_pr_reram__reram_cell area_ox=0.0676
X1322 rr3t3r_0[4|3]/a_460_290# WL4 SL3 VSS sky130_fd_pr__nfet_g5v0d10v5 ad=0.65 pd=3.3 as=0 ps=0 w=1 l=0.5
X1323 BLN3 rr3t3r_0[4|3]/a_860_290# sky130_fd_pr_reram__reram_cell area_ox=0.0676
X1324 rr3t3r_0[4|3]/a_60_290# WL4 SL3 VSS sky130_fd_pr__nfet_g5v0d10v5 ad=0.65 pd=3.3 as=0 ps=0 w=1 l=0.5
X1325 rr3t3r_0[4|3]/a_860_290# WL4 SL3 VSS sky130_fd_pr__nfet_g5v0d10v5 ad=0.65 pd=3.3 as=0 ps=0 w=1 l=0.5
X1326 BLP3 rr3t3r_0[5|3]/a_60_290# sky130_fd_pr_reram__reram_cell area_ox=0.0676
X1327 BLZ3 rr3t3r_0[5|3]/a_460_290# sky130_fd_pr_reram__reram_cell area_ox=0.0676
X1328 rr3t3r_0[5|3]/a_460_290# WL5 SL3 VSS sky130_fd_pr__nfet_g5v0d10v5 ad=0.65 pd=3.3 as=0 ps=0 w=1 l=0.5
X1329 BLN3 rr3t3r_0[5|3]/a_860_290# sky130_fd_pr_reram__reram_cell area_ox=0.0676
X1330 rr3t3r_0[5|3]/a_60_290# WL5 SL3 VSS sky130_fd_pr__nfet_g5v0d10v5 ad=0.65 pd=3.3 as=0 ps=0 w=1 l=0.5
X1331 rr3t3r_0[5|3]/a_860_290# WL5 SL3 VSS sky130_fd_pr__nfet_g5v0d10v5 ad=0.65 pd=3.3 as=0 ps=0 w=1 l=0.5
X1332 BLP3 rr3t3r_0[6|3]/a_60_290# sky130_fd_pr_reram__reram_cell area_ox=0.0676
X1333 BLZ3 rr3t3r_0[6|3]/a_460_290# sky130_fd_pr_reram__reram_cell area_ox=0.0676
X1334 rr3t3r_0[6|3]/a_460_290# WL6 SL3 VSS sky130_fd_pr__nfet_g5v0d10v5 ad=0.65 pd=3.3 as=0 ps=0 w=1 l=0.5
X1335 BLN3 rr3t3r_0[6|3]/a_860_290# sky130_fd_pr_reram__reram_cell area_ox=0.0676
X1336 rr3t3r_0[6|3]/a_60_290# WL6 SL3 VSS sky130_fd_pr__nfet_g5v0d10v5 ad=0.65 pd=3.3 as=0 ps=0 w=1 l=0.5
X1337 rr3t3r_0[6|3]/a_860_290# WL6 SL3 VSS sky130_fd_pr__nfet_g5v0d10v5 ad=0.65 pd=3.3 as=0 ps=0 w=1 l=0.5
X1338 BLP3 rr3t3r_0[7|3]/a_60_290# sky130_fd_pr_reram__reram_cell area_ox=0.0676
X1339 BLZ3 rr3t3r_0[7|3]/a_460_290# sky130_fd_pr_reram__reram_cell area_ox=0.0676
X1340 rr3t3r_0[7|3]/a_460_290# WL7 SL3 VSS sky130_fd_pr__nfet_g5v0d10v5 ad=0.65 pd=3.3 as=0 ps=0 w=1 l=0.5
X1341 BLN3 rr3t3r_0[7|3]/a_860_290# sky130_fd_pr_reram__reram_cell area_ox=0.0676
X1342 rr3t3r_0[7|3]/a_60_290# WL7 SL3 VSS sky130_fd_pr__nfet_g5v0d10v5 ad=0.65 pd=3.3 as=0 ps=0 w=1 l=0.5
X1343 rr3t3r_0[7|3]/a_860_290# WL7 SL3 VSS sky130_fd_pr__nfet_g5v0d10v5 ad=0.65 pd=3.3 as=0 ps=0 w=1 l=0.5
X1344 BLP3 rr3t3r_0[8|3]/a_60_290# sky130_fd_pr_reram__reram_cell area_ox=0.0676
X1345 BLZ3 rr3t3r_0[8|3]/a_460_290# sky130_fd_pr_reram__reram_cell area_ox=0.0676
X1346 rr3t3r_0[8|3]/a_460_290# WL8 SL3 VSS sky130_fd_pr__nfet_g5v0d10v5 ad=0.65 pd=3.3 as=0 ps=0 w=1 l=0.5
X1347 BLN3 rr3t3r_0[8|3]/a_860_290# sky130_fd_pr_reram__reram_cell area_ox=0.0676
X1348 rr3t3r_0[8|3]/a_60_290# WL8 SL3 VSS sky130_fd_pr__nfet_g5v0d10v5 ad=0.65 pd=3.3 as=0 ps=0 w=1 l=0.5
X1349 rr3t3r_0[8|3]/a_860_290# WL8 SL3 VSS sky130_fd_pr__nfet_g5v0d10v5 ad=0.65 pd=3.3 as=0 ps=0 w=1 l=0.5
X1350 BLP3 rr3t3r_0[9|3]/a_60_290# sky130_fd_pr_reram__reram_cell area_ox=0.0676
X1351 BLZ3 rr3t3r_0[9|3]/a_460_290# sky130_fd_pr_reram__reram_cell area_ox=0.0676
X1352 rr3t3r_0[9|3]/a_460_290# WL9 SL3 VSS sky130_fd_pr__nfet_g5v0d10v5 ad=0.65 pd=3.3 as=0 ps=0 w=1 l=0.5
X1353 BLN3 rr3t3r_0[9|3]/a_860_290# sky130_fd_pr_reram__reram_cell area_ox=0.0676
X1354 rr3t3r_0[9|3]/a_60_290# WL9 SL3 VSS sky130_fd_pr__nfet_g5v0d10v5 ad=0.65 pd=3.3 as=0 ps=0 w=1 l=0.5
X1355 rr3t3r_0[9|3]/a_860_290# WL9 SL3 VSS sky130_fd_pr__nfet_g5v0d10v5 ad=0.65 pd=3.3 as=0 ps=0 w=1 l=0.5
X1356 BLP3 rr3t3r_0[10|3]/a_60_290# sky130_fd_pr_reram__reram_cell area_ox=0.0676
X1357 BLZ3 rr3t3r_0[10|3]/a_460_290# sky130_fd_pr_reram__reram_cell area_ox=0.0676
X1358 rr3t3r_0[10|3]/a_460_290# WL10 SL3 VSS sky130_fd_pr__nfet_g5v0d10v5 ad=0.65 pd=3.3 as=0 ps=0 w=1 l=0.5
X1359 BLN3 rr3t3r_0[10|3]/a_860_290# sky130_fd_pr_reram__reram_cell area_ox=0.0676
X1360 rr3t3r_0[10|3]/a_60_290# WL10 SL3 VSS sky130_fd_pr__nfet_g5v0d10v5 ad=0.65 pd=3.3 as=0 ps=0 w=1 l=0.5
X1361 rr3t3r_0[10|3]/a_860_290# WL10 SL3 VSS sky130_fd_pr__nfet_g5v0d10v5 ad=0.65 pd=3.3 as=0 ps=0 w=1 l=0.5
X1362 BLP3 rr3t3r_0[11|3]/a_60_290# sky130_fd_pr_reram__reram_cell area_ox=0.0676
X1363 BLZ3 rr3t3r_0[11|3]/a_460_290# sky130_fd_pr_reram__reram_cell area_ox=0.0676
X1364 rr3t3r_0[11|3]/a_460_290# WL11 SL3 VSS sky130_fd_pr__nfet_g5v0d10v5 ad=0.65 pd=3.3 as=0 ps=0 w=1 l=0.5
X1365 BLN3 rr3t3r_0[11|3]/a_860_290# sky130_fd_pr_reram__reram_cell area_ox=0.0676
X1366 rr3t3r_0[11|3]/a_60_290# WL11 SL3 VSS sky130_fd_pr__nfet_g5v0d10v5 ad=0.65 pd=3.3 as=0 ps=0 w=1 l=0.5
X1367 rr3t3r_0[11|3]/a_860_290# WL11 SL3 VSS sky130_fd_pr__nfet_g5v0d10v5 ad=0.65 pd=3.3 as=0 ps=0 w=1 l=0.5
X1368 BLP3 rr3t3r_0[12|3]/a_60_290# sky130_fd_pr_reram__reram_cell area_ox=0.0676
X1369 BLZ3 rr3t3r_0[12|3]/a_460_290# sky130_fd_pr_reram__reram_cell area_ox=0.0676
X1370 rr3t3r_0[12|3]/a_460_290# WL12 SL3 VSS sky130_fd_pr__nfet_g5v0d10v5 ad=0.65 pd=3.3 as=0 ps=0 w=1 l=0.5
X1371 BLN3 rr3t3r_0[12|3]/a_860_290# sky130_fd_pr_reram__reram_cell area_ox=0.0676
X1372 rr3t3r_0[12|3]/a_60_290# WL12 SL3 VSS sky130_fd_pr__nfet_g5v0d10v5 ad=0.65 pd=3.3 as=0 ps=0 w=1 l=0.5
X1373 rr3t3r_0[12|3]/a_860_290# WL12 SL3 VSS sky130_fd_pr__nfet_g5v0d10v5 ad=0.65 pd=3.3 as=0 ps=0 w=1 l=0.5
X1374 BLP3 rr3t3r_0[13|3]/a_60_290# sky130_fd_pr_reram__reram_cell area_ox=0.0676
X1375 BLZ3 rr3t3r_0[13|3]/a_460_290# sky130_fd_pr_reram__reram_cell area_ox=0.0676
X1376 rr3t3r_0[13|3]/a_460_290# WL13 SL3 VSS sky130_fd_pr__nfet_g5v0d10v5 ad=0.65 pd=3.3 as=0 ps=0 w=1 l=0.5
X1377 BLN3 rr3t3r_0[13|3]/a_860_290# sky130_fd_pr_reram__reram_cell area_ox=0.0676
X1378 rr3t3r_0[13|3]/a_60_290# WL13 SL3 VSS sky130_fd_pr__nfet_g5v0d10v5 ad=0.65 pd=3.3 as=0 ps=0 w=1 l=0.5
X1379 rr3t3r_0[13|3]/a_860_290# WL13 SL3 VSS sky130_fd_pr__nfet_g5v0d10v5 ad=0.65 pd=3.3 as=0 ps=0 w=1 l=0.5
X1380 BLP3 rr3t3r_0[14|3]/a_60_290# sky130_fd_pr_reram__reram_cell area_ox=0.0676
X1381 BLZ3 rr3t3r_0[14|3]/a_460_290# sky130_fd_pr_reram__reram_cell area_ox=0.0676
X1382 rr3t3r_0[14|3]/a_460_290# WL14 SL3 VSS sky130_fd_pr__nfet_g5v0d10v5 ad=0.65 pd=3.3 as=0 ps=0 w=1 l=0.5
X1383 BLN3 rr3t3r_0[14|3]/a_860_290# sky130_fd_pr_reram__reram_cell area_ox=0.0676
X1384 rr3t3r_0[14|3]/a_60_290# WL14 SL3 VSS sky130_fd_pr__nfet_g5v0d10v5 ad=0.65 pd=3.3 as=0 ps=0 w=1 l=0.5
X1385 rr3t3r_0[14|3]/a_860_290# WL14 SL3 VSS sky130_fd_pr__nfet_g5v0d10v5 ad=0.65 pd=3.3 as=0 ps=0 w=1 l=0.5
X1386 BLP3 rr3t3r_0[15|3]/a_60_290# sky130_fd_pr_reram__reram_cell area_ox=0.0676
X1387 BLZ3 rr3t3r_0[15|3]/a_460_290# sky130_fd_pr_reram__reram_cell area_ox=0.0676
X1388 rr3t3r_0[15|3]/a_460_290# WL15 SL3 VSS sky130_fd_pr__nfet_g5v0d10v5 ad=0.65 pd=3.3 as=0 ps=0 w=1 l=0.5
X1389 BLN3 rr3t3r_0[15|3]/a_860_290# sky130_fd_pr_reram__reram_cell area_ox=0.0676
X1390 rr3t3r_0[15|3]/a_60_290# WL15 SL3 VSS sky130_fd_pr__nfet_g5v0d10v5 ad=0.65 pd=3.3 as=0 ps=0 w=1 l=0.5
X1391 rr3t3r_0[15|3]/a_860_290# WL15 SL3 VSS sky130_fd_pr__nfet_g5v0d10v5 ad=0.65 pd=3.3 as=0 ps=0 w=1 l=0.5
X1392 BLP3 rr3t3r_0[16|3]/a_60_290# sky130_fd_pr_reram__reram_cell area_ox=0.0676
X1393 BLZ3 rr3t3r_0[16|3]/a_460_290# sky130_fd_pr_reram__reram_cell area_ox=0.0676
X1394 rr3t3r_0[16|3]/a_460_290# WL16 SL3 VSS sky130_fd_pr__nfet_g5v0d10v5 ad=0.65 pd=3.3 as=0 ps=0 w=1 l=0.5
X1395 BLN3 rr3t3r_0[16|3]/a_860_290# sky130_fd_pr_reram__reram_cell area_ox=0.0676
X1396 rr3t3r_0[16|3]/a_60_290# WL16 SL3 VSS sky130_fd_pr__nfet_g5v0d10v5 ad=0.65 pd=3.3 as=0 ps=0 w=1 l=0.5
X1397 rr3t3r_0[16|3]/a_860_290# WL16 SL3 VSS sky130_fd_pr__nfet_g5v0d10v5 ad=0.65 pd=3.3 as=0 ps=0 w=1 l=0.5
X1398 BLP3 rr3t3r_0[17|3]/a_60_290# sky130_fd_pr_reram__reram_cell area_ox=0.0676
X1399 BLZ3 rr3t3r_0[17|3]/a_460_290# sky130_fd_pr_reram__reram_cell area_ox=0.0676
X1400 rr3t3r_0[17|3]/a_460_290# WL17 SL3 VSS sky130_fd_pr__nfet_g5v0d10v5 ad=0.65 pd=3.3 as=0 ps=0 w=1 l=0.5
X1401 BLN3 rr3t3r_0[17|3]/a_860_290# sky130_fd_pr_reram__reram_cell area_ox=0.0676
X1402 rr3t3r_0[17|3]/a_60_290# WL17 SL3 VSS sky130_fd_pr__nfet_g5v0d10v5 ad=0.65 pd=3.3 as=0 ps=0 w=1 l=0.5
X1403 rr3t3r_0[17|3]/a_860_290# WL17 SL3 VSS sky130_fd_pr__nfet_g5v0d10v5 ad=0.65 pd=3.3 as=0 ps=0 w=1 l=0.5
X1404 BLP3 rr3t3r_0[18|3]/a_60_290# sky130_fd_pr_reram__reram_cell area_ox=0.0676
X1405 BLZ3 rr3t3r_0[18|3]/a_460_290# sky130_fd_pr_reram__reram_cell area_ox=0.0676
X1406 rr3t3r_0[18|3]/a_460_290# WL18 SL3 VSS sky130_fd_pr__nfet_g5v0d10v5 ad=0.65 pd=3.3 as=0 ps=0 w=1 l=0.5
X1407 BLN3 rr3t3r_0[18|3]/a_860_290# sky130_fd_pr_reram__reram_cell area_ox=0.0676
X1408 rr3t3r_0[18|3]/a_60_290# WL18 SL3 VSS sky130_fd_pr__nfet_g5v0d10v5 ad=0.65 pd=3.3 as=0 ps=0 w=1 l=0.5
X1409 rr3t3r_0[18|3]/a_860_290# WL18 SL3 VSS sky130_fd_pr__nfet_g5v0d10v5 ad=0.65 pd=3.3 as=0 ps=0 w=1 l=0.5
X1410 BLP3 rr3t3r_0[19|3]/a_60_290# sky130_fd_pr_reram__reram_cell area_ox=0.0676
X1411 BLZ3 rr3t3r_0[19|3]/a_460_290# sky130_fd_pr_reram__reram_cell area_ox=0.0676
X1412 rr3t3r_0[19|3]/a_460_290# WL19 SL3 VSS sky130_fd_pr__nfet_g5v0d10v5 ad=0.65 pd=3.3 as=0 ps=0 w=1 l=0.5
X1413 BLN3 rr3t3r_0[19|3]/a_860_290# sky130_fd_pr_reram__reram_cell area_ox=0.0676
X1414 rr3t3r_0[19|3]/a_60_290# WL19 SL3 VSS sky130_fd_pr__nfet_g5v0d10v5 ad=0.65 pd=3.3 as=0 ps=0 w=1 l=0.5
X1415 rr3t3r_0[19|3]/a_860_290# WL19 SL3 VSS sky130_fd_pr__nfet_g5v0d10v5 ad=0.65 pd=3.3 as=0 ps=0 w=1 l=0.5
X1416 BLP3 rr3t3r_0[20|3]/a_60_290# sky130_fd_pr_reram__reram_cell area_ox=0.0676
X1417 BLZ3 rr3t3r_0[20|3]/a_460_290# sky130_fd_pr_reram__reram_cell area_ox=0.0676
X1418 rr3t3r_0[20|3]/a_460_290# WL20 SL3 VSS sky130_fd_pr__nfet_g5v0d10v5 ad=0.65 pd=3.3 as=0 ps=0 w=1 l=0.5
X1419 BLN3 rr3t3r_0[20|3]/a_860_290# sky130_fd_pr_reram__reram_cell area_ox=0.0676
X1420 rr3t3r_0[20|3]/a_60_290# WL20 SL3 VSS sky130_fd_pr__nfet_g5v0d10v5 ad=0.65 pd=3.3 as=0 ps=0 w=1 l=0.5
X1421 rr3t3r_0[20|3]/a_860_290# WL20 SL3 VSS sky130_fd_pr__nfet_g5v0d10v5 ad=0.65 pd=3.3 as=0 ps=0 w=1 l=0.5
X1422 BLP3 rr3t3r_0[21|3]/a_60_290# sky130_fd_pr_reram__reram_cell area_ox=0.0676
X1423 BLZ3 rr3t3r_0[21|3]/a_460_290# sky130_fd_pr_reram__reram_cell area_ox=0.0676
X1424 rr3t3r_0[21|3]/a_460_290# WL21 SL3 VSS sky130_fd_pr__nfet_g5v0d10v5 ad=0.65 pd=3.3 as=0 ps=0 w=1 l=0.5
X1425 BLN3 rr3t3r_0[21|3]/a_860_290# sky130_fd_pr_reram__reram_cell area_ox=0.0676
X1426 rr3t3r_0[21|3]/a_60_290# WL21 SL3 VSS sky130_fd_pr__nfet_g5v0d10v5 ad=0.65 pd=3.3 as=0 ps=0 w=1 l=0.5
X1427 rr3t3r_0[21|3]/a_860_290# WL21 SL3 VSS sky130_fd_pr__nfet_g5v0d10v5 ad=0.65 pd=3.3 as=0 ps=0 w=1 l=0.5
X1428 BLP3 rr3t3r_0[22|3]/a_60_290# sky130_fd_pr_reram__reram_cell area_ox=0.0676
X1429 BLZ3 rr3t3r_0[22|3]/a_460_290# sky130_fd_pr_reram__reram_cell area_ox=0.0676
X1430 rr3t3r_0[22|3]/a_460_290# WL22 SL3 VSS sky130_fd_pr__nfet_g5v0d10v5 ad=0.65 pd=3.3 as=0 ps=0 w=1 l=0.5
X1431 BLN3 rr3t3r_0[22|3]/a_860_290# sky130_fd_pr_reram__reram_cell area_ox=0.0676
X1432 rr3t3r_0[22|3]/a_60_290# WL22 SL3 VSS sky130_fd_pr__nfet_g5v0d10v5 ad=0.65 pd=3.3 as=0 ps=0 w=1 l=0.5
X1433 rr3t3r_0[22|3]/a_860_290# WL22 SL3 VSS sky130_fd_pr__nfet_g5v0d10v5 ad=0.65 pd=3.3 as=0 ps=0 w=1 l=0.5
X1434 BLP3 rr3t3r_0[23|3]/a_60_290# sky130_fd_pr_reram__reram_cell area_ox=0.0676
X1435 BLZ3 rr3t3r_0[23|3]/a_460_290# sky130_fd_pr_reram__reram_cell area_ox=0.0676
X1436 rr3t3r_0[23|3]/a_460_290# WL23 SL3 VSS sky130_fd_pr__nfet_g5v0d10v5 ad=0.65 pd=3.3 as=0 ps=0 w=1 l=0.5
X1437 BLN3 rr3t3r_0[23|3]/a_860_290# sky130_fd_pr_reram__reram_cell area_ox=0.0676
X1438 rr3t3r_0[23|3]/a_60_290# WL23 SL3 VSS sky130_fd_pr__nfet_g5v0d10v5 ad=0.65 pd=3.3 as=0 ps=0 w=1 l=0.5
X1439 rr3t3r_0[23|3]/a_860_290# WL23 SL3 VSS sky130_fd_pr__nfet_g5v0d10v5 ad=0.65 pd=3.3 as=0 ps=0 w=1 l=0.5
X1440 BLP3 rr3t3r_0[24|3]/a_60_290# sky130_fd_pr_reram__reram_cell area_ox=0.0676
X1441 BLZ3 rr3t3r_0[24|3]/a_460_290# sky130_fd_pr_reram__reram_cell area_ox=0.0676
X1442 rr3t3r_0[24|3]/a_460_290# WL24 SL3 VSS sky130_fd_pr__nfet_g5v0d10v5 ad=0.65 pd=3.3 as=0 ps=0 w=1 l=0.5
X1443 BLN3 rr3t3r_0[24|3]/a_860_290# sky130_fd_pr_reram__reram_cell area_ox=0.0676
X1444 rr3t3r_0[24|3]/a_60_290# WL24 SL3 VSS sky130_fd_pr__nfet_g5v0d10v5 ad=0.65 pd=3.3 as=0 ps=0 w=1 l=0.5
X1445 rr3t3r_0[24|3]/a_860_290# WL24 SL3 VSS sky130_fd_pr__nfet_g5v0d10v5 ad=0.65 pd=3.3 as=0 ps=0 w=1 l=0.5
X1446 BLP3 rr3t3r_0[25|3]/a_60_290# sky130_fd_pr_reram__reram_cell area_ox=0.0676
X1447 BLZ3 rr3t3r_0[25|3]/a_460_290# sky130_fd_pr_reram__reram_cell area_ox=0.0676
X1448 rr3t3r_0[25|3]/a_460_290# WL25 SL3 VSS sky130_fd_pr__nfet_g5v0d10v5 ad=0.65 pd=3.3 as=0 ps=0 w=1 l=0.5
X1449 BLN3 rr3t3r_0[25|3]/a_860_290# sky130_fd_pr_reram__reram_cell area_ox=0.0676
X1450 rr3t3r_0[25|3]/a_60_290# WL25 SL3 VSS sky130_fd_pr__nfet_g5v0d10v5 ad=0.65 pd=3.3 as=0 ps=0 w=1 l=0.5
X1451 rr3t3r_0[25|3]/a_860_290# WL25 SL3 VSS sky130_fd_pr__nfet_g5v0d10v5 ad=0.65 pd=3.3 as=0 ps=0 w=1 l=0.5
X1452 BLP3 rr3t3r_0[26|3]/a_60_290# sky130_fd_pr_reram__reram_cell area_ox=0.0676
X1453 BLZ3 rr3t3r_0[26|3]/a_460_290# sky130_fd_pr_reram__reram_cell area_ox=0.0676
X1454 rr3t3r_0[26|3]/a_460_290# WL26 SL3 VSS sky130_fd_pr__nfet_g5v0d10v5 ad=0.65 pd=3.3 as=0 ps=0 w=1 l=0.5
X1455 BLN3 rr3t3r_0[26|3]/a_860_290# sky130_fd_pr_reram__reram_cell area_ox=0.0676
X1456 rr3t3r_0[26|3]/a_60_290# WL26 SL3 VSS sky130_fd_pr__nfet_g5v0d10v5 ad=0.65 pd=3.3 as=0 ps=0 w=1 l=0.5
X1457 rr3t3r_0[26|3]/a_860_290# WL26 SL3 VSS sky130_fd_pr__nfet_g5v0d10v5 ad=0.65 pd=3.3 as=0 ps=0 w=1 l=0.5
X1458 BLP3 rr3t3r_0[27|3]/a_60_290# sky130_fd_pr_reram__reram_cell area_ox=0.0676
X1459 BLZ3 rr3t3r_0[27|3]/a_460_290# sky130_fd_pr_reram__reram_cell area_ox=0.0676
X1460 rr3t3r_0[27|3]/a_460_290# WL27 SL3 VSS sky130_fd_pr__nfet_g5v0d10v5 ad=0.65 pd=3.3 as=0 ps=0 w=1 l=0.5
X1461 BLN3 rr3t3r_0[27|3]/a_860_290# sky130_fd_pr_reram__reram_cell area_ox=0.0676
X1462 rr3t3r_0[27|3]/a_60_290# WL27 SL3 VSS sky130_fd_pr__nfet_g5v0d10v5 ad=0.65 pd=3.3 as=0 ps=0 w=1 l=0.5
X1463 rr3t3r_0[27|3]/a_860_290# WL27 SL3 VSS sky130_fd_pr__nfet_g5v0d10v5 ad=0.65 pd=3.3 as=0 ps=0 w=1 l=0.5
X1464 BLP3 rr3t3r_0[28|3]/a_60_290# sky130_fd_pr_reram__reram_cell area_ox=0.0676
X1465 BLZ3 rr3t3r_0[28|3]/a_460_290# sky130_fd_pr_reram__reram_cell area_ox=0.0676
X1466 rr3t3r_0[28|3]/a_460_290# WL28 SL3 VSS sky130_fd_pr__nfet_g5v0d10v5 ad=0.65 pd=3.3 as=0 ps=0 w=1 l=0.5
X1467 BLN3 rr3t3r_0[28|3]/a_860_290# sky130_fd_pr_reram__reram_cell area_ox=0.0676
X1468 rr3t3r_0[28|3]/a_60_290# WL28 SL3 VSS sky130_fd_pr__nfet_g5v0d10v5 ad=0.65 pd=3.3 as=0 ps=0 w=1 l=0.5
X1469 rr3t3r_0[28|3]/a_860_290# WL28 SL3 VSS sky130_fd_pr__nfet_g5v0d10v5 ad=0.65 pd=3.3 as=0 ps=0 w=1 l=0.5
X1470 BLP3 rr3t3r_0[29|3]/a_60_290# sky130_fd_pr_reram__reram_cell area_ox=0.0676
X1471 BLZ3 rr3t3r_0[29|3]/a_460_290# sky130_fd_pr_reram__reram_cell area_ox=0.0676
X1472 rr3t3r_0[29|3]/a_460_290# WL29 SL3 VSS sky130_fd_pr__nfet_g5v0d10v5 ad=0.65 pd=3.3 as=0 ps=0 w=1 l=0.5
X1473 BLN3 rr3t3r_0[29|3]/a_860_290# sky130_fd_pr_reram__reram_cell area_ox=0.0676
X1474 rr3t3r_0[29|3]/a_60_290# WL29 SL3 VSS sky130_fd_pr__nfet_g5v0d10v5 ad=0.65 pd=3.3 as=0 ps=0 w=1 l=0.5
X1475 rr3t3r_0[29|3]/a_860_290# WL29 SL3 VSS sky130_fd_pr__nfet_g5v0d10v5 ad=0.65 pd=3.3 as=0 ps=0 w=1 l=0.5
X1476 BLP3 rr3t3r_0[30|3]/a_60_290# sky130_fd_pr_reram__reram_cell area_ox=0.0676
X1477 BLZ3 rr3t3r_0[30|3]/a_460_290# sky130_fd_pr_reram__reram_cell area_ox=0.0676
X1478 rr3t3r_0[30|3]/a_460_290# WL30 SL3 VSS sky130_fd_pr__nfet_g5v0d10v5 ad=0.65 pd=3.3 as=0 ps=0 w=1 l=0.5
X1479 BLN3 rr3t3r_0[30|3]/a_860_290# sky130_fd_pr_reram__reram_cell area_ox=0.0676
X1480 rr3t3r_0[30|3]/a_60_290# WL30 SL3 VSS sky130_fd_pr__nfet_g5v0d10v5 ad=0.65 pd=3.3 as=0 ps=0 w=1 l=0.5
X1481 rr3t3r_0[30|3]/a_860_290# WL30 SL3 VSS sky130_fd_pr__nfet_g5v0d10v5 ad=0.65 pd=3.3 as=0 ps=0 w=1 l=0.5
X1482 BLP3 rr3t3r_0[31|3]/a_60_290# sky130_fd_pr_reram__reram_cell area_ox=0.0676
X1483 BLZ3 rr3t3r_0[31|3]/a_460_290# sky130_fd_pr_reram__reram_cell area_ox=0.0676
X1484 rr3t3r_0[31|3]/a_460_290# WL31 SL3 VSS sky130_fd_pr__nfet_g5v0d10v5 ad=0.65 pd=3.3 as=0 ps=0 w=1 l=0.5
X1485 BLN3 rr3t3r_0[31|3]/a_860_290# sky130_fd_pr_reram__reram_cell area_ox=0.0676
X1486 rr3t3r_0[31|3]/a_60_290# WL31 SL3 VSS sky130_fd_pr__nfet_g5v0d10v5 ad=0.65 pd=3.3 as=0 ps=0 w=1 l=0.5
X1487 rr3t3r_0[31|3]/a_860_290# WL31 SL3 VSS sky130_fd_pr__nfet_g5v0d10v5 ad=0.65 pd=3.3 as=0 ps=0 w=1 l=0.5
X1488 BLP3 rr3t3r_0[32|3]/a_60_290# sky130_fd_pr_reram__reram_cell area_ox=0.0676
X1489 BLZ3 rr3t3r_0[32|3]/a_460_290# sky130_fd_pr_reram__reram_cell area_ox=0.0676
X1490 rr3t3r_0[32|3]/a_460_290# WL32 SL3 VSS sky130_fd_pr__nfet_g5v0d10v5 ad=0.65 pd=3.3 as=0 ps=0 w=1 l=0.5
X1491 BLN3 rr3t3r_0[32|3]/a_860_290# sky130_fd_pr_reram__reram_cell area_ox=0.0676
X1492 rr3t3r_0[32|3]/a_60_290# WL32 SL3 VSS sky130_fd_pr__nfet_g5v0d10v5 ad=0.65 pd=3.3 as=0 ps=0 w=1 l=0.5
X1493 rr3t3r_0[32|3]/a_860_290# WL32 SL3 VSS sky130_fd_pr__nfet_g5v0d10v5 ad=0.65 pd=3.3 as=0 ps=0 w=1 l=0.5
X1494 BLP3 rr3t3r_0[33|3]/a_60_290# sky130_fd_pr_reram__reram_cell area_ox=0.0676
X1495 BLZ3 rr3t3r_0[33|3]/a_460_290# sky130_fd_pr_reram__reram_cell area_ox=0.0676
X1496 rr3t3r_0[33|3]/a_460_290# WL33 SL3 VSS sky130_fd_pr__nfet_g5v0d10v5 ad=0.65 pd=3.3 as=0 ps=0 w=1 l=0.5
X1497 BLN3 rr3t3r_0[33|3]/a_860_290# sky130_fd_pr_reram__reram_cell area_ox=0.0676
X1498 rr3t3r_0[33|3]/a_60_290# WL33 SL3 VSS sky130_fd_pr__nfet_g5v0d10v5 ad=0.65 pd=3.3 as=0 ps=0 w=1 l=0.5
X1499 rr3t3r_0[33|3]/a_860_290# WL33 SL3 VSS sky130_fd_pr__nfet_g5v0d10v5 ad=0.65 pd=3.3 as=0 ps=0 w=1 l=0.5
X1500 BLP3 rr3t3r_0[34|3]/a_60_290# sky130_fd_pr_reram__reram_cell area_ox=0.0676
X1501 BLZ3 rr3t3r_0[34|3]/a_460_290# sky130_fd_pr_reram__reram_cell area_ox=0.0676
X1502 rr3t3r_0[34|3]/a_460_290# WL34 SL3 VSS sky130_fd_pr__nfet_g5v0d10v5 ad=0.65 pd=3.3 as=0 ps=0 w=1 l=0.5
X1503 BLN3 rr3t3r_0[34|3]/a_860_290# sky130_fd_pr_reram__reram_cell area_ox=0.0676
X1504 rr3t3r_0[34|3]/a_60_290# WL34 SL3 VSS sky130_fd_pr__nfet_g5v0d10v5 ad=0.65 pd=3.3 as=0 ps=0 w=1 l=0.5
X1505 rr3t3r_0[34|3]/a_860_290# WL34 SL3 VSS sky130_fd_pr__nfet_g5v0d10v5 ad=0.65 pd=3.3 as=0 ps=0 w=1 l=0.5
X1506 BLP3 rr3t3r_0[35|3]/a_60_290# sky130_fd_pr_reram__reram_cell area_ox=0.0676
X1507 BLZ3 rr3t3r_0[35|3]/a_460_290# sky130_fd_pr_reram__reram_cell area_ox=0.0676
X1508 rr3t3r_0[35|3]/a_460_290# WL35 SL3 VSS sky130_fd_pr__nfet_g5v0d10v5 ad=0.65 pd=3.3 as=0 ps=0 w=1 l=0.5
X1509 BLN3 rr3t3r_0[35|3]/a_860_290# sky130_fd_pr_reram__reram_cell area_ox=0.0676
X1510 rr3t3r_0[35|3]/a_60_290# WL35 SL3 VSS sky130_fd_pr__nfet_g5v0d10v5 ad=0.65 pd=3.3 as=0 ps=0 w=1 l=0.5
X1511 rr3t3r_0[35|3]/a_860_290# WL35 SL3 VSS sky130_fd_pr__nfet_g5v0d10v5 ad=0.65 pd=3.3 as=0 ps=0 w=1 l=0.5
X1512 BLP3 rr3t3r_0[36|3]/a_60_290# sky130_fd_pr_reram__reram_cell area_ox=0.0676
X1513 BLZ3 rr3t3r_0[36|3]/a_460_290# sky130_fd_pr_reram__reram_cell area_ox=0.0676
X1514 rr3t3r_0[36|3]/a_460_290# WL36 SL3 VSS sky130_fd_pr__nfet_g5v0d10v5 ad=0.65 pd=3.3 as=0 ps=0 w=1 l=0.5
X1515 BLN3 rr3t3r_0[36|3]/a_860_290# sky130_fd_pr_reram__reram_cell area_ox=0.0676
X1516 rr3t3r_0[36|3]/a_60_290# WL36 SL3 VSS sky130_fd_pr__nfet_g5v0d10v5 ad=0.65 pd=3.3 as=0 ps=0 w=1 l=0.5
X1517 rr3t3r_0[36|3]/a_860_290# WL36 SL3 VSS sky130_fd_pr__nfet_g5v0d10v5 ad=0.65 pd=3.3 as=0 ps=0 w=1 l=0.5
X1518 BLP3 rr3t3r_0[37|3]/a_60_290# sky130_fd_pr_reram__reram_cell area_ox=0.0676
X1519 BLZ3 rr3t3r_0[37|3]/a_460_290# sky130_fd_pr_reram__reram_cell area_ox=0.0676
X1520 rr3t3r_0[37|3]/a_460_290# WL37 SL3 VSS sky130_fd_pr__nfet_g5v0d10v5 ad=0.65 pd=3.3 as=0 ps=0 w=1 l=0.5
X1521 BLN3 rr3t3r_0[37|3]/a_860_290# sky130_fd_pr_reram__reram_cell area_ox=0.0676
X1522 rr3t3r_0[37|3]/a_60_290# WL37 SL3 VSS sky130_fd_pr__nfet_g5v0d10v5 ad=0.65 pd=3.3 as=0 ps=0 w=1 l=0.5
X1523 rr3t3r_0[37|3]/a_860_290# WL37 SL3 VSS sky130_fd_pr__nfet_g5v0d10v5 ad=0.65 pd=3.3 as=0 ps=0 w=1 l=0.5
X1524 BLP3 rr3t3r_0[38|3]/a_60_290# sky130_fd_pr_reram__reram_cell area_ox=0.0676
X1525 BLZ3 rr3t3r_0[38|3]/a_460_290# sky130_fd_pr_reram__reram_cell area_ox=0.0676
X1526 rr3t3r_0[38|3]/a_460_290# WL38 SL3 VSS sky130_fd_pr__nfet_g5v0d10v5 ad=0.65 pd=3.3 as=0 ps=0 w=1 l=0.5
X1527 BLN3 rr3t3r_0[38|3]/a_860_290# sky130_fd_pr_reram__reram_cell area_ox=0.0676
X1528 rr3t3r_0[38|3]/a_60_290# WL38 SL3 VSS sky130_fd_pr__nfet_g5v0d10v5 ad=0.65 pd=3.3 as=0 ps=0 w=1 l=0.5
X1529 rr3t3r_0[38|3]/a_860_290# WL38 SL3 VSS sky130_fd_pr__nfet_g5v0d10v5 ad=0.65 pd=3.3 as=0 ps=0 w=1 l=0.5
X1530 BLP3 rr3t3r_0[39|3]/a_60_290# sky130_fd_pr_reram__reram_cell area_ox=0.0676
X1531 BLZ3 rr3t3r_0[39|3]/a_460_290# sky130_fd_pr_reram__reram_cell area_ox=0.0676
X1532 rr3t3r_0[39|3]/a_460_290# WL39 SL3 VSS sky130_fd_pr__nfet_g5v0d10v5 ad=0.65 pd=3.3 as=0 ps=0 w=1 l=0.5
X1533 BLN3 rr3t3r_0[39|3]/a_860_290# sky130_fd_pr_reram__reram_cell area_ox=0.0676
X1534 rr3t3r_0[39|3]/a_60_290# WL39 SL3 VSS sky130_fd_pr__nfet_g5v0d10v5 ad=0.65 pd=3.3 as=0 ps=0 w=1 l=0.5
X1535 rr3t3r_0[39|3]/a_860_290# WL39 SL3 VSS sky130_fd_pr__nfet_g5v0d10v5 ad=0.65 pd=3.3 as=0 ps=0 w=1 l=0.5
X1536 BLP3 rr3t3r_0[40|3]/a_60_290# sky130_fd_pr_reram__reram_cell area_ox=0.0676
X1537 BLZ3 rr3t3r_0[40|3]/a_460_290# sky130_fd_pr_reram__reram_cell area_ox=0.0676
X1538 rr3t3r_0[40|3]/a_460_290# WL40 SL3 VSS sky130_fd_pr__nfet_g5v0d10v5 ad=0.65 pd=3.3 as=0 ps=0 w=1 l=0.5
X1539 BLN3 rr3t3r_0[40|3]/a_860_290# sky130_fd_pr_reram__reram_cell area_ox=0.0676
X1540 rr3t3r_0[40|3]/a_60_290# WL40 SL3 VSS sky130_fd_pr__nfet_g5v0d10v5 ad=0.65 pd=3.3 as=0 ps=0 w=1 l=0.5
X1541 rr3t3r_0[40|3]/a_860_290# WL40 SL3 VSS sky130_fd_pr__nfet_g5v0d10v5 ad=0.65 pd=3.3 as=0 ps=0 w=1 l=0.5
X1542 BLP3 rr3t3r_0[41|3]/a_60_290# sky130_fd_pr_reram__reram_cell area_ox=0.0676
X1543 BLZ3 rr3t3r_0[41|3]/a_460_290# sky130_fd_pr_reram__reram_cell area_ox=0.0676
X1544 rr3t3r_0[41|3]/a_460_290# WL41 SL3 VSS sky130_fd_pr__nfet_g5v0d10v5 ad=0.65 pd=3.3 as=0 ps=0 w=1 l=0.5
X1545 BLN3 rr3t3r_0[41|3]/a_860_290# sky130_fd_pr_reram__reram_cell area_ox=0.0676
X1546 rr3t3r_0[41|3]/a_60_290# WL41 SL3 VSS sky130_fd_pr__nfet_g5v0d10v5 ad=0.65 pd=3.3 as=0 ps=0 w=1 l=0.5
X1547 rr3t3r_0[41|3]/a_860_290# WL41 SL3 VSS sky130_fd_pr__nfet_g5v0d10v5 ad=0.65 pd=3.3 as=0 ps=0 w=1 l=0.5
X1548 BLP3 rr3t3r_0[42|3]/a_60_290# sky130_fd_pr_reram__reram_cell area_ox=0.0676
X1549 BLZ3 rr3t3r_0[42|3]/a_460_290# sky130_fd_pr_reram__reram_cell area_ox=0.0676
X1550 rr3t3r_0[42|3]/a_460_290# WL42 SL3 VSS sky130_fd_pr__nfet_g5v0d10v5 ad=0.65 pd=3.3 as=0 ps=0 w=1 l=0.5
X1551 BLN3 rr3t3r_0[42|3]/a_860_290# sky130_fd_pr_reram__reram_cell area_ox=0.0676
X1552 rr3t3r_0[42|3]/a_60_290# WL42 SL3 VSS sky130_fd_pr__nfet_g5v0d10v5 ad=0.65 pd=3.3 as=0 ps=0 w=1 l=0.5
X1553 rr3t3r_0[42|3]/a_860_290# WL42 SL3 VSS sky130_fd_pr__nfet_g5v0d10v5 ad=0.65 pd=3.3 as=0 ps=0 w=1 l=0.5
X1554 BLP3 rr3t3r_0[43|3]/a_60_290# sky130_fd_pr_reram__reram_cell area_ox=0.0676
X1555 BLZ3 rr3t3r_0[43|3]/a_460_290# sky130_fd_pr_reram__reram_cell area_ox=0.0676
X1556 rr3t3r_0[43|3]/a_460_290# WL43 SL3 VSS sky130_fd_pr__nfet_g5v0d10v5 ad=0.65 pd=3.3 as=0 ps=0 w=1 l=0.5
X1557 BLN3 rr3t3r_0[43|3]/a_860_290# sky130_fd_pr_reram__reram_cell area_ox=0.0676
X1558 rr3t3r_0[43|3]/a_60_290# WL43 SL3 VSS sky130_fd_pr__nfet_g5v0d10v5 ad=0.65 pd=3.3 as=0 ps=0 w=1 l=0.5
X1559 rr3t3r_0[43|3]/a_860_290# WL43 SL3 VSS sky130_fd_pr__nfet_g5v0d10v5 ad=0.65 pd=3.3 as=0 ps=0 w=1 l=0.5
X1560 BLP3 rr3t3r_0[44|3]/a_60_290# sky130_fd_pr_reram__reram_cell area_ox=0.0676
X1561 BLZ3 rr3t3r_0[44|3]/a_460_290# sky130_fd_pr_reram__reram_cell area_ox=0.0676
X1562 rr3t3r_0[44|3]/a_460_290# WL44 SL3 VSS sky130_fd_pr__nfet_g5v0d10v5 ad=0.65 pd=3.3 as=0 ps=0 w=1 l=0.5
X1563 BLN3 rr3t3r_0[44|3]/a_860_290# sky130_fd_pr_reram__reram_cell area_ox=0.0676
X1564 rr3t3r_0[44|3]/a_60_290# WL44 SL3 VSS sky130_fd_pr__nfet_g5v0d10v5 ad=0.65 pd=3.3 as=0 ps=0 w=1 l=0.5
X1565 rr3t3r_0[44|3]/a_860_290# WL44 SL3 VSS sky130_fd_pr__nfet_g5v0d10v5 ad=0.65 pd=3.3 as=0 ps=0 w=1 l=0.5
X1566 BLP3 rr3t3r_0[45|3]/a_60_290# sky130_fd_pr_reram__reram_cell area_ox=0.0676
X1567 BLZ3 rr3t3r_0[45|3]/a_460_290# sky130_fd_pr_reram__reram_cell area_ox=0.0676
X1568 rr3t3r_0[45|3]/a_460_290# WL45 SL3 VSS sky130_fd_pr__nfet_g5v0d10v5 ad=0.65 pd=3.3 as=0 ps=0 w=1 l=0.5
X1569 BLN3 rr3t3r_0[45|3]/a_860_290# sky130_fd_pr_reram__reram_cell area_ox=0.0676
X1570 rr3t3r_0[45|3]/a_60_290# WL45 SL3 VSS sky130_fd_pr__nfet_g5v0d10v5 ad=0.65 pd=3.3 as=0 ps=0 w=1 l=0.5
X1571 rr3t3r_0[45|3]/a_860_290# WL45 SL3 VSS sky130_fd_pr__nfet_g5v0d10v5 ad=0.65 pd=3.3 as=0 ps=0 w=1 l=0.5
X1572 BLP3 rr3t3r_0[46|3]/a_60_290# sky130_fd_pr_reram__reram_cell area_ox=0.0676
X1573 BLZ3 rr3t3r_0[46|3]/a_460_290# sky130_fd_pr_reram__reram_cell area_ox=0.0676
X1574 rr3t3r_0[46|3]/a_460_290# WL46 SL3 VSS sky130_fd_pr__nfet_g5v0d10v5 ad=0.65 pd=3.3 as=0 ps=0 w=1 l=0.5
X1575 BLN3 rr3t3r_0[46|3]/a_860_290# sky130_fd_pr_reram__reram_cell area_ox=0.0676
X1576 rr3t3r_0[46|3]/a_60_290# WL46 SL3 VSS sky130_fd_pr__nfet_g5v0d10v5 ad=0.65 pd=3.3 as=0 ps=0 w=1 l=0.5
X1577 rr3t3r_0[46|3]/a_860_290# WL46 SL3 VSS sky130_fd_pr__nfet_g5v0d10v5 ad=0.65 pd=3.3 as=0 ps=0 w=1 l=0.5
X1578 BLP3 rr3t3r_0[47|3]/a_60_290# sky130_fd_pr_reram__reram_cell area_ox=0.0676
X1579 BLZ3 rr3t3r_0[47|3]/a_460_290# sky130_fd_pr_reram__reram_cell area_ox=0.0676
X1580 rr3t3r_0[47|3]/a_460_290# WL47 SL3 VSS sky130_fd_pr__nfet_g5v0d10v5 ad=0.65 pd=3.3 as=0 ps=0 w=1 l=0.5
X1581 BLN3 rr3t3r_0[47|3]/a_860_290# sky130_fd_pr_reram__reram_cell area_ox=0.0676
X1582 rr3t3r_0[47|3]/a_60_290# WL47 SL3 VSS sky130_fd_pr__nfet_g5v0d10v5 ad=0.65 pd=3.3 as=0 ps=0 w=1 l=0.5
X1583 rr3t3r_0[47|3]/a_860_290# WL47 SL3 VSS sky130_fd_pr__nfet_g5v0d10v5 ad=0.65 pd=3.3 as=0 ps=0 w=1 l=0.5
X1584 BLP3 rr3t3r_0[48|3]/a_60_290# sky130_fd_pr_reram__reram_cell area_ox=0.0676
X1585 BLZ3 rr3t3r_0[48|3]/a_460_290# sky130_fd_pr_reram__reram_cell area_ox=0.0676
X1586 rr3t3r_0[48|3]/a_460_290# WL48 SL3 VSS sky130_fd_pr__nfet_g5v0d10v5 ad=0.65 pd=3.3 as=0 ps=0 w=1 l=0.5
X1587 BLN3 rr3t3r_0[48|3]/a_860_290# sky130_fd_pr_reram__reram_cell area_ox=0.0676
X1588 rr3t3r_0[48|3]/a_60_290# WL48 SL3 VSS sky130_fd_pr__nfet_g5v0d10v5 ad=0.65 pd=3.3 as=0 ps=0 w=1 l=0.5
X1589 rr3t3r_0[48|3]/a_860_290# WL48 SL3 VSS sky130_fd_pr__nfet_g5v0d10v5 ad=0.65 pd=3.3 as=0 ps=0 w=1 l=0.5
X1590 BLP3 rr3t3r_0[49|3]/a_60_290# sky130_fd_pr_reram__reram_cell area_ox=0.0676
X1591 BLZ3 rr3t3r_0[49|3]/a_460_290# sky130_fd_pr_reram__reram_cell area_ox=0.0676
X1592 rr3t3r_0[49|3]/a_460_290# WL49 SL3 VSS sky130_fd_pr__nfet_g5v0d10v5 ad=0.65 pd=3.3 as=0 ps=0 w=1 l=0.5
X1593 BLN3 rr3t3r_0[49|3]/a_860_290# sky130_fd_pr_reram__reram_cell area_ox=0.0676
X1594 rr3t3r_0[49|3]/a_60_290# WL49 SL3 VSS sky130_fd_pr__nfet_g5v0d10v5 ad=0.65 pd=3.3 as=0 ps=0 w=1 l=0.5
X1595 rr3t3r_0[49|3]/a_860_290# WL49 SL3 VSS sky130_fd_pr__nfet_g5v0d10v5 ad=0.65 pd=3.3 as=0 ps=0 w=1 l=0.5
X1596 BLP3 rr3t3r_0[50|3]/a_60_290# sky130_fd_pr_reram__reram_cell area_ox=0.0676
X1597 BLZ3 rr3t3r_0[50|3]/a_460_290# sky130_fd_pr_reram__reram_cell area_ox=0.0676
X1598 rr3t3r_0[50|3]/a_460_290# WL50 SL3 VSS sky130_fd_pr__nfet_g5v0d10v5 ad=0.65 pd=3.3 as=0 ps=0 w=1 l=0.5
X1599 BLN3 rr3t3r_0[50|3]/a_860_290# sky130_fd_pr_reram__reram_cell area_ox=0.0676
X1600 rr3t3r_0[50|3]/a_60_290# WL50 SL3 VSS sky130_fd_pr__nfet_g5v0d10v5 ad=0.65 pd=3.3 as=0 ps=0 w=1 l=0.5
X1601 rr3t3r_0[50|3]/a_860_290# WL50 SL3 VSS sky130_fd_pr__nfet_g5v0d10v5 ad=0.65 pd=3.3 as=0 ps=0 w=1 l=0.5
X1602 BLP3 rr3t3r_0[51|3]/a_60_290# sky130_fd_pr_reram__reram_cell area_ox=0.0676
X1603 BLZ3 rr3t3r_0[51|3]/a_460_290# sky130_fd_pr_reram__reram_cell area_ox=0.0676
X1604 rr3t3r_0[51|3]/a_460_290# WL51 SL3 VSS sky130_fd_pr__nfet_g5v0d10v5 ad=0.65 pd=3.3 as=0 ps=0 w=1 l=0.5
X1605 BLN3 rr3t3r_0[51|3]/a_860_290# sky130_fd_pr_reram__reram_cell area_ox=0.0676
X1606 rr3t3r_0[51|3]/a_60_290# WL51 SL3 VSS sky130_fd_pr__nfet_g5v0d10v5 ad=0.65 pd=3.3 as=0 ps=0 w=1 l=0.5
X1607 rr3t3r_0[51|3]/a_860_290# WL51 SL3 VSS sky130_fd_pr__nfet_g5v0d10v5 ad=0.65 pd=3.3 as=0 ps=0 w=1 l=0.5
X1608 BLP3 rr3t3r_0[52|3]/a_60_290# sky130_fd_pr_reram__reram_cell area_ox=0.0676
X1609 BLZ3 rr3t3r_0[52|3]/a_460_290# sky130_fd_pr_reram__reram_cell area_ox=0.0676
X1610 rr3t3r_0[52|3]/a_460_290# WL52 SL3 VSS sky130_fd_pr__nfet_g5v0d10v5 ad=0.65 pd=3.3 as=0 ps=0 w=1 l=0.5
X1611 BLN3 rr3t3r_0[52|3]/a_860_290# sky130_fd_pr_reram__reram_cell area_ox=0.0676
X1612 rr3t3r_0[52|3]/a_60_290# WL52 SL3 VSS sky130_fd_pr__nfet_g5v0d10v5 ad=0.65 pd=3.3 as=0 ps=0 w=1 l=0.5
X1613 rr3t3r_0[52|3]/a_860_290# WL52 SL3 VSS sky130_fd_pr__nfet_g5v0d10v5 ad=0.65 pd=3.3 as=0 ps=0 w=1 l=0.5
X1614 BLP3 rr3t3r_0[53|3]/a_60_290# sky130_fd_pr_reram__reram_cell area_ox=0.0676
X1615 BLZ3 rr3t3r_0[53|3]/a_460_290# sky130_fd_pr_reram__reram_cell area_ox=0.0676
X1616 rr3t3r_0[53|3]/a_460_290# WL53 SL3 VSS sky130_fd_pr__nfet_g5v0d10v5 ad=0.65 pd=3.3 as=0 ps=0 w=1 l=0.5
X1617 BLN3 rr3t3r_0[53|3]/a_860_290# sky130_fd_pr_reram__reram_cell area_ox=0.0676
X1618 rr3t3r_0[53|3]/a_60_290# WL53 SL3 VSS sky130_fd_pr__nfet_g5v0d10v5 ad=0.65 pd=3.3 as=0 ps=0 w=1 l=0.5
X1619 rr3t3r_0[53|3]/a_860_290# WL53 SL3 VSS sky130_fd_pr__nfet_g5v0d10v5 ad=0.65 pd=3.3 as=0 ps=0 w=1 l=0.5
X1620 BLP3 rr3t3r_0[54|3]/a_60_290# sky130_fd_pr_reram__reram_cell area_ox=0.0676
X1621 BLZ3 rr3t3r_0[54|3]/a_460_290# sky130_fd_pr_reram__reram_cell area_ox=0.0676
X1622 rr3t3r_0[54|3]/a_460_290# WL54 SL3 VSS sky130_fd_pr__nfet_g5v0d10v5 ad=0.65 pd=3.3 as=0 ps=0 w=1 l=0.5
X1623 BLN3 rr3t3r_0[54|3]/a_860_290# sky130_fd_pr_reram__reram_cell area_ox=0.0676
X1624 rr3t3r_0[54|3]/a_60_290# WL54 SL3 VSS sky130_fd_pr__nfet_g5v0d10v5 ad=0.65 pd=3.3 as=0 ps=0 w=1 l=0.5
X1625 rr3t3r_0[54|3]/a_860_290# WL54 SL3 VSS sky130_fd_pr__nfet_g5v0d10v5 ad=0.65 pd=3.3 as=0 ps=0 w=1 l=0.5
X1626 BLP3 rr3t3r_0[55|3]/a_60_290# sky130_fd_pr_reram__reram_cell area_ox=0.0676
X1627 BLZ3 rr3t3r_0[55|3]/a_460_290# sky130_fd_pr_reram__reram_cell area_ox=0.0676
X1628 rr3t3r_0[55|3]/a_460_290# WL55 SL3 VSS sky130_fd_pr__nfet_g5v0d10v5 ad=0.65 pd=3.3 as=0 ps=0 w=1 l=0.5
X1629 BLN3 rr3t3r_0[55|3]/a_860_290# sky130_fd_pr_reram__reram_cell area_ox=0.0676
X1630 rr3t3r_0[55|3]/a_60_290# WL55 SL3 VSS sky130_fd_pr__nfet_g5v0d10v5 ad=0.65 pd=3.3 as=0 ps=0 w=1 l=0.5
X1631 rr3t3r_0[55|3]/a_860_290# WL55 SL3 VSS sky130_fd_pr__nfet_g5v0d10v5 ad=0.65 pd=3.3 as=0 ps=0 w=1 l=0.5
X1632 BLP3 rr3t3r_0[56|3]/a_60_290# sky130_fd_pr_reram__reram_cell area_ox=0.0676
X1633 BLZ3 rr3t3r_0[56|3]/a_460_290# sky130_fd_pr_reram__reram_cell area_ox=0.0676
X1634 rr3t3r_0[56|3]/a_460_290# WL56 SL3 VSS sky130_fd_pr__nfet_g5v0d10v5 ad=0.65 pd=3.3 as=0 ps=0 w=1 l=0.5
X1635 BLN3 rr3t3r_0[56|3]/a_860_290# sky130_fd_pr_reram__reram_cell area_ox=0.0676
X1636 rr3t3r_0[56|3]/a_60_290# WL56 SL3 VSS sky130_fd_pr__nfet_g5v0d10v5 ad=0.65 pd=3.3 as=0 ps=0 w=1 l=0.5
X1637 rr3t3r_0[56|3]/a_860_290# WL56 SL3 VSS sky130_fd_pr__nfet_g5v0d10v5 ad=0.65 pd=3.3 as=0 ps=0 w=1 l=0.5
X1638 BLP3 rr3t3r_0[57|3]/a_60_290# sky130_fd_pr_reram__reram_cell area_ox=0.0676
X1639 BLZ3 rr3t3r_0[57|3]/a_460_290# sky130_fd_pr_reram__reram_cell area_ox=0.0676
X1640 rr3t3r_0[57|3]/a_460_290# WL57 SL3 VSS sky130_fd_pr__nfet_g5v0d10v5 ad=0.65 pd=3.3 as=0 ps=0 w=1 l=0.5
X1641 BLN3 rr3t3r_0[57|3]/a_860_290# sky130_fd_pr_reram__reram_cell area_ox=0.0676
X1642 rr3t3r_0[57|3]/a_60_290# WL57 SL3 VSS sky130_fd_pr__nfet_g5v0d10v5 ad=0.65 pd=3.3 as=0 ps=0 w=1 l=0.5
X1643 rr3t3r_0[57|3]/a_860_290# WL57 SL3 VSS sky130_fd_pr__nfet_g5v0d10v5 ad=0.65 pd=3.3 as=0 ps=0 w=1 l=0.5
X1644 BLP3 rr3t3r_0[58|3]/a_60_290# sky130_fd_pr_reram__reram_cell area_ox=0.0676
X1645 BLZ3 rr3t3r_0[58|3]/a_460_290# sky130_fd_pr_reram__reram_cell area_ox=0.0676
X1646 rr3t3r_0[58|3]/a_460_290# WL58 SL3 VSS sky130_fd_pr__nfet_g5v0d10v5 ad=0.65 pd=3.3 as=0 ps=0 w=1 l=0.5
X1647 BLN3 rr3t3r_0[58|3]/a_860_290# sky130_fd_pr_reram__reram_cell area_ox=0.0676
X1648 rr3t3r_0[58|3]/a_60_290# WL58 SL3 VSS sky130_fd_pr__nfet_g5v0d10v5 ad=0.65 pd=3.3 as=0 ps=0 w=1 l=0.5
X1649 rr3t3r_0[58|3]/a_860_290# WL58 SL3 VSS sky130_fd_pr__nfet_g5v0d10v5 ad=0.65 pd=3.3 as=0 ps=0 w=1 l=0.5
X1650 BLP3 rr3t3r_0[59|3]/a_60_290# sky130_fd_pr_reram__reram_cell area_ox=0.0676
X1651 BLZ3 rr3t3r_0[59|3]/a_460_290# sky130_fd_pr_reram__reram_cell area_ox=0.0676
X1652 rr3t3r_0[59|3]/a_460_290# WL59 SL3 VSS sky130_fd_pr__nfet_g5v0d10v5 ad=0.65 pd=3.3 as=0 ps=0 w=1 l=0.5
X1653 BLN3 rr3t3r_0[59|3]/a_860_290# sky130_fd_pr_reram__reram_cell area_ox=0.0676
X1654 rr3t3r_0[59|3]/a_60_290# WL59 SL3 VSS sky130_fd_pr__nfet_g5v0d10v5 ad=0.65 pd=3.3 as=0 ps=0 w=1 l=0.5
X1655 rr3t3r_0[59|3]/a_860_290# WL59 SL3 VSS sky130_fd_pr__nfet_g5v0d10v5 ad=0.65 pd=3.3 as=0 ps=0 w=1 l=0.5
X1656 BLP3 rr3t3r_0[60|3]/a_60_290# sky130_fd_pr_reram__reram_cell area_ox=0.0676
X1657 BLZ3 rr3t3r_0[60|3]/a_460_290# sky130_fd_pr_reram__reram_cell area_ox=0.0676
X1658 rr3t3r_0[60|3]/a_460_290# WL60 SL3 VSS sky130_fd_pr__nfet_g5v0d10v5 ad=0.65 pd=3.3 as=0 ps=0 w=1 l=0.5
X1659 BLN3 rr3t3r_0[60|3]/a_860_290# sky130_fd_pr_reram__reram_cell area_ox=0.0676
X1660 rr3t3r_0[60|3]/a_60_290# WL60 SL3 VSS sky130_fd_pr__nfet_g5v0d10v5 ad=0.65 pd=3.3 as=0 ps=0 w=1 l=0.5
X1661 rr3t3r_0[60|3]/a_860_290# WL60 SL3 VSS sky130_fd_pr__nfet_g5v0d10v5 ad=0.65 pd=3.3 as=0 ps=0 w=1 l=0.5
X1662 BLP3 rr3t3r_0[61|3]/a_60_290# sky130_fd_pr_reram__reram_cell area_ox=0.0676
X1663 BLZ3 rr3t3r_0[61|3]/a_460_290# sky130_fd_pr_reram__reram_cell area_ox=0.0676
X1664 rr3t3r_0[61|3]/a_460_290# WL61 SL3 VSS sky130_fd_pr__nfet_g5v0d10v5 ad=0.65 pd=3.3 as=0 ps=0 w=1 l=0.5
X1665 BLN3 rr3t3r_0[61|3]/a_860_290# sky130_fd_pr_reram__reram_cell area_ox=0.0676
X1666 rr3t3r_0[61|3]/a_60_290# WL61 SL3 VSS sky130_fd_pr__nfet_g5v0d10v5 ad=0.65 pd=3.3 as=0 ps=0 w=1 l=0.5
X1667 rr3t3r_0[61|3]/a_860_290# WL61 SL3 VSS sky130_fd_pr__nfet_g5v0d10v5 ad=0.65 pd=3.3 as=0 ps=0 w=1 l=0.5
X1668 BLP3 rr3t3r_0[62|3]/a_60_290# sky130_fd_pr_reram__reram_cell area_ox=0.0676
X1669 BLZ3 rr3t3r_0[62|3]/a_460_290# sky130_fd_pr_reram__reram_cell area_ox=0.0676
X1670 rr3t3r_0[62|3]/a_460_290# WL62 SL3 VSS sky130_fd_pr__nfet_g5v0d10v5 ad=0.65 pd=3.3 as=0 ps=0 w=1 l=0.5
X1671 BLN3 rr3t3r_0[62|3]/a_860_290# sky130_fd_pr_reram__reram_cell area_ox=0.0676
X1672 rr3t3r_0[62|3]/a_60_290# WL62 SL3 VSS sky130_fd_pr__nfet_g5v0d10v5 ad=0.65 pd=3.3 as=0 ps=0 w=1 l=0.5
X1673 rr3t3r_0[62|3]/a_860_290# WL62 SL3 VSS sky130_fd_pr__nfet_g5v0d10v5 ad=0.65 pd=3.3 as=0 ps=0 w=1 l=0.5
X1674 BLP3 rr3t3r_0[63|3]/a_60_290# sky130_fd_pr_reram__reram_cell area_ox=0.0676
X1675 BLZ3 rr3t3r_0[63|3]/a_460_290# sky130_fd_pr_reram__reram_cell area_ox=0.0676
X1676 rr3t3r_0[63|3]/a_460_290# WL63 SL3 VSS sky130_fd_pr__nfet_g5v0d10v5 ad=0.65 pd=3.3 as=0 ps=0 w=1 l=0.5
X1677 BLN3 rr3t3r_0[63|3]/a_860_290# sky130_fd_pr_reram__reram_cell area_ox=0.0676
X1678 rr3t3r_0[63|3]/a_60_290# WL63 SL3 VSS sky130_fd_pr__nfet_g5v0d10v5 ad=0.65 pd=3.3 as=0 ps=0 w=1 l=0.5
X1679 rr3t3r_0[63|3]/a_860_290# WL63 SL3 VSS sky130_fd_pr__nfet_g5v0d10v5 ad=0.65 pd=3.3 as=0 ps=0 w=1 l=0.5
X1680 BLP3 rr3t3r_0[64|3]/a_60_290# sky130_fd_pr_reram__reram_cell area_ox=0.0676
X1681 BLZ3 rr3t3r_0[64|3]/a_460_290# sky130_fd_pr_reram__reram_cell area_ox=0.0676
X1682 rr3t3r_0[64|3]/a_460_290# WL64 SL3 VSS sky130_fd_pr__nfet_g5v0d10v5 ad=0.65 pd=3.3 as=0 ps=0 w=1 l=0.5
X1683 BLN3 rr3t3r_0[64|3]/a_860_290# sky130_fd_pr_reram__reram_cell area_ox=0.0676
X1684 rr3t3r_0[64|3]/a_60_290# WL64 SL3 VSS sky130_fd_pr__nfet_g5v0d10v5 ad=0.65 pd=3.3 as=0 ps=0 w=1 l=0.5
X1685 rr3t3r_0[64|3]/a_860_290# WL64 SL3 VSS sky130_fd_pr__nfet_g5v0d10v5 ad=0.65 pd=3.3 as=0 ps=0 w=1 l=0.5
X1686 BLP3 rr3t3r_0[65|3]/a_60_290# sky130_fd_pr_reram__reram_cell area_ox=0.0676
X1687 BLZ3 rr3t3r_0[65|3]/a_460_290# sky130_fd_pr_reram__reram_cell area_ox=0.0676
X1688 rr3t3r_0[65|3]/a_460_290# WL65 SL3 VSS sky130_fd_pr__nfet_g5v0d10v5 ad=0.65 pd=3.3 as=0 ps=0 w=1 l=0.5
X1689 BLN3 rr3t3r_0[65|3]/a_860_290# sky130_fd_pr_reram__reram_cell area_ox=0.0676
X1690 rr3t3r_0[65|3]/a_60_290# WL65 SL3 VSS sky130_fd_pr__nfet_g5v0d10v5 ad=0.65 pd=3.3 as=0 ps=0 w=1 l=0.5
X1691 rr3t3r_0[65|3]/a_860_290# WL65 SL3 VSS sky130_fd_pr__nfet_g5v0d10v5 ad=0.65 pd=3.3 as=0 ps=0 w=1 l=0.5
X1692 BLP3 rr3t3r_0[66|3]/a_60_290# sky130_fd_pr_reram__reram_cell area_ox=0.0676
X1693 BLZ3 rr3t3r_0[66|3]/a_460_290# sky130_fd_pr_reram__reram_cell area_ox=0.0676
X1694 rr3t3r_0[66|3]/a_460_290# WL66 SL3 VSS sky130_fd_pr__nfet_g5v0d10v5 ad=0.65 pd=3.3 as=0 ps=0 w=1 l=0.5
X1695 BLN3 rr3t3r_0[66|3]/a_860_290# sky130_fd_pr_reram__reram_cell area_ox=0.0676
X1696 rr3t3r_0[66|3]/a_60_290# WL66 SL3 VSS sky130_fd_pr__nfet_g5v0d10v5 ad=0.65 pd=3.3 as=0 ps=0 w=1 l=0.5
X1697 rr3t3r_0[66|3]/a_860_290# WL66 SL3 VSS sky130_fd_pr__nfet_g5v0d10v5 ad=0.65 pd=3.3 as=0 ps=0 w=1 l=0.5
X1698 BLP3 rr3t3r_0[67|3]/a_60_290# sky130_fd_pr_reram__reram_cell area_ox=0.0676
X1699 BLZ3 rr3t3r_0[67|3]/a_460_290# sky130_fd_pr_reram__reram_cell area_ox=0.0676
X1700 rr3t3r_0[67|3]/a_460_290# WL67 SL3 VSS sky130_fd_pr__nfet_g5v0d10v5 ad=0.65 pd=3.3 as=0 ps=0 w=1 l=0.5
X1701 BLN3 rr3t3r_0[67|3]/a_860_290# sky130_fd_pr_reram__reram_cell area_ox=0.0676
X1702 rr3t3r_0[67|3]/a_60_290# WL67 SL3 VSS sky130_fd_pr__nfet_g5v0d10v5 ad=0.65 pd=3.3 as=0 ps=0 w=1 l=0.5
X1703 rr3t3r_0[67|3]/a_860_290# WL67 SL3 VSS sky130_fd_pr__nfet_g5v0d10v5 ad=0.65 pd=3.3 as=0 ps=0 w=1 l=0.5
X1704 BLP3 rr3t3r_0[68|3]/a_60_290# sky130_fd_pr_reram__reram_cell area_ox=0.0676
X1705 BLZ3 rr3t3r_0[68|3]/a_460_290# sky130_fd_pr_reram__reram_cell area_ox=0.0676
X1706 rr3t3r_0[68|3]/a_460_290# WL68 SL3 VSS sky130_fd_pr__nfet_g5v0d10v5 ad=0.65 pd=3.3 as=0 ps=0 w=1 l=0.5
X1707 BLN3 rr3t3r_0[68|3]/a_860_290# sky130_fd_pr_reram__reram_cell area_ox=0.0676
X1708 rr3t3r_0[68|3]/a_60_290# WL68 SL3 VSS sky130_fd_pr__nfet_g5v0d10v5 ad=0.65 pd=3.3 as=0 ps=0 w=1 l=0.5
X1709 rr3t3r_0[68|3]/a_860_290# WL68 SL3 VSS sky130_fd_pr__nfet_g5v0d10v5 ad=0.65 pd=3.3 as=0 ps=0 w=1 l=0.5
X1710 BLP3 rr3t3r_0[69|3]/a_60_290# sky130_fd_pr_reram__reram_cell area_ox=0.0676
X1711 BLZ3 rr3t3r_0[69|3]/a_460_290# sky130_fd_pr_reram__reram_cell area_ox=0.0676
X1712 rr3t3r_0[69|3]/a_460_290# WL69 SL3 VSS sky130_fd_pr__nfet_g5v0d10v5 ad=0.65 pd=3.3 as=0 ps=0 w=1 l=0.5
X1713 BLN3 rr3t3r_0[69|3]/a_860_290# sky130_fd_pr_reram__reram_cell area_ox=0.0676
X1714 rr3t3r_0[69|3]/a_60_290# WL69 SL3 VSS sky130_fd_pr__nfet_g5v0d10v5 ad=0.65 pd=3.3 as=0 ps=0 w=1 l=0.5
X1715 rr3t3r_0[69|3]/a_860_290# WL69 SL3 VSS sky130_fd_pr__nfet_g5v0d10v5 ad=0.65 pd=3.3 as=0 ps=0 w=1 l=0.5
X1716 BLP3 rr3t3r_0[70|3]/a_60_290# sky130_fd_pr_reram__reram_cell area_ox=0.0676
X1717 BLZ3 rr3t3r_0[70|3]/a_460_290# sky130_fd_pr_reram__reram_cell area_ox=0.0676
X1718 rr3t3r_0[70|3]/a_460_290# WL70 SL3 VSS sky130_fd_pr__nfet_g5v0d10v5 ad=0.65 pd=3.3 as=0 ps=0 w=1 l=0.5
X1719 BLN3 rr3t3r_0[70|3]/a_860_290# sky130_fd_pr_reram__reram_cell area_ox=0.0676
X1720 rr3t3r_0[70|3]/a_60_290# WL70 SL3 VSS sky130_fd_pr__nfet_g5v0d10v5 ad=0.65 pd=3.3 as=0 ps=0 w=1 l=0.5
X1721 rr3t3r_0[70|3]/a_860_290# WL70 SL3 VSS sky130_fd_pr__nfet_g5v0d10v5 ad=0.65 pd=3.3 as=0 ps=0 w=1 l=0.5
X1722 BLP3 rr3t3r_0[71|3]/a_60_290# sky130_fd_pr_reram__reram_cell area_ox=0.0676
X1723 BLZ3 rr3t3r_0[71|3]/a_460_290# sky130_fd_pr_reram__reram_cell area_ox=0.0676
X1724 rr3t3r_0[71|3]/a_460_290# WL71 SL3 VSS sky130_fd_pr__nfet_g5v0d10v5 ad=0.65 pd=3.3 as=0 ps=0 w=1 l=0.5
X1725 BLN3 rr3t3r_0[71|3]/a_860_290# sky130_fd_pr_reram__reram_cell area_ox=0.0676
X1726 rr3t3r_0[71|3]/a_60_290# WL71 SL3 VSS sky130_fd_pr__nfet_g5v0d10v5 ad=0.65 pd=3.3 as=0 ps=0 w=1 l=0.5
X1727 rr3t3r_0[71|3]/a_860_290# WL71 SL3 VSS sky130_fd_pr__nfet_g5v0d10v5 ad=0.65 pd=3.3 as=0 ps=0 w=1 l=0.5
X1728 BLP4 rr3t3r_0[0|4]/a_60_290# sky130_fd_pr_reram__reram_cell area_ox=0.0676
X1729 BLZ4 rr3t3r_0[0|4]/a_460_290# sky130_fd_pr_reram__reram_cell area_ox=0.0676
X1730 rr3t3r_0[0|4]/a_460_290# WL0 SL4 VSS sky130_fd_pr__nfet_g5v0d10v5 ad=0.65 pd=3.3 as=162 ps=756 w=1 l=0.5
X1731 BLN4 rr3t3r_0[0|4]/a_860_290# sky130_fd_pr_reram__reram_cell area_ox=0.0676
X1732 rr3t3r_0[0|4]/a_60_290# WL0 SL4 VSS sky130_fd_pr__nfet_g5v0d10v5 ad=0.65 pd=3.3 as=0 ps=0 w=1 l=0.5
X1733 rr3t3r_0[0|4]/a_860_290# WL0 SL4 VSS sky130_fd_pr__nfet_g5v0d10v5 ad=0.65 pd=3.3 as=0 ps=0 w=1 l=0.5
X1734 BLP4 rr3t3r_0[1|4]/a_60_290# sky130_fd_pr_reram__reram_cell area_ox=0.0676
X1735 BLZ4 rr3t3r_0[1|4]/a_460_290# sky130_fd_pr_reram__reram_cell area_ox=0.0676
X1736 rr3t3r_0[1|4]/a_460_290# WL1 SL4 VSS sky130_fd_pr__nfet_g5v0d10v5 ad=0.65 pd=3.3 as=0 ps=0 w=1 l=0.5
X1737 BLN4 rr3t3r_0[1|4]/a_860_290# sky130_fd_pr_reram__reram_cell area_ox=0.0676
X1738 rr3t3r_0[1|4]/a_60_290# WL1 SL4 VSS sky130_fd_pr__nfet_g5v0d10v5 ad=0.65 pd=3.3 as=0 ps=0 w=1 l=0.5
X1739 rr3t3r_0[1|4]/a_860_290# WL1 SL4 VSS sky130_fd_pr__nfet_g5v0d10v5 ad=0.65 pd=3.3 as=0 ps=0 w=1 l=0.5
X1740 BLP4 rr3t3r_0[2|4]/a_60_290# sky130_fd_pr_reram__reram_cell area_ox=0.0676
X1741 BLZ4 rr3t3r_0[2|4]/a_460_290# sky130_fd_pr_reram__reram_cell area_ox=0.0676
X1742 rr3t3r_0[2|4]/a_460_290# WL2 SL4 VSS sky130_fd_pr__nfet_g5v0d10v5 ad=0.65 pd=3.3 as=0 ps=0 w=1 l=0.5
X1743 BLN4 rr3t3r_0[2|4]/a_860_290# sky130_fd_pr_reram__reram_cell area_ox=0.0676
X1744 rr3t3r_0[2|4]/a_60_290# WL2 SL4 VSS sky130_fd_pr__nfet_g5v0d10v5 ad=0.65 pd=3.3 as=0 ps=0 w=1 l=0.5
X1745 rr3t3r_0[2|4]/a_860_290# WL2 SL4 VSS sky130_fd_pr__nfet_g5v0d10v5 ad=0.65 pd=3.3 as=0 ps=0 w=1 l=0.5
X1746 BLP4 rr3t3r_0[3|4]/a_60_290# sky130_fd_pr_reram__reram_cell area_ox=0.0676
X1747 BLZ4 rr3t3r_0[3|4]/a_460_290# sky130_fd_pr_reram__reram_cell area_ox=0.0676
X1748 rr3t3r_0[3|4]/a_460_290# WL3 SL4 VSS sky130_fd_pr__nfet_g5v0d10v5 ad=0.65 pd=3.3 as=0 ps=0 w=1 l=0.5
X1749 BLN4 rr3t3r_0[3|4]/a_860_290# sky130_fd_pr_reram__reram_cell area_ox=0.0676
X1750 rr3t3r_0[3|4]/a_60_290# WL3 SL4 VSS sky130_fd_pr__nfet_g5v0d10v5 ad=0.65 pd=3.3 as=0 ps=0 w=1 l=0.5
X1751 rr3t3r_0[3|4]/a_860_290# WL3 SL4 VSS sky130_fd_pr__nfet_g5v0d10v5 ad=0.65 pd=3.3 as=0 ps=0 w=1 l=0.5
X1752 BLP4 rr3t3r_0[4|4]/a_60_290# sky130_fd_pr_reram__reram_cell area_ox=0.0676
X1753 BLZ4 rr3t3r_0[4|4]/a_460_290# sky130_fd_pr_reram__reram_cell area_ox=0.0676
X1754 rr3t3r_0[4|4]/a_460_290# WL4 SL4 VSS sky130_fd_pr__nfet_g5v0d10v5 ad=0.65 pd=3.3 as=0 ps=0 w=1 l=0.5
X1755 BLN4 rr3t3r_0[4|4]/a_860_290# sky130_fd_pr_reram__reram_cell area_ox=0.0676
X1756 rr3t3r_0[4|4]/a_60_290# WL4 SL4 VSS sky130_fd_pr__nfet_g5v0d10v5 ad=0.65 pd=3.3 as=0 ps=0 w=1 l=0.5
X1757 rr3t3r_0[4|4]/a_860_290# WL4 SL4 VSS sky130_fd_pr__nfet_g5v0d10v5 ad=0.65 pd=3.3 as=0 ps=0 w=1 l=0.5
X1758 BLP4 rr3t3r_0[5|4]/a_60_290# sky130_fd_pr_reram__reram_cell area_ox=0.0676
X1759 BLZ4 rr3t3r_0[5|4]/a_460_290# sky130_fd_pr_reram__reram_cell area_ox=0.0676
X1760 rr3t3r_0[5|4]/a_460_290# WL5 SL4 VSS sky130_fd_pr__nfet_g5v0d10v5 ad=0.65 pd=3.3 as=0 ps=0 w=1 l=0.5
X1761 BLN4 rr3t3r_0[5|4]/a_860_290# sky130_fd_pr_reram__reram_cell area_ox=0.0676
X1762 rr3t3r_0[5|4]/a_60_290# WL5 SL4 VSS sky130_fd_pr__nfet_g5v0d10v5 ad=0.65 pd=3.3 as=0 ps=0 w=1 l=0.5
X1763 rr3t3r_0[5|4]/a_860_290# WL5 SL4 VSS sky130_fd_pr__nfet_g5v0d10v5 ad=0.65 pd=3.3 as=0 ps=0 w=1 l=0.5
X1764 BLP4 rr3t3r_0[6|4]/a_60_290# sky130_fd_pr_reram__reram_cell area_ox=0.0676
X1765 BLZ4 rr3t3r_0[6|4]/a_460_290# sky130_fd_pr_reram__reram_cell area_ox=0.0676
X1766 rr3t3r_0[6|4]/a_460_290# WL6 SL4 VSS sky130_fd_pr__nfet_g5v0d10v5 ad=0.65 pd=3.3 as=0 ps=0 w=1 l=0.5
X1767 BLN4 rr3t3r_0[6|4]/a_860_290# sky130_fd_pr_reram__reram_cell area_ox=0.0676
X1768 rr3t3r_0[6|4]/a_60_290# WL6 SL4 VSS sky130_fd_pr__nfet_g5v0d10v5 ad=0.65 pd=3.3 as=0 ps=0 w=1 l=0.5
X1769 rr3t3r_0[6|4]/a_860_290# WL6 SL4 VSS sky130_fd_pr__nfet_g5v0d10v5 ad=0.65 pd=3.3 as=0 ps=0 w=1 l=0.5
X1770 BLP4 rr3t3r_0[7|4]/a_60_290# sky130_fd_pr_reram__reram_cell area_ox=0.0676
X1771 BLZ4 rr3t3r_0[7|4]/a_460_290# sky130_fd_pr_reram__reram_cell area_ox=0.0676
X1772 rr3t3r_0[7|4]/a_460_290# WL7 SL4 VSS sky130_fd_pr__nfet_g5v0d10v5 ad=0.65 pd=3.3 as=0 ps=0 w=1 l=0.5
X1773 BLN4 rr3t3r_0[7|4]/a_860_290# sky130_fd_pr_reram__reram_cell area_ox=0.0676
X1774 rr3t3r_0[7|4]/a_60_290# WL7 SL4 VSS sky130_fd_pr__nfet_g5v0d10v5 ad=0.65 pd=3.3 as=0 ps=0 w=1 l=0.5
X1775 rr3t3r_0[7|4]/a_860_290# WL7 SL4 VSS sky130_fd_pr__nfet_g5v0d10v5 ad=0.65 pd=3.3 as=0 ps=0 w=1 l=0.5
X1776 BLP4 rr3t3r_0[8|4]/a_60_290# sky130_fd_pr_reram__reram_cell area_ox=0.0676
X1777 BLZ4 rr3t3r_0[8|4]/a_460_290# sky130_fd_pr_reram__reram_cell area_ox=0.0676
X1778 rr3t3r_0[8|4]/a_460_290# WL8 SL4 VSS sky130_fd_pr__nfet_g5v0d10v5 ad=0.65 pd=3.3 as=0 ps=0 w=1 l=0.5
X1779 BLN4 rr3t3r_0[8|4]/a_860_290# sky130_fd_pr_reram__reram_cell area_ox=0.0676
X1780 rr3t3r_0[8|4]/a_60_290# WL8 SL4 VSS sky130_fd_pr__nfet_g5v0d10v5 ad=0.65 pd=3.3 as=0 ps=0 w=1 l=0.5
X1781 rr3t3r_0[8|4]/a_860_290# WL8 SL4 VSS sky130_fd_pr__nfet_g5v0d10v5 ad=0.65 pd=3.3 as=0 ps=0 w=1 l=0.5
X1782 BLP4 rr3t3r_0[9|4]/a_60_290# sky130_fd_pr_reram__reram_cell area_ox=0.0676
X1783 BLZ4 rr3t3r_0[9|4]/a_460_290# sky130_fd_pr_reram__reram_cell area_ox=0.0676
X1784 rr3t3r_0[9|4]/a_460_290# WL9 SL4 VSS sky130_fd_pr__nfet_g5v0d10v5 ad=0.65 pd=3.3 as=0 ps=0 w=1 l=0.5
X1785 BLN4 rr3t3r_0[9|4]/a_860_290# sky130_fd_pr_reram__reram_cell area_ox=0.0676
X1786 rr3t3r_0[9|4]/a_60_290# WL9 SL4 VSS sky130_fd_pr__nfet_g5v0d10v5 ad=0.65 pd=3.3 as=0 ps=0 w=1 l=0.5
X1787 rr3t3r_0[9|4]/a_860_290# WL9 SL4 VSS sky130_fd_pr__nfet_g5v0d10v5 ad=0.65 pd=3.3 as=0 ps=0 w=1 l=0.5
X1788 BLP4 rr3t3r_0[10|4]/a_60_290# sky130_fd_pr_reram__reram_cell area_ox=0.0676
X1789 BLZ4 rr3t3r_0[10|4]/a_460_290# sky130_fd_pr_reram__reram_cell area_ox=0.0676
X1790 rr3t3r_0[10|4]/a_460_290# WL10 SL4 VSS sky130_fd_pr__nfet_g5v0d10v5 ad=0.65 pd=3.3 as=0 ps=0 w=1 l=0.5
X1791 BLN4 rr3t3r_0[10|4]/a_860_290# sky130_fd_pr_reram__reram_cell area_ox=0.0676
X1792 rr3t3r_0[10|4]/a_60_290# WL10 SL4 VSS sky130_fd_pr__nfet_g5v0d10v5 ad=0.65 pd=3.3 as=0 ps=0 w=1 l=0.5
X1793 rr3t3r_0[10|4]/a_860_290# WL10 SL4 VSS sky130_fd_pr__nfet_g5v0d10v5 ad=0.65 pd=3.3 as=0 ps=0 w=1 l=0.5
X1794 BLP4 rr3t3r_0[11|4]/a_60_290# sky130_fd_pr_reram__reram_cell area_ox=0.0676
X1795 BLZ4 rr3t3r_0[11|4]/a_460_290# sky130_fd_pr_reram__reram_cell area_ox=0.0676
X1796 rr3t3r_0[11|4]/a_460_290# WL11 SL4 VSS sky130_fd_pr__nfet_g5v0d10v5 ad=0.65 pd=3.3 as=0 ps=0 w=1 l=0.5
X1797 BLN4 rr3t3r_0[11|4]/a_860_290# sky130_fd_pr_reram__reram_cell area_ox=0.0676
X1798 rr3t3r_0[11|4]/a_60_290# WL11 SL4 VSS sky130_fd_pr__nfet_g5v0d10v5 ad=0.65 pd=3.3 as=0 ps=0 w=1 l=0.5
X1799 rr3t3r_0[11|4]/a_860_290# WL11 SL4 VSS sky130_fd_pr__nfet_g5v0d10v5 ad=0.65 pd=3.3 as=0 ps=0 w=1 l=0.5
X1800 BLP4 rr3t3r_0[12|4]/a_60_290# sky130_fd_pr_reram__reram_cell area_ox=0.0676
X1801 BLZ4 rr3t3r_0[12|4]/a_460_290# sky130_fd_pr_reram__reram_cell area_ox=0.0676
X1802 rr3t3r_0[12|4]/a_460_290# WL12 SL4 VSS sky130_fd_pr__nfet_g5v0d10v5 ad=0.65 pd=3.3 as=0 ps=0 w=1 l=0.5
X1803 BLN4 rr3t3r_0[12|4]/a_860_290# sky130_fd_pr_reram__reram_cell area_ox=0.0676
X1804 rr3t3r_0[12|4]/a_60_290# WL12 SL4 VSS sky130_fd_pr__nfet_g5v0d10v5 ad=0.65 pd=3.3 as=0 ps=0 w=1 l=0.5
X1805 rr3t3r_0[12|4]/a_860_290# WL12 SL4 VSS sky130_fd_pr__nfet_g5v0d10v5 ad=0.65 pd=3.3 as=0 ps=0 w=1 l=0.5
X1806 BLP4 rr3t3r_0[13|4]/a_60_290# sky130_fd_pr_reram__reram_cell area_ox=0.0676
X1807 BLZ4 rr3t3r_0[13|4]/a_460_290# sky130_fd_pr_reram__reram_cell area_ox=0.0676
X1808 rr3t3r_0[13|4]/a_460_290# WL13 SL4 VSS sky130_fd_pr__nfet_g5v0d10v5 ad=0.65 pd=3.3 as=0 ps=0 w=1 l=0.5
X1809 BLN4 rr3t3r_0[13|4]/a_860_290# sky130_fd_pr_reram__reram_cell area_ox=0.0676
X1810 rr3t3r_0[13|4]/a_60_290# WL13 SL4 VSS sky130_fd_pr__nfet_g5v0d10v5 ad=0.65 pd=3.3 as=0 ps=0 w=1 l=0.5
X1811 rr3t3r_0[13|4]/a_860_290# WL13 SL4 VSS sky130_fd_pr__nfet_g5v0d10v5 ad=0.65 pd=3.3 as=0 ps=0 w=1 l=0.5
X1812 BLP4 rr3t3r_0[14|4]/a_60_290# sky130_fd_pr_reram__reram_cell area_ox=0.0676
X1813 BLZ4 rr3t3r_0[14|4]/a_460_290# sky130_fd_pr_reram__reram_cell area_ox=0.0676
X1814 rr3t3r_0[14|4]/a_460_290# WL14 SL4 VSS sky130_fd_pr__nfet_g5v0d10v5 ad=0.65 pd=3.3 as=0 ps=0 w=1 l=0.5
X1815 BLN4 rr3t3r_0[14|4]/a_860_290# sky130_fd_pr_reram__reram_cell area_ox=0.0676
X1816 rr3t3r_0[14|4]/a_60_290# WL14 SL4 VSS sky130_fd_pr__nfet_g5v0d10v5 ad=0.65 pd=3.3 as=0 ps=0 w=1 l=0.5
X1817 rr3t3r_0[14|4]/a_860_290# WL14 SL4 VSS sky130_fd_pr__nfet_g5v0d10v5 ad=0.65 pd=3.3 as=0 ps=0 w=1 l=0.5
X1818 BLP4 rr3t3r_0[15|4]/a_60_290# sky130_fd_pr_reram__reram_cell area_ox=0.0676
X1819 BLZ4 rr3t3r_0[15|4]/a_460_290# sky130_fd_pr_reram__reram_cell area_ox=0.0676
X1820 rr3t3r_0[15|4]/a_460_290# WL15 SL4 VSS sky130_fd_pr__nfet_g5v0d10v5 ad=0.65 pd=3.3 as=0 ps=0 w=1 l=0.5
X1821 BLN4 rr3t3r_0[15|4]/a_860_290# sky130_fd_pr_reram__reram_cell area_ox=0.0676
X1822 rr3t3r_0[15|4]/a_60_290# WL15 SL4 VSS sky130_fd_pr__nfet_g5v0d10v5 ad=0.65 pd=3.3 as=0 ps=0 w=1 l=0.5
X1823 rr3t3r_0[15|4]/a_860_290# WL15 SL4 VSS sky130_fd_pr__nfet_g5v0d10v5 ad=0.65 pd=3.3 as=0 ps=0 w=1 l=0.5
X1824 BLP4 rr3t3r_0[16|4]/a_60_290# sky130_fd_pr_reram__reram_cell area_ox=0.0676
X1825 BLZ4 rr3t3r_0[16|4]/a_460_290# sky130_fd_pr_reram__reram_cell area_ox=0.0676
X1826 rr3t3r_0[16|4]/a_460_290# WL16 SL4 VSS sky130_fd_pr__nfet_g5v0d10v5 ad=0.65 pd=3.3 as=0 ps=0 w=1 l=0.5
X1827 BLN4 rr3t3r_0[16|4]/a_860_290# sky130_fd_pr_reram__reram_cell area_ox=0.0676
X1828 rr3t3r_0[16|4]/a_60_290# WL16 SL4 VSS sky130_fd_pr__nfet_g5v0d10v5 ad=0.65 pd=3.3 as=0 ps=0 w=1 l=0.5
X1829 rr3t3r_0[16|4]/a_860_290# WL16 SL4 VSS sky130_fd_pr__nfet_g5v0d10v5 ad=0.65 pd=3.3 as=0 ps=0 w=1 l=0.5
X1830 BLP4 rr3t3r_0[17|4]/a_60_290# sky130_fd_pr_reram__reram_cell area_ox=0.0676
X1831 BLZ4 rr3t3r_0[17|4]/a_460_290# sky130_fd_pr_reram__reram_cell area_ox=0.0676
X1832 rr3t3r_0[17|4]/a_460_290# WL17 SL4 VSS sky130_fd_pr__nfet_g5v0d10v5 ad=0.65 pd=3.3 as=0 ps=0 w=1 l=0.5
X1833 BLN4 rr3t3r_0[17|4]/a_860_290# sky130_fd_pr_reram__reram_cell area_ox=0.0676
X1834 rr3t3r_0[17|4]/a_60_290# WL17 SL4 VSS sky130_fd_pr__nfet_g5v0d10v5 ad=0.65 pd=3.3 as=0 ps=0 w=1 l=0.5
X1835 rr3t3r_0[17|4]/a_860_290# WL17 SL4 VSS sky130_fd_pr__nfet_g5v0d10v5 ad=0.65 pd=3.3 as=0 ps=0 w=1 l=0.5
X1836 BLP4 rr3t3r_0[18|4]/a_60_290# sky130_fd_pr_reram__reram_cell area_ox=0.0676
X1837 BLZ4 rr3t3r_0[18|4]/a_460_290# sky130_fd_pr_reram__reram_cell area_ox=0.0676
X1838 rr3t3r_0[18|4]/a_460_290# WL18 SL4 VSS sky130_fd_pr__nfet_g5v0d10v5 ad=0.65 pd=3.3 as=0 ps=0 w=1 l=0.5
X1839 BLN4 rr3t3r_0[18|4]/a_860_290# sky130_fd_pr_reram__reram_cell area_ox=0.0676
X1840 rr3t3r_0[18|4]/a_60_290# WL18 SL4 VSS sky130_fd_pr__nfet_g5v0d10v5 ad=0.65 pd=3.3 as=0 ps=0 w=1 l=0.5
X1841 rr3t3r_0[18|4]/a_860_290# WL18 SL4 VSS sky130_fd_pr__nfet_g5v0d10v5 ad=0.65 pd=3.3 as=0 ps=0 w=1 l=0.5
X1842 BLP4 rr3t3r_0[19|4]/a_60_290# sky130_fd_pr_reram__reram_cell area_ox=0.0676
X1843 BLZ4 rr3t3r_0[19|4]/a_460_290# sky130_fd_pr_reram__reram_cell area_ox=0.0676
X1844 rr3t3r_0[19|4]/a_460_290# WL19 SL4 VSS sky130_fd_pr__nfet_g5v0d10v5 ad=0.65 pd=3.3 as=0 ps=0 w=1 l=0.5
X1845 BLN4 rr3t3r_0[19|4]/a_860_290# sky130_fd_pr_reram__reram_cell area_ox=0.0676
X1846 rr3t3r_0[19|4]/a_60_290# WL19 SL4 VSS sky130_fd_pr__nfet_g5v0d10v5 ad=0.65 pd=3.3 as=0 ps=0 w=1 l=0.5
X1847 rr3t3r_0[19|4]/a_860_290# WL19 SL4 VSS sky130_fd_pr__nfet_g5v0d10v5 ad=0.65 pd=3.3 as=0 ps=0 w=1 l=0.5
X1848 BLP4 rr3t3r_0[20|4]/a_60_290# sky130_fd_pr_reram__reram_cell area_ox=0.0676
X1849 BLZ4 rr3t3r_0[20|4]/a_460_290# sky130_fd_pr_reram__reram_cell area_ox=0.0676
X1850 rr3t3r_0[20|4]/a_460_290# WL20 SL4 VSS sky130_fd_pr__nfet_g5v0d10v5 ad=0.65 pd=3.3 as=0 ps=0 w=1 l=0.5
X1851 BLN4 rr3t3r_0[20|4]/a_860_290# sky130_fd_pr_reram__reram_cell area_ox=0.0676
X1852 rr3t3r_0[20|4]/a_60_290# WL20 SL4 VSS sky130_fd_pr__nfet_g5v0d10v5 ad=0.65 pd=3.3 as=0 ps=0 w=1 l=0.5
X1853 rr3t3r_0[20|4]/a_860_290# WL20 SL4 VSS sky130_fd_pr__nfet_g5v0d10v5 ad=0.65 pd=3.3 as=0 ps=0 w=1 l=0.5
X1854 BLP4 rr3t3r_0[21|4]/a_60_290# sky130_fd_pr_reram__reram_cell area_ox=0.0676
X1855 BLZ4 rr3t3r_0[21|4]/a_460_290# sky130_fd_pr_reram__reram_cell area_ox=0.0676
X1856 rr3t3r_0[21|4]/a_460_290# WL21 SL4 VSS sky130_fd_pr__nfet_g5v0d10v5 ad=0.65 pd=3.3 as=0 ps=0 w=1 l=0.5
X1857 BLN4 rr3t3r_0[21|4]/a_860_290# sky130_fd_pr_reram__reram_cell area_ox=0.0676
X1858 rr3t3r_0[21|4]/a_60_290# WL21 SL4 VSS sky130_fd_pr__nfet_g5v0d10v5 ad=0.65 pd=3.3 as=0 ps=0 w=1 l=0.5
X1859 rr3t3r_0[21|4]/a_860_290# WL21 SL4 VSS sky130_fd_pr__nfet_g5v0d10v5 ad=0.65 pd=3.3 as=0 ps=0 w=1 l=0.5
X1860 BLP4 rr3t3r_0[22|4]/a_60_290# sky130_fd_pr_reram__reram_cell area_ox=0.0676
X1861 BLZ4 rr3t3r_0[22|4]/a_460_290# sky130_fd_pr_reram__reram_cell area_ox=0.0676
X1862 rr3t3r_0[22|4]/a_460_290# WL22 SL4 VSS sky130_fd_pr__nfet_g5v0d10v5 ad=0.65 pd=3.3 as=0 ps=0 w=1 l=0.5
X1863 BLN4 rr3t3r_0[22|4]/a_860_290# sky130_fd_pr_reram__reram_cell area_ox=0.0676
X1864 rr3t3r_0[22|4]/a_60_290# WL22 SL4 VSS sky130_fd_pr__nfet_g5v0d10v5 ad=0.65 pd=3.3 as=0 ps=0 w=1 l=0.5
X1865 rr3t3r_0[22|4]/a_860_290# WL22 SL4 VSS sky130_fd_pr__nfet_g5v0d10v5 ad=0.65 pd=3.3 as=0 ps=0 w=1 l=0.5
X1866 BLP4 rr3t3r_0[23|4]/a_60_290# sky130_fd_pr_reram__reram_cell area_ox=0.0676
X1867 BLZ4 rr3t3r_0[23|4]/a_460_290# sky130_fd_pr_reram__reram_cell area_ox=0.0676
X1868 rr3t3r_0[23|4]/a_460_290# WL23 SL4 VSS sky130_fd_pr__nfet_g5v0d10v5 ad=0.65 pd=3.3 as=0 ps=0 w=1 l=0.5
X1869 BLN4 rr3t3r_0[23|4]/a_860_290# sky130_fd_pr_reram__reram_cell area_ox=0.0676
X1870 rr3t3r_0[23|4]/a_60_290# WL23 SL4 VSS sky130_fd_pr__nfet_g5v0d10v5 ad=0.65 pd=3.3 as=0 ps=0 w=1 l=0.5
X1871 rr3t3r_0[23|4]/a_860_290# WL23 SL4 VSS sky130_fd_pr__nfet_g5v0d10v5 ad=0.65 pd=3.3 as=0 ps=0 w=1 l=0.5
X1872 BLP4 rr3t3r_0[24|4]/a_60_290# sky130_fd_pr_reram__reram_cell area_ox=0.0676
X1873 BLZ4 rr3t3r_0[24|4]/a_460_290# sky130_fd_pr_reram__reram_cell area_ox=0.0676
X1874 rr3t3r_0[24|4]/a_460_290# WL24 SL4 VSS sky130_fd_pr__nfet_g5v0d10v5 ad=0.65 pd=3.3 as=0 ps=0 w=1 l=0.5
X1875 BLN4 rr3t3r_0[24|4]/a_860_290# sky130_fd_pr_reram__reram_cell area_ox=0.0676
X1876 rr3t3r_0[24|4]/a_60_290# WL24 SL4 VSS sky130_fd_pr__nfet_g5v0d10v5 ad=0.65 pd=3.3 as=0 ps=0 w=1 l=0.5
X1877 rr3t3r_0[24|4]/a_860_290# WL24 SL4 VSS sky130_fd_pr__nfet_g5v0d10v5 ad=0.65 pd=3.3 as=0 ps=0 w=1 l=0.5
X1878 BLP4 rr3t3r_0[25|4]/a_60_290# sky130_fd_pr_reram__reram_cell area_ox=0.0676
X1879 BLZ4 rr3t3r_0[25|4]/a_460_290# sky130_fd_pr_reram__reram_cell area_ox=0.0676
X1880 rr3t3r_0[25|4]/a_460_290# WL25 SL4 VSS sky130_fd_pr__nfet_g5v0d10v5 ad=0.65 pd=3.3 as=0 ps=0 w=1 l=0.5
X1881 BLN4 rr3t3r_0[25|4]/a_860_290# sky130_fd_pr_reram__reram_cell area_ox=0.0676
X1882 rr3t3r_0[25|4]/a_60_290# WL25 SL4 VSS sky130_fd_pr__nfet_g5v0d10v5 ad=0.65 pd=3.3 as=0 ps=0 w=1 l=0.5
X1883 rr3t3r_0[25|4]/a_860_290# WL25 SL4 VSS sky130_fd_pr__nfet_g5v0d10v5 ad=0.65 pd=3.3 as=0 ps=0 w=1 l=0.5
X1884 BLP4 rr3t3r_0[26|4]/a_60_290# sky130_fd_pr_reram__reram_cell area_ox=0.0676
X1885 BLZ4 rr3t3r_0[26|4]/a_460_290# sky130_fd_pr_reram__reram_cell area_ox=0.0676
X1886 rr3t3r_0[26|4]/a_460_290# WL26 SL4 VSS sky130_fd_pr__nfet_g5v0d10v5 ad=0.65 pd=3.3 as=0 ps=0 w=1 l=0.5
X1887 BLN4 rr3t3r_0[26|4]/a_860_290# sky130_fd_pr_reram__reram_cell area_ox=0.0676
X1888 rr3t3r_0[26|4]/a_60_290# WL26 SL4 VSS sky130_fd_pr__nfet_g5v0d10v5 ad=0.65 pd=3.3 as=0 ps=0 w=1 l=0.5
X1889 rr3t3r_0[26|4]/a_860_290# WL26 SL4 VSS sky130_fd_pr__nfet_g5v0d10v5 ad=0.65 pd=3.3 as=0 ps=0 w=1 l=0.5
X1890 BLP4 rr3t3r_0[27|4]/a_60_290# sky130_fd_pr_reram__reram_cell area_ox=0.0676
X1891 BLZ4 rr3t3r_0[27|4]/a_460_290# sky130_fd_pr_reram__reram_cell area_ox=0.0676
X1892 rr3t3r_0[27|4]/a_460_290# WL27 SL4 VSS sky130_fd_pr__nfet_g5v0d10v5 ad=0.65 pd=3.3 as=0 ps=0 w=1 l=0.5
X1893 BLN4 rr3t3r_0[27|4]/a_860_290# sky130_fd_pr_reram__reram_cell area_ox=0.0676
X1894 rr3t3r_0[27|4]/a_60_290# WL27 SL4 VSS sky130_fd_pr__nfet_g5v0d10v5 ad=0.65 pd=3.3 as=0 ps=0 w=1 l=0.5
X1895 rr3t3r_0[27|4]/a_860_290# WL27 SL4 VSS sky130_fd_pr__nfet_g5v0d10v5 ad=0.65 pd=3.3 as=0 ps=0 w=1 l=0.5
X1896 BLP4 rr3t3r_0[28|4]/a_60_290# sky130_fd_pr_reram__reram_cell area_ox=0.0676
X1897 BLZ4 rr3t3r_0[28|4]/a_460_290# sky130_fd_pr_reram__reram_cell area_ox=0.0676
X1898 rr3t3r_0[28|4]/a_460_290# WL28 SL4 VSS sky130_fd_pr__nfet_g5v0d10v5 ad=0.65 pd=3.3 as=0 ps=0 w=1 l=0.5
X1899 BLN4 rr3t3r_0[28|4]/a_860_290# sky130_fd_pr_reram__reram_cell area_ox=0.0676
X1900 rr3t3r_0[28|4]/a_60_290# WL28 SL4 VSS sky130_fd_pr__nfet_g5v0d10v5 ad=0.65 pd=3.3 as=0 ps=0 w=1 l=0.5
X1901 rr3t3r_0[28|4]/a_860_290# WL28 SL4 VSS sky130_fd_pr__nfet_g5v0d10v5 ad=0.65 pd=3.3 as=0 ps=0 w=1 l=0.5
X1902 BLP4 rr3t3r_0[29|4]/a_60_290# sky130_fd_pr_reram__reram_cell area_ox=0.0676
X1903 BLZ4 rr3t3r_0[29|4]/a_460_290# sky130_fd_pr_reram__reram_cell area_ox=0.0676
X1904 rr3t3r_0[29|4]/a_460_290# WL29 SL4 VSS sky130_fd_pr__nfet_g5v0d10v5 ad=0.65 pd=3.3 as=0 ps=0 w=1 l=0.5
X1905 BLN4 rr3t3r_0[29|4]/a_860_290# sky130_fd_pr_reram__reram_cell area_ox=0.0676
X1906 rr3t3r_0[29|4]/a_60_290# WL29 SL4 VSS sky130_fd_pr__nfet_g5v0d10v5 ad=0.65 pd=3.3 as=0 ps=0 w=1 l=0.5
X1907 rr3t3r_0[29|4]/a_860_290# WL29 SL4 VSS sky130_fd_pr__nfet_g5v0d10v5 ad=0.65 pd=3.3 as=0 ps=0 w=1 l=0.5
X1908 BLP4 rr3t3r_0[30|4]/a_60_290# sky130_fd_pr_reram__reram_cell area_ox=0.0676
X1909 BLZ4 rr3t3r_0[30|4]/a_460_290# sky130_fd_pr_reram__reram_cell area_ox=0.0676
X1910 rr3t3r_0[30|4]/a_460_290# WL30 SL4 VSS sky130_fd_pr__nfet_g5v0d10v5 ad=0.65 pd=3.3 as=0 ps=0 w=1 l=0.5
X1911 BLN4 rr3t3r_0[30|4]/a_860_290# sky130_fd_pr_reram__reram_cell area_ox=0.0676
X1912 rr3t3r_0[30|4]/a_60_290# WL30 SL4 VSS sky130_fd_pr__nfet_g5v0d10v5 ad=0.65 pd=3.3 as=0 ps=0 w=1 l=0.5
X1913 rr3t3r_0[30|4]/a_860_290# WL30 SL4 VSS sky130_fd_pr__nfet_g5v0d10v5 ad=0.65 pd=3.3 as=0 ps=0 w=1 l=0.5
X1914 BLP4 rr3t3r_0[31|4]/a_60_290# sky130_fd_pr_reram__reram_cell area_ox=0.0676
X1915 BLZ4 rr3t3r_0[31|4]/a_460_290# sky130_fd_pr_reram__reram_cell area_ox=0.0676
X1916 rr3t3r_0[31|4]/a_460_290# WL31 SL4 VSS sky130_fd_pr__nfet_g5v0d10v5 ad=0.65 pd=3.3 as=0 ps=0 w=1 l=0.5
X1917 BLN4 rr3t3r_0[31|4]/a_860_290# sky130_fd_pr_reram__reram_cell area_ox=0.0676
X1918 rr3t3r_0[31|4]/a_60_290# WL31 SL4 VSS sky130_fd_pr__nfet_g5v0d10v5 ad=0.65 pd=3.3 as=0 ps=0 w=1 l=0.5
X1919 rr3t3r_0[31|4]/a_860_290# WL31 SL4 VSS sky130_fd_pr__nfet_g5v0d10v5 ad=0.65 pd=3.3 as=0 ps=0 w=1 l=0.5
X1920 BLP4 rr3t3r_0[32|4]/a_60_290# sky130_fd_pr_reram__reram_cell area_ox=0.0676
X1921 BLZ4 rr3t3r_0[32|4]/a_460_290# sky130_fd_pr_reram__reram_cell area_ox=0.0676
X1922 rr3t3r_0[32|4]/a_460_290# WL32 SL4 VSS sky130_fd_pr__nfet_g5v0d10v5 ad=0.65 pd=3.3 as=0 ps=0 w=1 l=0.5
X1923 BLN4 rr3t3r_0[32|4]/a_860_290# sky130_fd_pr_reram__reram_cell area_ox=0.0676
X1924 rr3t3r_0[32|4]/a_60_290# WL32 SL4 VSS sky130_fd_pr__nfet_g5v0d10v5 ad=0.65 pd=3.3 as=0 ps=0 w=1 l=0.5
X1925 rr3t3r_0[32|4]/a_860_290# WL32 SL4 VSS sky130_fd_pr__nfet_g5v0d10v5 ad=0.65 pd=3.3 as=0 ps=0 w=1 l=0.5
X1926 BLP4 rr3t3r_0[33|4]/a_60_290# sky130_fd_pr_reram__reram_cell area_ox=0.0676
X1927 BLZ4 rr3t3r_0[33|4]/a_460_290# sky130_fd_pr_reram__reram_cell area_ox=0.0676
X1928 rr3t3r_0[33|4]/a_460_290# WL33 SL4 VSS sky130_fd_pr__nfet_g5v0d10v5 ad=0.65 pd=3.3 as=0 ps=0 w=1 l=0.5
X1929 BLN4 rr3t3r_0[33|4]/a_860_290# sky130_fd_pr_reram__reram_cell area_ox=0.0676
X1930 rr3t3r_0[33|4]/a_60_290# WL33 SL4 VSS sky130_fd_pr__nfet_g5v0d10v5 ad=0.65 pd=3.3 as=0 ps=0 w=1 l=0.5
X1931 rr3t3r_0[33|4]/a_860_290# WL33 SL4 VSS sky130_fd_pr__nfet_g5v0d10v5 ad=0.65 pd=3.3 as=0 ps=0 w=1 l=0.5
X1932 BLP4 rr3t3r_0[34|4]/a_60_290# sky130_fd_pr_reram__reram_cell area_ox=0.0676
X1933 BLZ4 rr3t3r_0[34|4]/a_460_290# sky130_fd_pr_reram__reram_cell area_ox=0.0676
X1934 rr3t3r_0[34|4]/a_460_290# WL34 SL4 VSS sky130_fd_pr__nfet_g5v0d10v5 ad=0.65 pd=3.3 as=0 ps=0 w=1 l=0.5
X1935 BLN4 rr3t3r_0[34|4]/a_860_290# sky130_fd_pr_reram__reram_cell area_ox=0.0676
X1936 rr3t3r_0[34|4]/a_60_290# WL34 SL4 VSS sky130_fd_pr__nfet_g5v0d10v5 ad=0.65 pd=3.3 as=0 ps=0 w=1 l=0.5
X1937 rr3t3r_0[34|4]/a_860_290# WL34 SL4 VSS sky130_fd_pr__nfet_g5v0d10v5 ad=0.65 pd=3.3 as=0 ps=0 w=1 l=0.5
X1938 BLP4 rr3t3r_0[35|4]/a_60_290# sky130_fd_pr_reram__reram_cell area_ox=0.0676
X1939 BLZ4 rr3t3r_0[35|4]/a_460_290# sky130_fd_pr_reram__reram_cell area_ox=0.0676
X1940 rr3t3r_0[35|4]/a_460_290# WL35 SL4 VSS sky130_fd_pr__nfet_g5v0d10v5 ad=0.65 pd=3.3 as=0 ps=0 w=1 l=0.5
X1941 BLN4 rr3t3r_0[35|4]/a_860_290# sky130_fd_pr_reram__reram_cell area_ox=0.0676
X1942 rr3t3r_0[35|4]/a_60_290# WL35 SL4 VSS sky130_fd_pr__nfet_g5v0d10v5 ad=0.65 pd=3.3 as=0 ps=0 w=1 l=0.5
X1943 rr3t3r_0[35|4]/a_860_290# WL35 SL4 VSS sky130_fd_pr__nfet_g5v0d10v5 ad=0.65 pd=3.3 as=0 ps=0 w=1 l=0.5
X1944 BLP4 rr3t3r_0[36|4]/a_60_290# sky130_fd_pr_reram__reram_cell area_ox=0.0676
X1945 BLZ4 rr3t3r_0[36|4]/a_460_290# sky130_fd_pr_reram__reram_cell area_ox=0.0676
X1946 rr3t3r_0[36|4]/a_460_290# WL36 SL4 VSS sky130_fd_pr__nfet_g5v0d10v5 ad=0.65 pd=3.3 as=0 ps=0 w=1 l=0.5
X1947 BLN4 rr3t3r_0[36|4]/a_860_290# sky130_fd_pr_reram__reram_cell area_ox=0.0676
X1948 rr3t3r_0[36|4]/a_60_290# WL36 SL4 VSS sky130_fd_pr__nfet_g5v0d10v5 ad=0.65 pd=3.3 as=0 ps=0 w=1 l=0.5
X1949 rr3t3r_0[36|4]/a_860_290# WL36 SL4 VSS sky130_fd_pr__nfet_g5v0d10v5 ad=0.65 pd=3.3 as=0 ps=0 w=1 l=0.5
X1950 BLP4 rr3t3r_0[37|4]/a_60_290# sky130_fd_pr_reram__reram_cell area_ox=0.0676
X1951 BLZ4 rr3t3r_0[37|4]/a_460_290# sky130_fd_pr_reram__reram_cell area_ox=0.0676
X1952 rr3t3r_0[37|4]/a_460_290# WL37 SL4 VSS sky130_fd_pr__nfet_g5v0d10v5 ad=0.65 pd=3.3 as=0 ps=0 w=1 l=0.5
X1953 BLN4 rr3t3r_0[37|4]/a_860_290# sky130_fd_pr_reram__reram_cell area_ox=0.0676
X1954 rr3t3r_0[37|4]/a_60_290# WL37 SL4 VSS sky130_fd_pr__nfet_g5v0d10v5 ad=0.65 pd=3.3 as=0 ps=0 w=1 l=0.5
X1955 rr3t3r_0[37|4]/a_860_290# WL37 SL4 VSS sky130_fd_pr__nfet_g5v0d10v5 ad=0.65 pd=3.3 as=0 ps=0 w=1 l=0.5
X1956 BLP4 rr3t3r_0[38|4]/a_60_290# sky130_fd_pr_reram__reram_cell area_ox=0.0676
X1957 BLZ4 rr3t3r_0[38|4]/a_460_290# sky130_fd_pr_reram__reram_cell area_ox=0.0676
X1958 rr3t3r_0[38|4]/a_460_290# WL38 SL4 VSS sky130_fd_pr__nfet_g5v0d10v5 ad=0.65 pd=3.3 as=0 ps=0 w=1 l=0.5
X1959 BLN4 rr3t3r_0[38|4]/a_860_290# sky130_fd_pr_reram__reram_cell area_ox=0.0676
X1960 rr3t3r_0[38|4]/a_60_290# WL38 SL4 VSS sky130_fd_pr__nfet_g5v0d10v5 ad=0.65 pd=3.3 as=0 ps=0 w=1 l=0.5
X1961 rr3t3r_0[38|4]/a_860_290# WL38 SL4 VSS sky130_fd_pr__nfet_g5v0d10v5 ad=0.65 pd=3.3 as=0 ps=0 w=1 l=0.5
X1962 BLP4 rr3t3r_0[39|4]/a_60_290# sky130_fd_pr_reram__reram_cell area_ox=0.0676
X1963 BLZ4 rr3t3r_0[39|4]/a_460_290# sky130_fd_pr_reram__reram_cell area_ox=0.0676
X1964 rr3t3r_0[39|4]/a_460_290# WL39 SL4 VSS sky130_fd_pr__nfet_g5v0d10v5 ad=0.65 pd=3.3 as=0 ps=0 w=1 l=0.5
X1965 BLN4 rr3t3r_0[39|4]/a_860_290# sky130_fd_pr_reram__reram_cell area_ox=0.0676
X1966 rr3t3r_0[39|4]/a_60_290# WL39 SL4 VSS sky130_fd_pr__nfet_g5v0d10v5 ad=0.65 pd=3.3 as=0 ps=0 w=1 l=0.5
X1967 rr3t3r_0[39|4]/a_860_290# WL39 SL4 VSS sky130_fd_pr__nfet_g5v0d10v5 ad=0.65 pd=3.3 as=0 ps=0 w=1 l=0.5
X1968 BLP4 rr3t3r_0[40|4]/a_60_290# sky130_fd_pr_reram__reram_cell area_ox=0.0676
X1969 BLZ4 rr3t3r_0[40|4]/a_460_290# sky130_fd_pr_reram__reram_cell area_ox=0.0676
X1970 rr3t3r_0[40|4]/a_460_290# WL40 SL4 VSS sky130_fd_pr__nfet_g5v0d10v5 ad=0.65 pd=3.3 as=0 ps=0 w=1 l=0.5
X1971 BLN4 rr3t3r_0[40|4]/a_860_290# sky130_fd_pr_reram__reram_cell area_ox=0.0676
X1972 rr3t3r_0[40|4]/a_60_290# WL40 SL4 VSS sky130_fd_pr__nfet_g5v0d10v5 ad=0.65 pd=3.3 as=0 ps=0 w=1 l=0.5
X1973 rr3t3r_0[40|4]/a_860_290# WL40 SL4 VSS sky130_fd_pr__nfet_g5v0d10v5 ad=0.65 pd=3.3 as=0 ps=0 w=1 l=0.5
X1974 BLP4 rr3t3r_0[41|4]/a_60_290# sky130_fd_pr_reram__reram_cell area_ox=0.0676
X1975 BLZ4 rr3t3r_0[41|4]/a_460_290# sky130_fd_pr_reram__reram_cell area_ox=0.0676
X1976 rr3t3r_0[41|4]/a_460_290# WL41 SL4 VSS sky130_fd_pr__nfet_g5v0d10v5 ad=0.65 pd=3.3 as=0 ps=0 w=1 l=0.5
X1977 BLN4 rr3t3r_0[41|4]/a_860_290# sky130_fd_pr_reram__reram_cell area_ox=0.0676
X1978 rr3t3r_0[41|4]/a_60_290# WL41 SL4 VSS sky130_fd_pr__nfet_g5v0d10v5 ad=0.65 pd=3.3 as=0 ps=0 w=1 l=0.5
X1979 rr3t3r_0[41|4]/a_860_290# WL41 SL4 VSS sky130_fd_pr__nfet_g5v0d10v5 ad=0.65 pd=3.3 as=0 ps=0 w=1 l=0.5
X1980 BLP4 rr3t3r_0[42|4]/a_60_290# sky130_fd_pr_reram__reram_cell area_ox=0.0676
X1981 BLZ4 rr3t3r_0[42|4]/a_460_290# sky130_fd_pr_reram__reram_cell area_ox=0.0676
X1982 rr3t3r_0[42|4]/a_460_290# WL42 SL4 VSS sky130_fd_pr__nfet_g5v0d10v5 ad=0.65 pd=3.3 as=0 ps=0 w=1 l=0.5
X1983 BLN4 rr3t3r_0[42|4]/a_860_290# sky130_fd_pr_reram__reram_cell area_ox=0.0676
X1984 rr3t3r_0[42|4]/a_60_290# WL42 SL4 VSS sky130_fd_pr__nfet_g5v0d10v5 ad=0.65 pd=3.3 as=0 ps=0 w=1 l=0.5
X1985 rr3t3r_0[42|4]/a_860_290# WL42 SL4 VSS sky130_fd_pr__nfet_g5v0d10v5 ad=0.65 pd=3.3 as=0 ps=0 w=1 l=0.5
X1986 BLP4 rr3t3r_0[43|4]/a_60_290# sky130_fd_pr_reram__reram_cell area_ox=0.0676
X1987 BLZ4 rr3t3r_0[43|4]/a_460_290# sky130_fd_pr_reram__reram_cell area_ox=0.0676
X1988 rr3t3r_0[43|4]/a_460_290# WL43 SL4 VSS sky130_fd_pr__nfet_g5v0d10v5 ad=0.65 pd=3.3 as=0 ps=0 w=1 l=0.5
X1989 BLN4 rr3t3r_0[43|4]/a_860_290# sky130_fd_pr_reram__reram_cell area_ox=0.0676
X1990 rr3t3r_0[43|4]/a_60_290# WL43 SL4 VSS sky130_fd_pr__nfet_g5v0d10v5 ad=0.65 pd=3.3 as=0 ps=0 w=1 l=0.5
X1991 rr3t3r_0[43|4]/a_860_290# WL43 SL4 VSS sky130_fd_pr__nfet_g5v0d10v5 ad=0.65 pd=3.3 as=0 ps=0 w=1 l=0.5
X1992 BLP4 rr3t3r_0[44|4]/a_60_290# sky130_fd_pr_reram__reram_cell area_ox=0.0676
X1993 BLZ4 rr3t3r_0[44|4]/a_460_290# sky130_fd_pr_reram__reram_cell area_ox=0.0676
X1994 rr3t3r_0[44|4]/a_460_290# WL44 SL4 VSS sky130_fd_pr__nfet_g5v0d10v5 ad=0.65 pd=3.3 as=0 ps=0 w=1 l=0.5
X1995 BLN4 rr3t3r_0[44|4]/a_860_290# sky130_fd_pr_reram__reram_cell area_ox=0.0676
X1996 rr3t3r_0[44|4]/a_60_290# WL44 SL4 VSS sky130_fd_pr__nfet_g5v0d10v5 ad=0.65 pd=3.3 as=0 ps=0 w=1 l=0.5
X1997 rr3t3r_0[44|4]/a_860_290# WL44 SL4 VSS sky130_fd_pr__nfet_g5v0d10v5 ad=0.65 pd=3.3 as=0 ps=0 w=1 l=0.5
X1998 BLP4 rr3t3r_0[45|4]/a_60_290# sky130_fd_pr_reram__reram_cell area_ox=0.0676
X1999 BLZ4 rr3t3r_0[45|4]/a_460_290# sky130_fd_pr_reram__reram_cell area_ox=0.0676
X2000 rr3t3r_0[45|4]/a_460_290# WL45 SL4 VSS sky130_fd_pr__nfet_g5v0d10v5 ad=0.65 pd=3.3 as=0 ps=0 w=1 l=0.5
X2001 BLN4 rr3t3r_0[45|4]/a_860_290# sky130_fd_pr_reram__reram_cell area_ox=0.0676
X2002 rr3t3r_0[45|4]/a_60_290# WL45 SL4 VSS sky130_fd_pr__nfet_g5v0d10v5 ad=0.65 pd=3.3 as=0 ps=0 w=1 l=0.5
X2003 rr3t3r_0[45|4]/a_860_290# WL45 SL4 VSS sky130_fd_pr__nfet_g5v0d10v5 ad=0.65 pd=3.3 as=0 ps=0 w=1 l=0.5
X2004 BLP4 rr3t3r_0[46|4]/a_60_290# sky130_fd_pr_reram__reram_cell area_ox=0.0676
X2005 BLZ4 rr3t3r_0[46|4]/a_460_290# sky130_fd_pr_reram__reram_cell area_ox=0.0676
X2006 rr3t3r_0[46|4]/a_460_290# WL46 SL4 VSS sky130_fd_pr__nfet_g5v0d10v5 ad=0.65 pd=3.3 as=0 ps=0 w=1 l=0.5
X2007 BLN4 rr3t3r_0[46|4]/a_860_290# sky130_fd_pr_reram__reram_cell area_ox=0.0676
X2008 rr3t3r_0[46|4]/a_60_290# WL46 SL4 VSS sky130_fd_pr__nfet_g5v0d10v5 ad=0.65 pd=3.3 as=0 ps=0 w=1 l=0.5
X2009 rr3t3r_0[46|4]/a_860_290# WL46 SL4 VSS sky130_fd_pr__nfet_g5v0d10v5 ad=0.65 pd=3.3 as=0 ps=0 w=1 l=0.5
X2010 BLP4 rr3t3r_0[47|4]/a_60_290# sky130_fd_pr_reram__reram_cell area_ox=0.0676
X2011 BLZ4 rr3t3r_0[47|4]/a_460_290# sky130_fd_pr_reram__reram_cell area_ox=0.0676
X2012 rr3t3r_0[47|4]/a_460_290# WL47 SL4 VSS sky130_fd_pr__nfet_g5v0d10v5 ad=0.65 pd=3.3 as=0 ps=0 w=1 l=0.5
X2013 BLN4 rr3t3r_0[47|4]/a_860_290# sky130_fd_pr_reram__reram_cell area_ox=0.0676
X2014 rr3t3r_0[47|4]/a_60_290# WL47 SL4 VSS sky130_fd_pr__nfet_g5v0d10v5 ad=0.65 pd=3.3 as=0 ps=0 w=1 l=0.5
X2015 rr3t3r_0[47|4]/a_860_290# WL47 SL4 VSS sky130_fd_pr__nfet_g5v0d10v5 ad=0.65 pd=3.3 as=0 ps=0 w=1 l=0.5
X2016 BLP4 rr3t3r_0[48|4]/a_60_290# sky130_fd_pr_reram__reram_cell area_ox=0.0676
X2017 BLZ4 rr3t3r_0[48|4]/a_460_290# sky130_fd_pr_reram__reram_cell area_ox=0.0676
X2018 rr3t3r_0[48|4]/a_460_290# WL48 SL4 VSS sky130_fd_pr__nfet_g5v0d10v5 ad=0.65 pd=3.3 as=0 ps=0 w=1 l=0.5
X2019 BLN4 rr3t3r_0[48|4]/a_860_290# sky130_fd_pr_reram__reram_cell area_ox=0.0676
X2020 rr3t3r_0[48|4]/a_60_290# WL48 SL4 VSS sky130_fd_pr__nfet_g5v0d10v5 ad=0.65 pd=3.3 as=0 ps=0 w=1 l=0.5
X2021 rr3t3r_0[48|4]/a_860_290# WL48 SL4 VSS sky130_fd_pr__nfet_g5v0d10v5 ad=0.65 pd=3.3 as=0 ps=0 w=1 l=0.5
X2022 BLP4 rr3t3r_0[49|4]/a_60_290# sky130_fd_pr_reram__reram_cell area_ox=0.0676
X2023 BLZ4 rr3t3r_0[49|4]/a_460_290# sky130_fd_pr_reram__reram_cell area_ox=0.0676
X2024 rr3t3r_0[49|4]/a_460_290# WL49 SL4 VSS sky130_fd_pr__nfet_g5v0d10v5 ad=0.65 pd=3.3 as=0 ps=0 w=1 l=0.5
X2025 BLN4 rr3t3r_0[49|4]/a_860_290# sky130_fd_pr_reram__reram_cell area_ox=0.0676
X2026 rr3t3r_0[49|4]/a_60_290# WL49 SL4 VSS sky130_fd_pr__nfet_g5v0d10v5 ad=0.65 pd=3.3 as=0 ps=0 w=1 l=0.5
X2027 rr3t3r_0[49|4]/a_860_290# WL49 SL4 VSS sky130_fd_pr__nfet_g5v0d10v5 ad=0.65 pd=3.3 as=0 ps=0 w=1 l=0.5
X2028 BLP4 rr3t3r_0[50|4]/a_60_290# sky130_fd_pr_reram__reram_cell area_ox=0.0676
X2029 BLZ4 rr3t3r_0[50|4]/a_460_290# sky130_fd_pr_reram__reram_cell area_ox=0.0676
X2030 rr3t3r_0[50|4]/a_460_290# WL50 SL4 VSS sky130_fd_pr__nfet_g5v0d10v5 ad=0.65 pd=3.3 as=0 ps=0 w=1 l=0.5
X2031 BLN4 rr3t3r_0[50|4]/a_860_290# sky130_fd_pr_reram__reram_cell area_ox=0.0676
X2032 rr3t3r_0[50|4]/a_60_290# WL50 SL4 VSS sky130_fd_pr__nfet_g5v0d10v5 ad=0.65 pd=3.3 as=0 ps=0 w=1 l=0.5
X2033 rr3t3r_0[50|4]/a_860_290# WL50 SL4 VSS sky130_fd_pr__nfet_g5v0d10v5 ad=0.65 pd=3.3 as=0 ps=0 w=1 l=0.5
X2034 BLP4 rr3t3r_0[51|4]/a_60_290# sky130_fd_pr_reram__reram_cell area_ox=0.0676
X2035 BLZ4 rr3t3r_0[51|4]/a_460_290# sky130_fd_pr_reram__reram_cell area_ox=0.0676
X2036 rr3t3r_0[51|4]/a_460_290# WL51 SL4 VSS sky130_fd_pr__nfet_g5v0d10v5 ad=0.65 pd=3.3 as=0 ps=0 w=1 l=0.5
X2037 BLN4 rr3t3r_0[51|4]/a_860_290# sky130_fd_pr_reram__reram_cell area_ox=0.0676
X2038 rr3t3r_0[51|4]/a_60_290# WL51 SL4 VSS sky130_fd_pr__nfet_g5v0d10v5 ad=0.65 pd=3.3 as=0 ps=0 w=1 l=0.5
X2039 rr3t3r_0[51|4]/a_860_290# WL51 SL4 VSS sky130_fd_pr__nfet_g5v0d10v5 ad=0.65 pd=3.3 as=0 ps=0 w=1 l=0.5
X2040 BLP4 rr3t3r_0[52|4]/a_60_290# sky130_fd_pr_reram__reram_cell area_ox=0.0676
X2041 BLZ4 rr3t3r_0[52|4]/a_460_290# sky130_fd_pr_reram__reram_cell area_ox=0.0676
X2042 rr3t3r_0[52|4]/a_460_290# WL52 SL4 VSS sky130_fd_pr__nfet_g5v0d10v5 ad=0.65 pd=3.3 as=0 ps=0 w=1 l=0.5
X2043 BLN4 rr3t3r_0[52|4]/a_860_290# sky130_fd_pr_reram__reram_cell area_ox=0.0676
X2044 rr3t3r_0[52|4]/a_60_290# WL52 SL4 VSS sky130_fd_pr__nfet_g5v0d10v5 ad=0.65 pd=3.3 as=0 ps=0 w=1 l=0.5
X2045 rr3t3r_0[52|4]/a_860_290# WL52 SL4 VSS sky130_fd_pr__nfet_g5v0d10v5 ad=0.65 pd=3.3 as=0 ps=0 w=1 l=0.5
X2046 BLP4 rr3t3r_0[53|4]/a_60_290# sky130_fd_pr_reram__reram_cell area_ox=0.0676
X2047 BLZ4 rr3t3r_0[53|4]/a_460_290# sky130_fd_pr_reram__reram_cell area_ox=0.0676
X2048 rr3t3r_0[53|4]/a_460_290# WL53 SL4 VSS sky130_fd_pr__nfet_g5v0d10v5 ad=0.65 pd=3.3 as=0 ps=0 w=1 l=0.5
X2049 BLN4 rr3t3r_0[53|4]/a_860_290# sky130_fd_pr_reram__reram_cell area_ox=0.0676
X2050 rr3t3r_0[53|4]/a_60_290# WL53 SL4 VSS sky130_fd_pr__nfet_g5v0d10v5 ad=0.65 pd=3.3 as=0 ps=0 w=1 l=0.5
X2051 rr3t3r_0[53|4]/a_860_290# WL53 SL4 VSS sky130_fd_pr__nfet_g5v0d10v5 ad=0.65 pd=3.3 as=0 ps=0 w=1 l=0.5
X2052 BLP4 rr3t3r_0[54|4]/a_60_290# sky130_fd_pr_reram__reram_cell area_ox=0.0676
X2053 BLZ4 rr3t3r_0[54|4]/a_460_290# sky130_fd_pr_reram__reram_cell area_ox=0.0676
X2054 rr3t3r_0[54|4]/a_460_290# WL54 SL4 VSS sky130_fd_pr__nfet_g5v0d10v5 ad=0.65 pd=3.3 as=0 ps=0 w=1 l=0.5
X2055 BLN4 rr3t3r_0[54|4]/a_860_290# sky130_fd_pr_reram__reram_cell area_ox=0.0676
X2056 rr3t3r_0[54|4]/a_60_290# WL54 SL4 VSS sky130_fd_pr__nfet_g5v0d10v5 ad=0.65 pd=3.3 as=0 ps=0 w=1 l=0.5
X2057 rr3t3r_0[54|4]/a_860_290# WL54 SL4 VSS sky130_fd_pr__nfet_g5v0d10v5 ad=0.65 pd=3.3 as=0 ps=0 w=1 l=0.5
X2058 BLP4 rr3t3r_0[55|4]/a_60_290# sky130_fd_pr_reram__reram_cell area_ox=0.0676
X2059 BLZ4 rr3t3r_0[55|4]/a_460_290# sky130_fd_pr_reram__reram_cell area_ox=0.0676
X2060 rr3t3r_0[55|4]/a_460_290# WL55 SL4 VSS sky130_fd_pr__nfet_g5v0d10v5 ad=0.65 pd=3.3 as=0 ps=0 w=1 l=0.5
X2061 BLN4 rr3t3r_0[55|4]/a_860_290# sky130_fd_pr_reram__reram_cell area_ox=0.0676
X2062 rr3t3r_0[55|4]/a_60_290# WL55 SL4 VSS sky130_fd_pr__nfet_g5v0d10v5 ad=0.65 pd=3.3 as=0 ps=0 w=1 l=0.5
X2063 rr3t3r_0[55|4]/a_860_290# WL55 SL4 VSS sky130_fd_pr__nfet_g5v0d10v5 ad=0.65 pd=3.3 as=0 ps=0 w=1 l=0.5
X2064 BLP4 rr3t3r_0[56|4]/a_60_290# sky130_fd_pr_reram__reram_cell area_ox=0.0676
X2065 BLZ4 rr3t3r_0[56|4]/a_460_290# sky130_fd_pr_reram__reram_cell area_ox=0.0676
X2066 rr3t3r_0[56|4]/a_460_290# WL56 SL4 VSS sky130_fd_pr__nfet_g5v0d10v5 ad=0.65 pd=3.3 as=0 ps=0 w=1 l=0.5
X2067 BLN4 rr3t3r_0[56|4]/a_860_290# sky130_fd_pr_reram__reram_cell area_ox=0.0676
X2068 rr3t3r_0[56|4]/a_60_290# WL56 SL4 VSS sky130_fd_pr__nfet_g5v0d10v5 ad=0.65 pd=3.3 as=0 ps=0 w=1 l=0.5
X2069 rr3t3r_0[56|4]/a_860_290# WL56 SL4 VSS sky130_fd_pr__nfet_g5v0d10v5 ad=0.65 pd=3.3 as=0 ps=0 w=1 l=0.5
X2070 BLP4 rr3t3r_0[57|4]/a_60_290# sky130_fd_pr_reram__reram_cell area_ox=0.0676
X2071 BLZ4 rr3t3r_0[57|4]/a_460_290# sky130_fd_pr_reram__reram_cell area_ox=0.0676
X2072 rr3t3r_0[57|4]/a_460_290# WL57 SL4 VSS sky130_fd_pr__nfet_g5v0d10v5 ad=0.65 pd=3.3 as=0 ps=0 w=1 l=0.5
X2073 BLN4 rr3t3r_0[57|4]/a_860_290# sky130_fd_pr_reram__reram_cell area_ox=0.0676
X2074 rr3t3r_0[57|4]/a_60_290# WL57 SL4 VSS sky130_fd_pr__nfet_g5v0d10v5 ad=0.65 pd=3.3 as=0 ps=0 w=1 l=0.5
X2075 rr3t3r_0[57|4]/a_860_290# WL57 SL4 VSS sky130_fd_pr__nfet_g5v0d10v5 ad=0.65 pd=3.3 as=0 ps=0 w=1 l=0.5
X2076 BLP4 rr3t3r_0[58|4]/a_60_290# sky130_fd_pr_reram__reram_cell area_ox=0.0676
X2077 BLZ4 rr3t3r_0[58|4]/a_460_290# sky130_fd_pr_reram__reram_cell area_ox=0.0676
X2078 rr3t3r_0[58|4]/a_460_290# WL58 SL4 VSS sky130_fd_pr__nfet_g5v0d10v5 ad=0.65 pd=3.3 as=0 ps=0 w=1 l=0.5
X2079 BLN4 rr3t3r_0[58|4]/a_860_290# sky130_fd_pr_reram__reram_cell area_ox=0.0676
X2080 rr3t3r_0[58|4]/a_60_290# WL58 SL4 VSS sky130_fd_pr__nfet_g5v0d10v5 ad=0.65 pd=3.3 as=0 ps=0 w=1 l=0.5
X2081 rr3t3r_0[58|4]/a_860_290# WL58 SL4 VSS sky130_fd_pr__nfet_g5v0d10v5 ad=0.65 pd=3.3 as=0 ps=0 w=1 l=0.5
X2082 BLP4 rr3t3r_0[59|4]/a_60_290# sky130_fd_pr_reram__reram_cell area_ox=0.0676
X2083 BLZ4 rr3t3r_0[59|4]/a_460_290# sky130_fd_pr_reram__reram_cell area_ox=0.0676
X2084 rr3t3r_0[59|4]/a_460_290# WL59 SL4 VSS sky130_fd_pr__nfet_g5v0d10v5 ad=0.65 pd=3.3 as=0 ps=0 w=1 l=0.5
X2085 BLN4 rr3t3r_0[59|4]/a_860_290# sky130_fd_pr_reram__reram_cell area_ox=0.0676
X2086 rr3t3r_0[59|4]/a_60_290# WL59 SL4 VSS sky130_fd_pr__nfet_g5v0d10v5 ad=0.65 pd=3.3 as=0 ps=0 w=1 l=0.5
X2087 rr3t3r_0[59|4]/a_860_290# WL59 SL4 VSS sky130_fd_pr__nfet_g5v0d10v5 ad=0.65 pd=3.3 as=0 ps=0 w=1 l=0.5
X2088 BLP4 rr3t3r_0[60|4]/a_60_290# sky130_fd_pr_reram__reram_cell area_ox=0.0676
X2089 BLZ4 rr3t3r_0[60|4]/a_460_290# sky130_fd_pr_reram__reram_cell area_ox=0.0676
X2090 rr3t3r_0[60|4]/a_460_290# WL60 SL4 VSS sky130_fd_pr__nfet_g5v0d10v5 ad=0.65 pd=3.3 as=0 ps=0 w=1 l=0.5
X2091 BLN4 rr3t3r_0[60|4]/a_860_290# sky130_fd_pr_reram__reram_cell area_ox=0.0676
X2092 rr3t3r_0[60|4]/a_60_290# WL60 SL4 VSS sky130_fd_pr__nfet_g5v0d10v5 ad=0.65 pd=3.3 as=0 ps=0 w=1 l=0.5
X2093 rr3t3r_0[60|4]/a_860_290# WL60 SL4 VSS sky130_fd_pr__nfet_g5v0d10v5 ad=0.65 pd=3.3 as=0 ps=0 w=1 l=0.5
X2094 BLP4 rr3t3r_0[61|4]/a_60_290# sky130_fd_pr_reram__reram_cell area_ox=0.0676
X2095 BLZ4 rr3t3r_0[61|4]/a_460_290# sky130_fd_pr_reram__reram_cell area_ox=0.0676
X2096 rr3t3r_0[61|4]/a_460_290# WL61 SL4 VSS sky130_fd_pr__nfet_g5v0d10v5 ad=0.65 pd=3.3 as=0 ps=0 w=1 l=0.5
X2097 BLN4 rr3t3r_0[61|4]/a_860_290# sky130_fd_pr_reram__reram_cell area_ox=0.0676
X2098 rr3t3r_0[61|4]/a_60_290# WL61 SL4 VSS sky130_fd_pr__nfet_g5v0d10v5 ad=0.65 pd=3.3 as=0 ps=0 w=1 l=0.5
X2099 rr3t3r_0[61|4]/a_860_290# WL61 SL4 VSS sky130_fd_pr__nfet_g5v0d10v5 ad=0.65 pd=3.3 as=0 ps=0 w=1 l=0.5
X2100 BLP4 rr3t3r_0[62|4]/a_60_290# sky130_fd_pr_reram__reram_cell area_ox=0.0676
X2101 BLZ4 rr3t3r_0[62|4]/a_460_290# sky130_fd_pr_reram__reram_cell area_ox=0.0676
X2102 rr3t3r_0[62|4]/a_460_290# WL62 SL4 VSS sky130_fd_pr__nfet_g5v0d10v5 ad=0.65 pd=3.3 as=0 ps=0 w=1 l=0.5
X2103 BLN4 rr3t3r_0[62|4]/a_860_290# sky130_fd_pr_reram__reram_cell area_ox=0.0676
X2104 rr3t3r_0[62|4]/a_60_290# WL62 SL4 VSS sky130_fd_pr__nfet_g5v0d10v5 ad=0.65 pd=3.3 as=0 ps=0 w=1 l=0.5
X2105 rr3t3r_0[62|4]/a_860_290# WL62 SL4 VSS sky130_fd_pr__nfet_g5v0d10v5 ad=0.65 pd=3.3 as=0 ps=0 w=1 l=0.5
X2106 BLP4 rr3t3r_0[63|4]/a_60_290# sky130_fd_pr_reram__reram_cell area_ox=0.0676
X2107 BLZ4 rr3t3r_0[63|4]/a_460_290# sky130_fd_pr_reram__reram_cell area_ox=0.0676
X2108 rr3t3r_0[63|4]/a_460_290# WL63 SL4 VSS sky130_fd_pr__nfet_g5v0d10v5 ad=0.65 pd=3.3 as=0 ps=0 w=1 l=0.5
X2109 BLN4 rr3t3r_0[63|4]/a_860_290# sky130_fd_pr_reram__reram_cell area_ox=0.0676
X2110 rr3t3r_0[63|4]/a_60_290# WL63 SL4 VSS sky130_fd_pr__nfet_g5v0d10v5 ad=0.65 pd=3.3 as=0 ps=0 w=1 l=0.5
X2111 rr3t3r_0[63|4]/a_860_290# WL63 SL4 VSS sky130_fd_pr__nfet_g5v0d10v5 ad=0.65 pd=3.3 as=0 ps=0 w=1 l=0.5
X2112 BLP4 rr3t3r_0[64|4]/a_60_290# sky130_fd_pr_reram__reram_cell area_ox=0.0676
X2113 BLZ4 rr3t3r_0[64|4]/a_460_290# sky130_fd_pr_reram__reram_cell area_ox=0.0676
X2114 rr3t3r_0[64|4]/a_460_290# WL64 SL4 VSS sky130_fd_pr__nfet_g5v0d10v5 ad=0.65 pd=3.3 as=0 ps=0 w=1 l=0.5
X2115 BLN4 rr3t3r_0[64|4]/a_860_290# sky130_fd_pr_reram__reram_cell area_ox=0.0676
X2116 rr3t3r_0[64|4]/a_60_290# WL64 SL4 VSS sky130_fd_pr__nfet_g5v0d10v5 ad=0.65 pd=3.3 as=0 ps=0 w=1 l=0.5
X2117 rr3t3r_0[64|4]/a_860_290# WL64 SL4 VSS sky130_fd_pr__nfet_g5v0d10v5 ad=0.65 pd=3.3 as=0 ps=0 w=1 l=0.5
X2118 BLP4 rr3t3r_0[65|4]/a_60_290# sky130_fd_pr_reram__reram_cell area_ox=0.0676
X2119 BLZ4 rr3t3r_0[65|4]/a_460_290# sky130_fd_pr_reram__reram_cell area_ox=0.0676
X2120 rr3t3r_0[65|4]/a_460_290# WL65 SL4 VSS sky130_fd_pr__nfet_g5v0d10v5 ad=0.65 pd=3.3 as=0 ps=0 w=1 l=0.5
X2121 BLN4 rr3t3r_0[65|4]/a_860_290# sky130_fd_pr_reram__reram_cell area_ox=0.0676
X2122 rr3t3r_0[65|4]/a_60_290# WL65 SL4 VSS sky130_fd_pr__nfet_g5v0d10v5 ad=0.65 pd=3.3 as=0 ps=0 w=1 l=0.5
X2123 rr3t3r_0[65|4]/a_860_290# WL65 SL4 VSS sky130_fd_pr__nfet_g5v0d10v5 ad=0.65 pd=3.3 as=0 ps=0 w=1 l=0.5
X2124 BLP4 rr3t3r_0[66|4]/a_60_290# sky130_fd_pr_reram__reram_cell area_ox=0.0676
X2125 BLZ4 rr3t3r_0[66|4]/a_460_290# sky130_fd_pr_reram__reram_cell area_ox=0.0676
X2126 rr3t3r_0[66|4]/a_460_290# WL66 SL4 VSS sky130_fd_pr__nfet_g5v0d10v5 ad=0.65 pd=3.3 as=0 ps=0 w=1 l=0.5
X2127 BLN4 rr3t3r_0[66|4]/a_860_290# sky130_fd_pr_reram__reram_cell area_ox=0.0676
X2128 rr3t3r_0[66|4]/a_60_290# WL66 SL4 VSS sky130_fd_pr__nfet_g5v0d10v5 ad=0.65 pd=3.3 as=0 ps=0 w=1 l=0.5
X2129 rr3t3r_0[66|4]/a_860_290# WL66 SL4 VSS sky130_fd_pr__nfet_g5v0d10v5 ad=0.65 pd=3.3 as=0 ps=0 w=1 l=0.5
X2130 BLP4 rr3t3r_0[67|4]/a_60_290# sky130_fd_pr_reram__reram_cell area_ox=0.0676
X2131 BLZ4 rr3t3r_0[67|4]/a_460_290# sky130_fd_pr_reram__reram_cell area_ox=0.0676
X2132 rr3t3r_0[67|4]/a_460_290# WL67 SL4 VSS sky130_fd_pr__nfet_g5v0d10v5 ad=0.65 pd=3.3 as=0 ps=0 w=1 l=0.5
X2133 BLN4 rr3t3r_0[67|4]/a_860_290# sky130_fd_pr_reram__reram_cell area_ox=0.0676
X2134 rr3t3r_0[67|4]/a_60_290# WL67 SL4 VSS sky130_fd_pr__nfet_g5v0d10v5 ad=0.65 pd=3.3 as=0 ps=0 w=1 l=0.5
X2135 rr3t3r_0[67|4]/a_860_290# WL67 SL4 VSS sky130_fd_pr__nfet_g5v0d10v5 ad=0.65 pd=3.3 as=0 ps=0 w=1 l=0.5
X2136 BLP4 rr3t3r_0[68|4]/a_60_290# sky130_fd_pr_reram__reram_cell area_ox=0.0676
X2137 BLZ4 rr3t3r_0[68|4]/a_460_290# sky130_fd_pr_reram__reram_cell area_ox=0.0676
X2138 rr3t3r_0[68|4]/a_460_290# WL68 SL4 VSS sky130_fd_pr__nfet_g5v0d10v5 ad=0.65 pd=3.3 as=0 ps=0 w=1 l=0.5
X2139 BLN4 rr3t3r_0[68|4]/a_860_290# sky130_fd_pr_reram__reram_cell area_ox=0.0676
X2140 rr3t3r_0[68|4]/a_60_290# WL68 SL4 VSS sky130_fd_pr__nfet_g5v0d10v5 ad=0.65 pd=3.3 as=0 ps=0 w=1 l=0.5
X2141 rr3t3r_0[68|4]/a_860_290# WL68 SL4 VSS sky130_fd_pr__nfet_g5v0d10v5 ad=0.65 pd=3.3 as=0 ps=0 w=1 l=0.5
X2142 BLP4 rr3t3r_0[69|4]/a_60_290# sky130_fd_pr_reram__reram_cell area_ox=0.0676
X2143 BLZ4 rr3t3r_0[69|4]/a_460_290# sky130_fd_pr_reram__reram_cell area_ox=0.0676
X2144 rr3t3r_0[69|4]/a_460_290# WL69 SL4 VSS sky130_fd_pr__nfet_g5v0d10v5 ad=0.65 pd=3.3 as=0 ps=0 w=1 l=0.5
X2145 BLN4 rr3t3r_0[69|4]/a_860_290# sky130_fd_pr_reram__reram_cell area_ox=0.0676
X2146 rr3t3r_0[69|4]/a_60_290# WL69 SL4 VSS sky130_fd_pr__nfet_g5v0d10v5 ad=0.65 pd=3.3 as=0 ps=0 w=1 l=0.5
X2147 rr3t3r_0[69|4]/a_860_290# WL69 SL4 VSS sky130_fd_pr__nfet_g5v0d10v5 ad=0.65 pd=3.3 as=0 ps=0 w=1 l=0.5
X2148 BLP4 rr3t3r_0[70|4]/a_60_290# sky130_fd_pr_reram__reram_cell area_ox=0.0676
X2149 BLZ4 rr3t3r_0[70|4]/a_460_290# sky130_fd_pr_reram__reram_cell area_ox=0.0676
X2150 rr3t3r_0[70|4]/a_460_290# WL70 SL4 VSS sky130_fd_pr__nfet_g5v0d10v5 ad=0.65 pd=3.3 as=0 ps=0 w=1 l=0.5
X2151 BLN4 rr3t3r_0[70|4]/a_860_290# sky130_fd_pr_reram__reram_cell area_ox=0.0676
X2152 rr3t3r_0[70|4]/a_60_290# WL70 SL4 VSS sky130_fd_pr__nfet_g5v0d10v5 ad=0.65 pd=3.3 as=0 ps=0 w=1 l=0.5
X2153 rr3t3r_0[70|4]/a_860_290# WL70 SL4 VSS sky130_fd_pr__nfet_g5v0d10v5 ad=0.65 pd=3.3 as=0 ps=0 w=1 l=0.5
X2154 BLP4 rr3t3r_0[71|4]/a_60_290# sky130_fd_pr_reram__reram_cell area_ox=0.0676
X2155 BLZ4 rr3t3r_0[71|4]/a_460_290# sky130_fd_pr_reram__reram_cell area_ox=0.0676
X2156 rr3t3r_0[71|4]/a_460_290# WL71 SL4 VSS sky130_fd_pr__nfet_g5v0d10v5 ad=0.65 pd=3.3 as=0 ps=0 w=1 l=0.5
X2157 BLN4 rr3t3r_0[71|4]/a_860_290# sky130_fd_pr_reram__reram_cell area_ox=0.0676
X2158 rr3t3r_0[71|4]/a_60_290# WL71 SL4 VSS sky130_fd_pr__nfet_g5v0d10v5 ad=0.65 pd=3.3 as=0 ps=0 w=1 l=0.5
X2159 rr3t3r_0[71|4]/a_860_290# WL71 SL4 VSS sky130_fd_pr__nfet_g5v0d10v5 ad=0.65 pd=3.3 as=0 ps=0 w=1 l=0.5
X2160 BLP5 rr3t3r_0[0|5]/a_60_290# sky130_fd_pr_reram__reram_cell area_ox=0.0676
X2161 BLZ5 rr3t3r_0[0|5]/a_460_290# sky130_fd_pr_reram__reram_cell area_ox=0.0676
X2162 rr3t3r_0[0|5]/a_460_290# WL0 SL5 VSS sky130_fd_pr__nfet_g5v0d10v5 ad=0.65 pd=3.3 as=162 ps=756 w=1 l=0.5
X2163 BLN5 rr3t3r_0[0|5]/a_860_290# sky130_fd_pr_reram__reram_cell area_ox=0.0676
X2164 rr3t3r_0[0|5]/a_60_290# WL0 SL5 VSS sky130_fd_pr__nfet_g5v0d10v5 ad=0.65 pd=3.3 as=0 ps=0 w=1 l=0.5
X2165 rr3t3r_0[0|5]/a_860_290# WL0 SL5 VSS sky130_fd_pr__nfet_g5v0d10v5 ad=0.65 pd=3.3 as=0 ps=0 w=1 l=0.5
X2166 BLP5 rr3t3r_0[1|5]/a_60_290# sky130_fd_pr_reram__reram_cell area_ox=0.0676
X2167 BLZ5 rr3t3r_0[1|5]/a_460_290# sky130_fd_pr_reram__reram_cell area_ox=0.0676
X2168 rr3t3r_0[1|5]/a_460_290# WL1 SL5 VSS sky130_fd_pr__nfet_g5v0d10v5 ad=0.65 pd=3.3 as=0 ps=0 w=1 l=0.5
X2169 BLN5 rr3t3r_0[1|5]/a_860_290# sky130_fd_pr_reram__reram_cell area_ox=0.0676
X2170 rr3t3r_0[1|5]/a_60_290# WL1 SL5 VSS sky130_fd_pr__nfet_g5v0d10v5 ad=0.65 pd=3.3 as=0 ps=0 w=1 l=0.5
X2171 rr3t3r_0[1|5]/a_860_290# WL1 SL5 VSS sky130_fd_pr__nfet_g5v0d10v5 ad=0.65 pd=3.3 as=0 ps=0 w=1 l=0.5
X2172 BLP5 rr3t3r_0[2|5]/a_60_290# sky130_fd_pr_reram__reram_cell area_ox=0.0676
X2173 BLZ5 rr3t3r_0[2|5]/a_460_290# sky130_fd_pr_reram__reram_cell area_ox=0.0676
X2174 rr3t3r_0[2|5]/a_460_290# WL2 SL5 VSS sky130_fd_pr__nfet_g5v0d10v5 ad=0.65 pd=3.3 as=0 ps=0 w=1 l=0.5
X2175 BLN5 rr3t3r_0[2|5]/a_860_290# sky130_fd_pr_reram__reram_cell area_ox=0.0676
X2176 rr3t3r_0[2|5]/a_60_290# WL2 SL5 VSS sky130_fd_pr__nfet_g5v0d10v5 ad=0.65 pd=3.3 as=0 ps=0 w=1 l=0.5
X2177 rr3t3r_0[2|5]/a_860_290# WL2 SL5 VSS sky130_fd_pr__nfet_g5v0d10v5 ad=0.65 pd=3.3 as=0 ps=0 w=1 l=0.5
X2178 BLP5 rr3t3r_0[3|5]/a_60_290# sky130_fd_pr_reram__reram_cell area_ox=0.0676
X2179 BLZ5 rr3t3r_0[3|5]/a_460_290# sky130_fd_pr_reram__reram_cell area_ox=0.0676
X2180 rr3t3r_0[3|5]/a_460_290# WL3 SL5 VSS sky130_fd_pr__nfet_g5v0d10v5 ad=0.65 pd=3.3 as=0 ps=0 w=1 l=0.5
X2181 BLN5 rr3t3r_0[3|5]/a_860_290# sky130_fd_pr_reram__reram_cell area_ox=0.0676
X2182 rr3t3r_0[3|5]/a_60_290# WL3 SL5 VSS sky130_fd_pr__nfet_g5v0d10v5 ad=0.65 pd=3.3 as=0 ps=0 w=1 l=0.5
X2183 rr3t3r_0[3|5]/a_860_290# WL3 SL5 VSS sky130_fd_pr__nfet_g5v0d10v5 ad=0.65 pd=3.3 as=0 ps=0 w=1 l=0.5
X2184 BLP5 rr3t3r_0[4|5]/a_60_290# sky130_fd_pr_reram__reram_cell area_ox=0.0676
X2185 BLZ5 rr3t3r_0[4|5]/a_460_290# sky130_fd_pr_reram__reram_cell area_ox=0.0676
X2186 rr3t3r_0[4|5]/a_460_290# WL4 SL5 VSS sky130_fd_pr__nfet_g5v0d10v5 ad=0.65 pd=3.3 as=0 ps=0 w=1 l=0.5
X2187 BLN5 rr3t3r_0[4|5]/a_860_290# sky130_fd_pr_reram__reram_cell area_ox=0.0676
X2188 rr3t3r_0[4|5]/a_60_290# WL4 SL5 VSS sky130_fd_pr__nfet_g5v0d10v5 ad=0.65 pd=3.3 as=0 ps=0 w=1 l=0.5
X2189 rr3t3r_0[4|5]/a_860_290# WL4 SL5 VSS sky130_fd_pr__nfet_g5v0d10v5 ad=0.65 pd=3.3 as=0 ps=0 w=1 l=0.5
X2190 BLP5 rr3t3r_0[5|5]/a_60_290# sky130_fd_pr_reram__reram_cell area_ox=0.0676
X2191 BLZ5 rr3t3r_0[5|5]/a_460_290# sky130_fd_pr_reram__reram_cell area_ox=0.0676
X2192 rr3t3r_0[5|5]/a_460_290# WL5 SL5 VSS sky130_fd_pr__nfet_g5v0d10v5 ad=0.65 pd=3.3 as=0 ps=0 w=1 l=0.5
X2193 BLN5 rr3t3r_0[5|5]/a_860_290# sky130_fd_pr_reram__reram_cell area_ox=0.0676
X2194 rr3t3r_0[5|5]/a_60_290# WL5 SL5 VSS sky130_fd_pr__nfet_g5v0d10v5 ad=0.65 pd=3.3 as=0 ps=0 w=1 l=0.5
X2195 rr3t3r_0[5|5]/a_860_290# WL5 SL5 VSS sky130_fd_pr__nfet_g5v0d10v5 ad=0.65 pd=3.3 as=0 ps=0 w=1 l=0.5
X2196 BLP5 rr3t3r_0[6|5]/a_60_290# sky130_fd_pr_reram__reram_cell area_ox=0.0676
X2197 BLZ5 rr3t3r_0[6|5]/a_460_290# sky130_fd_pr_reram__reram_cell area_ox=0.0676
X2198 rr3t3r_0[6|5]/a_460_290# WL6 SL5 VSS sky130_fd_pr__nfet_g5v0d10v5 ad=0.65 pd=3.3 as=0 ps=0 w=1 l=0.5
X2199 BLN5 rr3t3r_0[6|5]/a_860_290# sky130_fd_pr_reram__reram_cell area_ox=0.0676
X2200 rr3t3r_0[6|5]/a_60_290# WL6 SL5 VSS sky130_fd_pr__nfet_g5v0d10v5 ad=0.65 pd=3.3 as=0 ps=0 w=1 l=0.5
X2201 rr3t3r_0[6|5]/a_860_290# WL6 SL5 VSS sky130_fd_pr__nfet_g5v0d10v5 ad=0.65 pd=3.3 as=0 ps=0 w=1 l=0.5
X2202 BLP5 rr3t3r_0[7|5]/a_60_290# sky130_fd_pr_reram__reram_cell area_ox=0.0676
X2203 BLZ5 rr3t3r_0[7|5]/a_460_290# sky130_fd_pr_reram__reram_cell area_ox=0.0676
X2204 rr3t3r_0[7|5]/a_460_290# WL7 SL5 VSS sky130_fd_pr__nfet_g5v0d10v5 ad=0.65 pd=3.3 as=0 ps=0 w=1 l=0.5
X2205 BLN5 rr3t3r_0[7|5]/a_860_290# sky130_fd_pr_reram__reram_cell area_ox=0.0676
X2206 rr3t3r_0[7|5]/a_60_290# WL7 SL5 VSS sky130_fd_pr__nfet_g5v0d10v5 ad=0.65 pd=3.3 as=0 ps=0 w=1 l=0.5
X2207 rr3t3r_0[7|5]/a_860_290# WL7 SL5 VSS sky130_fd_pr__nfet_g5v0d10v5 ad=0.65 pd=3.3 as=0 ps=0 w=1 l=0.5
X2208 BLP5 rr3t3r_0[8|5]/a_60_290# sky130_fd_pr_reram__reram_cell area_ox=0.0676
X2209 BLZ5 rr3t3r_0[8|5]/a_460_290# sky130_fd_pr_reram__reram_cell area_ox=0.0676
X2210 rr3t3r_0[8|5]/a_460_290# WL8 SL5 VSS sky130_fd_pr__nfet_g5v0d10v5 ad=0.65 pd=3.3 as=0 ps=0 w=1 l=0.5
X2211 BLN5 rr3t3r_0[8|5]/a_860_290# sky130_fd_pr_reram__reram_cell area_ox=0.0676
X2212 rr3t3r_0[8|5]/a_60_290# WL8 SL5 VSS sky130_fd_pr__nfet_g5v0d10v5 ad=0.65 pd=3.3 as=0 ps=0 w=1 l=0.5
X2213 rr3t3r_0[8|5]/a_860_290# WL8 SL5 VSS sky130_fd_pr__nfet_g5v0d10v5 ad=0.65 pd=3.3 as=0 ps=0 w=1 l=0.5
X2214 BLP5 rr3t3r_0[9|5]/a_60_290# sky130_fd_pr_reram__reram_cell area_ox=0.0676
X2215 BLZ5 rr3t3r_0[9|5]/a_460_290# sky130_fd_pr_reram__reram_cell area_ox=0.0676
X2216 rr3t3r_0[9|5]/a_460_290# WL9 SL5 VSS sky130_fd_pr__nfet_g5v0d10v5 ad=0.65 pd=3.3 as=0 ps=0 w=1 l=0.5
X2217 BLN5 rr3t3r_0[9|5]/a_860_290# sky130_fd_pr_reram__reram_cell area_ox=0.0676
X2218 rr3t3r_0[9|5]/a_60_290# WL9 SL5 VSS sky130_fd_pr__nfet_g5v0d10v5 ad=0.65 pd=3.3 as=0 ps=0 w=1 l=0.5
X2219 rr3t3r_0[9|5]/a_860_290# WL9 SL5 VSS sky130_fd_pr__nfet_g5v0d10v5 ad=0.65 pd=3.3 as=0 ps=0 w=1 l=0.5
X2220 BLP5 rr3t3r_0[10|5]/a_60_290# sky130_fd_pr_reram__reram_cell area_ox=0.0676
X2221 BLZ5 rr3t3r_0[10|5]/a_460_290# sky130_fd_pr_reram__reram_cell area_ox=0.0676
X2222 rr3t3r_0[10|5]/a_460_290# WL10 SL5 VSS sky130_fd_pr__nfet_g5v0d10v5 ad=0.65 pd=3.3 as=0 ps=0 w=1 l=0.5
X2223 BLN5 rr3t3r_0[10|5]/a_860_290# sky130_fd_pr_reram__reram_cell area_ox=0.0676
X2224 rr3t3r_0[10|5]/a_60_290# WL10 SL5 VSS sky130_fd_pr__nfet_g5v0d10v5 ad=0.65 pd=3.3 as=0 ps=0 w=1 l=0.5
X2225 rr3t3r_0[10|5]/a_860_290# WL10 SL5 VSS sky130_fd_pr__nfet_g5v0d10v5 ad=0.65 pd=3.3 as=0 ps=0 w=1 l=0.5
X2226 BLP5 rr3t3r_0[11|5]/a_60_290# sky130_fd_pr_reram__reram_cell area_ox=0.0676
X2227 BLZ5 rr3t3r_0[11|5]/a_460_290# sky130_fd_pr_reram__reram_cell area_ox=0.0676
X2228 rr3t3r_0[11|5]/a_460_290# WL11 SL5 VSS sky130_fd_pr__nfet_g5v0d10v5 ad=0.65 pd=3.3 as=0 ps=0 w=1 l=0.5
X2229 BLN5 rr3t3r_0[11|5]/a_860_290# sky130_fd_pr_reram__reram_cell area_ox=0.0676
X2230 rr3t3r_0[11|5]/a_60_290# WL11 SL5 VSS sky130_fd_pr__nfet_g5v0d10v5 ad=0.65 pd=3.3 as=0 ps=0 w=1 l=0.5
X2231 rr3t3r_0[11|5]/a_860_290# WL11 SL5 VSS sky130_fd_pr__nfet_g5v0d10v5 ad=0.65 pd=3.3 as=0 ps=0 w=1 l=0.5
X2232 BLP5 rr3t3r_0[12|5]/a_60_290# sky130_fd_pr_reram__reram_cell area_ox=0.0676
X2233 BLZ5 rr3t3r_0[12|5]/a_460_290# sky130_fd_pr_reram__reram_cell area_ox=0.0676
X2234 rr3t3r_0[12|5]/a_460_290# WL12 SL5 VSS sky130_fd_pr__nfet_g5v0d10v5 ad=0.65 pd=3.3 as=0 ps=0 w=1 l=0.5
X2235 BLN5 rr3t3r_0[12|5]/a_860_290# sky130_fd_pr_reram__reram_cell area_ox=0.0676
X2236 rr3t3r_0[12|5]/a_60_290# WL12 SL5 VSS sky130_fd_pr__nfet_g5v0d10v5 ad=0.65 pd=3.3 as=0 ps=0 w=1 l=0.5
X2237 rr3t3r_0[12|5]/a_860_290# WL12 SL5 VSS sky130_fd_pr__nfet_g5v0d10v5 ad=0.65 pd=3.3 as=0 ps=0 w=1 l=0.5
X2238 BLP5 rr3t3r_0[13|5]/a_60_290# sky130_fd_pr_reram__reram_cell area_ox=0.0676
X2239 BLZ5 rr3t3r_0[13|5]/a_460_290# sky130_fd_pr_reram__reram_cell area_ox=0.0676
X2240 rr3t3r_0[13|5]/a_460_290# WL13 SL5 VSS sky130_fd_pr__nfet_g5v0d10v5 ad=0.65 pd=3.3 as=0 ps=0 w=1 l=0.5
X2241 BLN5 rr3t3r_0[13|5]/a_860_290# sky130_fd_pr_reram__reram_cell area_ox=0.0676
X2242 rr3t3r_0[13|5]/a_60_290# WL13 SL5 VSS sky130_fd_pr__nfet_g5v0d10v5 ad=0.65 pd=3.3 as=0 ps=0 w=1 l=0.5
X2243 rr3t3r_0[13|5]/a_860_290# WL13 SL5 VSS sky130_fd_pr__nfet_g5v0d10v5 ad=0.65 pd=3.3 as=0 ps=0 w=1 l=0.5
X2244 BLP5 rr3t3r_0[14|5]/a_60_290# sky130_fd_pr_reram__reram_cell area_ox=0.0676
X2245 BLZ5 rr3t3r_0[14|5]/a_460_290# sky130_fd_pr_reram__reram_cell area_ox=0.0676
X2246 rr3t3r_0[14|5]/a_460_290# WL14 SL5 VSS sky130_fd_pr__nfet_g5v0d10v5 ad=0.65 pd=3.3 as=0 ps=0 w=1 l=0.5
X2247 BLN5 rr3t3r_0[14|5]/a_860_290# sky130_fd_pr_reram__reram_cell area_ox=0.0676
X2248 rr3t3r_0[14|5]/a_60_290# WL14 SL5 VSS sky130_fd_pr__nfet_g5v0d10v5 ad=0.65 pd=3.3 as=0 ps=0 w=1 l=0.5
X2249 rr3t3r_0[14|5]/a_860_290# WL14 SL5 VSS sky130_fd_pr__nfet_g5v0d10v5 ad=0.65 pd=3.3 as=0 ps=0 w=1 l=0.5
X2250 BLP5 rr3t3r_0[15|5]/a_60_290# sky130_fd_pr_reram__reram_cell area_ox=0.0676
X2251 BLZ5 rr3t3r_0[15|5]/a_460_290# sky130_fd_pr_reram__reram_cell area_ox=0.0676
X2252 rr3t3r_0[15|5]/a_460_290# WL15 SL5 VSS sky130_fd_pr__nfet_g5v0d10v5 ad=0.65 pd=3.3 as=0 ps=0 w=1 l=0.5
X2253 BLN5 rr3t3r_0[15|5]/a_860_290# sky130_fd_pr_reram__reram_cell area_ox=0.0676
X2254 rr3t3r_0[15|5]/a_60_290# WL15 SL5 VSS sky130_fd_pr__nfet_g5v0d10v5 ad=0.65 pd=3.3 as=0 ps=0 w=1 l=0.5
X2255 rr3t3r_0[15|5]/a_860_290# WL15 SL5 VSS sky130_fd_pr__nfet_g5v0d10v5 ad=0.65 pd=3.3 as=0 ps=0 w=1 l=0.5
X2256 BLP5 rr3t3r_0[16|5]/a_60_290# sky130_fd_pr_reram__reram_cell area_ox=0.0676
X2257 BLZ5 rr3t3r_0[16|5]/a_460_290# sky130_fd_pr_reram__reram_cell area_ox=0.0676
X2258 rr3t3r_0[16|5]/a_460_290# WL16 SL5 VSS sky130_fd_pr__nfet_g5v0d10v5 ad=0.65 pd=3.3 as=0 ps=0 w=1 l=0.5
X2259 BLN5 rr3t3r_0[16|5]/a_860_290# sky130_fd_pr_reram__reram_cell area_ox=0.0676
X2260 rr3t3r_0[16|5]/a_60_290# WL16 SL5 VSS sky130_fd_pr__nfet_g5v0d10v5 ad=0.65 pd=3.3 as=0 ps=0 w=1 l=0.5
X2261 rr3t3r_0[16|5]/a_860_290# WL16 SL5 VSS sky130_fd_pr__nfet_g5v0d10v5 ad=0.65 pd=3.3 as=0 ps=0 w=1 l=0.5
X2262 BLP5 rr3t3r_0[17|5]/a_60_290# sky130_fd_pr_reram__reram_cell area_ox=0.0676
X2263 BLZ5 rr3t3r_0[17|5]/a_460_290# sky130_fd_pr_reram__reram_cell area_ox=0.0676
X2264 rr3t3r_0[17|5]/a_460_290# WL17 SL5 VSS sky130_fd_pr__nfet_g5v0d10v5 ad=0.65 pd=3.3 as=0 ps=0 w=1 l=0.5
X2265 BLN5 rr3t3r_0[17|5]/a_860_290# sky130_fd_pr_reram__reram_cell area_ox=0.0676
X2266 rr3t3r_0[17|5]/a_60_290# WL17 SL5 VSS sky130_fd_pr__nfet_g5v0d10v5 ad=0.65 pd=3.3 as=0 ps=0 w=1 l=0.5
X2267 rr3t3r_0[17|5]/a_860_290# WL17 SL5 VSS sky130_fd_pr__nfet_g5v0d10v5 ad=0.65 pd=3.3 as=0 ps=0 w=1 l=0.5
X2268 BLP5 rr3t3r_0[18|5]/a_60_290# sky130_fd_pr_reram__reram_cell area_ox=0.0676
X2269 BLZ5 rr3t3r_0[18|5]/a_460_290# sky130_fd_pr_reram__reram_cell area_ox=0.0676
X2270 rr3t3r_0[18|5]/a_460_290# WL18 SL5 VSS sky130_fd_pr__nfet_g5v0d10v5 ad=0.65 pd=3.3 as=0 ps=0 w=1 l=0.5
X2271 BLN5 rr3t3r_0[18|5]/a_860_290# sky130_fd_pr_reram__reram_cell area_ox=0.0676
X2272 rr3t3r_0[18|5]/a_60_290# WL18 SL5 VSS sky130_fd_pr__nfet_g5v0d10v5 ad=0.65 pd=3.3 as=0 ps=0 w=1 l=0.5
X2273 rr3t3r_0[18|5]/a_860_290# WL18 SL5 VSS sky130_fd_pr__nfet_g5v0d10v5 ad=0.65 pd=3.3 as=0 ps=0 w=1 l=0.5
X2274 BLP5 rr3t3r_0[19|5]/a_60_290# sky130_fd_pr_reram__reram_cell area_ox=0.0676
X2275 BLZ5 rr3t3r_0[19|5]/a_460_290# sky130_fd_pr_reram__reram_cell area_ox=0.0676
X2276 rr3t3r_0[19|5]/a_460_290# WL19 SL5 VSS sky130_fd_pr__nfet_g5v0d10v5 ad=0.65 pd=3.3 as=0 ps=0 w=1 l=0.5
X2277 BLN5 rr3t3r_0[19|5]/a_860_290# sky130_fd_pr_reram__reram_cell area_ox=0.0676
X2278 rr3t3r_0[19|5]/a_60_290# WL19 SL5 VSS sky130_fd_pr__nfet_g5v0d10v5 ad=0.65 pd=3.3 as=0 ps=0 w=1 l=0.5
X2279 rr3t3r_0[19|5]/a_860_290# WL19 SL5 VSS sky130_fd_pr__nfet_g5v0d10v5 ad=0.65 pd=3.3 as=0 ps=0 w=1 l=0.5
X2280 BLP5 rr3t3r_0[20|5]/a_60_290# sky130_fd_pr_reram__reram_cell area_ox=0.0676
X2281 BLZ5 rr3t3r_0[20|5]/a_460_290# sky130_fd_pr_reram__reram_cell area_ox=0.0676
X2282 rr3t3r_0[20|5]/a_460_290# WL20 SL5 VSS sky130_fd_pr__nfet_g5v0d10v5 ad=0.65 pd=3.3 as=0 ps=0 w=1 l=0.5
X2283 BLN5 rr3t3r_0[20|5]/a_860_290# sky130_fd_pr_reram__reram_cell area_ox=0.0676
X2284 rr3t3r_0[20|5]/a_60_290# WL20 SL5 VSS sky130_fd_pr__nfet_g5v0d10v5 ad=0.65 pd=3.3 as=0 ps=0 w=1 l=0.5
X2285 rr3t3r_0[20|5]/a_860_290# WL20 SL5 VSS sky130_fd_pr__nfet_g5v0d10v5 ad=0.65 pd=3.3 as=0 ps=0 w=1 l=0.5
X2286 BLP5 rr3t3r_0[21|5]/a_60_290# sky130_fd_pr_reram__reram_cell area_ox=0.0676
X2287 BLZ5 rr3t3r_0[21|5]/a_460_290# sky130_fd_pr_reram__reram_cell area_ox=0.0676
X2288 rr3t3r_0[21|5]/a_460_290# WL21 SL5 VSS sky130_fd_pr__nfet_g5v0d10v5 ad=0.65 pd=3.3 as=0 ps=0 w=1 l=0.5
X2289 BLN5 rr3t3r_0[21|5]/a_860_290# sky130_fd_pr_reram__reram_cell area_ox=0.0676
X2290 rr3t3r_0[21|5]/a_60_290# WL21 SL5 VSS sky130_fd_pr__nfet_g5v0d10v5 ad=0.65 pd=3.3 as=0 ps=0 w=1 l=0.5
X2291 rr3t3r_0[21|5]/a_860_290# WL21 SL5 VSS sky130_fd_pr__nfet_g5v0d10v5 ad=0.65 pd=3.3 as=0 ps=0 w=1 l=0.5
X2292 BLP5 rr3t3r_0[22|5]/a_60_290# sky130_fd_pr_reram__reram_cell area_ox=0.0676
X2293 BLZ5 rr3t3r_0[22|5]/a_460_290# sky130_fd_pr_reram__reram_cell area_ox=0.0676
X2294 rr3t3r_0[22|5]/a_460_290# WL22 SL5 VSS sky130_fd_pr__nfet_g5v0d10v5 ad=0.65 pd=3.3 as=0 ps=0 w=1 l=0.5
X2295 BLN5 rr3t3r_0[22|5]/a_860_290# sky130_fd_pr_reram__reram_cell area_ox=0.0676
X2296 rr3t3r_0[22|5]/a_60_290# WL22 SL5 VSS sky130_fd_pr__nfet_g5v0d10v5 ad=0.65 pd=3.3 as=0 ps=0 w=1 l=0.5
X2297 rr3t3r_0[22|5]/a_860_290# WL22 SL5 VSS sky130_fd_pr__nfet_g5v0d10v5 ad=0.65 pd=3.3 as=0 ps=0 w=1 l=0.5
X2298 BLP5 rr3t3r_0[23|5]/a_60_290# sky130_fd_pr_reram__reram_cell area_ox=0.0676
X2299 BLZ5 rr3t3r_0[23|5]/a_460_290# sky130_fd_pr_reram__reram_cell area_ox=0.0676
X2300 rr3t3r_0[23|5]/a_460_290# WL23 SL5 VSS sky130_fd_pr__nfet_g5v0d10v5 ad=0.65 pd=3.3 as=0 ps=0 w=1 l=0.5
X2301 BLN5 rr3t3r_0[23|5]/a_860_290# sky130_fd_pr_reram__reram_cell area_ox=0.0676
X2302 rr3t3r_0[23|5]/a_60_290# WL23 SL5 VSS sky130_fd_pr__nfet_g5v0d10v5 ad=0.65 pd=3.3 as=0 ps=0 w=1 l=0.5
X2303 rr3t3r_0[23|5]/a_860_290# WL23 SL5 VSS sky130_fd_pr__nfet_g5v0d10v5 ad=0.65 pd=3.3 as=0 ps=0 w=1 l=0.5
X2304 BLP5 rr3t3r_0[24|5]/a_60_290# sky130_fd_pr_reram__reram_cell area_ox=0.0676
X2305 BLZ5 rr3t3r_0[24|5]/a_460_290# sky130_fd_pr_reram__reram_cell area_ox=0.0676
X2306 rr3t3r_0[24|5]/a_460_290# WL24 SL5 VSS sky130_fd_pr__nfet_g5v0d10v5 ad=0.65 pd=3.3 as=0 ps=0 w=1 l=0.5
X2307 BLN5 rr3t3r_0[24|5]/a_860_290# sky130_fd_pr_reram__reram_cell area_ox=0.0676
X2308 rr3t3r_0[24|5]/a_60_290# WL24 SL5 VSS sky130_fd_pr__nfet_g5v0d10v5 ad=0.65 pd=3.3 as=0 ps=0 w=1 l=0.5
X2309 rr3t3r_0[24|5]/a_860_290# WL24 SL5 VSS sky130_fd_pr__nfet_g5v0d10v5 ad=0.65 pd=3.3 as=0 ps=0 w=1 l=0.5
X2310 BLP5 rr3t3r_0[25|5]/a_60_290# sky130_fd_pr_reram__reram_cell area_ox=0.0676
X2311 BLZ5 rr3t3r_0[25|5]/a_460_290# sky130_fd_pr_reram__reram_cell area_ox=0.0676
X2312 rr3t3r_0[25|5]/a_460_290# WL25 SL5 VSS sky130_fd_pr__nfet_g5v0d10v5 ad=0.65 pd=3.3 as=0 ps=0 w=1 l=0.5
X2313 BLN5 rr3t3r_0[25|5]/a_860_290# sky130_fd_pr_reram__reram_cell area_ox=0.0676
X2314 rr3t3r_0[25|5]/a_60_290# WL25 SL5 VSS sky130_fd_pr__nfet_g5v0d10v5 ad=0.65 pd=3.3 as=0 ps=0 w=1 l=0.5
X2315 rr3t3r_0[25|5]/a_860_290# WL25 SL5 VSS sky130_fd_pr__nfet_g5v0d10v5 ad=0.65 pd=3.3 as=0 ps=0 w=1 l=0.5
X2316 BLP5 rr3t3r_0[26|5]/a_60_290# sky130_fd_pr_reram__reram_cell area_ox=0.0676
X2317 BLZ5 rr3t3r_0[26|5]/a_460_290# sky130_fd_pr_reram__reram_cell area_ox=0.0676
X2318 rr3t3r_0[26|5]/a_460_290# WL26 SL5 VSS sky130_fd_pr__nfet_g5v0d10v5 ad=0.65 pd=3.3 as=0 ps=0 w=1 l=0.5
X2319 BLN5 rr3t3r_0[26|5]/a_860_290# sky130_fd_pr_reram__reram_cell area_ox=0.0676
X2320 rr3t3r_0[26|5]/a_60_290# WL26 SL5 VSS sky130_fd_pr__nfet_g5v0d10v5 ad=0.65 pd=3.3 as=0 ps=0 w=1 l=0.5
X2321 rr3t3r_0[26|5]/a_860_290# WL26 SL5 VSS sky130_fd_pr__nfet_g5v0d10v5 ad=0.65 pd=3.3 as=0 ps=0 w=1 l=0.5
X2322 BLP5 rr3t3r_0[27|5]/a_60_290# sky130_fd_pr_reram__reram_cell area_ox=0.0676
X2323 BLZ5 rr3t3r_0[27|5]/a_460_290# sky130_fd_pr_reram__reram_cell area_ox=0.0676
X2324 rr3t3r_0[27|5]/a_460_290# WL27 SL5 VSS sky130_fd_pr__nfet_g5v0d10v5 ad=0.65 pd=3.3 as=0 ps=0 w=1 l=0.5
X2325 BLN5 rr3t3r_0[27|5]/a_860_290# sky130_fd_pr_reram__reram_cell area_ox=0.0676
X2326 rr3t3r_0[27|5]/a_60_290# WL27 SL5 VSS sky130_fd_pr__nfet_g5v0d10v5 ad=0.65 pd=3.3 as=0 ps=0 w=1 l=0.5
X2327 rr3t3r_0[27|5]/a_860_290# WL27 SL5 VSS sky130_fd_pr__nfet_g5v0d10v5 ad=0.65 pd=3.3 as=0 ps=0 w=1 l=0.5
X2328 BLP5 rr3t3r_0[28|5]/a_60_290# sky130_fd_pr_reram__reram_cell area_ox=0.0676
X2329 BLZ5 rr3t3r_0[28|5]/a_460_290# sky130_fd_pr_reram__reram_cell area_ox=0.0676
X2330 rr3t3r_0[28|5]/a_460_290# WL28 SL5 VSS sky130_fd_pr__nfet_g5v0d10v5 ad=0.65 pd=3.3 as=0 ps=0 w=1 l=0.5
X2331 BLN5 rr3t3r_0[28|5]/a_860_290# sky130_fd_pr_reram__reram_cell area_ox=0.0676
X2332 rr3t3r_0[28|5]/a_60_290# WL28 SL5 VSS sky130_fd_pr__nfet_g5v0d10v5 ad=0.65 pd=3.3 as=0 ps=0 w=1 l=0.5
X2333 rr3t3r_0[28|5]/a_860_290# WL28 SL5 VSS sky130_fd_pr__nfet_g5v0d10v5 ad=0.65 pd=3.3 as=0 ps=0 w=1 l=0.5
X2334 BLP5 rr3t3r_0[29|5]/a_60_290# sky130_fd_pr_reram__reram_cell area_ox=0.0676
X2335 BLZ5 rr3t3r_0[29|5]/a_460_290# sky130_fd_pr_reram__reram_cell area_ox=0.0676
X2336 rr3t3r_0[29|5]/a_460_290# WL29 SL5 VSS sky130_fd_pr__nfet_g5v0d10v5 ad=0.65 pd=3.3 as=0 ps=0 w=1 l=0.5
X2337 BLN5 rr3t3r_0[29|5]/a_860_290# sky130_fd_pr_reram__reram_cell area_ox=0.0676
X2338 rr3t3r_0[29|5]/a_60_290# WL29 SL5 VSS sky130_fd_pr__nfet_g5v0d10v5 ad=0.65 pd=3.3 as=0 ps=0 w=1 l=0.5
X2339 rr3t3r_0[29|5]/a_860_290# WL29 SL5 VSS sky130_fd_pr__nfet_g5v0d10v5 ad=0.65 pd=3.3 as=0 ps=0 w=1 l=0.5
X2340 BLP5 rr3t3r_0[30|5]/a_60_290# sky130_fd_pr_reram__reram_cell area_ox=0.0676
X2341 BLZ5 rr3t3r_0[30|5]/a_460_290# sky130_fd_pr_reram__reram_cell area_ox=0.0676
X2342 rr3t3r_0[30|5]/a_460_290# WL30 SL5 VSS sky130_fd_pr__nfet_g5v0d10v5 ad=0.65 pd=3.3 as=0 ps=0 w=1 l=0.5
X2343 BLN5 rr3t3r_0[30|5]/a_860_290# sky130_fd_pr_reram__reram_cell area_ox=0.0676
X2344 rr3t3r_0[30|5]/a_60_290# WL30 SL5 VSS sky130_fd_pr__nfet_g5v0d10v5 ad=0.65 pd=3.3 as=0 ps=0 w=1 l=0.5
X2345 rr3t3r_0[30|5]/a_860_290# WL30 SL5 VSS sky130_fd_pr__nfet_g5v0d10v5 ad=0.65 pd=3.3 as=0 ps=0 w=1 l=0.5
X2346 BLP5 rr3t3r_0[31|5]/a_60_290# sky130_fd_pr_reram__reram_cell area_ox=0.0676
X2347 BLZ5 rr3t3r_0[31|5]/a_460_290# sky130_fd_pr_reram__reram_cell area_ox=0.0676
X2348 rr3t3r_0[31|5]/a_460_290# WL31 SL5 VSS sky130_fd_pr__nfet_g5v0d10v5 ad=0.65 pd=3.3 as=0 ps=0 w=1 l=0.5
X2349 BLN5 rr3t3r_0[31|5]/a_860_290# sky130_fd_pr_reram__reram_cell area_ox=0.0676
X2350 rr3t3r_0[31|5]/a_60_290# WL31 SL5 VSS sky130_fd_pr__nfet_g5v0d10v5 ad=0.65 pd=3.3 as=0 ps=0 w=1 l=0.5
X2351 rr3t3r_0[31|5]/a_860_290# WL31 SL5 VSS sky130_fd_pr__nfet_g5v0d10v5 ad=0.65 pd=3.3 as=0 ps=0 w=1 l=0.5
X2352 BLP5 rr3t3r_0[32|5]/a_60_290# sky130_fd_pr_reram__reram_cell area_ox=0.0676
X2353 BLZ5 rr3t3r_0[32|5]/a_460_290# sky130_fd_pr_reram__reram_cell area_ox=0.0676
X2354 rr3t3r_0[32|5]/a_460_290# WL32 SL5 VSS sky130_fd_pr__nfet_g5v0d10v5 ad=0.65 pd=3.3 as=0 ps=0 w=1 l=0.5
X2355 BLN5 rr3t3r_0[32|5]/a_860_290# sky130_fd_pr_reram__reram_cell area_ox=0.0676
X2356 rr3t3r_0[32|5]/a_60_290# WL32 SL5 VSS sky130_fd_pr__nfet_g5v0d10v5 ad=0.65 pd=3.3 as=0 ps=0 w=1 l=0.5
X2357 rr3t3r_0[32|5]/a_860_290# WL32 SL5 VSS sky130_fd_pr__nfet_g5v0d10v5 ad=0.65 pd=3.3 as=0 ps=0 w=1 l=0.5
X2358 BLP5 rr3t3r_0[33|5]/a_60_290# sky130_fd_pr_reram__reram_cell area_ox=0.0676
X2359 BLZ5 rr3t3r_0[33|5]/a_460_290# sky130_fd_pr_reram__reram_cell area_ox=0.0676
X2360 rr3t3r_0[33|5]/a_460_290# WL33 SL5 VSS sky130_fd_pr__nfet_g5v0d10v5 ad=0.65 pd=3.3 as=0 ps=0 w=1 l=0.5
X2361 BLN5 rr3t3r_0[33|5]/a_860_290# sky130_fd_pr_reram__reram_cell area_ox=0.0676
X2362 rr3t3r_0[33|5]/a_60_290# WL33 SL5 VSS sky130_fd_pr__nfet_g5v0d10v5 ad=0.65 pd=3.3 as=0 ps=0 w=1 l=0.5
X2363 rr3t3r_0[33|5]/a_860_290# WL33 SL5 VSS sky130_fd_pr__nfet_g5v0d10v5 ad=0.65 pd=3.3 as=0 ps=0 w=1 l=0.5
X2364 BLP5 rr3t3r_0[34|5]/a_60_290# sky130_fd_pr_reram__reram_cell area_ox=0.0676
X2365 BLZ5 rr3t3r_0[34|5]/a_460_290# sky130_fd_pr_reram__reram_cell area_ox=0.0676
X2366 rr3t3r_0[34|5]/a_460_290# WL34 SL5 VSS sky130_fd_pr__nfet_g5v0d10v5 ad=0.65 pd=3.3 as=0 ps=0 w=1 l=0.5
X2367 BLN5 rr3t3r_0[34|5]/a_860_290# sky130_fd_pr_reram__reram_cell area_ox=0.0676
X2368 rr3t3r_0[34|5]/a_60_290# WL34 SL5 VSS sky130_fd_pr__nfet_g5v0d10v5 ad=0.65 pd=3.3 as=0 ps=0 w=1 l=0.5
X2369 rr3t3r_0[34|5]/a_860_290# WL34 SL5 VSS sky130_fd_pr__nfet_g5v0d10v5 ad=0.65 pd=3.3 as=0 ps=0 w=1 l=0.5
X2370 BLP5 rr3t3r_0[35|5]/a_60_290# sky130_fd_pr_reram__reram_cell area_ox=0.0676
X2371 BLZ5 rr3t3r_0[35|5]/a_460_290# sky130_fd_pr_reram__reram_cell area_ox=0.0676
X2372 rr3t3r_0[35|5]/a_460_290# WL35 SL5 VSS sky130_fd_pr__nfet_g5v0d10v5 ad=0.65 pd=3.3 as=0 ps=0 w=1 l=0.5
X2373 BLN5 rr3t3r_0[35|5]/a_860_290# sky130_fd_pr_reram__reram_cell area_ox=0.0676
X2374 rr3t3r_0[35|5]/a_60_290# WL35 SL5 VSS sky130_fd_pr__nfet_g5v0d10v5 ad=0.65 pd=3.3 as=0 ps=0 w=1 l=0.5
X2375 rr3t3r_0[35|5]/a_860_290# WL35 SL5 VSS sky130_fd_pr__nfet_g5v0d10v5 ad=0.65 pd=3.3 as=0 ps=0 w=1 l=0.5
X2376 BLP5 rr3t3r_0[36|5]/a_60_290# sky130_fd_pr_reram__reram_cell area_ox=0.0676
X2377 BLZ5 rr3t3r_0[36|5]/a_460_290# sky130_fd_pr_reram__reram_cell area_ox=0.0676
X2378 rr3t3r_0[36|5]/a_460_290# WL36 SL5 VSS sky130_fd_pr__nfet_g5v0d10v5 ad=0.65 pd=3.3 as=0 ps=0 w=1 l=0.5
X2379 BLN5 rr3t3r_0[36|5]/a_860_290# sky130_fd_pr_reram__reram_cell area_ox=0.0676
X2380 rr3t3r_0[36|5]/a_60_290# WL36 SL5 VSS sky130_fd_pr__nfet_g5v0d10v5 ad=0.65 pd=3.3 as=0 ps=0 w=1 l=0.5
X2381 rr3t3r_0[36|5]/a_860_290# WL36 SL5 VSS sky130_fd_pr__nfet_g5v0d10v5 ad=0.65 pd=3.3 as=0 ps=0 w=1 l=0.5
X2382 BLP5 rr3t3r_0[37|5]/a_60_290# sky130_fd_pr_reram__reram_cell area_ox=0.0676
X2383 BLZ5 rr3t3r_0[37|5]/a_460_290# sky130_fd_pr_reram__reram_cell area_ox=0.0676
X2384 rr3t3r_0[37|5]/a_460_290# WL37 SL5 VSS sky130_fd_pr__nfet_g5v0d10v5 ad=0.65 pd=3.3 as=0 ps=0 w=1 l=0.5
X2385 BLN5 rr3t3r_0[37|5]/a_860_290# sky130_fd_pr_reram__reram_cell area_ox=0.0676
X2386 rr3t3r_0[37|5]/a_60_290# WL37 SL5 VSS sky130_fd_pr__nfet_g5v0d10v5 ad=0.65 pd=3.3 as=0 ps=0 w=1 l=0.5
X2387 rr3t3r_0[37|5]/a_860_290# WL37 SL5 VSS sky130_fd_pr__nfet_g5v0d10v5 ad=0.65 pd=3.3 as=0 ps=0 w=1 l=0.5
X2388 BLP5 rr3t3r_0[38|5]/a_60_290# sky130_fd_pr_reram__reram_cell area_ox=0.0676
X2389 BLZ5 rr3t3r_0[38|5]/a_460_290# sky130_fd_pr_reram__reram_cell area_ox=0.0676
X2390 rr3t3r_0[38|5]/a_460_290# WL38 SL5 VSS sky130_fd_pr__nfet_g5v0d10v5 ad=0.65 pd=3.3 as=0 ps=0 w=1 l=0.5
X2391 BLN5 rr3t3r_0[38|5]/a_860_290# sky130_fd_pr_reram__reram_cell area_ox=0.0676
X2392 rr3t3r_0[38|5]/a_60_290# WL38 SL5 VSS sky130_fd_pr__nfet_g5v0d10v5 ad=0.65 pd=3.3 as=0 ps=0 w=1 l=0.5
X2393 rr3t3r_0[38|5]/a_860_290# WL38 SL5 VSS sky130_fd_pr__nfet_g5v0d10v5 ad=0.65 pd=3.3 as=0 ps=0 w=1 l=0.5
X2394 BLP5 rr3t3r_0[39|5]/a_60_290# sky130_fd_pr_reram__reram_cell area_ox=0.0676
X2395 BLZ5 rr3t3r_0[39|5]/a_460_290# sky130_fd_pr_reram__reram_cell area_ox=0.0676
X2396 rr3t3r_0[39|5]/a_460_290# WL39 SL5 VSS sky130_fd_pr__nfet_g5v0d10v5 ad=0.65 pd=3.3 as=0 ps=0 w=1 l=0.5
X2397 BLN5 rr3t3r_0[39|5]/a_860_290# sky130_fd_pr_reram__reram_cell area_ox=0.0676
X2398 rr3t3r_0[39|5]/a_60_290# WL39 SL5 VSS sky130_fd_pr__nfet_g5v0d10v5 ad=0.65 pd=3.3 as=0 ps=0 w=1 l=0.5
X2399 rr3t3r_0[39|5]/a_860_290# WL39 SL5 VSS sky130_fd_pr__nfet_g5v0d10v5 ad=0.65 pd=3.3 as=0 ps=0 w=1 l=0.5
X2400 BLP5 rr3t3r_0[40|5]/a_60_290# sky130_fd_pr_reram__reram_cell area_ox=0.0676
X2401 BLZ5 rr3t3r_0[40|5]/a_460_290# sky130_fd_pr_reram__reram_cell area_ox=0.0676
X2402 rr3t3r_0[40|5]/a_460_290# WL40 SL5 VSS sky130_fd_pr__nfet_g5v0d10v5 ad=0.65 pd=3.3 as=0 ps=0 w=1 l=0.5
X2403 BLN5 rr3t3r_0[40|5]/a_860_290# sky130_fd_pr_reram__reram_cell area_ox=0.0676
X2404 rr3t3r_0[40|5]/a_60_290# WL40 SL5 VSS sky130_fd_pr__nfet_g5v0d10v5 ad=0.65 pd=3.3 as=0 ps=0 w=1 l=0.5
X2405 rr3t3r_0[40|5]/a_860_290# WL40 SL5 VSS sky130_fd_pr__nfet_g5v0d10v5 ad=0.65 pd=3.3 as=0 ps=0 w=1 l=0.5
X2406 BLP5 rr3t3r_0[41|5]/a_60_290# sky130_fd_pr_reram__reram_cell area_ox=0.0676
X2407 BLZ5 rr3t3r_0[41|5]/a_460_290# sky130_fd_pr_reram__reram_cell area_ox=0.0676
X2408 rr3t3r_0[41|5]/a_460_290# WL41 SL5 VSS sky130_fd_pr__nfet_g5v0d10v5 ad=0.65 pd=3.3 as=0 ps=0 w=1 l=0.5
X2409 BLN5 rr3t3r_0[41|5]/a_860_290# sky130_fd_pr_reram__reram_cell area_ox=0.0676
X2410 rr3t3r_0[41|5]/a_60_290# WL41 SL5 VSS sky130_fd_pr__nfet_g5v0d10v5 ad=0.65 pd=3.3 as=0 ps=0 w=1 l=0.5
X2411 rr3t3r_0[41|5]/a_860_290# WL41 SL5 VSS sky130_fd_pr__nfet_g5v0d10v5 ad=0.65 pd=3.3 as=0 ps=0 w=1 l=0.5
X2412 BLP5 rr3t3r_0[42|5]/a_60_290# sky130_fd_pr_reram__reram_cell area_ox=0.0676
X2413 BLZ5 rr3t3r_0[42|5]/a_460_290# sky130_fd_pr_reram__reram_cell area_ox=0.0676
X2414 rr3t3r_0[42|5]/a_460_290# WL42 SL5 VSS sky130_fd_pr__nfet_g5v0d10v5 ad=0.65 pd=3.3 as=0 ps=0 w=1 l=0.5
X2415 BLN5 rr3t3r_0[42|5]/a_860_290# sky130_fd_pr_reram__reram_cell area_ox=0.0676
X2416 rr3t3r_0[42|5]/a_60_290# WL42 SL5 VSS sky130_fd_pr__nfet_g5v0d10v5 ad=0.65 pd=3.3 as=0 ps=0 w=1 l=0.5
X2417 rr3t3r_0[42|5]/a_860_290# WL42 SL5 VSS sky130_fd_pr__nfet_g5v0d10v5 ad=0.65 pd=3.3 as=0 ps=0 w=1 l=0.5
X2418 BLP5 rr3t3r_0[43|5]/a_60_290# sky130_fd_pr_reram__reram_cell area_ox=0.0676
X2419 BLZ5 rr3t3r_0[43|5]/a_460_290# sky130_fd_pr_reram__reram_cell area_ox=0.0676
X2420 rr3t3r_0[43|5]/a_460_290# WL43 SL5 VSS sky130_fd_pr__nfet_g5v0d10v5 ad=0.65 pd=3.3 as=0 ps=0 w=1 l=0.5
X2421 BLN5 rr3t3r_0[43|5]/a_860_290# sky130_fd_pr_reram__reram_cell area_ox=0.0676
X2422 rr3t3r_0[43|5]/a_60_290# WL43 SL5 VSS sky130_fd_pr__nfet_g5v0d10v5 ad=0.65 pd=3.3 as=0 ps=0 w=1 l=0.5
X2423 rr3t3r_0[43|5]/a_860_290# WL43 SL5 VSS sky130_fd_pr__nfet_g5v0d10v5 ad=0.65 pd=3.3 as=0 ps=0 w=1 l=0.5
X2424 BLP5 rr3t3r_0[44|5]/a_60_290# sky130_fd_pr_reram__reram_cell area_ox=0.0676
X2425 BLZ5 rr3t3r_0[44|5]/a_460_290# sky130_fd_pr_reram__reram_cell area_ox=0.0676
X2426 rr3t3r_0[44|5]/a_460_290# WL44 SL5 VSS sky130_fd_pr__nfet_g5v0d10v5 ad=0.65 pd=3.3 as=0 ps=0 w=1 l=0.5
X2427 BLN5 rr3t3r_0[44|5]/a_860_290# sky130_fd_pr_reram__reram_cell area_ox=0.0676
X2428 rr3t3r_0[44|5]/a_60_290# WL44 SL5 VSS sky130_fd_pr__nfet_g5v0d10v5 ad=0.65 pd=3.3 as=0 ps=0 w=1 l=0.5
X2429 rr3t3r_0[44|5]/a_860_290# WL44 SL5 VSS sky130_fd_pr__nfet_g5v0d10v5 ad=0.65 pd=3.3 as=0 ps=0 w=1 l=0.5
X2430 BLP5 rr3t3r_0[45|5]/a_60_290# sky130_fd_pr_reram__reram_cell area_ox=0.0676
X2431 BLZ5 rr3t3r_0[45|5]/a_460_290# sky130_fd_pr_reram__reram_cell area_ox=0.0676
X2432 rr3t3r_0[45|5]/a_460_290# WL45 SL5 VSS sky130_fd_pr__nfet_g5v0d10v5 ad=0.65 pd=3.3 as=0 ps=0 w=1 l=0.5
X2433 BLN5 rr3t3r_0[45|5]/a_860_290# sky130_fd_pr_reram__reram_cell area_ox=0.0676
X2434 rr3t3r_0[45|5]/a_60_290# WL45 SL5 VSS sky130_fd_pr__nfet_g5v0d10v5 ad=0.65 pd=3.3 as=0 ps=0 w=1 l=0.5
X2435 rr3t3r_0[45|5]/a_860_290# WL45 SL5 VSS sky130_fd_pr__nfet_g5v0d10v5 ad=0.65 pd=3.3 as=0 ps=0 w=1 l=0.5
X2436 BLP5 rr3t3r_0[46|5]/a_60_290# sky130_fd_pr_reram__reram_cell area_ox=0.0676
X2437 BLZ5 rr3t3r_0[46|5]/a_460_290# sky130_fd_pr_reram__reram_cell area_ox=0.0676
X2438 rr3t3r_0[46|5]/a_460_290# WL46 SL5 VSS sky130_fd_pr__nfet_g5v0d10v5 ad=0.65 pd=3.3 as=0 ps=0 w=1 l=0.5
X2439 BLN5 rr3t3r_0[46|5]/a_860_290# sky130_fd_pr_reram__reram_cell area_ox=0.0676
X2440 rr3t3r_0[46|5]/a_60_290# WL46 SL5 VSS sky130_fd_pr__nfet_g5v0d10v5 ad=0.65 pd=3.3 as=0 ps=0 w=1 l=0.5
X2441 rr3t3r_0[46|5]/a_860_290# WL46 SL5 VSS sky130_fd_pr__nfet_g5v0d10v5 ad=0.65 pd=3.3 as=0 ps=0 w=1 l=0.5
X2442 BLP5 rr3t3r_0[47|5]/a_60_290# sky130_fd_pr_reram__reram_cell area_ox=0.0676
X2443 BLZ5 rr3t3r_0[47|5]/a_460_290# sky130_fd_pr_reram__reram_cell area_ox=0.0676
X2444 rr3t3r_0[47|5]/a_460_290# WL47 SL5 VSS sky130_fd_pr__nfet_g5v0d10v5 ad=0.65 pd=3.3 as=0 ps=0 w=1 l=0.5
X2445 BLN5 rr3t3r_0[47|5]/a_860_290# sky130_fd_pr_reram__reram_cell area_ox=0.0676
X2446 rr3t3r_0[47|5]/a_60_290# WL47 SL5 VSS sky130_fd_pr__nfet_g5v0d10v5 ad=0.65 pd=3.3 as=0 ps=0 w=1 l=0.5
X2447 rr3t3r_0[47|5]/a_860_290# WL47 SL5 VSS sky130_fd_pr__nfet_g5v0d10v5 ad=0.65 pd=3.3 as=0 ps=0 w=1 l=0.5
X2448 BLP5 rr3t3r_0[48|5]/a_60_290# sky130_fd_pr_reram__reram_cell area_ox=0.0676
X2449 BLZ5 rr3t3r_0[48|5]/a_460_290# sky130_fd_pr_reram__reram_cell area_ox=0.0676
X2450 rr3t3r_0[48|5]/a_460_290# WL48 SL5 VSS sky130_fd_pr__nfet_g5v0d10v5 ad=0.65 pd=3.3 as=0 ps=0 w=1 l=0.5
X2451 BLN5 rr3t3r_0[48|5]/a_860_290# sky130_fd_pr_reram__reram_cell area_ox=0.0676
X2452 rr3t3r_0[48|5]/a_60_290# WL48 SL5 VSS sky130_fd_pr__nfet_g5v0d10v5 ad=0.65 pd=3.3 as=0 ps=0 w=1 l=0.5
X2453 rr3t3r_0[48|5]/a_860_290# WL48 SL5 VSS sky130_fd_pr__nfet_g5v0d10v5 ad=0.65 pd=3.3 as=0 ps=0 w=1 l=0.5
X2454 BLP5 rr3t3r_0[49|5]/a_60_290# sky130_fd_pr_reram__reram_cell area_ox=0.0676
X2455 BLZ5 rr3t3r_0[49|5]/a_460_290# sky130_fd_pr_reram__reram_cell area_ox=0.0676
X2456 rr3t3r_0[49|5]/a_460_290# WL49 SL5 VSS sky130_fd_pr__nfet_g5v0d10v5 ad=0.65 pd=3.3 as=0 ps=0 w=1 l=0.5
X2457 BLN5 rr3t3r_0[49|5]/a_860_290# sky130_fd_pr_reram__reram_cell area_ox=0.0676
X2458 rr3t3r_0[49|5]/a_60_290# WL49 SL5 VSS sky130_fd_pr__nfet_g5v0d10v5 ad=0.65 pd=3.3 as=0 ps=0 w=1 l=0.5
X2459 rr3t3r_0[49|5]/a_860_290# WL49 SL5 VSS sky130_fd_pr__nfet_g5v0d10v5 ad=0.65 pd=3.3 as=0 ps=0 w=1 l=0.5
X2460 BLP5 rr3t3r_0[50|5]/a_60_290# sky130_fd_pr_reram__reram_cell area_ox=0.0676
X2461 BLZ5 rr3t3r_0[50|5]/a_460_290# sky130_fd_pr_reram__reram_cell area_ox=0.0676
X2462 rr3t3r_0[50|5]/a_460_290# WL50 SL5 VSS sky130_fd_pr__nfet_g5v0d10v5 ad=0.65 pd=3.3 as=0 ps=0 w=1 l=0.5
X2463 BLN5 rr3t3r_0[50|5]/a_860_290# sky130_fd_pr_reram__reram_cell area_ox=0.0676
X2464 rr3t3r_0[50|5]/a_60_290# WL50 SL5 VSS sky130_fd_pr__nfet_g5v0d10v5 ad=0.65 pd=3.3 as=0 ps=0 w=1 l=0.5
X2465 rr3t3r_0[50|5]/a_860_290# WL50 SL5 VSS sky130_fd_pr__nfet_g5v0d10v5 ad=0.65 pd=3.3 as=0 ps=0 w=1 l=0.5
X2466 BLP5 rr3t3r_0[51|5]/a_60_290# sky130_fd_pr_reram__reram_cell area_ox=0.0676
X2467 BLZ5 rr3t3r_0[51|5]/a_460_290# sky130_fd_pr_reram__reram_cell area_ox=0.0676
X2468 rr3t3r_0[51|5]/a_460_290# WL51 SL5 VSS sky130_fd_pr__nfet_g5v0d10v5 ad=0.65 pd=3.3 as=0 ps=0 w=1 l=0.5
X2469 BLN5 rr3t3r_0[51|5]/a_860_290# sky130_fd_pr_reram__reram_cell area_ox=0.0676
X2470 rr3t3r_0[51|5]/a_60_290# WL51 SL5 VSS sky130_fd_pr__nfet_g5v0d10v5 ad=0.65 pd=3.3 as=0 ps=0 w=1 l=0.5
X2471 rr3t3r_0[51|5]/a_860_290# WL51 SL5 VSS sky130_fd_pr__nfet_g5v0d10v5 ad=0.65 pd=3.3 as=0 ps=0 w=1 l=0.5
X2472 BLP5 rr3t3r_0[52|5]/a_60_290# sky130_fd_pr_reram__reram_cell area_ox=0.0676
X2473 BLZ5 rr3t3r_0[52|5]/a_460_290# sky130_fd_pr_reram__reram_cell area_ox=0.0676
X2474 rr3t3r_0[52|5]/a_460_290# WL52 SL5 VSS sky130_fd_pr__nfet_g5v0d10v5 ad=0.65 pd=3.3 as=0 ps=0 w=1 l=0.5
X2475 BLN5 rr3t3r_0[52|5]/a_860_290# sky130_fd_pr_reram__reram_cell area_ox=0.0676
X2476 rr3t3r_0[52|5]/a_60_290# WL52 SL5 VSS sky130_fd_pr__nfet_g5v0d10v5 ad=0.65 pd=3.3 as=0 ps=0 w=1 l=0.5
X2477 rr3t3r_0[52|5]/a_860_290# WL52 SL5 VSS sky130_fd_pr__nfet_g5v0d10v5 ad=0.65 pd=3.3 as=0 ps=0 w=1 l=0.5
X2478 BLP5 rr3t3r_0[53|5]/a_60_290# sky130_fd_pr_reram__reram_cell area_ox=0.0676
X2479 BLZ5 rr3t3r_0[53|5]/a_460_290# sky130_fd_pr_reram__reram_cell area_ox=0.0676
X2480 rr3t3r_0[53|5]/a_460_290# WL53 SL5 VSS sky130_fd_pr__nfet_g5v0d10v5 ad=0.65 pd=3.3 as=0 ps=0 w=1 l=0.5
X2481 BLN5 rr3t3r_0[53|5]/a_860_290# sky130_fd_pr_reram__reram_cell area_ox=0.0676
X2482 rr3t3r_0[53|5]/a_60_290# WL53 SL5 VSS sky130_fd_pr__nfet_g5v0d10v5 ad=0.65 pd=3.3 as=0 ps=0 w=1 l=0.5
X2483 rr3t3r_0[53|5]/a_860_290# WL53 SL5 VSS sky130_fd_pr__nfet_g5v0d10v5 ad=0.65 pd=3.3 as=0 ps=0 w=1 l=0.5
X2484 BLP5 rr3t3r_0[54|5]/a_60_290# sky130_fd_pr_reram__reram_cell area_ox=0.0676
X2485 BLZ5 rr3t3r_0[54|5]/a_460_290# sky130_fd_pr_reram__reram_cell area_ox=0.0676
X2486 rr3t3r_0[54|5]/a_460_290# WL54 SL5 VSS sky130_fd_pr__nfet_g5v0d10v5 ad=0.65 pd=3.3 as=0 ps=0 w=1 l=0.5
X2487 BLN5 rr3t3r_0[54|5]/a_860_290# sky130_fd_pr_reram__reram_cell area_ox=0.0676
X2488 rr3t3r_0[54|5]/a_60_290# WL54 SL5 VSS sky130_fd_pr__nfet_g5v0d10v5 ad=0.65 pd=3.3 as=0 ps=0 w=1 l=0.5
X2489 rr3t3r_0[54|5]/a_860_290# WL54 SL5 VSS sky130_fd_pr__nfet_g5v0d10v5 ad=0.65 pd=3.3 as=0 ps=0 w=1 l=0.5
X2490 BLP5 rr3t3r_0[55|5]/a_60_290# sky130_fd_pr_reram__reram_cell area_ox=0.0676
X2491 BLZ5 rr3t3r_0[55|5]/a_460_290# sky130_fd_pr_reram__reram_cell area_ox=0.0676
X2492 rr3t3r_0[55|5]/a_460_290# WL55 SL5 VSS sky130_fd_pr__nfet_g5v0d10v5 ad=0.65 pd=3.3 as=0 ps=0 w=1 l=0.5
X2493 BLN5 rr3t3r_0[55|5]/a_860_290# sky130_fd_pr_reram__reram_cell area_ox=0.0676
X2494 rr3t3r_0[55|5]/a_60_290# WL55 SL5 VSS sky130_fd_pr__nfet_g5v0d10v5 ad=0.65 pd=3.3 as=0 ps=0 w=1 l=0.5
X2495 rr3t3r_0[55|5]/a_860_290# WL55 SL5 VSS sky130_fd_pr__nfet_g5v0d10v5 ad=0.65 pd=3.3 as=0 ps=0 w=1 l=0.5
X2496 BLP5 rr3t3r_0[56|5]/a_60_290# sky130_fd_pr_reram__reram_cell area_ox=0.0676
X2497 BLZ5 rr3t3r_0[56|5]/a_460_290# sky130_fd_pr_reram__reram_cell area_ox=0.0676
X2498 rr3t3r_0[56|5]/a_460_290# WL56 SL5 VSS sky130_fd_pr__nfet_g5v0d10v5 ad=0.65 pd=3.3 as=0 ps=0 w=1 l=0.5
X2499 BLN5 rr3t3r_0[56|5]/a_860_290# sky130_fd_pr_reram__reram_cell area_ox=0.0676
X2500 rr3t3r_0[56|5]/a_60_290# WL56 SL5 VSS sky130_fd_pr__nfet_g5v0d10v5 ad=0.65 pd=3.3 as=0 ps=0 w=1 l=0.5
X2501 rr3t3r_0[56|5]/a_860_290# WL56 SL5 VSS sky130_fd_pr__nfet_g5v0d10v5 ad=0.65 pd=3.3 as=0 ps=0 w=1 l=0.5
X2502 BLP5 rr3t3r_0[57|5]/a_60_290# sky130_fd_pr_reram__reram_cell area_ox=0.0676
X2503 BLZ5 rr3t3r_0[57|5]/a_460_290# sky130_fd_pr_reram__reram_cell area_ox=0.0676
X2504 rr3t3r_0[57|5]/a_460_290# WL57 SL5 VSS sky130_fd_pr__nfet_g5v0d10v5 ad=0.65 pd=3.3 as=0 ps=0 w=1 l=0.5
X2505 BLN5 rr3t3r_0[57|5]/a_860_290# sky130_fd_pr_reram__reram_cell area_ox=0.0676
X2506 rr3t3r_0[57|5]/a_60_290# WL57 SL5 VSS sky130_fd_pr__nfet_g5v0d10v5 ad=0.65 pd=3.3 as=0 ps=0 w=1 l=0.5
X2507 rr3t3r_0[57|5]/a_860_290# WL57 SL5 VSS sky130_fd_pr__nfet_g5v0d10v5 ad=0.65 pd=3.3 as=0 ps=0 w=1 l=0.5
X2508 BLP5 rr3t3r_0[58|5]/a_60_290# sky130_fd_pr_reram__reram_cell area_ox=0.0676
X2509 BLZ5 rr3t3r_0[58|5]/a_460_290# sky130_fd_pr_reram__reram_cell area_ox=0.0676
X2510 rr3t3r_0[58|5]/a_460_290# WL58 SL5 VSS sky130_fd_pr__nfet_g5v0d10v5 ad=0.65 pd=3.3 as=0 ps=0 w=1 l=0.5
X2511 BLN5 rr3t3r_0[58|5]/a_860_290# sky130_fd_pr_reram__reram_cell area_ox=0.0676
X2512 rr3t3r_0[58|5]/a_60_290# WL58 SL5 VSS sky130_fd_pr__nfet_g5v0d10v5 ad=0.65 pd=3.3 as=0 ps=0 w=1 l=0.5
X2513 rr3t3r_0[58|5]/a_860_290# WL58 SL5 VSS sky130_fd_pr__nfet_g5v0d10v5 ad=0.65 pd=3.3 as=0 ps=0 w=1 l=0.5
X2514 BLP5 rr3t3r_0[59|5]/a_60_290# sky130_fd_pr_reram__reram_cell area_ox=0.0676
X2515 BLZ5 rr3t3r_0[59|5]/a_460_290# sky130_fd_pr_reram__reram_cell area_ox=0.0676
X2516 rr3t3r_0[59|5]/a_460_290# WL59 SL5 VSS sky130_fd_pr__nfet_g5v0d10v5 ad=0.65 pd=3.3 as=0 ps=0 w=1 l=0.5
X2517 BLN5 rr3t3r_0[59|5]/a_860_290# sky130_fd_pr_reram__reram_cell area_ox=0.0676
X2518 rr3t3r_0[59|5]/a_60_290# WL59 SL5 VSS sky130_fd_pr__nfet_g5v0d10v5 ad=0.65 pd=3.3 as=0 ps=0 w=1 l=0.5
X2519 rr3t3r_0[59|5]/a_860_290# WL59 SL5 VSS sky130_fd_pr__nfet_g5v0d10v5 ad=0.65 pd=3.3 as=0 ps=0 w=1 l=0.5
X2520 BLP5 rr3t3r_0[60|5]/a_60_290# sky130_fd_pr_reram__reram_cell area_ox=0.0676
X2521 BLZ5 rr3t3r_0[60|5]/a_460_290# sky130_fd_pr_reram__reram_cell area_ox=0.0676
X2522 rr3t3r_0[60|5]/a_460_290# WL60 SL5 VSS sky130_fd_pr__nfet_g5v0d10v5 ad=0.65 pd=3.3 as=0 ps=0 w=1 l=0.5
X2523 BLN5 rr3t3r_0[60|5]/a_860_290# sky130_fd_pr_reram__reram_cell area_ox=0.0676
X2524 rr3t3r_0[60|5]/a_60_290# WL60 SL5 VSS sky130_fd_pr__nfet_g5v0d10v5 ad=0.65 pd=3.3 as=0 ps=0 w=1 l=0.5
X2525 rr3t3r_0[60|5]/a_860_290# WL60 SL5 VSS sky130_fd_pr__nfet_g5v0d10v5 ad=0.65 pd=3.3 as=0 ps=0 w=1 l=0.5
X2526 BLP5 rr3t3r_0[61|5]/a_60_290# sky130_fd_pr_reram__reram_cell area_ox=0.0676
X2527 BLZ5 rr3t3r_0[61|5]/a_460_290# sky130_fd_pr_reram__reram_cell area_ox=0.0676
X2528 rr3t3r_0[61|5]/a_460_290# WL61 SL5 VSS sky130_fd_pr__nfet_g5v0d10v5 ad=0.65 pd=3.3 as=0 ps=0 w=1 l=0.5
X2529 BLN5 rr3t3r_0[61|5]/a_860_290# sky130_fd_pr_reram__reram_cell area_ox=0.0676
X2530 rr3t3r_0[61|5]/a_60_290# WL61 SL5 VSS sky130_fd_pr__nfet_g5v0d10v5 ad=0.65 pd=3.3 as=0 ps=0 w=1 l=0.5
X2531 rr3t3r_0[61|5]/a_860_290# WL61 SL5 VSS sky130_fd_pr__nfet_g5v0d10v5 ad=0.65 pd=3.3 as=0 ps=0 w=1 l=0.5
X2532 BLP5 rr3t3r_0[62|5]/a_60_290# sky130_fd_pr_reram__reram_cell area_ox=0.0676
X2533 BLZ5 rr3t3r_0[62|5]/a_460_290# sky130_fd_pr_reram__reram_cell area_ox=0.0676
X2534 rr3t3r_0[62|5]/a_460_290# WL62 SL5 VSS sky130_fd_pr__nfet_g5v0d10v5 ad=0.65 pd=3.3 as=0 ps=0 w=1 l=0.5
X2535 BLN5 rr3t3r_0[62|5]/a_860_290# sky130_fd_pr_reram__reram_cell area_ox=0.0676
X2536 rr3t3r_0[62|5]/a_60_290# WL62 SL5 VSS sky130_fd_pr__nfet_g5v0d10v5 ad=0.65 pd=3.3 as=0 ps=0 w=1 l=0.5
X2537 rr3t3r_0[62|5]/a_860_290# WL62 SL5 VSS sky130_fd_pr__nfet_g5v0d10v5 ad=0.65 pd=3.3 as=0 ps=0 w=1 l=0.5
X2538 BLP5 rr3t3r_0[63|5]/a_60_290# sky130_fd_pr_reram__reram_cell area_ox=0.0676
X2539 BLZ5 rr3t3r_0[63|5]/a_460_290# sky130_fd_pr_reram__reram_cell area_ox=0.0676
X2540 rr3t3r_0[63|5]/a_460_290# WL63 SL5 VSS sky130_fd_pr__nfet_g5v0d10v5 ad=0.65 pd=3.3 as=0 ps=0 w=1 l=0.5
X2541 BLN5 rr3t3r_0[63|5]/a_860_290# sky130_fd_pr_reram__reram_cell area_ox=0.0676
X2542 rr3t3r_0[63|5]/a_60_290# WL63 SL5 VSS sky130_fd_pr__nfet_g5v0d10v5 ad=0.65 pd=3.3 as=0 ps=0 w=1 l=0.5
X2543 rr3t3r_0[63|5]/a_860_290# WL63 SL5 VSS sky130_fd_pr__nfet_g5v0d10v5 ad=0.65 pd=3.3 as=0 ps=0 w=1 l=0.5
X2544 BLP5 rr3t3r_0[64|5]/a_60_290# sky130_fd_pr_reram__reram_cell area_ox=0.0676
X2545 BLZ5 rr3t3r_0[64|5]/a_460_290# sky130_fd_pr_reram__reram_cell area_ox=0.0676
X2546 rr3t3r_0[64|5]/a_460_290# WL64 SL5 VSS sky130_fd_pr__nfet_g5v0d10v5 ad=0.65 pd=3.3 as=0 ps=0 w=1 l=0.5
X2547 BLN5 rr3t3r_0[64|5]/a_860_290# sky130_fd_pr_reram__reram_cell area_ox=0.0676
X2548 rr3t3r_0[64|5]/a_60_290# WL64 SL5 VSS sky130_fd_pr__nfet_g5v0d10v5 ad=0.65 pd=3.3 as=0 ps=0 w=1 l=0.5
X2549 rr3t3r_0[64|5]/a_860_290# WL64 SL5 VSS sky130_fd_pr__nfet_g5v0d10v5 ad=0.65 pd=3.3 as=0 ps=0 w=1 l=0.5
X2550 BLP5 rr3t3r_0[65|5]/a_60_290# sky130_fd_pr_reram__reram_cell area_ox=0.0676
X2551 BLZ5 rr3t3r_0[65|5]/a_460_290# sky130_fd_pr_reram__reram_cell area_ox=0.0676
X2552 rr3t3r_0[65|5]/a_460_290# WL65 SL5 VSS sky130_fd_pr__nfet_g5v0d10v5 ad=0.65 pd=3.3 as=0 ps=0 w=1 l=0.5
X2553 BLN5 rr3t3r_0[65|5]/a_860_290# sky130_fd_pr_reram__reram_cell area_ox=0.0676
X2554 rr3t3r_0[65|5]/a_60_290# WL65 SL5 VSS sky130_fd_pr__nfet_g5v0d10v5 ad=0.65 pd=3.3 as=0 ps=0 w=1 l=0.5
X2555 rr3t3r_0[65|5]/a_860_290# WL65 SL5 VSS sky130_fd_pr__nfet_g5v0d10v5 ad=0.65 pd=3.3 as=0 ps=0 w=1 l=0.5
X2556 BLP5 rr3t3r_0[66|5]/a_60_290# sky130_fd_pr_reram__reram_cell area_ox=0.0676
X2557 BLZ5 rr3t3r_0[66|5]/a_460_290# sky130_fd_pr_reram__reram_cell area_ox=0.0676
X2558 rr3t3r_0[66|5]/a_460_290# WL66 SL5 VSS sky130_fd_pr__nfet_g5v0d10v5 ad=0.65 pd=3.3 as=0 ps=0 w=1 l=0.5
X2559 BLN5 rr3t3r_0[66|5]/a_860_290# sky130_fd_pr_reram__reram_cell area_ox=0.0676
X2560 rr3t3r_0[66|5]/a_60_290# WL66 SL5 VSS sky130_fd_pr__nfet_g5v0d10v5 ad=0.65 pd=3.3 as=0 ps=0 w=1 l=0.5
X2561 rr3t3r_0[66|5]/a_860_290# WL66 SL5 VSS sky130_fd_pr__nfet_g5v0d10v5 ad=0.65 pd=3.3 as=0 ps=0 w=1 l=0.5
X2562 BLP5 rr3t3r_0[67|5]/a_60_290# sky130_fd_pr_reram__reram_cell area_ox=0.0676
X2563 BLZ5 rr3t3r_0[67|5]/a_460_290# sky130_fd_pr_reram__reram_cell area_ox=0.0676
X2564 rr3t3r_0[67|5]/a_460_290# WL67 SL5 VSS sky130_fd_pr__nfet_g5v0d10v5 ad=0.65 pd=3.3 as=0 ps=0 w=1 l=0.5
X2565 BLN5 rr3t3r_0[67|5]/a_860_290# sky130_fd_pr_reram__reram_cell area_ox=0.0676
X2566 rr3t3r_0[67|5]/a_60_290# WL67 SL5 VSS sky130_fd_pr__nfet_g5v0d10v5 ad=0.65 pd=3.3 as=0 ps=0 w=1 l=0.5
X2567 rr3t3r_0[67|5]/a_860_290# WL67 SL5 VSS sky130_fd_pr__nfet_g5v0d10v5 ad=0.65 pd=3.3 as=0 ps=0 w=1 l=0.5
X2568 BLP5 rr3t3r_0[68|5]/a_60_290# sky130_fd_pr_reram__reram_cell area_ox=0.0676
X2569 BLZ5 rr3t3r_0[68|5]/a_460_290# sky130_fd_pr_reram__reram_cell area_ox=0.0676
X2570 rr3t3r_0[68|5]/a_460_290# WL68 SL5 VSS sky130_fd_pr__nfet_g5v0d10v5 ad=0.65 pd=3.3 as=0 ps=0 w=1 l=0.5
X2571 BLN5 rr3t3r_0[68|5]/a_860_290# sky130_fd_pr_reram__reram_cell area_ox=0.0676
X2572 rr3t3r_0[68|5]/a_60_290# WL68 SL5 VSS sky130_fd_pr__nfet_g5v0d10v5 ad=0.65 pd=3.3 as=0 ps=0 w=1 l=0.5
X2573 rr3t3r_0[68|5]/a_860_290# WL68 SL5 VSS sky130_fd_pr__nfet_g5v0d10v5 ad=0.65 pd=3.3 as=0 ps=0 w=1 l=0.5
X2574 BLP5 rr3t3r_0[69|5]/a_60_290# sky130_fd_pr_reram__reram_cell area_ox=0.0676
X2575 BLZ5 rr3t3r_0[69|5]/a_460_290# sky130_fd_pr_reram__reram_cell area_ox=0.0676
X2576 rr3t3r_0[69|5]/a_460_290# WL69 SL5 VSS sky130_fd_pr__nfet_g5v0d10v5 ad=0.65 pd=3.3 as=0 ps=0 w=1 l=0.5
X2577 BLN5 rr3t3r_0[69|5]/a_860_290# sky130_fd_pr_reram__reram_cell area_ox=0.0676
X2578 rr3t3r_0[69|5]/a_60_290# WL69 SL5 VSS sky130_fd_pr__nfet_g5v0d10v5 ad=0.65 pd=3.3 as=0 ps=0 w=1 l=0.5
X2579 rr3t3r_0[69|5]/a_860_290# WL69 SL5 VSS sky130_fd_pr__nfet_g5v0d10v5 ad=0.65 pd=3.3 as=0 ps=0 w=1 l=0.5
X2580 BLP5 rr3t3r_0[70|5]/a_60_290# sky130_fd_pr_reram__reram_cell area_ox=0.0676
X2581 BLZ5 rr3t3r_0[70|5]/a_460_290# sky130_fd_pr_reram__reram_cell area_ox=0.0676
X2582 rr3t3r_0[70|5]/a_460_290# WL70 SL5 VSS sky130_fd_pr__nfet_g5v0d10v5 ad=0.65 pd=3.3 as=0 ps=0 w=1 l=0.5
X2583 BLN5 rr3t3r_0[70|5]/a_860_290# sky130_fd_pr_reram__reram_cell area_ox=0.0676
X2584 rr3t3r_0[70|5]/a_60_290# WL70 SL5 VSS sky130_fd_pr__nfet_g5v0d10v5 ad=0.65 pd=3.3 as=0 ps=0 w=1 l=0.5
X2585 rr3t3r_0[70|5]/a_860_290# WL70 SL5 VSS sky130_fd_pr__nfet_g5v0d10v5 ad=0.65 pd=3.3 as=0 ps=0 w=1 l=0.5
X2586 BLP5 rr3t3r_0[71|5]/a_60_290# sky130_fd_pr_reram__reram_cell area_ox=0.0676
X2587 BLZ5 rr3t3r_0[71|5]/a_460_290# sky130_fd_pr_reram__reram_cell area_ox=0.0676
X2588 rr3t3r_0[71|5]/a_460_290# WL71 SL5 VSS sky130_fd_pr__nfet_g5v0d10v5 ad=0.65 pd=3.3 as=0 ps=0 w=1 l=0.5
X2589 BLN5 rr3t3r_0[71|5]/a_860_290# sky130_fd_pr_reram__reram_cell area_ox=0.0676
X2590 rr3t3r_0[71|5]/a_60_290# WL71 SL5 VSS sky130_fd_pr__nfet_g5v0d10v5 ad=0.65 pd=3.3 as=0 ps=0 w=1 l=0.5
X2591 rr3t3r_0[71|5]/a_860_290# WL71 SL5 VSS sky130_fd_pr__nfet_g5v0d10v5 ad=0.65 pd=3.3 as=0 ps=0 w=1 l=0.5
X2592 BLP6 rr3t3r_0[0|6]/a_60_290# sky130_fd_pr_reram__reram_cell area_ox=0.0676
X2593 BLZ6 rr3t3r_0[0|6]/a_460_290# sky130_fd_pr_reram__reram_cell area_ox=0.0676
X2594 rr3t3r_0[0|6]/a_460_290# WL0 SL6 VSS sky130_fd_pr__nfet_g5v0d10v5 ad=0.65 pd=3.3 as=162 ps=756 w=1 l=0.5
X2595 BLN6 rr3t3r_0[0|6]/a_860_290# sky130_fd_pr_reram__reram_cell area_ox=0.0676
X2596 rr3t3r_0[0|6]/a_60_290# WL0 SL6 VSS sky130_fd_pr__nfet_g5v0d10v5 ad=0.65 pd=3.3 as=0 ps=0 w=1 l=0.5
X2597 rr3t3r_0[0|6]/a_860_290# WL0 SL6 VSS sky130_fd_pr__nfet_g5v0d10v5 ad=0.65 pd=3.3 as=0 ps=0 w=1 l=0.5
X2598 BLP6 rr3t3r_0[1|6]/a_60_290# sky130_fd_pr_reram__reram_cell area_ox=0.0676
X2599 BLZ6 rr3t3r_0[1|6]/a_460_290# sky130_fd_pr_reram__reram_cell area_ox=0.0676
X2600 rr3t3r_0[1|6]/a_460_290# WL1 SL6 VSS sky130_fd_pr__nfet_g5v0d10v5 ad=0.65 pd=3.3 as=0 ps=0 w=1 l=0.5
X2601 BLN6 rr3t3r_0[1|6]/a_860_290# sky130_fd_pr_reram__reram_cell area_ox=0.0676
X2602 rr3t3r_0[1|6]/a_60_290# WL1 SL6 VSS sky130_fd_pr__nfet_g5v0d10v5 ad=0.65 pd=3.3 as=0 ps=0 w=1 l=0.5
X2603 rr3t3r_0[1|6]/a_860_290# WL1 SL6 VSS sky130_fd_pr__nfet_g5v0d10v5 ad=0.65 pd=3.3 as=0 ps=0 w=1 l=0.5
X2604 BLP6 rr3t3r_0[2|6]/a_60_290# sky130_fd_pr_reram__reram_cell area_ox=0.0676
X2605 BLZ6 rr3t3r_0[2|6]/a_460_290# sky130_fd_pr_reram__reram_cell area_ox=0.0676
X2606 rr3t3r_0[2|6]/a_460_290# WL2 SL6 VSS sky130_fd_pr__nfet_g5v0d10v5 ad=0.65 pd=3.3 as=0 ps=0 w=1 l=0.5
X2607 BLN6 rr3t3r_0[2|6]/a_860_290# sky130_fd_pr_reram__reram_cell area_ox=0.0676
X2608 rr3t3r_0[2|6]/a_60_290# WL2 SL6 VSS sky130_fd_pr__nfet_g5v0d10v5 ad=0.65 pd=3.3 as=0 ps=0 w=1 l=0.5
X2609 rr3t3r_0[2|6]/a_860_290# WL2 SL6 VSS sky130_fd_pr__nfet_g5v0d10v5 ad=0.65 pd=3.3 as=0 ps=0 w=1 l=0.5
X2610 BLP6 rr3t3r_0[3|6]/a_60_290# sky130_fd_pr_reram__reram_cell area_ox=0.0676
X2611 BLZ6 rr3t3r_0[3|6]/a_460_290# sky130_fd_pr_reram__reram_cell area_ox=0.0676
X2612 rr3t3r_0[3|6]/a_460_290# WL3 SL6 VSS sky130_fd_pr__nfet_g5v0d10v5 ad=0.65 pd=3.3 as=0 ps=0 w=1 l=0.5
X2613 BLN6 rr3t3r_0[3|6]/a_860_290# sky130_fd_pr_reram__reram_cell area_ox=0.0676
X2614 rr3t3r_0[3|6]/a_60_290# WL3 SL6 VSS sky130_fd_pr__nfet_g5v0d10v5 ad=0.65 pd=3.3 as=0 ps=0 w=1 l=0.5
X2615 rr3t3r_0[3|6]/a_860_290# WL3 SL6 VSS sky130_fd_pr__nfet_g5v0d10v5 ad=0.65 pd=3.3 as=0 ps=0 w=1 l=0.5
X2616 BLP6 rr3t3r_0[4|6]/a_60_290# sky130_fd_pr_reram__reram_cell area_ox=0.0676
X2617 BLZ6 rr3t3r_0[4|6]/a_460_290# sky130_fd_pr_reram__reram_cell area_ox=0.0676
X2618 rr3t3r_0[4|6]/a_460_290# WL4 SL6 VSS sky130_fd_pr__nfet_g5v0d10v5 ad=0.65 pd=3.3 as=0 ps=0 w=1 l=0.5
X2619 BLN6 rr3t3r_0[4|6]/a_860_290# sky130_fd_pr_reram__reram_cell area_ox=0.0676
X2620 rr3t3r_0[4|6]/a_60_290# WL4 SL6 VSS sky130_fd_pr__nfet_g5v0d10v5 ad=0.65 pd=3.3 as=0 ps=0 w=1 l=0.5
X2621 rr3t3r_0[4|6]/a_860_290# WL4 SL6 VSS sky130_fd_pr__nfet_g5v0d10v5 ad=0.65 pd=3.3 as=0 ps=0 w=1 l=0.5
X2622 BLP6 rr3t3r_0[5|6]/a_60_290# sky130_fd_pr_reram__reram_cell area_ox=0.0676
X2623 BLZ6 rr3t3r_0[5|6]/a_460_290# sky130_fd_pr_reram__reram_cell area_ox=0.0676
X2624 rr3t3r_0[5|6]/a_460_290# WL5 SL6 VSS sky130_fd_pr__nfet_g5v0d10v5 ad=0.65 pd=3.3 as=0 ps=0 w=1 l=0.5
X2625 BLN6 rr3t3r_0[5|6]/a_860_290# sky130_fd_pr_reram__reram_cell area_ox=0.0676
X2626 rr3t3r_0[5|6]/a_60_290# WL5 SL6 VSS sky130_fd_pr__nfet_g5v0d10v5 ad=0.65 pd=3.3 as=0 ps=0 w=1 l=0.5
X2627 rr3t3r_0[5|6]/a_860_290# WL5 SL6 VSS sky130_fd_pr__nfet_g5v0d10v5 ad=0.65 pd=3.3 as=0 ps=0 w=1 l=0.5
X2628 BLP6 rr3t3r_0[6|6]/a_60_290# sky130_fd_pr_reram__reram_cell area_ox=0.0676
X2629 BLZ6 rr3t3r_0[6|6]/a_460_290# sky130_fd_pr_reram__reram_cell area_ox=0.0676
X2630 rr3t3r_0[6|6]/a_460_290# WL6 SL6 VSS sky130_fd_pr__nfet_g5v0d10v5 ad=0.65 pd=3.3 as=0 ps=0 w=1 l=0.5
X2631 BLN6 rr3t3r_0[6|6]/a_860_290# sky130_fd_pr_reram__reram_cell area_ox=0.0676
X2632 rr3t3r_0[6|6]/a_60_290# WL6 SL6 VSS sky130_fd_pr__nfet_g5v0d10v5 ad=0.65 pd=3.3 as=0 ps=0 w=1 l=0.5
X2633 rr3t3r_0[6|6]/a_860_290# WL6 SL6 VSS sky130_fd_pr__nfet_g5v0d10v5 ad=0.65 pd=3.3 as=0 ps=0 w=1 l=0.5
X2634 BLP6 rr3t3r_0[7|6]/a_60_290# sky130_fd_pr_reram__reram_cell area_ox=0.0676
X2635 BLZ6 rr3t3r_0[7|6]/a_460_290# sky130_fd_pr_reram__reram_cell area_ox=0.0676
X2636 rr3t3r_0[7|6]/a_460_290# WL7 SL6 VSS sky130_fd_pr__nfet_g5v0d10v5 ad=0.65 pd=3.3 as=0 ps=0 w=1 l=0.5
X2637 BLN6 rr3t3r_0[7|6]/a_860_290# sky130_fd_pr_reram__reram_cell area_ox=0.0676
X2638 rr3t3r_0[7|6]/a_60_290# WL7 SL6 VSS sky130_fd_pr__nfet_g5v0d10v5 ad=0.65 pd=3.3 as=0 ps=0 w=1 l=0.5
X2639 rr3t3r_0[7|6]/a_860_290# WL7 SL6 VSS sky130_fd_pr__nfet_g5v0d10v5 ad=0.65 pd=3.3 as=0 ps=0 w=1 l=0.5
X2640 BLP6 rr3t3r_0[8|6]/a_60_290# sky130_fd_pr_reram__reram_cell area_ox=0.0676
X2641 BLZ6 rr3t3r_0[8|6]/a_460_290# sky130_fd_pr_reram__reram_cell area_ox=0.0676
X2642 rr3t3r_0[8|6]/a_460_290# WL8 SL6 VSS sky130_fd_pr__nfet_g5v0d10v5 ad=0.65 pd=3.3 as=0 ps=0 w=1 l=0.5
X2643 BLN6 rr3t3r_0[8|6]/a_860_290# sky130_fd_pr_reram__reram_cell area_ox=0.0676
X2644 rr3t3r_0[8|6]/a_60_290# WL8 SL6 VSS sky130_fd_pr__nfet_g5v0d10v5 ad=0.65 pd=3.3 as=0 ps=0 w=1 l=0.5
X2645 rr3t3r_0[8|6]/a_860_290# WL8 SL6 VSS sky130_fd_pr__nfet_g5v0d10v5 ad=0.65 pd=3.3 as=0 ps=0 w=1 l=0.5
X2646 BLP6 rr3t3r_0[9|6]/a_60_290# sky130_fd_pr_reram__reram_cell area_ox=0.0676
X2647 BLZ6 rr3t3r_0[9|6]/a_460_290# sky130_fd_pr_reram__reram_cell area_ox=0.0676
X2648 rr3t3r_0[9|6]/a_460_290# WL9 SL6 VSS sky130_fd_pr__nfet_g5v0d10v5 ad=0.65 pd=3.3 as=0 ps=0 w=1 l=0.5
X2649 BLN6 rr3t3r_0[9|6]/a_860_290# sky130_fd_pr_reram__reram_cell area_ox=0.0676
X2650 rr3t3r_0[9|6]/a_60_290# WL9 SL6 VSS sky130_fd_pr__nfet_g5v0d10v5 ad=0.65 pd=3.3 as=0 ps=0 w=1 l=0.5
X2651 rr3t3r_0[9|6]/a_860_290# WL9 SL6 VSS sky130_fd_pr__nfet_g5v0d10v5 ad=0.65 pd=3.3 as=0 ps=0 w=1 l=0.5
X2652 BLP6 rr3t3r_0[10|6]/a_60_290# sky130_fd_pr_reram__reram_cell area_ox=0.0676
X2653 BLZ6 rr3t3r_0[10|6]/a_460_290# sky130_fd_pr_reram__reram_cell area_ox=0.0676
X2654 rr3t3r_0[10|6]/a_460_290# WL10 SL6 VSS sky130_fd_pr__nfet_g5v0d10v5 ad=0.65 pd=3.3 as=0 ps=0 w=1 l=0.5
X2655 BLN6 rr3t3r_0[10|6]/a_860_290# sky130_fd_pr_reram__reram_cell area_ox=0.0676
X2656 rr3t3r_0[10|6]/a_60_290# WL10 SL6 VSS sky130_fd_pr__nfet_g5v0d10v5 ad=0.65 pd=3.3 as=0 ps=0 w=1 l=0.5
X2657 rr3t3r_0[10|6]/a_860_290# WL10 SL6 VSS sky130_fd_pr__nfet_g5v0d10v5 ad=0.65 pd=3.3 as=0 ps=0 w=1 l=0.5
X2658 BLP6 rr3t3r_0[11|6]/a_60_290# sky130_fd_pr_reram__reram_cell area_ox=0.0676
X2659 BLZ6 rr3t3r_0[11|6]/a_460_290# sky130_fd_pr_reram__reram_cell area_ox=0.0676
X2660 rr3t3r_0[11|6]/a_460_290# WL11 SL6 VSS sky130_fd_pr__nfet_g5v0d10v5 ad=0.65 pd=3.3 as=0 ps=0 w=1 l=0.5
X2661 BLN6 rr3t3r_0[11|6]/a_860_290# sky130_fd_pr_reram__reram_cell area_ox=0.0676
X2662 rr3t3r_0[11|6]/a_60_290# WL11 SL6 VSS sky130_fd_pr__nfet_g5v0d10v5 ad=0.65 pd=3.3 as=0 ps=0 w=1 l=0.5
X2663 rr3t3r_0[11|6]/a_860_290# WL11 SL6 VSS sky130_fd_pr__nfet_g5v0d10v5 ad=0.65 pd=3.3 as=0 ps=0 w=1 l=0.5
X2664 BLP6 rr3t3r_0[12|6]/a_60_290# sky130_fd_pr_reram__reram_cell area_ox=0.0676
X2665 BLZ6 rr3t3r_0[12|6]/a_460_290# sky130_fd_pr_reram__reram_cell area_ox=0.0676
X2666 rr3t3r_0[12|6]/a_460_290# WL12 SL6 VSS sky130_fd_pr__nfet_g5v0d10v5 ad=0.65 pd=3.3 as=0 ps=0 w=1 l=0.5
X2667 BLN6 rr3t3r_0[12|6]/a_860_290# sky130_fd_pr_reram__reram_cell area_ox=0.0676
X2668 rr3t3r_0[12|6]/a_60_290# WL12 SL6 VSS sky130_fd_pr__nfet_g5v0d10v5 ad=0.65 pd=3.3 as=0 ps=0 w=1 l=0.5
X2669 rr3t3r_0[12|6]/a_860_290# WL12 SL6 VSS sky130_fd_pr__nfet_g5v0d10v5 ad=0.65 pd=3.3 as=0 ps=0 w=1 l=0.5
X2670 BLP6 rr3t3r_0[13|6]/a_60_290# sky130_fd_pr_reram__reram_cell area_ox=0.0676
X2671 BLZ6 rr3t3r_0[13|6]/a_460_290# sky130_fd_pr_reram__reram_cell area_ox=0.0676
X2672 rr3t3r_0[13|6]/a_460_290# WL13 SL6 VSS sky130_fd_pr__nfet_g5v0d10v5 ad=0.65 pd=3.3 as=0 ps=0 w=1 l=0.5
X2673 BLN6 rr3t3r_0[13|6]/a_860_290# sky130_fd_pr_reram__reram_cell area_ox=0.0676
X2674 rr3t3r_0[13|6]/a_60_290# WL13 SL6 VSS sky130_fd_pr__nfet_g5v0d10v5 ad=0.65 pd=3.3 as=0 ps=0 w=1 l=0.5
X2675 rr3t3r_0[13|6]/a_860_290# WL13 SL6 VSS sky130_fd_pr__nfet_g5v0d10v5 ad=0.65 pd=3.3 as=0 ps=0 w=1 l=0.5
X2676 BLP6 rr3t3r_0[14|6]/a_60_290# sky130_fd_pr_reram__reram_cell area_ox=0.0676
X2677 BLZ6 rr3t3r_0[14|6]/a_460_290# sky130_fd_pr_reram__reram_cell area_ox=0.0676
X2678 rr3t3r_0[14|6]/a_460_290# WL14 SL6 VSS sky130_fd_pr__nfet_g5v0d10v5 ad=0.65 pd=3.3 as=0 ps=0 w=1 l=0.5
X2679 BLN6 rr3t3r_0[14|6]/a_860_290# sky130_fd_pr_reram__reram_cell area_ox=0.0676
X2680 rr3t3r_0[14|6]/a_60_290# WL14 SL6 VSS sky130_fd_pr__nfet_g5v0d10v5 ad=0.65 pd=3.3 as=0 ps=0 w=1 l=0.5
X2681 rr3t3r_0[14|6]/a_860_290# WL14 SL6 VSS sky130_fd_pr__nfet_g5v0d10v5 ad=0.65 pd=3.3 as=0 ps=0 w=1 l=0.5
X2682 BLP6 rr3t3r_0[15|6]/a_60_290# sky130_fd_pr_reram__reram_cell area_ox=0.0676
X2683 BLZ6 rr3t3r_0[15|6]/a_460_290# sky130_fd_pr_reram__reram_cell area_ox=0.0676
X2684 rr3t3r_0[15|6]/a_460_290# WL15 SL6 VSS sky130_fd_pr__nfet_g5v0d10v5 ad=0.65 pd=3.3 as=0 ps=0 w=1 l=0.5
X2685 BLN6 rr3t3r_0[15|6]/a_860_290# sky130_fd_pr_reram__reram_cell area_ox=0.0676
X2686 rr3t3r_0[15|6]/a_60_290# WL15 SL6 VSS sky130_fd_pr__nfet_g5v0d10v5 ad=0.65 pd=3.3 as=0 ps=0 w=1 l=0.5
X2687 rr3t3r_0[15|6]/a_860_290# WL15 SL6 VSS sky130_fd_pr__nfet_g5v0d10v5 ad=0.65 pd=3.3 as=0 ps=0 w=1 l=0.5
X2688 BLP6 rr3t3r_0[16|6]/a_60_290# sky130_fd_pr_reram__reram_cell area_ox=0.0676
X2689 BLZ6 rr3t3r_0[16|6]/a_460_290# sky130_fd_pr_reram__reram_cell area_ox=0.0676
X2690 rr3t3r_0[16|6]/a_460_290# WL16 SL6 VSS sky130_fd_pr__nfet_g5v0d10v5 ad=0.65 pd=3.3 as=0 ps=0 w=1 l=0.5
X2691 BLN6 rr3t3r_0[16|6]/a_860_290# sky130_fd_pr_reram__reram_cell area_ox=0.0676
X2692 rr3t3r_0[16|6]/a_60_290# WL16 SL6 VSS sky130_fd_pr__nfet_g5v0d10v5 ad=0.65 pd=3.3 as=0 ps=0 w=1 l=0.5
X2693 rr3t3r_0[16|6]/a_860_290# WL16 SL6 VSS sky130_fd_pr__nfet_g5v0d10v5 ad=0.65 pd=3.3 as=0 ps=0 w=1 l=0.5
X2694 BLP6 rr3t3r_0[17|6]/a_60_290# sky130_fd_pr_reram__reram_cell area_ox=0.0676
X2695 BLZ6 rr3t3r_0[17|6]/a_460_290# sky130_fd_pr_reram__reram_cell area_ox=0.0676
X2696 rr3t3r_0[17|6]/a_460_290# WL17 SL6 VSS sky130_fd_pr__nfet_g5v0d10v5 ad=0.65 pd=3.3 as=0 ps=0 w=1 l=0.5
X2697 BLN6 rr3t3r_0[17|6]/a_860_290# sky130_fd_pr_reram__reram_cell area_ox=0.0676
X2698 rr3t3r_0[17|6]/a_60_290# WL17 SL6 VSS sky130_fd_pr__nfet_g5v0d10v5 ad=0.65 pd=3.3 as=0 ps=0 w=1 l=0.5
X2699 rr3t3r_0[17|6]/a_860_290# WL17 SL6 VSS sky130_fd_pr__nfet_g5v0d10v5 ad=0.65 pd=3.3 as=0 ps=0 w=1 l=0.5
X2700 BLP6 rr3t3r_0[18|6]/a_60_290# sky130_fd_pr_reram__reram_cell area_ox=0.0676
X2701 BLZ6 rr3t3r_0[18|6]/a_460_290# sky130_fd_pr_reram__reram_cell area_ox=0.0676
X2702 rr3t3r_0[18|6]/a_460_290# WL18 SL6 VSS sky130_fd_pr__nfet_g5v0d10v5 ad=0.65 pd=3.3 as=0 ps=0 w=1 l=0.5
X2703 BLN6 rr3t3r_0[18|6]/a_860_290# sky130_fd_pr_reram__reram_cell area_ox=0.0676
X2704 rr3t3r_0[18|6]/a_60_290# WL18 SL6 VSS sky130_fd_pr__nfet_g5v0d10v5 ad=0.65 pd=3.3 as=0 ps=0 w=1 l=0.5
X2705 rr3t3r_0[18|6]/a_860_290# WL18 SL6 VSS sky130_fd_pr__nfet_g5v0d10v5 ad=0.65 pd=3.3 as=0 ps=0 w=1 l=0.5
X2706 BLP6 rr3t3r_0[19|6]/a_60_290# sky130_fd_pr_reram__reram_cell area_ox=0.0676
X2707 BLZ6 rr3t3r_0[19|6]/a_460_290# sky130_fd_pr_reram__reram_cell area_ox=0.0676
X2708 rr3t3r_0[19|6]/a_460_290# WL19 SL6 VSS sky130_fd_pr__nfet_g5v0d10v5 ad=0.65 pd=3.3 as=0 ps=0 w=1 l=0.5
X2709 BLN6 rr3t3r_0[19|6]/a_860_290# sky130_fd_pr_reram__reram_cell area_ox=0.0676
X2710 rr3t3r_0[19|6]/a_60_290# WL19 SL6 VSS sky130_fd_pr__nfet_g5v0d10v5 ad=0.65 pd=3.3 as=0 ps=0 w=1 l=0.5
X2711 rr3t3r_0[19|6]/a_860_290# WL19 SL6 VSS sky130_fd_pr__nfet_g5v0d10v5 ad=0.65 pd=3.3 as=0 ps=0 w=1 l=0.5
X2712 BLP6 rr3t3r_0[20|6]/a_60_290# sky130_fd_pr_reram__reram_cell area_ox=0.0676
X2713 BLZ6 rr3t3r_0[20|6]/a_460_290# sky130_fd_pr_reram__reram_cell area_ox=0.0676
X2714 rr3t3r_0[20|6]/a_460_290# WL20 SL6 VSS sky130_fd_pr__nfet_g5v0d10v5 ad=0.65 pd=3.3 as=0 ps=0 w=1 l=0.5
X2715 BLN6 rr3t3r_0[20|6]/a_860_290# sky130_fd_pr_reram__reram_cell area_ox=0.0676
X2716 rr3t3r_0[20|6]/a_60_290# WL20 SL6 VSS sky130_fd_pr__nfet_g5v0d10v5 ad=0.65 pd=3.3 as=0 ps=0 w=1 l=0.5
X2717 rr3t3r_0[20|6]/a_860_290# WL20 SL6 VSS sky130_fd_pr__nfet_g5v0d10v5 ad=0.65 pd=3.3 as=0 ps=0 w=1 l=0.5
X2718 BLP6 rr3t3r_0[21|6]/a_60_290# sky130_fd_pr_reram__reram_cell area_ox=0.0676
X2719 BLZ6 rr3t3r_0[21|6]/a_460_290# sky130_fd_pr_reram__reram_cell area_ox=0.0676
X2720 rr3t3r_0[21|6]/a_460_290# WL21 SL6 VSS sky130_fd_pr__nfet_g5v0d10v5 ad=0.65 pd=3.3 as=0 ps=0 w=1 l=0.5
X2721 BLN6 rr3t3r_0[21|6]/a_860_290# sky130_fd_pr_reram__reram_cell area_ox=0.0676
X2722 rr3t3r_0[21|6]/a_60_290# WL21 SL6 VSS sky130_fd_pr__nfet_g5v0d10v5 ad=0.65 pd=3.3 as=0 ps=0 w=1 l=0.5
X2723 rr3t3r_0[21|6]/a_860_290# WL21 SL6 VSS sky130_fd_pr__nfet_g5v0d10v5 ad=0.65 pd=3.3 as=0 ps=0 w=1 l=0.5
X2724 BLP6 rr3t3r_0[22|6]/a_60_290# sky130_fd_pr_reram__reram_cell area_ox=0.0676
X2725 BLZ6 rr3t3r_0[22|6]/a_460_290# sky130_fd_pr_reram__reram_cell area_ox=0.0676
X2726 rr3t3r_0[22|6]/a_460_290# WL22 SL6 VSS sky130_fd_pr__nfet_g5v0d10v5 ad=0.65 pd=3.3 as=0 ps=0 w=1 l=0.5
X2727 BLN6 rr3t3r_0[22|6]/a_860_290# sky130_fd_pr_reram__reram_cell area_ox=0.0676
X2728 rr3t3r_0[22|6]/a_60_290# WL22 SL6 VSS sky130_fd_pr__nfet_g5v0d10v5 ad=0.65 pd=3.3 as=0 ps=0 w=1 l=0.5
X2729 rr3t3r_0[22|6]/a_860_290# WL22 SL6 VSS sky130_fd_pr__nfet_g5v0d10v5 ad=0.65 pd=3.3 as=0 ps=0 w=1 l=0.5
X2730 BLP6 rr3t3r_0[23|6]/a_60_290# sky130_fd_pr_reram__reram_cell area_ox=0.0676
X2731 BLZ6 rr3t3r_0[23|6]/a_460_290# sky130_fd_pr_reram__reram_cell area_ox=0.0676
X2732 rr3t3r_0[23|6]/a_460_290# WL23 SL6 VSS sky130_fd_pr__nfet_g5v0d10v5 ad=0.65 pd=3.3 as=0 ps=0 w=1 l=0.5
X2733 BLN6 rr3t3r_0[23|6]/a_860_290# sky130_fd_pr_reram__reram_cell area_ox=0.0676
X2734 rr3t3r_0[23|6]/a_60_290# WL23 SL6 VSS sky130_fd_pr__nfet_g5v0d10v5 ad=0.65 pd=3.3 as=0 ps=0 w=1 l=0.5
X2735 rr3t3r_0[23|6]/a_860_290# WL23 SL6 VSS sky130_fd_pr__nfet_g5v0d10v5 ad=0.65 pd=3.3 as=0 ps=0 w=1 l=0.5
X2736 BLP6 rr3t3r_0[24|6]/a_60_290# sky130_fd_pr_reram__reram_cell area_ox=0.0676
X2737 BLZ6 rr3t3r_0[24|6]/a_460_290# sky130_fd_pr_reram__reram_cell area_ox=0.0676
X2738 rr3t3r_0[24|6]/a_460_290# WL24 SL6 VSS sky130_fd_pr__nfet_g5v0d10v5 ad=0.65 pd=3.3 as=0 ps=0 w=1 l=0.5
X2739 BLN6 rr3t3r_0[24|6]/a_860_290# sky130_fd_pr_reram__reram_cell area_ox=0.0676
X2740 rr3t3r_0[24|6]/a_60_290# WL24 SL6 VSS sky130_fd_pr__nfet_g5v0d10v5 ad=0.65 pd=3.3 as=0 ps=0 w=1 l=0.5
X2741 rr3t3r_0[24|6]/a_860_290# WL24 SL6 VSS sky130_fd_pr__nfet_g5v0d10v5 ad=0.65 pd=3.3 as=0 ps=0 w=1 l=0.5
X2742 BLP6 rr3t3r_0[25|6]/a_60_290# sky130_fd_pr_reram__reram_cell area_ox=0.0676
X2743 BLZ6 rr3t3r_0[25|6]/a_460_290# sky130_fd_pr_reram__reram_cell area_ox=0.0676
X2744 rr3t3r_0[25|6]/a_460_290# WL25 SL6 VSS sky130_fd_pr__nfet_g5v0d10v5 ad=0.65 pd=3.3 as=0 ps=0 w=1 l=0.5
X2745 BLN6 rr3t3r_0[25|6]/a_860_290# sky130_fd_pr_reram__reram_cell area_ox=0.0676
X2746 rr3t3r_0[25|6]/a_60_290# WL25 SL6 VSS sky130_fd_pr__nfet_g5v0d10v5 ad=0.65 pd=3.3 as=0 ps=0 w=1 l=0.5
X2747 rr3t3r_0[25|6]/a_860_290# WL25 SL6 VSS sky130_fd_pr__nfet_g5v0d10v5 ad=0.65 pd=3.3 as=0 ps=0 w=1 l=0.5
X2748 BLP6 rr3t3r_0[26|6]/a_60_290# sky130_fd_pr_reram__reram_cell area_ox=0.0676
X2749 BLZ6 rr3t3r_0[26|6]/a_460_290# sky130_fd_pr_reram__reram_cell area_ox=0.0676
X2750 rr3t3r_0[26|6]/a_460_290# WL26 SL6 VSS sky130_fd_pr__nfet_g5v0d10v5 ad=0.65 pd=3.3 as=0 ps=0 w=1 l=0.5
X2751 BLN6 rr3t3r_0[26|6]/a_860_290# sky130_fd_pr_reram__reram_cell area_ox=0.0676
X2752 rr3t3r_0[26|6]/a_60_290# WL26 SL6 VSS sky130_fd_pr__nfet_g5v0d10v5 ad=0.65 pd=3.3 as=0 ps=0 w=1 l=0.5
X2753 rr3t3r_0[26|6]/a_860_290# WL26 SL6 VSS sky130_fd_pr__nfet_g5v0d10v5 ad=0.65 pd=3.3 as=0 ps=0 w=1 l=0.5
X2754 BLP6 rr3t3r_0[27|6]/a_60_290# sky130_fd_pr_reram__reram_cell area_ox=0.0676
X2755 BLZ6 rr3t3r_0[27|6]/a_460_290# sky130_fd_pr_reram__reram_cell area_ox=0.0676
X2756 rr3t3r_0[27|6]/a_460_290# WL27 SL6 VSS sky130_fd_pr__nfet_g5v0d10v5 ad=0.65 pd=3.3 as=0 ps=0 w=1 l=0.5
X2757 BLN6 rr3t3r_0[27|6]/a_860_290# sky130_fd_pr_reram__reram_cell area_ox=0.0676
X2758 rr3t3r_0[27|6]/a_60_290# WL27 SL6 VSS sky130_fd_pr__nfet_g5v0d10v5 ad=0.65 pd=3.3 as=0 ps=0 w=1 l=0.5
X2759 rr3t3r_0[27|6]/a_860_290# WL27 SL6 VSS sky130_fd_pr__nfet_g5v0d10v5 ad=0.65 pd=3.3 as=0 ps=0 w=1 l=0.5
X2760 BLP6 rr3t3r_0[28|6]/a_60_290# sky130_fd_pr_reram__reram_cell area_ox=0.0676
X2761 BLZ6 rr3t3r_0[28|6]/a_460_290# sky130_fd_pr_reram__reram_cell area_ox=0.0676
X2762 rr3t3r_0[28|6]/a_460_290# WL28 SL6 VSS sky130_fd_pr__nfet_g5v0d10v5 ad=0.65 pd=3.3 as=0 ps=0 w=1 l=0.5
X2763 BLN6 rr3t3r_0[28|6]/a_860_290# sky130_fd_pr_reram__reram_cell area_ox=0.0676
X2764 rr3t3r_0[28|6]/a_60_290# WL28 SL6 VSS sky130_fd_pr__nfet_g5v0d10v5 ad=0.65 pd=3.3 as=0 ps=0 w=1 l=0.5
X2765 rr3t3r_0[28|6]/a_860_290# WL28 SL6 VSS sky130_fd_pr__nfet_g5v0d10v5 ad=0.65 pd=3.3 as=0 ps=0 w=1 l=0.5
X2766 BLP6 rr3t3r_0[29|6]/a_60_290# sky130_fd_pr_reram__reram_cell area_ox=0.0676
X2767 BLZ6 rr3t3r_0[29|6]/a_460_290# sky130_fd_pr_reram__reram_cell area_ox=0.0676
X2768 rr3t3r_0[29|6]/a_460_290# WL29 SL6 VSS sky130_fd_pr__nfet_g5v0d10v5 ad=0.65 pd=3.3 as=0 ps=0 w=1 l=0.5
X2769 BLN6 rr3t3r_0[29|6]/a_860_290# sky130_fd_pr_reram__reram_cell area_ox=0.0676
X2770 rr3t3r_0[29|6]/a_60_290# WL29 SL6 VSS sky130_fd_pr__nfet_g5v0d10v5 ad=0.65 pd=3.3 as=0 ps=0 w=1 l=0.5
X2771 rr3t3r_0[29|6]/a_860_290# WL29 SL6 VSS sky130_fd_pr__nfet_g5v0d10v5 ad=0.65 pd=3.3 as=0 ps=0 w=1 l=0.5
X2772 BLP6 rr3t3r_0[30|6]/a_60_290# sky130_fd_pr_reram__reram_cell area_ox=0.0676
X2773 BLZ6 rr3t3r_0[30|6]/a_460_290# sky130_fd_pr_reram__reram_cell area_ox=0.0676
X2774 rr3t3r_0[30|6]/a_460_290# WL30 SL6 VSS sky130_fd_pr__nfet_g5v0d10v5 ad=0.65 pd=3.3 as=0 ps=0 w=1 l=0.5
X2775 BLN6 rr3t3r_0[30|6]/a_860_290# sky130_fd_pr_reram__reram_cell area_ox=0.0676
X2776 rr3t3r_0[30|6]/a_60_290# WL30 SL6 VSS sky130_fd_pr__nfet_g5v0d10v5 ad=0.65 pd=3.3 as=0 ps=0 w=1 l=0.5
X2777 rr3t3r_0[30|6]/a_860_290# WL30 SL6 VSS sky130_fd_pr__nfet_g5v0d10v5 ad=0.65 pd=3.3 as=0 ps=0 w=1 l=0.5
X2778 BLP6 rr3t3r_0[31|6]/a_60_290# sky130_fd_pr_reram__reram_cell area_ox=0.0676
X2779 BLZ6 rr3t3r_0[31|6]/a_460_290# sky130_fd_pr_reram__reram_cell area_ox=0.0676
X2780 rr3t3r_0[31|6]/a_460_290# WL31 SL6 VSS sky130_fd_pr__nfet_g5v0d10v5 ad=0.65 pd=3.3 as=0 ps=0 w=1 l=0.5
X2781 BLN6 rr3t3r_0[31|6]/a_860_290# sky130_fd_pr_reram__reram_cell area_ox=0.0676
X2782 rr3t3r_0[31|6]/a_60_290# WL31 SL6 VSS sky130_fd_pr__nfet_g5v0d10v5 ad=0.65 pd=3.3 as=0 ps=0 w=1 l=0.5
X2783 rr3t3r_0[31|6]/a_860_290# WL31 SL6 VSS sky130_fd_pr__nfet_g5v0d10v5 ad=0.65 pd=3.3 as=0 ps=0 w=1 l=0.5
X2784 BLP6 rr3t3r_0[32|6]/a_60_290# sky130_fd_pr_reram__reram_cell area_ox=0.0676
X2785 BLZ6 rr3t3r_0[32|6]/a_460_290# sky130_fd_pr_reram__reram_cell area_ox=0.0676
X2786 rr3t3r_0[32|6]/a_460_290# WL32 SL6 VSS sky130_fd_pr__nfet_g5v0d10v5 ad=0.65 pd=3.3 as=0 ps=0 w=1 l=0.5
X2787 BLN6 rr3t3r_0[32|6]/a_860_290# sky130_fd_pr_reram__reram_cell area_ox=0.0676
X2788 rr3t3r_0[32|6]/a_60_290# WL32 SL6 VSS sky130_fd_pr__nfet_g5v0d10v5 ad=0.65 pd=3.3 as=0 ps=0 w=1 l=0.5
X2789 rr3t3r_0[32|6]/a_860_290# WL32 SL6 VSS sky130_fd_pr__nfet_g5v0d10v5 ad=0.65 pd=3.3 as=0 ps=0 w=1 l=0.5
X2790 BLP6 rr3t3r_0[33|6]/a_60_290# sky130_fd_pr_reram__reram_cell area_ox=0.0676
X2791 BLZ6 rr3t3r_0[33|6]/a_460_290# sky130_fd_pr_reram__reram_cell area_ox=0.0676
X2792 rr3t3r_0[33|6]/a_460_290# WL33 SL6 VSS sky130_fd_pr__nfet_g5v0d10v5 ad=0.65 pd=3.3 as=0 ps=0 w=1 l=0.5
X2793 BLN6 rr3t3r_0[33|6]/a_860_290# sky130_fd_pr_reram__reram_cell area_ox=0.0676
X2794 rr3t3r_0[33|6]/a_60_290# WL33 SL6 VSS sky130_fd_pr__nfet_g5v0d10v5 ad=0.65 pd=3.3 as=0 ps=0 w=1 l=0.5
X2795 rr3t3r_0[33|6]/a_860_290# WL33 SL6 VSS sky130_fd_pr__nfet_g5v0d10v5 ad=0.65 pd=3.3 as=0 ps=0 w=1 l=0.5
X2796 BLP6 rr3t3r_0[34|6]/a_60_290# sky130_fd_pr_reram__reram_cell area_ox=0.0676
X2797 BLZ6 rr3t3r_0[34|6]/a_460_290# sky130_fd_pr_reram__reram_cell area_ox=0.0676
X2798 rr3t3r_0[34|6]/a_460_290# WL34 SL6 VSS sky130_fd_pr__nfet_g5v0d10v5 ad=0.65 pd=3.3 as=0 ps=0 w=1 l=0.5
X2799 BLN6 rr3t3r_0[34|6]/a_860_290# sky130_fd_pr_reram__reram_cell area_ox=0.0676
X2800 rr3t3r_0[34|6]/a_60_290# WL34 SL6 VSS sky130_fd_pr__nfet_g5v0d10v5 ad=0.65 pd=3.3 as=0 ps=0 w=1 l=0.5
X2801 rr3t3r_0[34|6]/a_860_290# WL34 SL6 VSS sky130_fd_pr__nfet_g5v0d10v5 ad=0.65 pd=3.3 as=0 ps=0 w=1 l=0.5
X2802 BLP6 rr3t3r_0[35|6]/a_60_290# sky130_fd_pr_reram__reram_cell area_ox=0.0676
X2803 BLZ6 rr3t3r_0[35|6]/a_460_290# sky130_fd_pr_reram__reram_cell area_ox=0.0676
X2804 rr3t3r_0[35|6]/a_460_290# WL35 SL6 VSS sky130_fd_pr__nfet_g5v0d10v5 ad=0.65 pd=3.3 as=0 ps=0 w=1 l=0.5
X2805 BLN6 rr3t3r_0[35|6]/a_860_290# sky130_fd_pr_reram__reram_cell area_ox=0.0676
X2806 rr3t3r_0[35|6]/a_60_290# WL35 SL6 VSS sky130_fd_pr__nfet_g5v0d10v5 ad=0.65 pd=3.3 as=0 ps=0 w=1 l=0.5
X2807 rr3t3r_0[35|6]/a_860_290# WL35 SL6 VSS sky130_fd_pr__nfet_g5v0d10v5 ad=0.65 pd=3.3 as=0 ps=0 w=1 l=0.5
X2808 BLP6 rr3t3r_0[36|6]/a_60_290# sky130_fd_pr_reram__reram_cell area_ox=0.0676
X2809 BLZ6 rr3t3r_0[36|6]/a_460_290# sky130_fd_pr_reram__reram_cell area_ox=0.0676
X2810 rr3t3r_0[36|6]/a_460_290# WL36 SL6 VSS sky130_fd_pr__nfet_g5v0d10v5 ad=0.65 pd=3.3 as=0 ps=0 w=1 l=0.5
X2811 BLN6 rr3t3r_0[36|6]/a_860_290# sky130_fd_pr_reram__reram_cell area_ox=0.0676
X2812 rr3t3r_0[36|6]/a_60_290# WL36 SL6 VSS sky130_fd_pr__nfet_g5v0d10v5 ad=0.65 pd=3.3 as=0 ps=0 w=1 l=0.5
X2813 rr3t3r_0[36|6]/a_860_290# WL36 SL6 VSS sky130_fd_pr__nfet_g5v0d10v5 ad=0.65 pd=3.3 as=0 ps=0 w=1 l=0.5
X2814 BLP6 rr3t3r_0[37|6]/a_60_290# sky130_fd_pr_reram__reram_cell area_ox=0.0676
X2815 BLZ6 rr3t3r_0[37|6]/a_460_290# sky130_fd_pr_reram__reram_cell area_ox=0.0676
X2816 rr3t3r_0[37|6]/a_460_290# WL37 SL6 VSS sky130_fd_pr__nfet_g5v0d10v5 ad=0.65 pd=3.3 as=0 ps=0 w=1 l=0.5
X2817 BLN6 rr3t3r_0[37|6]/a_860_290# sky130_fd_pr_reram__reram_cell area_ox=0.0676
X2818 rr3t3r_0[37|6]/a_60_290# WL37 SL6 VSS sky130_fd_pr__nfet_g5v0d10v5 ad=0.65 pd=3.3 as=0 ps=0 w=1 l=0.5
X2819 rr3t3r_0[37|6]/a_860_290# WL37 SL6 VSS sky130_fd_pr__nfet_g5v0d10v5 ad=0.65 pd=3.3 as=0 ps=0 w=1 l=0.5
X2820 BLP6 rr3t3r_0[38|6]/a_60_290# sky130_fd_pr_reram__reram_cell area_ox=0.0676
X2821 BLZ6 rr3t3r_0[38|6]/a_460_290# sky130_fd_pr_reram__reram_cell area_ox=0.0676
X2822 rr3t3r_0[38|6]/a_460_290# WL38 SL6 VSS sky130_fd_pr__nfet_g5v0d10v5 ad=0.65 pd=3.3 as=0 ps=0 w=1 l=0.5
X2823 BLN6 rr3t3r_0[38|6]/a_860_290# sky130_fd_pr_reram__reram_cell area_ox=0.0676
X2824 rr3t3r_0[38|6]/a_60_290# WL38 SL6 VSS sky130_fd_pr__nfet_g5v0d10v5 ad=0.65 pd=3.3 as=0 ps=0 w=1 l=0.5
X2825 rr3t3r_0[38|6]/a_860_290# WL38 SL6 VSS sky130_fd_pr__nfet_g5v0d10v5 ad=0.65 pd=3.3 as=0 ps=0 w=1 l=0.5
X2826 BLP6 rr3t3r_0[39|6]/a_60_290# sky130_fd_pr_reram__reram_cell area_ox=0.0676
X2827 BLZ6 rr3t3r_0[39|6]/a_460_290# sky130_fd_pr_reram__reram_cell area_ox=0.0676
X2828 rr3t3r_0[39|6]/a_460_290# WL39 SL6 VSS sky130_fd_pr__nfet_g5v0d10v5 ad=0.65 pd=3.3 as=0 ps=0 w=1 l=0.5
X2829 BLN6 rr3t3r_0[39|6]/a_860_290# sky130_fd_pr_reram__reram_cell area_ox=0.0676
X2830 rr3t3r_0[39|6]/a_60_290# WL39 SL6 VSS sky130_fd_pr__nfet_g5v0d10v5 ad=0.65 pd=3.3 as=0 ps=0 w=1 l=0.5
X2831 rr3t3r_0[39|6]/a_860_290# WL39 SL6 VSS sky130_fd_pr__nfet_g5v0d10v5 ad=0.65 pd=3.3 as=0 ps=0 w=1 l=0.5
X2832 BLP6 rr3t3r_0[40|6]/a_60_290# sky130_fd_pr_reram__reram_cell area_ox=0.0676
X2833 BLZ6 rr3t3r_0[40|6]/a_460_290# sky130_fd_pr_reram__reram_cell area_ox=0.0676
X2834 rr3t3r_0[40|6]/a_460_290# WL40 SL6 VSS sky130_fd_pr__nfet_g5v0d10v5 ad=0.65 pd=3.3 as=0 ps=0 w=1 l=0.5
X2835 BLN6 rr3t3r_0[40|6]/a_860_290# sky130_fd_pr_reram__reram_cell area_ox=0.0676
X2836 rr3t3r_0[40|6]/a_60_290# WL40 SL6 VSS sky130_fd_pr__nfet_g5v0d10v5 ad=0.65 pd=3.3 as=0 ps=0 w=1 l=0.5
X2837 rr3t3r_0[40|6]/a_860_290# WL40 SL6 VSS sky130_fd_pr__nfet_g5v0d10v5 ad=0.65 pd=3.3 as=0 ps=0 w=1 l=0.5
X2838 BLP6 rr3t3r_0[41|6]/a_60_290# sky130_fd_pr_reram__reram_cell area_ox=0.0676
X2839 BLZ6 rr3t3r_0[41|6]/a_460_290# sky130_fd_pr_reram__reram_cell area_ox=0.0676
X2840 rr3t3r_0[41|6]/a_460_290# WL41 SL6 VSS sky130_fd_pr__nfet_g5v0d10v5 ad=0.65 pd=3.3 as=0 ps=0 w=1 l=0.5
X2841 BLN6 rr3t3r_0[41|6]/a_860_290# sky130_fd_pr_reram__reram_cell area_ox=0.0676
X2842 rr3t3r_0[41|6]/a_60_290# WL41 SL6 VSS sky130_fd_pr__nfet_g5v0d10v5 ad=0.65 pd=3.3 as=0 ps=0 w=1 l=0.5
X2843 rr3t3r_0[41|6]/a_860_290# WL41 SL6 VSS sky130_fd_pr__nfet_g5v0d10v5 ad=0.65 pd=3.3 as=0 ps=0 w=1 l=0.5
X2844 BLP6 rr3t3r_0[42|6]/a_60_290# sky130_fd_pr_reram__reram_cell area_ox=0.0676
X2845 BLZ6 rr3t3r_0[42|6]/a_460_290# sky130_fd_pr_reram__reram_cell area_ox=0.0676
X2846 rr3t3r_0[42|6]/a_460_290# WL42 SL6 VSS sky130_fd_pr__nfet_g5v0d10v5 ad=0.65 pd=3.3 as=0 ps=0 w=1 l=0.5
X2847 BLN6 rr3t3r_0[42|6]/a_860_290# sky130_fd_pr_reram__reram_cell area_ox=0.0676
X2848 rr3t3r_0[42|6]/a_60_290# WL42 SL6 VSS sky130_fd_pr__nfet_g5v0d10v5 ad=0.65 pd=3.3 as=0 ps=0 w=1 l=0.5
X2849 rr3t3r_0[42|6]/a_860_290# WL42 SL6 VSS sky130_fd_pr__nfet_g5v0d10v5 ad=0.65 pd=3.3 as=0 ps=0 w=1 l=0.5
X2850 BLP6 rr3t3r_0[43|6]/a_60_290# sky130_fd_pr_reram__reram_cell area_ox=0.0676
X2851 BLZ6 rr3t3r_0[43|6]/a_460_290# sky130_fd_pr_reram__reram_cell area_ox=0.0676
X2852 rr3t3r_0[43|6]/a_460_290# WL43 SL6 VSS sky130_fd_pr__nfet_g5v0d10v5 ad=0.65 pd=3.3 as=0 ps=0 w=1 l=0.5
X2853 BLN6 rr3t3r_0[43|6]/a_860_290# sky130_fd_pr_reram__reram_cell area_ox=0.0676
X2854 rr3t3r_0[43|6]/a_60_290# WL43 SL6 VSS sky130_fd_pr__nfet_g5v0d10v5 ad=0.65 pd=3.3 as=0 ps=0 w=1 l=0.5
X2855 rr3t3r_0[43|6]/a_860_290# WL43 SL6 VSS sky130_fd_pr__nfet_g5v0d10v5 ad=0.65 pd=3.3 as=0 ps=0 w=1 l=0.5
X2856 BLP6 rr3t3r_0[44|6]/a_60_290# sky130_fd_pr_reram__reram_cell area_ox=0.0676
X2857 BLZ6 rr3t3r_0[44|6]/a_460_290# sky130_fd_pr_reram__reram_cell area_ox=0.0676
X2858 rr3t3r_0[44|6]/a_460_290# WL44 SL6 VSS sky130_fd_pr__nfet_g5v0d10v5 ad=0.65 pd=3.3 as=0 ps=0 w=1 l=0.5
X2859 BLN6 rr3t3r_0[44|6]/a_860_290# sky130_fd_pr_reram__reram_cell area_ox=0.0676
X2860 rr3t3r_0[44|6]/a_60_290# WL44 SL6 VSS sky130_fd_pr__nfet_g5v0d10v5 ad=0.65 pd=3.3 as=0 ps=0 w=1 l=0.5
X2861 rr3t3r_0[44|6]/a_860_290# WL44 SL6 VSS sky130_fd_pr__nfet_g5v0d10v5 ad=0.65 pd=3.3 as=0 ps=0 w=1 l=0.5
X2862 BLP6 rr3t3r_0[45|6]/a_60_290# sky130_fd_pr_reram__reram_cell area_ox=0.0676
X2863 BLZ6 rr3t3r_0[45|6]/a_460_290# sky130_fd_pr_reram__reram_cell area_ox=0.0676
X2864 rr3t3r_0[45|6]/a_460_290# WL45 SL6 VSS sky130_fd_pr__nfet_g5v0d10v5 ad=0.65 pd=3.3 as=0 ps=0 w=1 l=0.5
X2865 BLN6 rr3t3r_0[45|6]/a_860_290# sky130_fd_pr_reram__reram_cell area_ox=0.0676
X2866 rr3t3r_0[45|6]/a_60_290# WL45 SL6 VSS sky130_fd_pr__nfet_g5v0d10v5 ad=0.65 pd=3.3 as=0 ps=0 w=1 l=0.5
X2867 rr3t3r_0[45|6]/a_860_290# WL45 SL6 VSS sky130_fd_pr__nfet_g5v0d10v5 ad=0.65 pd=3.3 as=0 ps=0 w=1 l=0.5
X2868 BLP6 rr3t3r_0[46|6]/a_60_290# sky130_fd_pr_reram__reram_cell area_ox=0.0676
X2869 BLZ6 rr3t3r_0[46|6]/a_460_290# sky130_fd_pr_reram__reram_cell area_ox=0.0676
X2870 rr3t3r_0[46|6]/a_460_290# WL46 SL6 VSS sky130_fd_pr__nfet_g5v0d10v5 ad=0.65 pd=3.3 as=0 ps=0 w=1 l=0.5
X2871 BLN6 rr3t3r_0[46|6]/a_860_290# sky130_fd_pr_reram__reram_cell area_ox=0.0676
X2872 rr3t3r_0[46|6]/a_60_290# WL46 SL6 VSS sky130_fd_pr__nfet_g5v0d10v5 ad=0.65 pd=3.3 as=0 ps=0 w=1 l=0.5
X2873 rr3t3r_0[46|6]/a_860_290# WL46 SL6 VSS sky130_fd_pr__nfet_g5v0d10v5 ad=0.65 pd=3.3 as=0 ps=0 w=1 l=0.5
X2874 BLP6 rr3t3r_0[47|6]/a_60_290# sky130_fd_pr_reram__reram_cell area_ox=0.0676
X2875 BLZ6 rr3t3r_0[47|6]/a_460_290# sky130_fd_pr_reram__reram_cell area_ox=0.0676
X2876 rr3t3r_0[47|6]/a_460_290# WL47 SL6 VSS sky130_fd_pr__nfet_g5v0d10v5 ad=0.65 pd=3.3 as=0 ps=0 w=1 l=0.5
X2877 BLN6 rr3t3r_0[47|6]/a_860_290# sky130_fd_pr_reram__reram_cell area_ox=0.0676
X2878 rr3t3r_0[47|6]/a_60_290# WL47 SL6 VSS sky130_fd_pr__nfet_g5v0d10v5 ad=0.65 pd=3.3 as=0 ps=0 w=1 l=0.5
X2879 rr3t3r_0[47|6]/a_860_290# WL47 SL6 VSS sky130_fd_pr__nfet_g5v0d10v5 ad=0.65 pd=3.3 as=0 ps=0 w=1 l=0.5
X2880 BLP6 rr3t3r_0[48|6]/a_60_290# sky130_fd_pr_reram__reram_cell area_ox=0.0676
X2881 BLZ6 rr3t3r_0[48|6]/a_460_290# sky130_fd_pr_reram__reram_cell area_ox=0.0676
X2882 rr3t3r_0[48|6]/a_460_290# WL48 SL6 VSS sky130_fd_pr__nfet_g5v0d10v5 ad=0.65 pd=3.3 as=0 ps=0 w=1 l=0.5
X2883 BLN6 rr3t3r_0[48|6]/a_860_290# sky130_fd_pr_reram__reram_cell area_ox=0.0676
X2884 rr3t3r_0[48|6]/a_60_290# WL48 SL6 VSS sky130_fd_pr__nfet_g5v0d10v5 ad=0.65 pd=3.3 as=0 ps=0 w=1 l=0.5
X2885 rr3t3r_0[48|6]/a_860_290# WL48 SL6 VSS sky130_fd_pr__nfet_g5v0d10v5 ad=0.65 pd=3.3 as=0 ps=0 w=1 l=0.5
X2886 BLP6 rr3t3r_0[49|6]/a_60_290# sky130_fd_pr_reram__reram_cell area_ox=0.0676
X2887 BLZ6 rr3t3r_0[49|6]/a_460_290# sky130_fd_pr_reram__reram_cell area_ox=0.0676
X2888 rr3t3r_0[49|6]/a_460_290# WL49 SL6 VSS sky130_fd_pr__nfet_g5v0d10v5 ad=0.65 pd=3.3 as=0 ps=0 w=1 l=0.5
X2889 BLN6 rr3t3r_0[49|6]/a_860_290# sky130_fd_pr_reram__reram_cell area_ox=0.0676
X2890 rr3t3r_0[49|6]/a_60_290# WL49 SL6 VSS sky130_fd_pr__nfet_g5v0d10v5 ad=0.65 pd=3.3 as=0 ps=0 w=1 l=0.5
X2891 rr3t3r_0[49|6]/a_860_290# WL49 SL6 VSS sky130_fd_pr__nfet_g5v0d10v5 ad=0.65 pd=3.3 as=0 ps=0 w=1 l=0.5
X2892 BLP6 rr3t3r_0[50|6]/a_60_290# sky130_fd_pr_reram__reram_cell area_ox=0.0676
X2893 BLZ6 rr3t3r_0[50|6]/a_460_290# sky130_fd_pr_reram__reram_cell area_ox=0.0676
X2894 rr3t3r_0[50|6]/a_460_290# WL50 SL6 VSS sky130_fd_pr__nfet_g5v0d10v5 ad=0.65 pd=3.3 as=0 ps=0 w=1 l=0.5
X2895 BLN6 rr3t3r_0[50|6]/a_860_290# sky130_fd_pr_reram__reram_cell area_ox=0.0676
X2896 rr3t3r_0[50|6]/a_60_290# WL50 SL6 VSS sky130_fd_pr__nfet_g5v0d10v5 ad=0.65 pd=3.3 as=0 ps=0 w=1 l=0.5
X2897 rr3t3r_0[50|6]/a_860_290# WL50 SL6 VSS sky130_fd_pr__nfet_g5v0d10v5 ad=0.65 pd=3.3 as=0 ps=0 w=1 l=0.5
X2898 BLP6 rr3t3r_0[51|6]/a_60_290# sky130_fd_pr_reram__reram_cell area_ox=0.0676
X2899 BLZ6 rr3t3r_0[51|6]/a_460_290# sky130_fd_pr_reram__reram_cell area_ox=0.0676
X2900 rr3t3r_0[51|6]/a_460_290# WL51 SL6 VSS sky130_fd_pr__nfet_g5v0d10v5 ad=0.65 pd=3.3 as=0 ps=0 w=1 l=0.5
X2901 BLN6 rr3t3r_0[51|6]/a_860_290# sky130_fd_pr_reram__reram_cell area_ox=0.0676
X2902 rr3t3r_0[51|6]/a_60_290# WL51 SL6 VSS sky130_fd_pr__nfet_g5v0d10v5 ad=0.65 pd=3.3 as=0 ps=0 w=1 l=0.5
X2903 rr3t3r_0[51|6]/a_860_290# WL51 SL6 VSS sky130_fd_pr__nfet_g5v0d10v5 ad=0.65 pd=3.3 as=0 ps=0 w=1 l=0.5
X2904 BLP6 rr3t3r_0[52|6]/a_60_290# sky130_fd_pr_reram__reram_cell area_ox=0.0676
X2905 BLZ6 rr3t3r_0[52|6]/a_460_290# sky130_fd_pr_reram__reram_cell area_ox=0.0676
X2906 rr3t3r_0[52|6]/a_460_290# WL52 SL6 VSS sky130_fd_pr__nfet_g5v0d10v5 ad=0.65 pd=3.3 as=0 ps=0 w=1 l=0.5
X2907 BLN6 rr3t3r_0[52|6]/a_860_290# sky130_fd_pr_reram__reram_cell area_ox=0.0676
X2908 rr3t3r_0[52|6]/a_60_290# WL52 SL6 VSS sky130_fd_pr__nfet_g5v0d10v5 ad=0.65 pd=3.3 as=0 ps=0 w=1 l=0.5
X2909 rr3t3r_0[52|6]/a_860_290# WL52 SL6 VSS sky130_fd_pr__nfet_g5v0d10v5 ad=0.65 pd=3.3 as=0 ps=0 w=1 l=0.5
X2910 BLP6 rr3t3r_0[53|6]/a_60_290# sky130_fd_pr_reram__reram_cell area_ox=0.0676
X2911 BLZ6 rr3t3r_0[53|6]/a_460_290# sky130_fd_pr_reram__reram_cell area_ox=0.0676
X2912 rr3t3r_0[53|6]/a_460_290# WL53 SL6 VSS sky130_fd_pr__nfet_g5v0d10v5 ad=0.65 pd=3.3 as=0 ps=0 w=1 l=0.5
X2913 BLN6 rr3t3r_0[53|6]/a_860_290# sky130_fd_pr_reram__reram_cell area_ox=0.0676
X2914 rr3t3r_0[53|6]/a_60_290# WL53 SL6 VSS sky130_fd_pr__nfet_g5v0d10v5 ad=0.65 pd=3.3 as=0 ps=0 w=1 l=0.5
X2915 rr3t3r_0[53|6]/a_860_290# WL53 SL6 VSS sky130_fd_pr__nfet_g5v0d10v5 ad=0.65 pd=3.3 as=0 ps=0 w=1 l=0.5
X2916 BLP6 rr3t3r_0[54|6]/a_60_290# sky130_fd_pr_reram__reram_cell area_ox=0.0676
X2917 BLZ6 rr3t3r_0[54|6]/a_460_290# sky130_fd_pr_reram__reram_cell area_ox=0.0676
X2918 rr3t3r_0[54|6]/a_460_290# WL54 SL6 VSS sky130_fd_pr__nfet_g5v0d10v5 ad=0.65 pd=3.3 as=0 ps=0 w=1 l=0.5
X2919 BLN6 rr3t3r_0[54|6]/a_860_290# sky130_fd_pr_reram__reram_cell area_ox=0.0676
X2920 rr3t3r_0[54|6]/a_60_290# WL54 SL6 VSS sky130_fd_pr__nfet_g5v0d10v5 ad=0.65 pd=3.3 as=0 ps=0 w=1 l=0.5
X2921 rr3t3r_0[54|6]/a_860_290# WL54 SL6 VSS sky130_fd_pr__nfet_g5v0d10v5 ad=0.65 pd=3.3 as=0 ps=0 w=1 l=0.5
X2922 BLP6 rr3t3r_0[55|6]/a_60_290# sky130_fd_pr_reram__reram_cell area_ox=0.0676
X2923 BLZ6 rr3t3r_0[55|6]/a_460_290# sky130_fd_pr_reram__reram_cell area_ox=0.0676
X2924 rr3t3r_0[55|6]/a_460_290# WL55 SL6 VSS sky130_fd_pr__nfet_g5v0d10v5 ad=0.65 pd=3.3 as=0 ps=0 w=1 l=0.5
X2925 BLN6 rr3t3r_0[55|6]/a_860_290# sky130_fd_pr_reram__reram_cell area_ox=0.0676
X2926 rr3t3r_0[55|6]/a_60_290# WL55 SL6 VSS sky130_fd_pr__nfet_g5v0d10v5 ad=0.65 pd=3.3 as=0 ps=0 w=1 l=0.5
X2927 rr3t3r_0[55|6]/a_860_290# WL55 SL6 VSS sky130_fd_pr__nfet_g5v0d10v5 ad=0.65 pd=3.3 as=0 ps=0 w=1 l=0.5
X2928 BLP6 rr3t3r_0[56|6]/a_60_290# sky130_fd_pr_reram__reram_cell area_ox=0.0676
X2929 BLZ6 rr3t3r_0[56|6]/a_460_290# sky130_fd_pr_reram__reram_cell area_ox=0.0676
X2930 rr3t3r_0[56|6]/a_460_290# WL56 SL6 VSS sky130_fd_pr__nfet_g5v0d10v5 ad=0.65 pd=3.3 as=0 ps=0 w=1 l=0.5
X2931 BLN6 rr3t3r_0[56|6]/a_860_290# sky130_fd_pr_reram__reram_cell area_ox=0.0676
X2932 rr3t3r_0[56|6]/a_60_290# WL56 SL6 VSS sky130_fd_pr__nfet_g5v0d10v5 ad=0.65 pd=3.3 as=0 ps=0 w=1 l=0.5
X2933 rr3t3r_0[56|6]/a_860_290# WL56 SL6 VSS sky130_fd_pr__nfet_g5v0d10v5 ad=0.65 pd=3.3 as=0 ps=0 w=1 l=0.5
X2934 BLP6 rr3t3r_0[57|6]/a_60_290# sky130_fd_pr_reram__reram_cell area_ox=0.0676
X2935 BLZ6 rr3t3r_0[57|6]/a_460_290# sky130_fd_pr_reram__reram_cell area_ox=0.0676
X2936 rr3t3r_0[57|6]/a_460_290# WL57 SL6 VSS sky130_fd_pr__nfet_g5v0d10v5 ad=0.65 pd=3.3 as=0 ps=0 w=1 l=0.5
X2937 BLN6 rr3t3r_0[57|6]/a_860_290# sky130_fd_pr_reram__reram_cell area_ox=0.0676
X2938 rr3t3r_0[57|6]/a_60_290# WL57 SL6 VSS sky130_fd_pr__nfet_g5v0d10v5 ad=0.65 pd=3.3 as=0 ps=0 w=1 l=0.5
X2939 rr3t3r_0[57|6]/a_860_290# WL57 SL6 VSS sky130_fd_pr__nfet_g5v0d10v5 ad=0.65 pd=3.3 as=0 ps=0 w=1 l=0.5
X2940 BLP6 rr3t3r_0[58|6]/a_60_290# sky130_fd_pr_reram__reram_cell area_ox=0.0676
X2941 BLZ6 rr3t3r_0[58|6]/a_460_290# sky130_fd_pr_reram__reram_cell area_ox=0.0676
X2942 rr3t3r_0[58|6]/a_460_290# WL58 SL6 VSS sky130_fd_pr__nfet_g5v0d10v5 ad=0.65 pd=3.3 as=0 ps=0 w=1 l=0.5
X2943 BLN6 rr3t3r_0[58|6]/a_860_290# sky130_fd_pr_reram__reram_cell area_ox=0.0676
X2944 rr3t3r_0[58|6]/a_60_290# WL58 SL6 VSS sky130_fd_pr__nfet_g5v0d10v5 ad=0.65 pd=3.3 as=0 ps=0 w=1 l=0.5
X2945 rr3t3r_0[58|6]/a_860_290# WL58 SL6 VSS sky130_fd_pr__nfet_g5v0d10v5 ad=0.65 pd=3.3 as=0 ps=0 w=1 l=0.5
X2946 BLP6 rr3t3r_0[59|6]/a_60_290# sky130_fd_pr_reram__reram_cell area_ox=0.0676
X2947 BLZ6 rr3t3r_0[59|6]/a_460_290# sky130_fd_pr_reram__reram_cell area_ox=0.0676
X2948 rr3t3r_0[59|6]/a_460_290# WL59 SL6 VSS sky130_fd_pr__nfet_g5v0d10v5 ad=0.65 pd=3.3 as=0 ps=0 w=1 l=0.5
X2949 BLN6 rr3t3r_0[59|6]/a_860_290# sky130_fd_pr_reram__reram_cell area_ox=0.0676
X2950 rr3t3r_0[59|6]/a_60_290# WL59 SL6 VSS sky130_fd_pr__nfet_g5v0d10v5 ad=0.65 pd=3.3 as=0 ps=0 w=1 l=0.5
X2951 rr3t3r_0[59|6]/a_860_290# WL59 SL6 VSS sky130_fd_pr__nfet_g5v0d10v5 ad=0.65 pd=3.3 as=0 ps=0 w=1 l=0.5
X2952 BLP6 rr3t3r_0[60|6]/a_60_290# sky130_fd_pr_reram__reram_cell area_ox=0.0676
X2953 BLZ6 rr3t3r_0[60|6]/a_460_290# sky130_fd_pr_reram__reram_cell area_ox=0.0676
X2954 rr3t3r_0[60|6]/a_460_290# WL60 SL6 VSS sky130_fd_pr__nfet_g5v0d10v5 ad=0.65 pd=3.3 as=0 ps=0 w=1 l=0.5
X2955 BLN6 rr3t3r_0[60|6]/a_860_290# sky130_fd_pr_reram__reram_cell area_ox=0.0676
X2956 rr3t3r_0[60|6]/a_60_290# WL60 SL6 VSS sky130_fd_pr__nfet_g5v0d10v5 ad=0.65 pd=3.3 as=0 ps=0 w=1 l=0.5
X2957 rr3t3r_0[60|6]/a_860_290# WL60 SL6 VSS sky130_fd_pr__nfet_g5v0d10v5 ad=0.65 pd=3.3 as=0 ps=0 w=1 l=0.5
X2958 BLP6 rr3t3r_0[61|6]/a_60_290# sky130_fd_pr_reram__reram_cell area_ox=0.0676
X2959 BLZ6 rr3t3r_0[61|6]/a_460_290# sky130_fd_pr_reram__reram_cell area_ox=0.0676
X2960 rr3t3r_0[61|6]/a_460_290# WL61 SL6 VSS sky130_fd_pr__nfet_g5v0d10v5 ad=0.65 pd=3.3 as=0 ps=0 w=1 l=0.5
X2961 BLN6 rr3t3r_0[61|6]/a_860_290# sky130_fd_pr_reram__reram_cell area_ox=0.0676
X2962 rr3t3r_0[61|6]/a_60_290# WL61 SL6 VSS sky130_fd_pr__nfet_g5v0d10v5 ad=0.65 pd=3.3 as=0 ps=0 w=1 l=0.5
X2963 rr3t3r_0[61|6]/a_860_290# WL61 SL6 VSS sky130_fd_pr__nfet_g5v0d10v5 ad=0.65 pd=3.3 as=0 ps=0 w=1 l=0.5
X2964 BLP6 rr3t3r_0[62|6]/a_60_290# sky130_fd_pr_reram__reram_cell area_ox=0.0676
X2965 BLZ6 rr3t3r_0[62|6]/a_460_290# sky130_fd_pr_reram__reram_cell area_ox=0.0676
X2966 rr3t3r_0[62|6]/a_460_290# WL62 SL6 VSS sky130_fd_pr__nfet_g5v0d10v5 ad=0.65 pd=3.3 as=0 ps=0 w=1 l=0.5
X2967 BLN6 rr3t3r_0[62|6]/a_860_290# sky130_fd_pr_reram__reram_cell area_ox=0.0676
X2968 rr3t3r_0[62|6]/a_60_290# WL62 SL6 VSS sky130_fd_pr__nfet_g5v0d10v5 ad=0.65 pd=3.3 as=0 ps=0 w=1 l=0.5
X2969 rr3t3r_0[62|6]/a_860_290# WL62 SL6 VSS sky130_fd_pr__nfet_g5v0d10v5 ad=0.65 pd=3.3 as=0 ps=0 w=1 l=0.5
X2970 BLP6 rr3t3r_0[63|6]/a_60_290# sky130_fd_pr_reram__reram_cell area_ox=0.0676
X2971 BLZ6 rr3t3r_0[63|6]/a_460_290# sky130_fd_pr_reram__reram_cell area_ox=0.0676
X2972 rr3t3r_0[63|6]/a_460_290# WL63 SL6 VSS sky130_fd_pr__nfet_g5v0d10v5 ad=0.65 pd=3.3 as=0 ps=0 w=1 l=0.5
X2973 BLN6 rr3t3r_0[63|6]/a_860_290# sky130_fd_pr_reram__reram_cell area_ox=0.0676
X2974 rr3t3r_0[63|6]/a_60_290# WL63 SL6 VSS sky130_fd_pr__nfet_g5v0d10v5 ad=0.65 pd=3.3 as=0 ps=0 w=1 l=0.5
X2975 rr3t3r_0[63|6]/a_860_290# WL63 SL6 VSS sky130_fd_pr__nfet_g5v0d10v5 ad=0.65 pd=3.3 as=0 ps=0 w=1 l=0.5
X2976 BLP6 rr3t3r_0[64|6]/a_60_290# sky130_fd_pr_reram__reram_cell area_ox=0.0676
X2977 BLZ6 rr3t3r_0[64|6]/a_460_290# sky130_fd_pr_reram__reram_cell area_ox=0.0676
X2978 rr3t3r_0[64|6]/a_460_290# WL64 SL6 VSS sky130_fd_pr__nfet_g5v0d10v5 ad=0.65 pd=3.3 as=0 ps=0 w=1 l=0.5
X2979 BLN6 rr3t3r_0[64|6]/a_860_290# sky130_fd_pr_reram__reram_cell area_ox=0.0676
X2980 rr3t3r_0[64|6]/a_60_290# WL64 SL6 VSS sky130_fd_pr__nfet_g5v0d10v5 ad=0.65 pd=3.3 as=0 ps=0 w=1 l=0.5
X2981 rr3t3r_0[64|6]/a_860_290# WL64 SL6 VSS sky130_fd_pr__nfet_g5v0d10v5 ad=0.65 pd=3.3 as=0 ps=0 w=1 l=0.5
X2982 BLP6 rr3t3r_0[65|6]/a_60_290# sky130_fd_pr_reram__reram_cell area_ox=0.0676
X2983 BLZ6 rr3t3r_0[65|6]/a_460_290# sky130_fd_pr_reram__reram_cell area_ox=0.0676
X2984 rr3t3r_0[65|6]/a_460_290# WL65 SL6 VSS sky130_fd_pr__nfet_g5v0d10v5 ad=0.65 pd=3.3 as=0 ps=0 w=1 l=0.5
X2985 BLN6 rr3t3r_0[65|6]/a_860_290# sky130_fd_pr_reram__reram_cell area_ox=0.0676
X2986 rr3t3r_0[65|6]/a_60_290# WL65 SL6 VSS sky130_fd_pr__nfet_g5v0d10v5 ad=0.65 pd=3.3 as=0 ps=0 w=1 l=0.5
X2987 rr3t3r_0[65|6]/a_860_290# WL65 SL6 VSS sky130_fd_pr__nfet_g5v0d10v5 ad=0.65 pd=3.3 as=0 ps=0 w=1 l=0.5
X2988 BLP6 rr3t3r_0[66|6]/a_60_290# sky130_fd_pr_reram__reram_cell area_ox=0.0676
X2989 BLZ6 rr3t3r_0[66|6]/a_460_290# sky130_fd_pr_reram__reram_cell area_ox=0.0676
X2990 rr3t3r_0[66|6]/a_460_290# WL66 SL6 VSS sky130_fd_pr__nfet_g5v0d10v5 ad=0.65 pd=3.3 as=0 ps=0 w=1 l=0.5
X2991 BLN6 rr3t3r_0[66|6]/a_860_290# sky130_fd_pr_reram__reram_cell area_ox=0.0676
X2992 rr3t3r_0[66|6]/a_60_290# WL66 SL6 VSS sky130_fd_pr__nfet_g5v0d10v5 ad=0.65 pd=3.3 as=0 ps=0 w=1 l=0.5
X2993 rr3t3r_0[66|6]/a_860_290# WL66 SL6 VSS sky130_fd_pr__nfet_g5v0d10v5 ad=0.65 pd=3.3 as=0 ps=0 w=1 l=0.5
X2994 BLP6 rr3t3r_0[67|6]/a_60_290# sky130_fd_pr_reram__reram_cell area_ox=0.0676
X2995 BLZ6 rr3t3r_0[67|6]/a_460_290# sky130_fd_pr_reram__reram_cell area_ox=0.0676
X2996 rr3t3r_0[67|6]/a_460_290# WL67 SL6 VSS sky130_fd_pr__nfet_g5v0d10v5 ad=0.65 pd=3.3 as=0 ps=0 w=1 l=0.5
X2997 BLN6 rr3t3r_0[67|6]/a_860_290# sky130_fd_pr_reram__reram_cell area_ox=0.0676
X2998 rr3t3r_0[67|6]/a_60_290# WL67 SL6 VSS sky130_fd_pr__nfet_g5v0d10v5 ad=0.65 pd=3.3 as=0 ps=0 w=1 l=0.5
X2999 rr3t3r_0[67|6]/a_860_290# WL67 SL6 VSS sky130_fd_pr__nfet_g5v0d10v5 ad=0.65 pd=3.3 as=0 ps=0 w=1 l=0.5
X3000 BLP6 rr3t3r_0[68|6]/a_60_290# sky130_fd_pr_reram__reram_cell area_ox=0.0676
X3001 BLZ6 rr3t3r_0[68|6]/a_460_290# sky130_fd_pr_reram__reram_cell area_ox=0.0676
X3002 rr3t3r_0[68|6]/a_460_290# WL68 SL6 VSS sky130_fd_pr__nfet_g5v0d10v5 ad=0.65 pd=3.3 as=0 ps=0 w=1 l=0.5
X3003 BLN6 rr3t3r_0[68|6]/a_860_290# sky130_fd_pr_reram__reram_cell area_ox=0.0676
X3004 rr3t3r_0[68|6]/a_60_290# WL68 SL6 VSS sky130_fd_pr__nfet_g5v0d10v5 ad=0.65 pd=3.3 as=0 ps=0 w=1 l=0.5
X3005 rr3t3r_0[68|6]/a_860_290# WL68 SL6 VSS sky130_fd_pr__nfet_g5v0d10v5 ad=0.65 pd=3.3 as=0 ps=0 w=1 l=0.5
X3006 BLP6 rr3t3r_0[69|6]/a_60_290# sky130_fd_pr_reram__reram_cell area_ox=0.0676
X3007 BLZ6 rr3t3r_0[69|6]/a_460_290# sky130_fd_pr_reram__reram_cell area_ox=0.0676
X3008 rr3t3r_0[69|6]/a_460_290# WL69 SL6 VSS sky130_fd_pr__nfet_g5v0d10v5 ad=0.65 pd=3.3 as=0 ps=0 w=1 l=0.5
X3009 BLN6 rr3t3r_0[69|6]/a_860_290# sky130_fd_pr_reram__reram_cell area_ox=0.0676
X3010 rr3t3r_0[69|6]/a_60_290# WL69 SL6 VSS sky130_fd_pr__nfet_g5v0d10v5 ad=0.65 pd=3.3 as=0 ps=0 w=1 l=0.5
X3011 rr3t3r_0[69|6]/a_860_290# WL69 SL6 VSS sky130_fd_pr__nfet_g5v0d10v5 ad=0.65 pd=3.3 as=0 ps=0 w=1 l=0.5
X3012 BLP6 rr3t3r_0[70|6]/a_60_290# sky130_fd_pr_reram__reram_cell area_ox=0.0676
X3013 BLZ6 rr3t3r_0[70|6]/a_460_290# sky130_fd_pr_reram__reram_cell area_ox=0.0676
X3014 rr3t3r_0[70|6]/a_460_290# WL70 SL6 VSS sky130_fd_pr__nfet_g5v0d10v5 ad=0.65 pd=3.3 as=0 ps=0 w=1 l=0.5
X3015 BLN6 rr3t3r_0[70|6]/a_860_290# sky130_fd_pr_reram__reram_cell area_ox=0.0676
X3016 rr3t3r_0[70|6]/a_60_290# WL70 SL6 VSS sky130_fd_pr__nfet_g5v0d10v5 ad=0.65 pd=3.3 as=0 ps=0 w=1 l=0.5
X3017 rr3t3r_0[70|6]/a_860_290# WL70 SL6 VSS sky130_fd_pr__nfet_g5v0d10v5 ad=0.65 pd=3.3 as=0 ps=0 w=1 l=0.5
X3018 BLP6 rr3t3r_0[71|6]/a_60_290# sky130_fd_pr_reram__reram_cell area_ox=0.0676
X3019 BLZ6 rr3t3r_0[71|6]/a_460_290# sky130_fd_pr_reram__reram_cell area_ox=0.0676
X3020 rr3t3r_0[71|6]/a_460_290# WL71 SL6 VSS sky130_fd_pr__nfet_g5v0d10v5 ad=0.65 pd=3.3 as=0 ps=0 w=1 l=0.5
X3021 BLN6 rr3t3r_0[71|6]/a_860_290# sky130_fd_pr_reram__reram_cell area_ox=0.0676
X3022 rr3t3r_0[71|6]/a_60_290# WL71 SL6 VSS sky130_fd_pr__nfet_g5v0d10v5 ad=0.65 pd=3.3 as=0 ps=0 w=1 l=0.5
X3023 rr3t3r_0[71|6]/a_860_290# WL71 SL6 VSS sky130_fd_pr__nfet_g5v0d10v5 ad=0.65 pd=3.3 as=0 ps=0 w=1 l=0.5
X3024 BLP7 rr3t3r_0[0|7]/a_60_290# sky130_fd_pr_reram__reram_cell area_ox=0.0676
X3025 BLZ7 rr3t3r_0[0|7]/a_460_290# sky130_fd_pr_reram__reram_cell area_ox=0.0676
X3026 rr3t3r_0[0|7]/a_460_290# WL0 SL7 VSS sky130_fd_pr__nfet_g5v0d10v5 ad=0.65 pd=3.3 as=162 ps=756 w=1 l=0.5
X3027 BLN7 rr3t3r_0[0|7]/a_860_290# sky130_fd_pr_reram__reram_cell area_ox=0.0676
X3028 rr3t3r_0[0|7]/a_60_290# WL0 SL7 VSS sky130_fd_pr__nfet_g5v0d10v5 ad=0.65 pd=3.3 as=0 ps=0 w=1 l=0.5
X3029 rr3t3r_0[0|7]/a_860_290# WL0 SL7 VSS sky130_fd_pr__nfet_g5v0d10v5 ad=0.65 pd=3.3 as=0 ps=0 w=1 l=0.5
X3030 BLP7 rr3t3r_0[1|7]/a_60_290# sky130_fd_pr_reram__reram_cell area_ox=0.0676
X3031 BLZ7 rr3t3r_0[1|7]/a_460_290# sky130_fd_pr_reram__reram_cell area_ox=0.0676
X3032 rr3t3r_0[1|7]/a_460_290# WL1 SL7 VSS sky130_fd_pr__nfet_g5v0d10v5 ad=0.65 pd=3.3 as=0 ps=0 w=1 l=0.5
X3033 BLN7 rr3t3r_0[1|7]/a_860_290# sky130_fd_pr_reram__reram_cell area_ox=0.0676
X3034 rr3t3r_0[1|7]/a_60_290# WL1 SL7 VSS sky130_fd_pr__nfet_g5v0d10v5 ad=0.65 pd=3.3 as=0 ps=0 w=1 l=0.5
X3035 rr3t3r_0[1|7]/a_860_290# WL1 SL7 VSS sky130_fd_pr__nfet_g5v0d10v5 ad=0.65 pd=3.3 as=0 ps=0 w=1 l=0.5
X3036 BLP7 rr3t3r_0[2|7]/a_60_290# sky130_fd_pr_reram__reram_cell area_ox=0.0676
X3037 BLZ7 rr3t3r_0[2|7]/a_460_290# sky130_fd_pr_reram__reram_cell area_ox=0.0676
X3038 rr3t3r_0[2|7]/a_460_290# WL2 SL7 VSS sky130_fd_pr__nfet_g5v0d10v5 ad=0.65 pd=3.3 as=0 ps=0 w=1 l=0.5
X3039 BLN7 rr3t3r_0[2|7]/a_860_290# sky130_fd_pr_reram__reram_cell area_ox=0.0676
X3040 rr3t3r_0[2|7]/a_60_290# WL2 SL7 VSS sky130_fd_pr__nfet_g5v0d10v5 ad=0.65 pd=3.3 as=0 ps=0 w=1 l=0.5
X3041 rr3t3r_0[2|7]/a_860_290# WL2 SL7 VSS sky130_fd_pr__nfet_g5v0d10v5 ad=0.65 pd=3.3 as=0 ps=0 w=1 l=0.5
X3042 BLP7 rr3t3r_0[3|7]/a_60_290# sky130_fd_pr_reram__reram_cell area_ox=0.0676
X3043 BLZ7 rr3t3r_0[3|7]/a_460_290# sky130_fd_pr_reram__reram_cell area_ox=0.0676
X3044 rr3t3r_0[3|7]/a_460_290# WL3 SL7 VSS sky130_fd_pr__nfet_g5v0d10v5 ad=0.65 pd=3.3 as=0 ps=0 w=1 l=0.5
X3045 BLN7 rr3t3r_0[3|7]/a_860_290# sky130_fd_pr_reram__reram_cell area_ox=0.0676
X3046 rr3t3r_0[3|7]/a_60_290# WL3 SL7 VSS sky130_fd_pr__nfet_g5v0d10v5 ad=0.65 pd=3.3 as=0 ps=0 w=1 l=0.5
X3047 rr3t3r_0[3|7]/a_860_290# WL3 SL7 VSS sky130_fd_pr__nfet_g5v0d10v5 ad=0.65 pd=3.3 as=0 ps=0 w=1 l=0.5
X3048 BLP7 rr3t3r_0[4|7]/a_60_290# sky130_fd_pr_reram__reram_cell area_ox=0.0676
X3049 BLZ7 rr3t3r_0[4|7]/a_460_290# sky130_fd_pr_reram__reram_cell area_ox=0.0676
X3050 rr3t3r_0[4|7]/a_460_290# WL4 SL7 VSS sky130_fd_pr__nfet_g5v0d10v5 ad=0.65 pd=3.3 as=0 ps=0 w=1 l=0.5
X3051 BLN7 rr3t3r_0[4|7]/a_860_290# sky130_fd_pr_reram__reram_cell area_ox=0.0676
X3052 rr3t3r_0[4|7]/a_60_290# WL4 SL7 VSS sky130_fd_pr__nfet_g5v0d10v5 ad=0.65 pd=3.3 as=0 ps=0 w=1 l=0.5
X3053 rr3t3r_0[4|7]/a_860_290# WL4 SL7 VSS sky130_fd_pr__nfet_g5v0d10v5 ad=0.65 pd=3.3 as=0 ps=0 w=1 l=0.5
X3054 BLP7 rr3t3r_0[5|7]/a_60_290# sky130_fd_pr_reram__reram_cell area_ox=0.0676
X3055 BLZ7 rr3t3r_0[5|7]/a_460_290# sky130_fd_pr_reram__reram_cell area_ox=0.0676
X3056 rr3t3r_0[5|7]/a_460_290# WL5 SL7 VSS sky130_fd_pr__nfet_g5v0d10v5 ad=0.65 pd=3.3 as=0 ps=0 w=1 l=0.5
X3057 BLN7 rr3t3r_0[5|7]/a_860_290# sky130_fd_pr_reram__reram_cell area_ox=0.0676
X3058 rr3t3r_0[5|7]/a_60_290# WL5 SL7 VSS sky130_fd_pr__nfet_g5v0d10v5 ad=0.65 pd=3.3 as=0 ps=0 w=1 l=0.5
X3059 rr3t3r_0[5|7]/a_860_290# WL5 SL7 VSS sky130_fd_pr__nfet_g5v0d10v5 ad=0.65 pd=3.3 as=0 ps=0 w=1 l=0.5
X3060 BLP7 rr3t3r_0[6|7]/a_60_290# sky130_fd_pr_reram__reram_cell area_ox=0.0676
X3061 BLZ7 rr3t3r_0[6|7]/a_460_290# sky130_fd_pr_reram__reram_cell area_ox=0.0676
X3062 rr3t3r_0[6|7]/a_460_290# WL6 SL7 VSS sky130_fd_pr__nfet_g5v0d10v5 ad=0.65 pd=3.3 as=0 ps=0 w=1 l=0.5
X3063 BLN7 rr3t3r_0[6|7]/a_860_290# sky130_fd_pr_reram__reram_cell area_ox=0.0676
X3064 rr3t3r_0[6|7]/a_60_290# WL6 SL7 VSS sky130_fd_pr__nfet_g5v0d10v5 ad=0.65 pd=3.3 as=0 ps=0 w=1 l=0.5
X3065 rr3t3r_0[6|7]/a_860_290# WL6 SL7 VSS sky130_fd_pr__nfet_g5v0d10v5 ad=0.65 pd=3.3 as=0 ps=0 w=1 l=0.5
X3066 BLP7 rr3t3r_0[7|7]/a_60_290# sky130_fd_pr_reram__reram_cell area_ox=0.0676
X3067 BLZ7 rr3t3r_0[7|7]/a_460_290# sky130_fd_pr_reram__reram_cell area_ox=0.0676
X3068 rr3t3r_0[7|7]/a_460_290# WL7 SL7 VSS sky130_fd_pr__nfet_g5v0d10v5 ad=0.65 pd=3.3 as=0 ps=0 w=1 l=0.5
X3069 BLN7 rr3t3r_0[7|7]/a_860_290# sky130_fd_pr_reram__reram_cell area_ox=0.0676
X3070 rr3t3r_0[7|7]/a_60_290# WL7 SL7 VSS sky130_fd_pr__nfet_g5v0d10v5 ad=0.65 pd=3.3 as=0 ps=0 w=1 l=0.5
X3071 rr3t3r_0[7|7]/a_860_290# WL7 SL7 VSS sky130_fd_pr__nfet_g5v0d10v5 ad=0.65 pd=3.3 as=0 ps=0 w=1 l=0.5
X3072 BLP7 rr3t3r_0[8|7]/a_60_290# sky130_fd_pr_reram__reram_cell area_ox=0.0676
X3073 BLZ7 rr3t3r_0[8|7]/a_460_290# sky130_fd_pr_reram__reram_cell area_ox=0.0676
X3074 rr3t3r_0[8|7]/a_460_290# WL8 SL7 VSS sky130_fd_pr__nfet_g5v0d10v5 ad=0.65 pd=3.3 as=0 ps=0 w=1 l=0.5
X3075 BLN7 rr3t3r_0[8|7]/a_860_290# sky130_fd_pr_reram__reram_cell area_ox=0.0676
X3076 rr3t3r_0[8|7]/a_60_290# WL8 SL7 VSS sky130_fd_pr__nfet_g5v0d10v5 ad=0.65 pd=3.3 as=0 ps=0 w=1 l=0.5
X3077 rr3t3r_0[8|7]/a_860_290# WL8 SL7 VSS sky130_fd_pr__nfet_g5v0d10v5 ad=0.65 pd=3.3 as=0 ps=0 w=1 l=0.5
X3078 BLP7 rr3t3r_0[9|7]/a_60_290# sky130_fd_pr_reram__reram_cell area_ox=0.0676
X3079 BLZ7 rr3t3r_0[9|7]/a_460_290# sky130_fd_pr_reram__reram_cell area_ox=0.0676
X3080 rr3t3r_0[9|7]/a_460_290# WL9 SL7 VSS sky130_fd_pr__nfet_g5v0d10v5 ad=0.65 pd=3.3 as=0 ps=0 w=1 l=0.5
X3081 BLN7 rr3t3r_0[9|7]/a_860_290# sky130_fd_pr_reram__reram_cell area_ox=0.0676
X3082 rr3t3r_0[9|7]/a_60_290# WL9 SL7 VSS sky130_fd_pr__nfet_g5v0d10v5 ad=0.65 pd=3.3 as=0 ps=0 w=1 l=0.5
X3083 rr3t3r_0[9|7]/a_860_290# WL9 SL7 VSS sky130_fd_pr__nfet_g5v0d10v5 ad=0.65 pd=3.3 as=0 ps=0 w=1 l=0.5
X3084 BLP7 rr3t3r_0[10|7]/a_60_290# sky130_fd_pr_reram__reram_cell area_ox=0.0676
X3085 BLZ7 rr3t3r_0[10|7]/a_460_290# sky130_fd_pr_reram__reram_cell area_ox=0.0676
X3086 rr3t3r_0[10|7]/a_460_290# WL10 SL7 VSS sky130_fd_pr__nfet_g5v0d10v5 ad=0.65 pd=3.3 as=0 ps=0 w=1 l=0.5
X3087 BLN7 rr3t3r_0[10|7]/a_860_290# sky130_fd_pr_reram__reram_cell area_ox=0.0676
X3088 rr3t3r_0[10|7]/a_60_290# WL10 SL7 VSS sky130_fd_pr__nfet_g5v0d10v5 ad=0.65 pd=3.3 as=0 ps=0 w=1 l=0.5
X3089 rr3t3r_0[10|7]/a_860_290# WL10 SL7 VSS sky130_fd_pr__nfet_g5v0d10v5 ad=0.65 pd=3.3 as=0 ps=0 w=1 l=0.5
X3090 BLP7 rr3t3r_0[11|7]/a_60_290# sky130_fd_pr_reram__reram_cell area_ox=0.0676
X3091 BLZ7 rr3t3r_0[11|7]/a_460_290# sky130_fd_pr_reram__reram_cell area_ox=0.0676
X3092 rr3t3r_0[11|7]/a_460_290# WL11 SL7 VSS sky130_fd_pr__nfet_g5v0d10v5 ad=0.65 pd=3.3 as=0 ps=0 w=1 l=0.5
X3093 BLN7 rr3t3r_0[11|7]/a_860_290# sky130_fd_pr_reram__reram_cell area_ox=0.0676
X3094 rr3t3r_0[11|7]/a_60_290# WL11 SL7 VSS sky130_fd_pr__nfet_g5v0d10v5 ad=0.65 pd=3.3 as=0 ps=0 w=1 l=0.5
X3095 rr3t3r_0[11|7]/a_860_290# WL11 SL7 VSS sky130_fd_pr__nfet_g5v0d10v5 ad=0.65 pd=3.3 as=0 ps=0 w=1 l=0.5
X3096 BLP7 rr3t3r_0[12|7]/a_60_290# sky130_fd_pr_reram__reram_cell area_ox=0.0676
X3097 BLZ7 rr3t3r_0[12|7]/a_460_290# sky130_fd_pr_reram__reram_cell area_ox=0.0676
X3098 rr3t3r_0[12|7]/a_460_290# WL12 SL7 VSS sky130_fd_pr__nfet_g5v0d10v5 ad=0.65 pd=3.3 as=0 ps=0 w=1 l=0.5
X3099 BLN7 rr3t3r_0[12|7]/a_860_290# sky130_fd_pr_reram__reram_cell area_ox=0.0676
X3100 rr3t3r_0[12|7]/a_60_290# WL12 SL7 VSS sky130_fd_pr__nfet_g5v0d10v5 ad=0.65 pd=3.3 as=0 ps=0 w=1 l=0.5
X3101 rr3t3r_0[12|7]/a_860_290# WL12 SL7 VSS sky130_fd_pr__nfet_g5v0d10v5 ad=0.65 pd=3.3 as=0 ps=0 w=1 l=0.5
X3102 BLP7 rr3t3r_0[13|7]/a_60_290# sky130_fd_pr_reram__reram_cell area_ox=0.0676
X3103 BLZ7 rr3t3r_0[13|7]/a_460_290# sky130_fd_pr_reram__reram_cell area_ox=0.0676
X3104 rr3t3r_0[13|7]/a_460_290# WL13 SL7 VSS sky130_fd_pr__nfet_g5v0d10v5 ad=0.65 pd=3.3 as=0 ps=0 w=1 l=0.5
X3105 BLN7 rr3t3r_0[13|7]/a_860_290# sky130_fd_pr_reram__reram_cell area_ox=0.0676
X3106 rr3t3r_0[13|7]/a_60_290# WL13 SL7 VSS sky130_fd_pr__nfet_g5v0d10v5 ad=0.65 pd=3.3 as=0 ps=0 w=1 l=0.5
X3107 rr3t3r_0[13|7]/a_860_290# WL13 SL7 VSS sky130_fd_pr__nfet_g5v0d10v5 ad=0.65 pd=3.3 as=0 ps=0 w=1 l=0.5
X3108 BLP7 rr3t3r_0[14|7]/a_60_290# sky130_fd_pr_reram__reram_cell area_ox=0.0676
X3109 BLZ7 rr3t3r_0[14|7]/a_460_290# sky130_fd_pr_reram__reram_cell area_ox=0.0676
X3110 rr3t3r_0[14|7]/a_460_290# WL14 SL7 VSS sky130_fd_pr__nfet_g5v0d10v5 ad=0.65 pd=3.3 as=0 ps=0 w=1 l=0.5
X3111 BLN7 rr3t3r_0[14|7]/a_860_290# sky130_fd_pr_reram__reram_cell area_ox=0.0676
X3112 rr3t3r_0[14|7]/a_60_290# WL14 SL7 VSS sky130_fd_pr__nfet_g5v0d10v5 ad=0.65 pd=3.3 as=0 ps=0 w=1 l=0.5
X3113 rr3t3r_0[14|7]/a_860_290# WL14 SL7 VSS sky130_fd_pr__nfet_g5v0d10v5 ad=0.65 pd=3.3 as=0 ps=0 w=1 l=0.5
X3114 BLP7 rr3t3r_0[15|7]/a_60_290# sky130_fd_pr_reram__reram_cell area_ox=0.0676
X3115 BLZ7 rr3t3r_0[15|7]/a_460_290# sky130_fd_pr_reram__reram_cell area_ox=0.0676
X3116 rr3t3r_0[15|7]/a_460_290# WL15 SL7 VSS sky130_fd_pr__nfet_g5v0d10v5 ad=0.65 pd=3.3 as=0 ps=0 w=1 l=0.5
X3117 BLN7 rr3t3r_0[15|7]/a_860_290# sky130_fd_pr_reram__reram_cell area_ox=0.0676
X3118 rr3t3r_0[15|7]/a_60_290# WL15 SL7 VSS sky130_fd_pr__nfet_g5v0d10v5 ad=0.65 pd=3.3 as=0 ps=0 w=1 l=0.5
X3119 rr3t3r_0[15|7]/a_860_290# WL15 SL7 VSS sky130_fd_pr__nfet_g5v0d10v5 ad=0.65 pd=3.3 as=0 ps=0 w=1 l=0.5
X3120 BLP7 rr3t3r_0[16|7]/a_60_290# sky130_fd_pr_reram__reram_cell area_ox=0.0676
X3121 BLZ7 rr3t3r_0[16|7]/a_460_290# sky130_fd_pr_reram__reram_cell area_ox=0.0676
X3122 rr3t3r_0[16|7]/a_460_290# WL16 SL7 VSS sky130_fd_pr__nfet_g5v0d10v5 ad=0.65 pd=3.3 as=0 ps=0 w=1 l=0.5
X3123 BLN7 rr3t3r_0[16|7]/a_860_290# sky130_fd_pr_reram__reram_cell area_ox=0.0676
X3124 rr3t3r_0[16|7]/a_60_290# WL16 SL7 VSS sky130_fd_pr__nfet_g5v0d10v5 ad=0.65 pd=3.3 as=0 ps=0 w=1 l=0.5
X3125 rr3t3r_0[16|7]/a_860_290# WL16 SL7 VSS sky130_fd_pr__nfet_g5v0d10v5 ad=0.65 pd=3.3 as=0 ps=0 w=1 l=0.5
X3126 BLP7 rr3t3r_0[17|7]/a_60_290# sky130_fd_pr_reram__reram_cell area_ox=0.0676
X3127 BLZ7 rr3t3r_0[17|7]/a_460_290# sky130_fd_pr_reram__reram_cell area_ox=0.0676
X3128 rr3t3r_0[17|7]/a_460_290# WL17 SL7 VSS sky130_fd_pr__nfet_g5v0d10v5 ad=0.65 pd=3.3 as=0 ps=0 w=1 l=0.5
X3129 BLN7 rr3t3r_0[17|7]/a_860_290# sky130_fd_pr_reram__reram_cell area_ox=0.0676
X3130 rr3t3r_0[17|7]/a_60_290# WL17 SL7 VSS sky130_fd_pr__nfet_g5v0d10v5 ad=0.65 pd=3.3 as=0 ps=0 w=1 l=0.5
X3131 rr3t3r_0[17|7]/a_860_290# WL17 SL7 VSS sky130_fd_pr__nfet_g5v0d10v5 ad=0.65 pd=3.3 as=0 ps=0 w=1 l=0.5
X3132 BLP7 rr3t3r_0[18|7]/a_60_290# sky130_fd_pr_reram__reram_cell area_ox=0.0676
X3133 BLZ7 rr3t3r_0[18|7]/a_460_290# sky130_fd_pr_reram__reram_cell area_ox=0.0676
X3134 rr3t3r_0[18|7]/a_460_290# WL18 SL7 VSS sky130_fd_pr__nfet_g5v0d10v5 ad=0.65 pd=3.3 as=0 ps=0 w=1 l=0.5
X3135 BLN7 rr3t3r_0[18|7]/a_860_290# sky130_fd_pr_reram__reram_cell area_ox=0.0676
X3136 rr3t3r_0[18|7]/a_60_290# WL18 SL7 VSS sky130_fd_pr__nfet_g5v0d10v5 ad=0.65 pd=3.3 as=0 ps=0 w=1 l=0.5
X3137 rr3t3r_0[18|7]/a_860_290# WL18 SL7 VSS sky130_fd_pr__nfet_g5v0d10v5 ad=0.65 pd=3.3 as=0 ps=0 w=1 l=0.5
X3138 BLP7 rr3t3r_0[19|7]/a_60_290# sky130_fd_pr_reram__reram_cell area_ox=0.0676
X3139 BLZ7 rr3t3r_0[19|7]/a_460_290# sky130_fd_pr_reram__reram_cell area_ox=0.0676
X3140 rr3t3r_0[19|7]/a_460_290# WL19 SL7 VSS sky130_fd_pr__nfet_g5v0d10v5 ad=0.65 pd=3.3 as=0 ps=0 w=1 l=0.5
X3141 BLN7 rr3t3r_0[19|7]/a_860_290# sky130_fd_pr_reram__reram_cell area_ox=0.0676
X3142 rr3t3r_0[19|7]/a_60_290# WL19 SL7 VSS sky130_fd_pr__nfet_g5v0d10v5 ad=0.65 pd=3.3 as=0 ps=0 w=1 l=0.5
X3143 rr3t3r_0[19|7]/a_860_290# WL19 SL7 VSS sky130_fd_pr__nfet_g5v0d10v5 ad=0.65 pd=3.3 as=0 ps=0 w=1 l=0.5
X3144 BLP7 rr3t3r_0[20|7]/a_60_290# sky130_fd_pr_reram__reram_cell area_ox=0.0676
X3145 BLZ7 rr3t3r_0[20|7]/a_460_290# sky130_fd_pr_reram__reram_cell area_ox=0.0676
X3146 rr3t3r_0[20|7]/a_460_290# WL20 SL7 VSS sky130_fd_pr__nfet_g5v0d10v5 ad=0.65 pd=3.3 as=0 ps=0 w=1 l=0.5
X3147 BLN7 rr3t3r_0[20|7]/a_860_290# sky130_fd_pr_reram__reram_cell area_ox=0.0676
X3148 rr3t3r_0[20|7]/a_60_290# WL20 SL7 VSS sky130_fd_pr__nfet_g5v0d10v5 ad=0.65 pd=3.3 as=0 ps=0 w=1 l=0.5
X3149 rr3t3r_0[20|7]/a_860_290# WL20 SL7 VSS sky130_fd_pr__nfet_g5v0d10v5 ad=0.65 pd=3.3 as=0 ps=0 w=1 l=0.5
X3150 BLP7 rr3t3r_0[21|7]/a_60_290# sky130_fd_pr_reram__reram_cell area_ox=0.0676
X3151 BLZ7 rr3t3r_0[21|7]/a_460_290# sky130_fd_pr_reram__reram_cell area_ox=0.0676
X3152 rr3t3r_0[21|7]/a_460_290# WL21 SL7 VSS sky130_fd_pr__nfet_g5v0d10v5 ad=0.65 pd=3.3 as=0 ps=0 w=1 l=0.5
X3153 BLN7 rr3t3r_0[21|7]/a_860_290# sky130_fd_pr_reram__reram_cell area_ox=0.0676
X3154 rr3t3r_0[21|7]/a_60_290# WL21 SL7 VSS sky130_fd_pr__nfet_g5v0d10v5 ad=0.65 pd=3.3 as=0 ps=0 w=1 l=0.5
X3155 rr3t3r_0[21|7]/a_860_290# WL21 SL7 VSS sky130_fd_pr__nfet_g5v0d10v5 ad=0.65 pd=3.3 as=0 ps=0 w=1 l=0.5
X3156 BLP7 rr3t3r_0[22|7]/a_60_290# sky130_fd_pr_reram__reram_cell area_ox=0.0676
X3157 BLZ7 rr3t3r_0[22|7]/a_460_290# sky130_fd_pr_reram__reram_cell area_ox=0.0676
X3158 rr3t3r_0[22|7]/a_460_290# WL22 SL7 VSS sky130_fd_pr__nfet_g5v0d10v5 ad=0.65 pd=3.3 as=0 ps=0 w=1 l=0.5
X3159 BLN7 rr3t3r_0[22|7]/a_860_290# sky130_fd_pr_reram__reram_cell area_ox=0.0676
X3160 rr3t3r_0[22|7]/a_60_290# WL22 SL7 VSS sky130_fd_pr__nfet_g5v0d10v5 ad=0.65 pd=3.3 as=0 ps=0 w=1 l=0.5
X3161 rr3t3r_0[22|7]/a_860_290# WL22 SL7 VSS sky130_fd_pr__nfet_g5v0d10v5 ad=0.65 pd=3.3 as=0 ps=0 w=1 l=0.5
X3162 BLP7 rr3t3r_0[23|7]/a_60_290# sky130_fd_pr_reram__reram_cell area_ox=0.0676
X3163 BLZ7 rr3t3r_0[23|7]/a_460_290# sky130_fd_pr_reram__reram_cell area_ox=0.0676
X3164 rr3t3r_0[23|7]/a_460_290# WL23 SL7 VSS sky130_fd_pr__nfet_g5v0d10v5 ad=0.65 pd=3.3 as=0 ps=0 w=1 l=0.5
X3165 BLN7 rr3t3r_0[23|7]/a_860_290# sky130_fd_pr_reram__reram_cell area_ox=0.0676
X3166 rr3t3r_0[23|7]/a_60_290# WL23 SL7 VSS sky130_fd_pr__nfet_g5v0d10v5 ad=0.65 pd=3.3 as=0 ps=0 w=1 l=0.5
X3167 rr3t3r_0[23|7]/a_860_290# WL23 SL7 VSS sky130_fd_pr__nfet_g5v0d10v5 ad=0.65 pd=3.3 as=0 ps=0 w=1 l=0.5
X3168 BLP7 rr3t3r_0[24|7]/a_60_290# sky130_fd_pr_reram__reram_cell area_ox=0.0676
X3169 BLZ7 rr3t3r_0[24|7]/a_460_290# sky130_fd_pr_reram__reram_cell area_ox=0.0676
X3170 rr3t3r_0[24|7]/a_460_290# WL24 SL7 VSS sky130_fd_pr__nfet_g5v0d10v5 ad=0.65 pd=3.3 as=0 ps=0 w=1 l=0.5
X3171 BLN7 rr3t3r_0[24|7]/a_860_290# sky130_fd_pr_reram__reram_cell area_ox=0.0676
X3172 rr3t3r_0[24|7]/a_60_290# WL24 SL7 VSS sky130_fd_pr__nfet_g5v0d10v5 ad=0.65 pd=3.3 as=0 ps=0 w=1 l=0.5
X3173 rr3t3r_0[24|7]/a_860_290# WL24 SL7 VSS sky130_fd_pr__nfet_g5v0d10v5 ad=0.65 pd=3.3 as=0 ps=0 w=1 l=0.5
X3174 BLP7 rr3t3r_0[25|7]/a_60_290# sky130_fd_pr_reram__reram_cell area_ox=0.0676
X3175 BLZ7 rr3t3r_0[25|7]/a_460_290# sky130_fd_pr_reram__reram_cell area_ox=0.0676
X3176 rr3t3r_0[25|7]/a_460_290# WL25 SL7 VSS sky130_fd_pr__nfet_g5v0d10v5 ad=0.65 pd=3.3 as=0 ps=0 w=1 l=0.5
X3177 BLN7 rr3t3r_0[25|7]/a_860_290# sky130_fd_pr_reram__reram_cell area_ox=0.0676
X3178 rr3t3r_0[25|7]/a_60_290# WL25 SL7 VSS sky130_fd_pr__nfet_g5v0d10v5 ad=0.65 pd=3.3 as=0 ps=0 w=1 l=0.5
X3179 rr3t3r_0[25|7]/a_860_290# WL25 SL7 VSS sky130_fd_pr__nfet_g5v0d10v5 ad=0.65 pd=3.3 as=0 ps=0 w=1 l=0.5
X3180 BLP7 rr3t3r_0[26|7]/a_60_290# sky130_fd_pr_reram__reram_cell area_ox=0.0676
X3181 BLZ7 rr3t3r_0[26|7]/a_460_290# sky130_fd_pr_reram__reram_cell area_ox=0.0676
X3182 rr3t3r_0[26|7]/a_460_290# WL26 SL7 VSS sky130_fd_pr__nfet_g5v0d10v5 ad=0.65 pd=3.3 as=0 ps=0 w=1 l=0.5
X3183 BLN7 rr3t3r_0[26|7]/a_860_290# sky130_fd_pr_reram__reram_cell area_ox=0.0676
X3184 rr3t3r_0[26|7]/a_60_290# WL26 SL7 VSS sky130_fd_pr__nfet_g5v0d10v5 ad=0.65 pd=3.3 as=0 ps=0 w=1 l=0.5
X3185 rr3t3r_0[26|7]/a_860_290# WL26 SL7 VSS sky130_fd_pr__nfet_g5v0d10v5 ad=0.65 pd=3.3 as=0 ps=0 w=1 l=0.5
X3186 BLP7 rr3t3r_0[27|7]/a_60_290# sky130_fd_pr_reram__reram_cell area_ox=0.0676
X3187 BLZ7 rr3t3r_0[27|7]/a_460_290# sky130_fd_pr_reram__reram_cell area_ox=0.0676
X3188 rr3t3r_0[27|7]/a_460_290# WL27 SL7 VSS sky130_fd_pr__nfet_g5v0d10v5 ad=0.65 pd=3.3 as=0 ps=0 w=1 l=0.5
X3189 BLN7 rr3t3r_0[27|7]/a_860_290# sky130_fd_pr_reram__reram_cell area_ox=0.0676
X3190 rr3t3r_0[27|7]/a_60_290# WL27 SL7 VSS sky130_fd_pr__nfet_g5v0d10v5 ad=0.65 pd=3.3 as=0 ps=0 w=1 l=0.5
X3191 rr3t3r_0[27|7]/a_860_290# WL27 SL7 VSS sky130_fd_pr__nfet_g5v0d10v5 ad=0.65 pd=3.3 as=0 ps=0 w=1 l=0.5
X3192 BLP7 rr3t3r_0[28|7]/a_60_290# sky130_fd_pr_reram__reram_cell area_ox=0.0676
X3193 BLZ7 rr3t3r_0[28|7]/a_460_290# sky130_fd_pr_reram__reram_cell area_ox=0.0676
X3194 rr3t3r_0[28|7]/a_460_290# WL28 SL7 VSS sky130_fd_pr__nfet_g5v0d10v5 ad=0.65 pd=3.3 as=0 ps=0 w=1 l=0.5
X3195 BLN7 rr3t3r_0[28|7]/a_860_290# sky130_fd_pr_reram__reram_cell area_ox=0.0676
X3196 rr3t3r_0[28|7]/a_60_290# WL28 SL7 VSS sky130_fd_pr__nfet_g5v0d10v5 ad=0.65 pd=3.3 as=0 ps=0 w=1 l=0.5
X3197 rr3t3r_0[28|7]/a_860_290# WL28 SL7 VSS sky130_fd_pr__nfet_g5v0d10v5 ad=0.65 pd=3.3 as=0 ps=0 w=1 l=0.5
X3198 BLP7 rr3t3r_0[29|7]/a_60_290# sky130_fd_pr_reram__reram_cell area_ox=0.0676
X3199 BLZ7 rr3t3r_0[29|7]/a_460_290# sky130_fd_pr_reram__reram_cell area_ox=0.0676
X3200 rr3t3r_0[29|7]/a_460_290# WL29 SL7 VSS sky130_fd_pr__nfet_g5v0d10v5 ad=0.65 pd=3.3 as=0 ps=0 w=1 l=0.5
X3201 BLN7 rr3t3r_0[29|7]/a_860_290# sky130_fd_pr_reram__reram_cell area_ox=0.0676
X3202 rr3t3r_0[29|7]/a_60_290# WL29 SL7 VSS sky130_fd_pr__nfet_g5v0d10v5 ad=0.65 pd=3.3 as=0 ps=0 w=1 l=0.5
X3203 rr3t3r_0[29|7]/a_860_290# WL29 SL7 VSS sky130_fd_pr__nfet_g5v0d10v5 ad=0.65 pd=3.3 as=0 ps=0 w=1 l=0.5
X3204 BLP7 rr3t3r_0[30|7]/a_60_290# sky130_fd_pr_reram__reram_cell area_ox=0.0676
X3205 BLZ7 rr3t3r_0[30|7]/a_460_290# sky130_fd_pr_reram__reram_cell area_ox=0.0676
X3206 rr3t3r_0[30|7]/a_460_290# WL30 SL7 VSS sky130_fd_pr__nfet_g5v0d10v5 ad=0.65 pd=3.3 as=0 ps=0 w=1 l=0.5
X3207 BLN7 rr3t3r_0[30|7]/a_860_290# sky130_fd_pr_reram__reram_cell area_ox=0.0676
X3208 rr3t3r_0[30|7]/a_60_290# WL30 SL7 VSS sky130_fd_pr__nfet_g5v0d10v5 ad=0.65 pd=3.3 as=0 ps=0 w=1 l=0.5
X3209 rr3t3r_0[30|7]/a_860_290# WL30 SL7 VSS sky130_fd_pr__nfet_g5v0d10v5 ad=0.65 pd=3.3 as=0 ps=0 w=1 l=0.5
X3210 BLP7 rr3t3r_0[31|7]/a_60_290# sky130_fd_pr_reram__reram_cell area_ox=0.0676
X3211 BLZ7 rr3t3r_0[31|7]/a_460_290# sky130_fd_pr_reram__reram_cell area_ox=0.0676
X3212 rr3t3r_0[31|7]/a_460_290# WL31 SL7 VSS sky130_fd_pr__nfet_g5v0d10v5 ad=0.65 pd=3.3 as=0 ps=0 w=1 l=0.5
X3213 BLN7 rr3t3r_0[31|7]/a_860_290# sky130_fd_pr_reram__reram_cell area_ox=0.0676
X3214 rr3t3r_0[31|7]/a_60_290# WL31 SL7 VSS sky130_fd_pr__nfet_g5v0d10v5 ad=0.65 pd=3.3 as=0 ps=0 w=1 l=0.5
X3215 rr3t3r_0[31|7]/a_860_290# WL31 SL7 VSS sky130_fd_pr__nfet_g5v0d10v5 ad=0.65 pd=3.3 as=0 ps=0 w=1 l=0.5
X3216 BLP7 rr3t3r_0[32|7]/a_60_290# sky130_fd_pr_reram__reram_cell area_ox=0.0676
X3217 BLZ7 rr3t3r_0[32|7]/a_460_290# sky130_fd_pr_reram__reram_cell area_ox=0.0676
X3218 rr3t3r_0[32|7]/a_460_290# WL32 SL7 VSS sky130_fd_pr__nfet_g5v0d10v5 ad=0.65 pd=3.3 as=0 ps=0 w=1 l=0.5
X3219 BLN7 rr3t3r_0[32|7]/a_860_290# sky130_fd_pr_reram__reram_cell area_ox=0.0676
X3220 rr3t3r_0[32|7]/a_60_290# WL32 SL7 VSS sky130_fd_pr__nfet_g5v0d10v5 ad=0.65 pd=3.3 as=0 ps=0 w=1 l=0.5
X3221 rr3t3r_0[32|7]/a_860_290# WL32 SL7 VSS sky130_fd_pr__nfet_g5v0d10v5 ad=0.65 pd=3.3 as=0 ps=0 w=1 l=0.5
X3222 BLP7 rr3t3r_0[33|7]/a_60_290# sky130_fd_pr_reram__reram_cell area_ox=0.0676
X3223 BLZ7 rr3t3r_0[33|7]/a_460_290# sky130_fd_pr_reram__reram_cell area_ox=0.0676
X3224 rr3t3r_0[33|7]/a_460_290# WL33 SL7 VSS sky130_fd_pr__nfet_g5v0d10v5 ad=0.65 pd=3.3 as=0 ps=0 w=1 l=0.5
X3225 BLN7 rr3t3r_0[33|7]/a_860_290# sky130_fd_pr_reram__reram_cell area_ox=0.0676
X3226 rr3t3r_0[33|7]/a_60_290# WL33 SL7 VSS sky130_fd_pr__nfet_g5v0d10v5 ad=0.65 pd=3.3 as=0 ps=0 w=1 l=0.5
X3227 rr3t3r_0[33|7]/a_860_290# WL33 SL7 VSS sky130_fd_pr__nfet_g5v0d10v5 ad=0.65 pd=3.3 as=0 ps=0 w=1 l=0.5
X3228 BLP7 rr3t3r_0[34|7]/a_60_290# sky130_fd_pr_reram__reram_cell area_ox=0.0676
X3229 BLZ7 rr3t3r_0[34|7]/a_460_290# sky130_fd_pr_reram__reram_cell area_ox=0.0676
X3230 rr3t3r_0[34|7]/a_460_290# WL34 SL7 VSS sky130_fd_pr__nfet_g5v0d10v5 ad=0.65 pd=3.3 as=0 ps=0 w=1 l=0.5
X3231 BLN7 rr3t3r_0[34|7]/a_860_290# sky130_fd_pr_reram__reram_cell area_ox=0.0676
X3232 rr3t3r_0[34|7]/a_60_290# WL34 SL7 VSS sky130_fd_pr__nfet_g5v0d10v5 ad=0.65 pd=3.3 as=0 ps=0 w=1 l=0.5
X3233 rr3t3r_0[34|7]/a_860_290# WL34 SL7 VSS sky130_fd_pr__nfet_g5v0d10v5 ad=0.65 pd=3.3 as=0 ps=0 w=1 l=0.5
X3234 BLP7 rr3t3r_0[35|7]/a_60_290# sky130_fd_pr_reram__reram_cell area_ox=0.0676
X3235 BLZ7 rr3t3r_0[35|7]/a_460_290# sky130_fd_pr_reram__reram_cell area_ox=0.0676
X3236 rr3t3r_0[35|7]/a_460_290# WL35 SL7 VSS sky130_fd_pr__nfet_g5v0d10v5 ad=0.65 pd=3.3 as=0 ps=0 w=1 l=0.5
X3237 BLN7 rr3t3r_0[35|7]/a_860_290# sky130_fd_pr_reram__reram_cell area_ox=0.0676
X3238 rr3t3r_0[35|7]/a_60_290# WL35 SL7 VSS sky130_fd_pr__nfet_g5v0d10v5 ad=0.65 pd=3.3 as=0 ps=0 w=1 l=0.5
X3239 rr3t3r_0[35|7]/a_860_290# WL35 SL7 VSS sky130_fd_pr__nfet_g5v0d10v5 ad=0.65 pd=3.3 as=0 ps=0 w=1 l=0.5
X3240 BLP7 rr3t3r_0[36|7]/a_60_290# sky130_fd_pr_reram__reram_cell area_ox=0.0676
X3241 BLZ7 rr3t3r_0[36|7]/a_460_290# sky130_fd_pr_reram__reram_cell area_ox=0.0676
X3242 rr3t3r_0[36|7]/a_460_290# WL36 SL7 VSS sky130_fd_pr__nfet_g5v0d10v5 ad=0.65 pd=3.3 as=0 ps=0 w=1 l=0.5
X3243 BLN7 rr3t3r_0[36|7]/a_860_290# sky130_fd_pr_reram__reram_cell area_ox=0.0676
X3244 rr3t3r_0[36|7]/a_60_290# WL36 SL7 VSS sky130_fd_pr__nfet_g5v0d10v5 ad=0.65 pd=3.3 as=0 ps=0 w=1 l=0.5
X3245 rr3t3r_0[36|7]/a_860_290# WL36 SL7 VSS sky130_fd_pr__nfet_g5v0d10v5 ad=0.65 pd=3.3 as=0 ps=0 w=1 l=0.5
X3246 BLP7 rr3t3r_0[37|7]/a_60_290# sky130_fd_pr_reram__reram_cell area_ox=0.0676
X3247 BLZ7 rr3t3r_0[37|7]/a_460_290# sky130_fd_pr_reram__reram_cell area_ox=0.0676
X3248 rr3t3r_0[37|7]/a_460_290# WL37 SL7 VSS sky130_fd_pr__nfet_g5v0d10v5 ad=0.65 pd=3.3 as=0 ps=0 w=1 l=0.5
X3249 BLN7 rr3t3r_0[37|7]/a_860_290# sky130_fd_pr_reram__reram_cell area_ox=0.0676
X3250 rr3t3r_0[37|7]/a_60_290# WL37 SL7 VSS sky130_fd_pr__nfet_g5v0d10v5 ad=0.65 pd=3.3 as=0 ps=0 w=1 l=0.5
X3251 rr3t3r_0[37|7]/a_860_290# WL37 SL7 VSS sky130_fd_pr__nfet_g5v0d10v5 ad=0.65 pd=3.3 as=0 ps=0 w=1 l=0.5
X3252 BLP7 rr3t3r_0[38|7]/a_60_290# sky130_fd_pr_reram__reram_cell area_ox=0.0676
X3253 BLZ7 rr3t3r_0[38|7]/a_460_290# sky130_fd_pr_reram__reram_cell area_ox=0.0676
X3254 rr3t3r_0[38|7]/a_460_290# WL38 SL7 VSS sky130_fd_pr__nfet_g5v0d10v5 ad=0.65 pd=3.3 as=0 ps=0 w=1 l=0.5
X3255 BLN7 rr3t3r_0[38|7]/a_860_290# sky130_fd_pr_reram__reram_cell area_ox=0.0676
X3256 rr3t3r_0[38|7]/a_60_290# WL38 SL7 VSS sky130_fd_pr__nfet_g5v0d10v5 ad=0.65 pd=3.3 as=0 ps=0 w=1 l=0.5
X3257 rr3t3r_0[38|7]/a_860_290# WL38 SL7 VSS sky130_fd_pr__nfet_g5v0d10v5 ad=0.65 pd=3.3 as=0 ps=0 w=1 l=0.5
X3258 BLP7 rr3t3r_0[39|7]/a_60_290# sky130_fd_pr_reram__reram_cell area_ox=0.0676
X3259 BLZ7 rr3t3r_0[39|7]/a_460_290# sky130_fd_pr_reram__reram_cell area_ox=0.0676
X3260 rr3t3r_0[39|7]/a_460_290# WL39 SL7 VSS sky130_fd_pr__nfet_g5v0d10v5 ad=0.65 pd=3.3 as=0 ps=0 w=1 l=0.5
X3261 BLN7 rr3t3r_0[39|7]/a_860_290# sky130_fd_pr_reram__reram_cell area_ox=0.0676
X3262 rr3t3r_0[39|7]/a_60_290# WL39 SL7 VSS sky130_fd_pr__nfet_g5v0d10v5 ad=0.65 pd=3.3 as=0 ps=0 w=1 l=0.5
X3263 rr3t3r_0[39|7]/a_860_290# WL39 SL7 VSS sky130_fd_pr__nfet_g5v0d10v5 ad=0.65 pd=3.3 as=0 ps=0 w=1 l=0.5
X3264 BLP7 rr3t3r_0[40|7]/a_60_290# sky130_fd_pr_reram__reram_cell area_ox=0.0676
X3265 BLZ7 rr3t3r_0[40|7]/a_460_290# sky130_fd_pr_reram__reram_cell area_ox=0.0676
X3266 rr3t3r_0[40|7]/a_460_290# WL40 SL7 VSS sky130_fd_pr__nfet_g5v0d10v5 ad=0.65 pd=3.3 as=0 ps=0 w=1 l=0.5
X3267 BLN7 rr3t3r_0[40|7]/a_860_290# sky130_fd_pr_reram__reram_cell area_ox=0.0676
X3268 rr3t3r_0[40|7]/a_60_290# WL40 SL7 VSS sky130_fd_pr__nfet_g5v0d10v5 ad=0.65 pd=3.3 as=0 ps=0 w=1 l=0.5
X3269 rr3t3r_0[40|7]/a_860_290# WL40 SL7 VSS sky130_fd_pr__nfet_g5v0d10v5 ad=0.65 pd=3.3 as=0 ps=0 w=1 l=0.5
X3270 BLP7 rr3t3r_0[41|7]/a_60_290# sky130_fd_pr_reram__reram_cell area_ox=0.0676
X3271 BLZ7 rr3t3r_0[41|7]/a_460_290# sky130_fd_pr_reram__reram_cell area_ox=0.0676
X3272 rr3t3r_0[41|7]/a_460_290# WL41 SL7 VSS sky130_fd_pr__nfet_g5v0d10v5 ad=0.65 pd=3.3 as=0 ps=0 w=1 l=0.5
X3273 BLN7 rr3t3r_0[41|7]/a_860_290# sky130_fd_pr_reram__reram_cell area_ox=0.0676
X3274 rr3t3r_0[41|7]/a_60_290# WL41 SL7 VSS sky130_fd_pr__nfet_g5v0d10v5 ad=0.65 pd=3.3 as=0 ps=0 w=1 l=0.5
X3275 rr3t3r_0[41|7]/a_860_290# WL41 SL7 VSS sky130_fd_pr__nfet_g5v0d10v5 ad=0.65 pd=3.3 as=0 ps=0 w=1 l=0.5
X3276 BLP7 rr3t3r_0[42|7]/a_60_290# sky130_fd_pr_reram__reram_cell area_ox=0.0676
X3277 BLZ7 rr3t3r_0[42|7]/a_460_290# sky130_fd_pr_reram__reram_cell area_ox=0.0676
X3278 rr3t3r_0[42|7]/a_460_290# WL42 SL7 VSS sky130_fd_pr__nfet_g5v0d10v5 ad=0.65 pd=3.3 as=0 ps=0 w=1 l=0.5
X3279 BLN7 rr3t3r_0[42|7]/a_860_290# sky130_fd_pr_reram__reram_cell area_ox=0.0676
X3280 rr3t3r_0[42|7]/a_60_290# WL42 SL7 VSS sky130_fd_pr__nfet_g5v0d10v5 ad=0.65 pd=3.3 as=0 ps=0 w=1 l=0.5
X3281 rr3t3r_0[42|7]/a_860_290# WL42 SL7 VSS sky130_fd_pr__nfet_g5v0d10v5 ad=0.65 pd=3.3 as=0 ps=0 w=1 l=0.5
X3282 BLP7 rr3t3r_0[43|7]/a_60_290# sky130_fd_pr_reram__reram_cell area_ox=0.0676
X3283 BLZ7 rr3t3r_0[43|7]/a_460_290# sky130_fd_pr_reram__reram_cell area_ox=0.0676
X3284 rr3t3r_0[43|7]/a_460_290# WL43 SL7 VSS sky130_fd_pr__nfet_g5v0d10v5 ad=0.65 pd=3.3 as=0 ps=0 w=1 l=0.5
X3285 BLN7 rr3t3r_0[43|7]/a_860_290# sky130_fd_pr_reram__reram_cell area_ox=0.0676
X3286 rr3t3r_0[43|7]/a_60_290# WL43 SL7 VSS sky130_fd_pr__nfet_g5v0d10v5 ad=0.65 pd=3.3 as=0 ps=0 w=1 l=0.5
X3287 rr3t3r_0[43|7]/a_860_290# WL43 SL7 VSS sky130_fd_pr__nfet_g5v0d10v5 ad=0.65 pd=3.3 as=0 ps=0 w=1 l=0.5
X3288 BLP7 rr3t3r_0[44|7]/a_60_290# sky130_fd_pr_reram__reram_cell area_ox=0.0676
X3289 BLZ7 rr3t3r_0[44|7]/a_460_290# sky130_fd_pr_reram__reram_cell area_ox=0.0676
X3290 rr3t3r_0[44|7]/a_460_290# WL44 SL7 VSS sky130_fd_pr__nfet_g5v0d10v5 ad=0.65 pd=3.3 as=0 ps=0 w=1 l=0.5
X3291 BLN7 rr3t3r_0[44|7]/a_860_290# sky130_fd_pr_reram__reram_cell area_ox=0.0676
X3292 rr3t3r_0[44|7]/a_60_290# WL44 SL7 VSS sky130_fd_pr__nfet_g5v0d10v5 ad=0.65 pd=3.3 as=0 ps=0 w=1 l=0.5
X3293 rr3t3r_0[44|7]/a_860_290# WL44 SL7 VSS sky130_fd_pr__nfet_g5v0d10v5 ad=0.65 pd=3.3 as=0 ps=0 w=1 l=0.5
X3294 BLP7 rr3t3r_0[45|7]/a_60_290# sky130_fd_pr_reram__reram_cell area_ox=0.0676
X3295 BLZ7 rr3t3r_0[45|7]/a_460_290# sky130_fd_pr_reram__reram_cell area_ox=0.0676
X3296 rr3t3r_0[45|7]/a_460_290# WL45 SL7 VSS sky130_fd_pr__nfet_g5v0d10v5 ad=0.65 pd=3.3 as=0 ps=0 w=1 l=0.5
X3297 BLN7 rr3t3r_0[45|7]/a_860_290# sky130_fd_pr_reram__reram_cell area_ox=0.0676
X3298 rr3t3r_0[45|7]/a_60_290# WL45 SL7 VSS sky130_fd_pr__nfet_g5v0d10v5 ad=0.65 pd=3.3 as=0 ps=0 w=1 l=0.5
X3299 rr3t3r_0[45|7]/a_860_290# WL45 SL7 VSS sky130_fd_pr__nfet_g5v0d10v5 ad=0.65 pd=3.3 as=0 ps=0 w=1 l=0.5
X3300 BLP7 rr3t3r_0[46|7]/a_60_290# sky130_fd_pr_reram__reram_cell area_ox=0.0676
X3301 BLZ7 rr3t3r_0[46|7]/a_460_290# sky130_fd_pr_reram__reram_cell area_ox=0.0676
X3302 rr3t3r_0[46|7]/a_460_290# WL46 SL7 VSS sky130_fd_pr__nfet_g5v0d10v5 ad=0.65 pd=3.3 as=0 ps=0 w=1 l=0.5
X3303 BLN7 rr3t3r_0[46|7]/a_860_290# sky130_fd_pr_reram__reram_cell area_ox=0.0676
X3304 rr3t3r_0[46|7]/a_60_290# WL46 SL7 VSS sky130_fd_pr__nfet_g5v0d10v5 ad=0.65 pd=3.3 as=0 ps=0 w=1 l=0.5
X3305 rr3t3r_0[46|7]/a_860_290# WL46 SL7 VSS sky130_fd_pr__nfet_g5v0d10v5 ad=0.65 pd=3.3 as=0 ps=0 w=1 l=0.5
X3306 BLP7 rr3t3r_0[47|7]/a_60_290# sky130_fd_pr_reram__reram_cell area_ox=0.0676
X3307 BLZ7 rr3t3r_0[47|7]/a_460_290# sky130_fd_pr_reram__reram_cell area_ox=0.0676
X3308 rr3t3r_0[47|7]/a_460_290# WL47 SL7 VSS sky130_fd_pr__nfet_g5v0d10v5 ad=0.65 pd=3.3 as=0 ps=0 w=1 l=0.5
X3309 BLN7 rr3t3r_0[47|7]/a_860_290# sky130_fd_pr_reram__reram_cell area_ox=0.0676
X3310 rr3t3r_0[47|7]/a_60_290# WL47 SL7 VSS sky130_fd_pr__nfet_g5v0d10v5 ad=0.65 pd=3.3 as=0 ps=0 w=1 l=0.5
X3311 rr3t3r_0[47|7]/a_860_290# WL47 SL7 VSS sky130_fd_pr__nfet_g5v0d10v5 ad=0.65 pd=3.3 as=0 ps=0 w=1 l=0.5
X3312 BLP7 rr3t3r_0[48|7]/a_60_290# sky130_fd_pr_reram__reram_cell area_ox=0.0676
X3313 BLZ7 rr3t3r_0[48|7]/a_460_290# sky130_fd_pr_reram__reram_cell area_ox=0.0676
X3314 rr3t3r_0[48|7]/a_460_290# WL48 SL7 VSS sky130_fd_pr__nfet_g5v0d10v5 ad=0.65 pd=3.3 as=0 ps=0 w=1 l=0.5
X3315 BLN7 rr3t3r_0[48|7]/a_860_290# sky130_fd_pr_reram__reram_cell area_ox=0.0676
X3316 rr3t3r_0[48|7]/a_60_290# WL48 SL7 VSS sky130_fd_pr__nfet_g5v0d10v5 ad=0.65 pd=3.3 as=0 ps=0 w=1 l=0.5
X3317 rr3t3r_0[48|7]/a_860_290# WL48 SL7 VSS sky130_fd_pr__nfet_g5v0d10v5 ad=0.65 pd=3.3 as=0 ps=0 w=1 l=0.5
X3318 BLP7 rr3t3r_0[49|7]/a_60_290# sky130_fd_pr_reram__reram_cell area_ox=0.0676
X3319 BLZ7 rr3t3r_0[49|7]/a_460_290# sky130_fd_pr_reram__reram_cell area_ox=0.0676
X3320 rr3t3r_0[49|7]/a_460_290# WL49 SL7 VSS sky130_fd_pr__nfet_g5v0d10v5 ad=0.65 pd=3.3 as=0 ps=0 w=1 l=0.5
X3321 BLN7 rr3t3r_0[49|7]/a_860_290# sky130_fd_pr_reram__reram_cell area_ox=0.0676
X3322 rr3t3r_0[49|7]/a_60_290# WL49 SL7 VSS sky130_fd_pr__nfet_g5v0d10v5 ad=0.65 pd=3.3 as=0 ps=0 w=1 l=0.5
X3323 rr3t3r_0[49|7]/a_860_290# WL49 SL7 VSS sky130_fd_pr__nfet_g5v0d10v5 ad=0.65 pd=3.3 as=0 ps=0 w=1 l=0.5
X3324 BLP7 rr3t3r_0[50|7]/a_60_290# sky130_fd_pr_reram__reram_cell area_ox=0.0676
X3325 BLZ7 rr3t3r_0[50|7]/a_460_290# sky130_fd_pr_reram__reram_cell area_ox=0.0676
X3326 rr3t3r_0[50|7]/a_460_290# WL50 SL7 VSS sky130_fd_pr__nfet_g5v0d10v5 ad=0.65 pd=3.3 as=0 ps=0 w=1 l=0.5
X3327 BLN7 rr3t3r_0[50|7]/a_860_290# sky130_fd_pr_reram__reram_cell area_ox=0.0676
X3328 rr3t3r_0[50|7]/a_60_290# WL50 SL7 VSS sky130_fd_pr__nfet_g5v0d10v5 ad=0.65 pd=3.3 as=0 ps=0 w=1 l=0.5
X3329 rr3t3r_0[50|7]/a_860_290# WL50 SL7 VSS sky130_fd_pr__nfet_g5v0d10v5 ad=0.65 pd=3.3 as=0 ps=0 w=1 l=0.5
X3330 BLP7 rr3t3r_0[51|7]/a_60_290# sky130_fd_pr_reram__reram_cell area_ox=0.0676
X3331 BLZ7 rr3t3r_0[51|7]/a_460_290# sky130_fd_pr_reram__reram_cell area_ox=0.0676
X3332 rr3t3r_0[51|7]/a_460_290# WL51 SL7 VSS sky130_fd_pr__nfet_g5v0d10v5 ad=0.65 pd=3.3 as=0 ps=0 w=1 l=0.5
X3333 BLN7 rr3t3r_0[51|7]/a_860_290# sky130_fd_pr_reram__reram_cell area_ox=0.0676
X3334 rr3t3r_0[51|7]/a_60_290# WL51 SL7 VSS sky130_fd_pr__nfet_g5v0d10v5 ad=0.65 pd=3.3 as=0 ps=0 w=1 l=0.5
X3335 rr3t3r_0[51|7]/a_860_290# WL51 SL7 VSS sky130_fd_pr__nfet_g5v0d10v5 ad=0.65 pd=3.3 as=0 ps=0 w=1 l=0.5
X3336 BLP7 rr3t3r_0[52|7]/a_60_290# sky130_fd_pr_reram__reram_cell area_ox=0.0676
X3337 BLZ7 rr3t3r_0[52|7]/a_460_290# sky130_fd_pr_reram__reram_cell area_ox=0.0676
X3338 rr3t3r_0[52|7]/a_460_290# WL52 SL7 VSS sky130_fd_pr__nfet_g5v0d10v5 ad=0.65 pd=3.3 as=0 ps=0 w=1 l=0.5
X3339 BLN7 rr3t3r_0[52|7]/a_860_290# sky130_fd_pr_reram__reram_cell area_ox=0.0676
X3340 rr3t3r_0[52|7]/a_60_290# WL52 SL7 VSS sky130_fd_pr__nfet_g5v0d10v5 ad=0.65 pd=3.3 as=0 ps=0 w=1 l=0.5
X3341 rr3t3r_0[52|7]/a_860_290# WL52 SL7 VSS sky130_fd_pr__nfet_g5v0d10v5 ad=0.65 pd=3.3 as=0 ps=0 w=1 l=0.5
X3342 BLP7 rr3t3r_0[53|7]/a_60_290# sky130_fd_pr_reram__reram_cell area_ox=0.0676
X3343 BLZ7 rr3t3r_0[53|7]/a_460_290# sky130_fd_pr_reram__reram_cell area_ox=0.0676
X3344 rr3t3r_0[53|7]/a_460_290# WL53 SL7 VSS sky130_fd_pr__nfet_g5v0d10v5 ad=0.65 pd=3.3 as=0 ps=0 w=1 l=0.5
X3345 BLN7 rr3t3r_0[53|7]/a_860_290# sky130_fd_pr_reram__reram_cell area_ox=0.0676
X3346 rr3t3r_0[53|7]/a_60_290# WL53 SL7 VSS sky130_fd_pr__nfet_g5v0d10v5 ad=0.65 pd=3.3 as=0 ps=0 w=1 l=0.5
X3347 rr3t3r_0[53|7]/a_860_290# WL53 SL7 VSS sky130_fd_pr__nfet_g5v0d10v5 ad=0.65 pd=3.3 as=0 ps=0 w=1 l=0.5
X3348 BLP7 rr3t3r_0[54|7]/a_60_290# sky130_fd_pr_reram__reram_cell area_ox=0.0676
X3349 BLZ7 rr3t3r_0[54|7]/a_460_290# sky130_fd_pr_reram__reram_cell area_ox=0.0676
X3350 rr3t3r_0[54|7]/a_460_290# WL54 SL7 VSS sky130_fd_pr__nfet_g5v0d10v5 ad=0.65 pd=3.3 as=0 ps=0 w=1 l=0.5
X3351 BLN7 rr3t3r_0[54|7]/a_860_290# sky130_fd_pr_reram__reram_cell area_ox=0.0676
X3352 rr3t3r_0[54|7]/a_60_290# WL54 SL7 VSS sky130_fd_pr__nfet_g5v0d10v5 ad=0.65 pd=3.3 as=0 ps=0 w=1 l=0.5
X3353 rr3t3r_0[54|7]/a_860_290# WL54 SL7 VSS sky130_fd_pr__nfet_g5v0d10v5 ad=0.65 pd=3.3 as=0 ps=0 w=1 l=0.5
X3354 BLP7 rr3t3r_0[55|7]/a_60_290# sky130_fd_pr_reram__reram_cell area_ox=0.0676
X3355 BLZ7 rr3t3r_0[55|7]/a_460_290# sky130_fd_pr_reram__reram_cell area_ox=0.0676
X3356 rr3t3r_0[55|7]/a_460_290# WL55 SL7 VSS sky130_fd_pr__nfet_g5v0d10v5 ad=0.65 pd=3.3 as=0 ps=0 w=1 l=0.5
X3357 BLN7 rr3t3r_0[55|7]/a_860_290# sky130_fd_pr_reram__reram_cell area_ox=0.0676
X3358 rr3t3r_0[55|7]/a_60_290# WL55 SL7 VSS sky130_fd_pr__nfet_g5v0d10v5 ad=0.65 pd=3.3 as=0 ps=0 w=1 l=0.5
X3359 rr3t3r_0[55|7]/a_860_290# WL55 SL7 VSS sky130_fd_pr__nfet_g5v0d10v5 ad=0.65 pd=3.3 as=0 ps=0 w=1 l=0.5
X3360 BLP7 rr3t3r_0[56|7]/a_60_290# sky130_fd_pr_reram__reram_cell area_ox=0.0676
X3361 BLZ7 rr3t3r_0[56|7]/a_460_290# sky130_fd_pr_reram__reram_cell area_ox=0.0676
X3362 rr3t3r_0[56|7]/a_460_290# WL56 SL7 VSS sky130_fd_pr__nfet_g5v0d10v5 ad=0.65 pd=3.3 as=0 ps=0 w=1 l=0.5
X3363 BLN7 rr3t3r_0[56|7]/a_860_290# sky130_fd_pr_reram__reram_cell area_ox=0.0676
X3364 rr3t3r_0[56|7]/a_60_290# WL56 SL7 VSS sky130_fd_pr__nfet_g5v0d10v5 ad=0.65 pd=3.3 as=0 ps=0 w=1 l=0.5
X3365 rr3t3r_0[56|7]/a_860_290# WL56 SL7 VSS sky130_fd_pr__nfet_g5v0d10v5 ad=0.65 pd=3.3 as=0 ps=0 w=1 l=0.5
X3366 BLP7 rr3t3r_0[57|7]/a_60_290# sky130_fd_pr_reram__reram_cell area_ox=0.0676
X3367 BLZ7 rr3t3r_0[57|7]/a_460_290# sky130_fd_pr_reram__reram_cell area_ox=0.0676
X3368 rr3t3r_0[57|7]/a_460_290# WL57 SL7 VSS sky130_fd_pr__nfet_g5v0d10v5 ad=0.65 pd=3.3 as=0 ps=0 w=1 l=0.5
X3369 BLN7 rr3t3r_0[57|7]/a_860_290# sky130_fd_pr_reram__reram_cell area_ox=0.0676
X3370 rr3t3r_0[57|7]/a_60_290# WL57 SL7 VSS sky130_fd_pr__nfet_g5v0d10v5 ad=0.65 pd=3.3 as=0 ps=0 w=1 l=0.5
X3371 rr3t3r_0[57|7]/a_860_290# WL57 SL7 VSS sky130_fd_pr__nfet_g5v0d10v5 ad=0.65 pd=3.3 as=0 ps=0 w=1 l=0.5
X3372 BLP7 rr3t3r_0[58|7]/a_60_290# sky130_fd_pr_reram__reram_cell area_ox=0.0676
X3373 BLZ7 rr3t3r_0[58|7]/a_460_290# sky130_fd_pr_reram__reram_cell area_ox=0.0676
X3374 rr3t3r_0[58|7]/a_460_290# WL58 SL7 VSS sky130_fd_pr__nfet_g5v0d10v5 ad=0.65 pd=3.3 as=0 ps=0 w=1 l=0.5
X3375 BLN7 rr3t3r_0[58|7]/a_860_290# sky130_fd_pr_reram__reram_cell area_ox=0.0676
X3376 rr3t3r_0[58|7]/a_60_290# WL58 SL7 VSS sky130_fd_pr__nfet_g5v0d10v5 ad=0.65 pd=3.3 as=0 ps=0 w=1 l=0.5
X3377 rr3t3r_0[58|7]/a_860_290# WL58 SL7 VSS sky130_fd_pr__nfet_g5v0d10v5 ad=0.65 pd=3.3 as=0 ps=0 w=1 l=0.5
X3378 BLP7 rr3t3r_0[59|7]/a_60_290# sky130_fd_pr_reram__reram_cell area_ox=0.0676
X3379 BLZ7 rr3t3r_0[59|7]/a_460_290# sky130_fd_pr_reram__reram_cell area_ox=0.0676
X3380 rr3t3r_0[59|7]/a_460_290# WL59 SL7 VSS sky130_fd_pr__nfet_g5v0d10v5 ad=0.65 pd=3.3 as=0 ps=0 w=1 l=0.5
X3381 BLN7 rr3t3r_0[59|7]/a_860_290# sky130_fd_pr_reram__reram_cell area_ox=0.0676
X3382 rr3t3r_0[59|7]/a_60_290# WL59 SL7 VSS sky130_fd_pr__nfet_g5v0d10v5 ad=0.65 pd=3.3 as=0 ps=0 w=1 l=0.5
X3383 rr3t3r_0[59|7]/a_860_290# WL59 SL7 VSS sky130_fd_pr__nfet_g5v0d10v5 ad=0.65 pd=3.3 as=0 ps=0 w=1 l=0.5
X3384 BLP7 rr3t3r_0[60|7]/a_60_290# sky130_fd_pr_reram__reram_cell area_ox=0.0676
X3385 BLZ7 rr3t3r_0[60|7]/a_460_290# sky130_fd_pr_reram__reram_cell area_ox=0.0676
X3386 rr3t3r_0[60|7]/a_460_290# WL60 SL7 VSS sky130_fd_pr__nfet_g5v0d10v5 ad=0.65 pd=3.3 as=0 ps=0 w=1 l=0.5
X3387 BLN7 rr3t3r_0[60|7]/a_860_290# sky130_fd_pr_reram__reram_cell area_ox=0.0676
X3388 rr3t3r_0[60|7]/a_60_290# WL60 SL7 VSS sky130_fd_pr__nfet_g5v0d10v5 ad=0.65 pd=3.3 as=0 ps=0 w=1 l=0.5
X3389 rr3t3r_0[60|7]/a_860_290# WL60 SL7 VSS sky130_fd_pr__nfet_g5v0d10v5 ad=0.65 pd=3.3 as=0 ps=0 w=1 l=0.5
X3390 BLP7 rr3t3r_0[61|7]/a_60_290# sky130_fd_pr_reram__reram_cell area_ox=0.0676
X3391 BLZ7 rr3t3r_0[61|7]/a_460_290# sky130_fd_pr_reram__reram_cell area_ox=0.0676
X3392 rr3t3r_0[61|7]/a_460_290# WL61 SL7 VSS sky130_fd_pr__nfet_g5v0d10v5 ad=0.65 pd=3.3 as=0 ps=0 w=1 l=0.5
X3393 BLN7 rr3t3r_0[61|7]/a_860_290# sky130_fd_pr_reram__reram_cell area_ox=0.0676
X3394 rr3t3r_0[61|7]/a_60_290# WL61 SL7 VSS sky130_fd_pr__nfet_g5v0d10v5 ad=0.65 pd=3.3 as=0 ps=0 w=1 l=0.5
X3395 rr3t3r_0[61|7]/a_860_290# WL61 SL7 VSS sky130_fd_pr__nfet_g5v0d10v5 ad=0.65 pd=3.3 as=0 ps=0 w=1 l=0.5
X3396 BLP7 rr3t3r_0[62|7]/a_60_290# sky130_fd_pr_reram__reram_cell area_ox=0.0676
X3397 BLZ7 rr3t3r_0[62|7]/a_460_290# sky130_fd_pr_reram__reram_cell area_ox=0.0676
X3398 rr3t3r_0[62|7]/a_460_290# WL62 SL7 VSS sky130_fd_pr__nfet_g5v0d10v5 ad=0.65 pd=3.3 as=0 ps=0 w=1 l=0.5
X3399 BLN7 rr3t3r_0[62|7]/a_860_290# sky130_fd_pr_reram__reram_cell area_ox=0.0676
X3400 rr3t3r_0[62|7]/a_60_290# WL62 SL7 VSS sky130_fd_pr__nfet_g5v0d10v5 ad=0.65 pd=3.3 as=0 ps=0 w=1 l=0.5
X3401 rr3t3r_0[62|7]/a_860_290# WL62 SL7 VSS sky130_fd_pr__nfet_g5v0d10v5 ad=0.65 pd=3.3 as=0 ps=0 w=1 l=0.5
X3402 BLP7 rr3t3r_0[63|7]/a_60_290# sky130_fd_pr_reram__reram_cell area_ox=0.0676
X3403 BLZ7 rr3t3r_0[63|7]/a_460_290# sky130_fd_pr_reram__reram_cell area_ox=0.0676
X3404 rr3t3r_0[63|7]/a_460_290# WL63 SL7 VSS sky130_fd_pr__nfet_g5v0d10v5 ad=0.65 pd=3.3 as=0 ps=0 w=1 l=0.5
X3405 BLN7 rr3t3r_0[63|7]/a_860_290# sky130_fd_pr_reram__reram_cell area_ox=0.0676
X3406 rr3t3r_0[63|7]/a_60_290# WL63 SL7 VSS sky130_fd_pr__nfet_g5v0d10v5 ad=0.65 pd=3.3 as=0 ps=0 w=1 l=0.5
X3407 rr3t3r_0[63|7]/a_860_290# WL63 SL7 VSS sky130_fd_pr__nfet_g5v0d10v5 ad=0.65 pd=3.3 as=0 ps=0 w=1 l=0.5
X3408 BLP7 rr3t3r_0[64|7]/a_60_290# sky130_fd_pr_reram__reram_cell area_ox=0.0676
X3409 BLZ7 rr3t3r_0[64|7]/a_460_290# sky130_fd_pr_reram__reram_cell area_ox=0.0676
X3410 rr3t3r_0[64|7]/a_460_290# WL64 SL7 VSS sky130_fd_pr__nfet_g5v0d10v5 ad=0.65 pd=3.3 as=0 ps=0 w=1 l=0.5
X3411 BLN7 rr3t3r_0[64|7]/a_860_290# sky130_fd_pr_reram__reram_cell area_ox=0.0676
X3412 rr3t3r_0[64|7]/a_60_290# WL64 SL7 VSS sky130_fd_pr__nfet_g5v0d10v5 ad=0.65 pd=3.3 as=0 ps=0 w=1 l=0.5
X3413 rr3t3r_0[64|7]/a_860_290# WL64 SL7 VSS sky130_fd_pr__nfet_g5v0d10v5 ad=0.65 pd=3.3 as=0 ps=0 w=1 l=0.5
X3414 BLP7 rr3t3r_0[65|7]/a_60_290# sky130_fd_pr_reram__reram_cell area_ox=0.0676
X3415 BLZ7 rr3t3r_0[65|7]/a_460_290# sky130_fd_pr_reram__reram_cell area_ox=0.0676
X3416 rr3t3r_0[65|7]/a_460_290# WL65 SL7 VSS sky130_fd_pr__nfet_g5v0d10v5 ad=0.65 pd=3.3 as=0 ps=0 w=1 l=0.5
X3417 BLN7 rr3t3r_0[65|7]/a_860_290# sky130_fd_pr_reram__reram_cell area_ox=0.0676
X3418 rr3t3r_0[65|7]/a_60_290# WL65 SL7 VSS sky130_fd_pr__nfet_g5v0d10v5 ad=0.65 pd=3.3 as=0 ps=0 w=1 l=0.5
X3419 rr3t3r_0[65|7]/a_860_290# WL65 SL7 VSS sky130_fd_pr__nfet_g5v0d10v5 ad=0.65 pd=3.3 as=0 ps=0 w=1 l=0.5
X3420 BLP7 rr3t3r_0[66|7]/a_60_290# sky130_fd_pr_reram__reram_cell area_ox=0.0676
X3421 BLZ7 rr3t3r_0[66|7]/a_460_290# sky130_fd_pr_reram__reram_cell area_ox=0.0676
X3422 rr3t3r_0[66|7]/a_460_290# WL66 SL7 VSS sky130_fd_pr__nfet_g5v0d10v5 ad=0.65 pd=3.3 as=0 ps=0 w=1 l=0.5
X3423 BLN7 rr3t3r_0[66|7]/a_860_290# sky130_fd_pr_reram__reram_cell area_ox=0.0676
X3424 rr3t3r_0[66|7]/a_60_290# WL66 SL7 VSS sky130_fd_pr__nfet_g5v0d10v5 ad=0.65 pd=3.3 as=0 ps=0 w=1 l=0.5
X3425 rr3t3r_0[66|7]/a_860_290# WL66 SL7 VSS sky130_fd_pr__nfet_g5v0d10v5 ad=0.65 pd=3.3 as=0 ps=0 w=1 l=0.5
X3426 BLP7 rr3t3r_0[67|7]/a_60_290# sky130_fd_pr_reram__reram_cell area_ox=0.0676
X3427 BLZ7 rr3t3r_0[67|7]/a_460_290# sky130_fd_pr_reram__reram_cell area_ox=0.0676
X3428 rr3t3r_0[67|7]/a_460_290# WL67 SL7 VSS sky130_fd_pr__nfet_g5v0d10v5 ad=0.65 pd=3.3 as=0 ps=0 w=1 l=0.5
X3429 BLN7 rr3t3r_0[67|7]/a_860_290# sky130_fd_pr_reram__reram_cell area_ox=0.0676
X3430 rr3t3r_0[67|7]/a_60_290# WL67 SL7 VSS sky130_fd_pr__nfet_g5v0d10v5 ad=0.65 pd=3.3 as=0 ps=0 w=1 l=0.5
X3431 rr3t3r_0[67|7]/a_860_290# WL67 SL7 VSS sky130_fd_pr__nfet_g5v0d10v5 ad=0.65 pd=3.3 as=0 ps=0 w=1 l=0.5
X3432 BLP7 rr3t3r_0[68|7]/a_60_290# sky130_fd_pr_reram__reram_cell area_ox=0.0676
X3433 BLZ7 rr3t3r_0[68|7]/a_460_290# sky130_fd_pr_reram__reram_cell area_ox=0.0676
X3434 rr3t3r_0[68|7]/a_460_290# WL68 SL7 VSS sky130_fd_pr__nfet_g5v0d10v5 ad=0.65 pd=3.3 as=0 ps=0 w=1 l=0.5
X3435 BLN7 rr3t3r_0[68|7]/a_860_290# sky130_fd_pr_reram__reram_cell area_ox=0.0676
X3436 rr3t3r_0[68|7]/a_60_290# WL68 SL7 VSS sky130_fd_pr__nfet_g5v0d10v5 ad=0.65 pd=3.3 as=0 ps=0 w=1 l=0.5
X3437 rr3t3r_0[68|7]/a_860_290# WL68 SL7 VSS sky130_fd_pr__nfet_g5v0d10v5 ad=0.65 pd=3.3 as=0 ps=0 w=1 l=0.5
X3438 BLP7 rr3t3r_0[69|7]/a_60_290# sky130_fd_pr_reram__reram_cell area_ox=0.0676
X3439 BLZ7 rr3t3r_0[69|7]/a_460_290# sky130_fd_pr_reram__reram_cell area_ox=0.0676
X3440 rr3t3r_0[69|7]/a_460_290# WL69 SL7 VSS sky130_fd_pr__nfet_g5v0d10v5 ad=0.65 pd=3.3 as=0 ps=0 w=1 l=0.5
X3441 BLN7 rr3t3r_0[69|7]/a_860_290# sky130_fd_pr_reram__reram_cell area_ox=0.0676
X3442 rr3t3r_0[69|7]/a_60_290# WL69 SL7 VSS sky130_fd_pr__nfet_g5v0d10v5 ad=0.65 pd=3.3 as=0 ps=0 w=1 l=0.5
X3443 rr3t3r_0[69|7]/a_860_290# WL69 SL7 VSS sky130_fd_pr__nfet_g5v0d10v5 ad=0.65 pd=3.3 as=0 ps=0 w=1 l=0.5
X3444 BLP7 rr3t3r_0[70|7]/a_60_290# sky130_fd_pr_reram__reram_cell area_ox=0.0676
X3445 BLZ7 rr3t3r_0[70|7]/a_460_290# sky130_fd_pr_reram__reram_cell area_ox=0.0676
X3446 rr3t3r_0[70|7]/a_460_290# WL70 SL7 VSS sky130_fd_pr__nfet_g5v0d10v5 ad=0.65 pd=3.3 as=0 ps=0 w=1 l=0.5
X3447 BLN7 rr3t3r_0[70|7]/a_860_290# sky130_fd_pr_reram__reram_cell area_ox=0.0676
X3448 rr3t3r_0[70|7]/a_60_290# WL70 SL7 VSS sky130_fd_pr__nfet_g5v0d10v5 ad=0.65 pd=3.3 as=0 ps=0 w=1 l=0.5
X3449 rr3t3r_0[70|7]/a_860_290# WL70 SL7 VSS sky130_fd_pr__nfet_g5v0d10v5 ad=0.65 pd=3.3 as=0 ps=0 w=1 l=0.5
X3450 BLP7 rr3t3r_0[71|7]/a_60_290# sky130_fd_pr_reram__reram_cell area_ox=0.0676
X3451 BLZ7 rr3t3r_0[71|7]/a_460_290# sky130_fd_pr_reram__reram_cell area_ox=0.0676
X3452 rr3t3r_0[71|7]/a_460_290# WL71 SL7 VSS sky130_fd_pr__nfet_g5v0d10v5 ad=0.65 pd=3.3 as=0 ps=0 w=1 l=0.5
X3453 BLN7 rr3t3r_0[71|7]/a_860_290# sky130_fd_pr_reram__reram_cell area_ox=0.0676
X3454 rr3t3r_0[71|7]/a_60_290# WL71 SL7 VSS sky130_fd_pr__nfet_g5v0d10v5 ad=0.65 pd=3.3 as=0 ps=0 w=1 l=0.5
X3455 rr3t3r_0[71|7]/a_860_290# WL71 SL7 VSS sky130_fd_pr__nfet_g5v0d10v5 ad=0.65 pd=3.3 as=0 ps=0 w=1 l=0.5
X3456 BLP8 rr3t3r_0[0|8]/a_60_290# sky130_fd_pr_reram__reram_cell area_ox=0.0676
X3457 BLZ8 rr3t3r_0[0|8]/a_460_290# sky130_fd_pr_reram__reram_cell area_ox=0.0676
X3458 rr3t3r_0[0|8]/a_460_290# WL0 SL8 VSS sky130_fd_pr__nfet_g5v0d10v5 ad=0.65 pd=3.3 as=162 ps=756 w=1 l=0.5
X3459 BLN8 rr3t3r_0[0|8]/a_860_290# sky130_fd_pr_reram__reram_cell area_ox=0.0676
X3460 rr3t3r_0[0|8]/a_60_290# WL0 SL8 VSS sky130_fd_pr__nfet_g5v0d10v5 ad=0.65 pd=3.3 as=0 ps=0 w=1 l=0.5
X3461 rr3t3r_0[0|8]/a_860_290# WL0 SL8 VSS sky130_fd_pr__nfet_g5v0d10v5 ad=0.65 pd=3.3 as=0 ps=0 w=1 l=0.5
X3462 BLP8 rr3t3r_0[1|8]/a_60_290# sky130_fd_pr_reram__reram_cell area_ox=0.0676
X3463 BLZ8 rr3t3r_0[1|8]/a_460_290# sky130_fd_pr_reram__reram_cell area_ox=0.0676
X3464 rr3t3r_0[1|8]/a_460_290# WL1 SL8 VSS sky130_fd_pr__nfet_g5v0d10v5 ad=0.65 pd=3.3 as=0 ps=0 w=1 l=0.5
X3465 BLN8 rr3t3r_0[1|8]/a_860_290# sky130_fd_pr_reram__reram_cell area_ox=0.0676
X3466 rr3t3r_0[1|8]/a_60_290# WL1 SL8 VSS sky130_fd_pr__nfet_g5v0d10v5 ad=0.65 pd=3.3 as=0 ps=0 w=1 l=0.5
X3467 rr3t3r_0[1|8]/a_860_290# WL1 SL8 VSS sky130_fd_pr__nfet_g5v0d10v5 ad=0.65 pd=3.3 as=0 ps=0 w=1 l=0.5
X3468 BLP8 rr3t3r_0[2|8]/a_60_290# sky130_fd_pr_reram__reram_cell area_ox=0.0676
X3469 BLZ8 rr3t3r_0[2|8]/a_460_290# sky130_fd_pr_reram__reram_cell area_ox=0.0676
X3470 rr3t3r_0[2|8]/a_460_290# WL2 SL8 VSS sky130_fd_pr__nfet_g5v0d10v5 ad=0.65 pd=3.3 as=0 ps=0 w=1 l=0.5
X3471 BLN8 rr3t3r_0[2|8]/a_860_290# sky130_fd_pr_reram__reram_cell area_ox=0.0676
X3472 rr3t3r_0[2|8]/a_60_290# WL2 SL8 VSS sky130_fd_pr__nfet_g5v0d10v5 ad=0.65 pd=3.3 as=0 ps=0 w=1 l=0.5
X3473 rr3t3r_0[2|8]/a_860_290# WL2 SL8 VSS sky130_fd_pr__nfet_g5v0d10v5 ad=0.65 pd=3.3 as=0 ps=0 w=1 l=0.5
X3474 BLP8 rr3t3r_0[3|8]/a_60_290# sky130_fd_pr_reram__reram_cell area_ox=0.0676
X3475 BLZ8 rr3t3r_0[3|8]/a_460_290# sky130_fd_pr_reram__reram_cell area_ox=0.0676
X3476 rr3t3r_0[3|8]/a_460_290# WL3 SL8 VSS sky130_fd_pr__nfet_g5v0d10v5 ad=0.65 pd=3.3 as=0 ps=0 w=1 l=0.5
X3477 BLN8 rr3t3r_0[3|8]/a_860_290# sky130_fd_pr_reram__reram_cell area_ox=0.0676
X3478 rr3t3r_0[3|8]/a_60_290# WL3 SL8 VSS sky130_fd_pr__nfet_g5v0d10v5 ad=0.65 pd=3.3 as=0 ps=0 w=1 l=0.5
X3479 rr3t3r_0[3|8]/a_860_290# WL3 SL8 VSS sky130_fd_pr__nfet_g5v0d10v5 ad=0.65 pd=3.3 as=0 ps=0 w=1 l=0.5
X3480 BLP8 rr3t3r_0[4|8]/a_60_290# sky130_fd_pr_reram__reram_cell area_ox=0.0676
X3481 BLZ8 rr3t3r_0[4|8]/a_460_290# sky130_fd_pr_reram__reram_cell area_ox=0.0676
X3482 rr3t3r_0[4|8]/a_460_290# WL4 SL8 VSS sky130_fd_pr__nfet_g5v0d10v5 ad=0.65 pd=3.3 as=0 ps=0 w=1 l=0.5
X3483 BLN8 rr3t3r_0[4|8]/a_860_290# sky130_fd_pr_reram__reram_cell area_ox=0.0676
X3484 rr3t3r_0[4|8]/a_60_290# WL4 SL8 VSS sky130_fd_pr__nfet_g5v0d10v5 ad=0.65 pd=3.3 as=0 ps=0 w=1 l=0.5
X3485 rr3t3r_0[4|8]/a_860_290# WL4 SL8 VSS sky130_fd_pr__nfet_g5v0d10v5 ad=0.65 pd=3.3 as=0 ps=0 w=1 l=0.5
X3486 BLP8 rr3t3r_0[5|8]/a_60_290# sky130_fd_pr_reram__reram_cell area_ox=0.0676
X3487 BLZ8 rr3t3r_0[5|8]/a_460_290# sky130_fd_pr_reram__reram_cell area_ox=0.0676
X3488 rr3t3r_0[5|8]/a_460_290# WL5 SL8 VSS sky130_fd_pr__nfet_g5v0d10v5 ad=0.65 pd=3.3 as=0 ps=0 w=1 l=0.5
X3489 BLN8 rr3t3r_0[5|8]/a_860_290# sky130_fd_pr_reram__reram_cell area_ox=0.0676
X3490 rr3t3r_0[5|8]/a_60_290# WL5 SL8 VSS sky130_fd_pr__nfet_g5v0d10v5 ad=0.65 pd=3.3 as=0 ps=0 w=1 l=0.5
X3491 rr3t3r_0[5|8]/a_860_290# WL5 SL8 VSS sky130_fd_pr__nfet_g5v0d10v5 ad=0.65 pd=3.3 as=0 ps=0 w=1 l=0.5
X3492 BLP8 rr3t3r_0[6|8]/a_60_290# sky130_fd_pr_reram__reram_cell area_ox=0.0676
X3493 BLZ8 rr3t3r_0[6|8]/a_460_290# sky130_fd_pr_reram__reram_cell area_ox=0.0676
X3494 rr3t3r_0[6|8]/a_460_290# WL6 SL8 VSS sky130_fd_pr__nfet_g5v0d10v5 ad=0.65 pd=3.3 as=0 ps=0 w=1 l=0.5
X3495 BLN8 rr3t3r_0[6|8]/a_860_290# sky130_fd_pr_reram__reram_cell area_ox=0.0676
X3496 rr3t3r_0[6|8]/a_60_290# WL6 SL8 VSS sky130_fd_pr__nfet_g5v0d10v5 ad=0.65 pd=3.3 as=0 ps=0 w=1 l=0.5
X3497 rr3t3r_0[6|8]/a_860_290# WL6 SL8 VSS sky130_fd_pr__nfet_g5v0d10v5 ad=0.65 pd=3.3 as=0 ps=0 w=1 l=0.5
X3498 BLP8 rr3t3r_0[7|8]/a_60_290# sky130_fd_pr_reram__reram_cell area_ox=0.0676
X3499 BLZ8 rr3t3r_0[7|8]/a_460_290# sky130_fd_pr_reram__reram_cell area_ox=0.0676
X3500 rr3t3r_0[7|8]/a_460_290# WL7 SL8 VSS sky130_fd_pr__nfet_g5v0d10v5 ad=0.65 pd=3.3 as=0 ps=0 w=1 l=0.5
X3501 BLN8 rr3t3r_0[7|8]/a_860_290# sky130_fd_pr_reram__reram_cell area_ox=0.0676
X3502 rr3t3r_0[7|8]/a_60_290# WL7 SL8 VSS sky130_fd_pr__nfet_g5v0d10v5 ad=0.65 pd=3.3 as=0 ps=0 w=1 l=0.5
X3503 rr3t3r_0[7|8]/a_860_290# WL7 SL8 VSS sky130_fd_pr__nfet_g5v0d10v5 ad=0.65 pd=3.3 as=0 ps=0 w=1 l=0.5
X3504 BLP8 rr3t3r_0[8|8]/a_60_290# sky130_fd_pr_reram__reram_cell area_ox=0.0676
X3505 BLZ8 rr3t3r_0[8|8]/a_460_290# sky130_fd_pr_reram__reram_cell area_ox=0.0676
X3506 rr3t3r_0[8|8]/a_460_290# WL8 SL8 VSS sky130_fd_pr__nfet_g5v0d10v5 ad=0.65 pd=3.3 as=0 ps=0 w=1 l=0.5
X3507 BLN8 rr3t3r_0[8|8]/a_860_290# sky130_fd_pr_reram__reram_cell area_ox=0.0676
X3508 rr3t3r_0[8|8]/a_60_290# WL8 SL8 VSS sky130_fd_pr__nfet_g5v0d10v5 ad=0.65 pd=3.3 as=0 ps=0 w=1 l=0.5
X3509 rr3t3r_0[8|8]/a_860_290# WL8 SL8 VSS sky130_fd_pr__nfet_g5v0d10v5 ad=0.65 pd=3.3 as=0 ps=0 w=1 l=0.5
X3510 BLP8 rr3t3r_0[9|8]/a_60_290# sky130_fd_pr_reram__reram_cell area_ox=0.0676
X3511 BLZ8 rr3t3r_0[9|8]/a_460_290# sky130_fd_pr_reram__reram_cell area_ox=0.0676
X3512 rr3t3r_0[9|8]/a_460_290# WL9 SL8 VSS sky130_fd_pr__nfet_g5v0d10v5 ad=0.65 pd=3.3 as=0 ps=0 w=1 l=0.5
X3513 BLN8 rr3t3r_0[9|8]/a_860_290# sky130_fd_pr_reram__reram_cell area_ox=0.0676
X3514 rr3t3r_0[9|8]/a_60_290# WL9 SL8 VSS sky130_fd_pr__nfet_g5v0d10v5 ad=0.65 pd=3.3 as=0 ps=0 w=1 l=0.5
X3515 rr3t3r_0[9|8]/a_860_290# WL9 SL8 VSS sky130_fd_pr__nfet_g5v0d10v5 ad=0.65 pd=3.3 as=0 ps=0 w=1 l=0.5
X3516 BLP8 rr3t3r_0[10|8]/a_60_290# sky130_fd_pr_reram__reram_cell area_ox=0.0676
X3517 BLZ8 rr3t3r_0[10|8]/a_460_290# sky130_fd_pr_reram__reram_cell area_ox=0.0676
X3518 rr3t3r_0[10|8]/a_460_290# WL10 SL8 VSS sky130_fd_pr__nfet_g5v0d10v5 ad=0.65 pd=3.3 as=0 ps=0 w=1 l=0.5
X3519 BLN8 rr3t3r_0[10|8]/a_860_290# sky130_fd_pr_reram__reram_cell area_ox=0.0676
X3520 rr3t3r_0[10|8]/a_60_290# WL10 SL8 VSS sky130_fd_pr__nfet_g5v0d10v5 ad=0.65 pd=3.3 as=0 ps=0 w=1 l=0.5
X3521 rr3t3r_0[10|8]/a_860_290# WL10 SL8 VSS sky130_fd_pr__nfet_g5v0d10v5 ad=0.65 pd=3.3 as=0 ps=0 w=1 l=0.5
X3522 BLP8 rr3t3r_0[11|8]/a_60_290# sky130_fd_pr_reram__reram_cell area_ox=0.0676
X3523 BLZ8 rr3t3r_0[11|8]/a_460_290# sky130_fd_pr_reram__reram_cell area_ox=0.0676
X3524 rr3t3r_0[11|8]/a_460_290# WL11 SL8 VSS sky130_fd_pr__nfet_g5v0d10v5 ad=0.65 pd=3.3 as=0 ps=0 w=1 l=0.5
X3525 BLN8 rr3t3r_0[11|8]/a_860_290# sky130_fd_pr_reram__reram_cell area_ox=0.0676
X3526 rr3t3r_0[11|8]/a_60_290# WL11 SL8 VSS sky130_fd_pr__nfet_g5v0d10v5 ad=0.65 pd=3.3 as=0 ps=0 w=1 l=0.5
X3527 rr3t3r_0[11|8]/a_860_290# WL11 SL8 VSS sky130_fd_pr__nfet_g5v0d10v5 ad=0.65 pd=3.3 as=0 ps=0 w=1 l=0.5
X3528 BLP8 rr3t3r_0[12|8]/a_60_290# sky130_fd_pr_reram__reram_cell area_ox=0.0676
X3529 BLZ8 rr3t3r_0[12|8]/a_460_290# sky130_fd_pr_reram__reram_cell area_ox=0.0676
X3530 rr3t3r_0[12|8]/a_460_290# WL12 SL8 VSS sky130_fd_pr__nfet_g5v0d10v5 ad=0.65 pd=3.3 as=0 ps=0 w=1 l=0.5
X3531 BLN8 rr3t3r_0[12|8]/a_860_290# sky130_fd_pr_reram__reram_cell area_ox=0.0676
X3532 rr3t3r_0[12|8]/a_60_290# WL12 SL8 VSS sky130_fd_pr__nfet_g5v0d10v5 ad=0.65 pd=3.3 as=0 ps=0 w=1 l=0.5
X3533 rr3t3r_0[12|8]/a_860_290# WL12 SL8 VSS sky130_fd_pr__nfet_g5v0d10v5 ad=0.65 pd=3.3 as=0 ps=0 w=1 l=0.5
X3534 BLP8 rr3t3r_0[13|8]/a_60_290# sky130_fd_pr_reram__reram_cell area_ox=0.0676
X3535 BLZ8 rr3t3r_0[13|8]/a_460_290# sky130_fd_pr_reram__reram_cell area_ox=0.0676
X3536 rr3t3r_0[13|8]/a_460_290# WL13 SL8 VSS sky130_fd_pr__nfet_g5v0d10v5 ad=0.65 pd=3.3 as=0 ps=0 w=1 l=0.5
X3537 BLN8 rr3t3r_0[13|8]/a_860_290# sky130_fd_pr_reram__reram_cell area_ox=0.0676
X3538 rr3t3r_0[13|8]/a_60_290# WL13 SL8 VSS sky130_fd_pr__nfet_g5v0d10v5 ad=0.65 pd=3.3 as=0 ps=0 w=1 l=0.5
X3539 rr3t3r_0[13|8]/a_860_290# WL13 SL8 VSS sky130_fd_pr__nfet_g5v0d10v5 ad=0.65 pd=3.3 as=0 ps=0 w=1 l=0.5
X3540 BLP8 rr3t3r_0[14|8]/a_60_290# sky130_fd_pr_reram__reram_cell area_ox=0.0676
X3541 BLZ8 rr3t3r_0[14|8]/a_460_290# sky130_fd_pr_reram__reram_cell area_ox=0.0676
X3542 rr3t3r_0[14|8]/a_460_290# WL14 SL8 VSS sky130_fd_pr__nfet_g5v0d10v5 ad=0.65 pd=3.3 as=0 ps=0 w=1 l=0.5
X3543 BLN8 rr3t3r_0[14|8]/a_860_290# sky130_fd_pr_reram__reram_cell area_ox=0.0676
X3544 rr3t3r_0[14|8]/a_60_290# WL14 SL8 VSS sky130_fd_pr__nfet_g5v0d10v5 ad=0.65 pd=3.3 as=0 ps=0 w=1 l=0.5
X3545 rr3t3r_0[14|8]/a_860_290# WL14 SL8 VSS sky130_fd_pr__nfet_g5v0d10v5 ad=0.65 pd=3.3 as=0 ps=0 w=1 l=0.5
X3546 BLP8 rr3t3r_0[15|8]/a_60_290# sky130_fd_pr_reram__reram_cell area_ox=0.0676
X3547 BLZ8 rr3t3r_0[15|8]/a_460_290# sky130_fd_pr_reram__reram_cell area_ox=0.0676
X3548 rr3t3r_0[15|8]/a_460_290# WL15 SL8 VSS sky130_fd_pr__nfet_g5v0d10v5 ad=0.65 pd=3.3 as=0 ps=0 w=1 l=0.5
X3549 BLN8 rr3t3r_0[15|8]/a_860_290# sky130_fd_pr_reram__reram_cell area_ox=0.0676
X3550 rr3t3r_0[15|8]/a_60_290# WL15 SL8 VSS sky130_fd_pr__nfet_g5v0d10v5 ad=0.65 pd=3.3 as=0 ps=0 w=1 l=0.5
X3551 rr3t3r_0[15|8]/a_860_290# WL15 SL8 VSS sky130_fd_pr__nfet_g5v0d10v5 ad=0.65 pd=3.3 as=0 ps=0 w=1 l=0.5
X3552 BLP8 rr3t3r_0[16|8]/a_60_290# sky130_fd_pr_reram__reram_cell area_ox=0.0676
X3553 BLZ8 rr3t3r_0[16|8]/a_460_290# sky130_fd_pr_reram__reram_cell area_ox=0.0676
X3554 rr3t3r_0[16|8]/a_460_290# WL16 SL8 VSS sky130_fd_pr__nfet_g5v0d10v5 ad=0.65 pd=3.3 as=0 ps=0 w=1 l=0.5
X3555 BLN8 rr3t3r_0[16|8]/a_860_290# sky130_fd_pr_reram__reram_cell area_ox=0.0676
X3556 rr3t3r_0[16|8]/a_60_290# WL16 SL8 VSS sky130_fd_pr__nfet_g5v0d10v5 ad=0.65 pd=3.3 as=0 ps=0 w=1 l=0.5
X3557 rr3t3r_0[16|8]/a_860_290# WL16 SL8 VSS sky130_fd_pr__nfet_g5v0d10v5 ad=0.65 pd=3.3 as=0 ps=0 w=1 l=0.5
X3558 BLP8 rr3t3r_0[17|8]/a_60_290# sky130_fd_pr_reram__reram_cell area_ox=0.0676
X3559 BLZ8 rr3t3r_0[17|8]/a_460_290# sky130_fd_pr_reram__reram_cell area_ox=0.0676
X3560 rr3t3r_0[17|8]/a_460_290# WL17 SL8 VSS sky130_fd_pr__nfet_g5v0d10v5 ad=0.65 pd=3.3 as=0 ps=0 w=1 l=0.5
X3561 BLN8 rr3t3r_0[17|8]/a_860_290# sky130_fd_pr_reram__reram_cell area_ox=0.0676
X3562 rr3t3r_0[17|8]/a_60_290# WL17 SL8 VSS sky130_fd_pr__nfet_g5v0d10v5 ad=0.65 pd=3.3 as=0 ps=0 w=1 l=0.5
X3563 rr3t3r_0[17|8]/a_860_290# WL17 SL8 VSS sky130_fd_pr__nfet_g5v0d10v5 ad=0.65 pd=3.3 as=0 ps=0 w=1 l=0.5
X3564 BLP8 rr3t3r_0[18|8]/a_60_290# sky130_fd_pr_reram__reram_cell area_ox=0.0676
X3565 BLZ8 rr3t3r_0[18|8]/a_460_290# sky130_fd_pr_reram__reram_cell area_ox=0.0676
X3566 rr3t3r_0[18|8]/a_460_290# WL18 SL8 VSS sky130_fd_pr__nfet_g5v0d10v5 ad=0.65 pd=3.3 as=0 ps=0 w=1 l=0.5
X3567 BLN8 rr3t3r_0[18|8]/a_860_290# sky130_fd_pr_reram__reram_cell area_ox=0.0676
X3568 rr3t3r_0[18|8]/a_60_290# WL18 SL8 VSS sky130_fd_pr__nfet_g5v0d10v5 ad=0.65 pd=3.3 as=0 ps=0 w=1 l=0.5
X3569 rr3t3r_0[18|8]/a_860_290# WL18 SL8 VSS sky130_fd_pr__nfet_g5v0d10v5 ad=0.65 pd=3.3 as=0 ps=0 w=1 l=0.5
X3570 BLP8 rr3t3r_0[19|8]/a_60_290# sky130_fd_pr_reram__reram_cell area_ox=0.0676
X3571 BLZ8 rr3t3r_0[19|8]/a_460_290# sky130_fd_pr_reram__reram_cell area_ox=0.0676
X3572 rr3t3r_0[19|8]/a_460_290# WL19 SL8 VSS sky130_fd_pr__nfet_g5v0d10v5 ad=0.65 pd=3.3 as=0 ps=0 w=1 l=0.5
X3573 BLN8 rr3t3r_0[19|8]/a_860_290# sky130_fd_pr_reram__reram_cell area_ox=0.0676
X3574 rr3t3r_0[19|8]/a_60_290# WL19 SL8 VSS sky130_fd_pr__nfet_g5v0d10v5 ad=0.65 pd=3.3 as=0 ps=0 w=1 l=0.5
X3575 rr3t3r_0[19|8]/a_860_290# WL19 SL8 VSS sky130_fd_pr__nfet_g5v0d10v5 ad=0.65 pd=3.3 as=0 ps=0 w=1 l=0.5
X3576 BLP8 rr3t3r_0[20|8]/a_60_290# sky130_fd_pr_reram__reram_cell area_ox=0.0676
X3577 BLZ8 rr3t3r_0[20|8]/a_460_290# sky130_fd_pr_reram__reram_cell area_ox=0.0676
X3578 rr3t3r_0[20|8]/a_460_290# WL20 SL8 VSS sky130_fd_pr__nfet_g5v0d10v5 ad=0.65 pd=3.3 as=0 ps=0 w=1 l=0.5
X3579 BLN8 rr3t3r_0[20|8]/a_860_290# sky130_fd_pr_reram__reram_cell area_ox=0.0676
X3580 rr3t3r_0[20|8]/a_60_290# WL20 SL8 VSS sky130_fd_pr__nfet_g5v0d10v5 ad=0.65 pd=3.3 as=0 ps=0 w=1 l=0.5
X3581 rr3t3r_0[20|8]/a_860_290# WL20 SL8 VSS sky130_fd_pr__nfet_g5v0d10v5 ad=0.65 pd=3.3 as=0 ps=0 w=1 l=0.5
X3582 BLP8 rr3t3r_0[21|8]/a_60_290# sky130_fd_pr_reram__reram_cell area_ox=0.0676
X3583 BLZ8 rr3t3r_0[21|8]/a_460_290# sky130_fd_pr_reram__reram_cell area_ox=0.0676
X3584 rr3t3r_0[21|8]/a_460_290# WL21 SL8 VSS sky130_fd_pr__nfet_g5v0d10v5 ad=0.65 pd=3.3 as=0 ps=0 w=1 l=0.5
X3585 BLN8 rr3t3r_0[21|8]/a_860_290# sky130_fd_pr_reram__reram_cell area_ox=0.0676
X3586 rr3t3r_0[21|8]/a_60_290# WL21 SL8 VSS sky130_fd_pr__nfet_g5v0d10v5 ad=0.65 pd=3.3 as=0 ps=0 w=1 l=0.5
X3587 rr3t3r_0[21|8]/a_860_290# WL21 SL8 VSS sky130_fd_pr__nfet_g5v0d10v5 ad=0.65 pd=3.3 as=0 ps=0 w=1 l=0.5
X3588 BLP8 rr3t3r_0[22|8]/a_60_290# sky130_fd_pr_reram__reram_cell area_ox=0.0676
X3589 BLZ8 rr3t3r_0[22|8]/a_460_290# sky130_fd_pr_reram__reram_cell area_ox=0.0676
X3590 rr3t3r_0[22|8]/a_460_290# WL22 SL8 VSS sky130_fd_pr__nfet_g5v0d10v5 ad=0.65 pd=3.3 as=0 ps=0 w=1 l=0.5
X3591 BLN8 rr3t3r_0[22|8]/a_860_290# sky130_fd_pr_reram__reram_cell area_ox=0.0676
X3592 rr3t3r_0[22|8]/a_60_290# WL22 SL8 VSS sky130_fd_pr__nfet_g5v0d10v5 ad=0.65 pd=3.3 as=0 ps=0 w=1 l=0.5
X3593 rr3t3r_0[22|8]/a_860_290# WL22 SL8 VSS sky130_fd_pr__nfet_g5v0d10v5 ad=0.65 pd=3.3 as=0 ps=0 w=1 l=0.5
X3594 BLP8 rr3t3r_0[23|8]/a_60_290# sky130_fd_pr_reram__reram_cell area_ox=0.0676
X3595 BLZ8 rr3t3r_0[23|8]/a_460_290# sky130_fd_pr_reram__reram_cell area_ox=0.0676
X3596 rr3t3r_0[23|8]/a_460_290# WL23 SL8 VSS sky130_fd_pr__nfet_g5v0d10v5 ad=0.65 pd=3.3 as=0 ps=0 w=1 l=0.5
X3597 BLN8 rr3t3r_0[23|8]/a_860_290# sky130_fd_pr_reram__reram_cell area_ox=0.0676
X3598 rr3t3r_0[23|8]/a_60_290# WL23 SL8 VSS sky130_fd_pr__nfet_g5v0d10v5 ad=0.65 pd=3.3 as=0 ps=0 w=1 l=0.5
X3599 rr3t3r_0[23|8]/a_860_290# WL23 SL8 VSS sky130_fd_pr__nfet_g5v0d10v5 ad=0.65 pd=3.3 as=0 ps=0 w=1 l=0.5
X3600 BLP8 rr3t3r_0[24|8]/a_60_290# sky130_fd_pr_reram__reram_cell area_ox=0.0676
X3601 BLZ8 rr3t3r_0[24|8]/a_460_290# sky130_fd_pr_reram__reram_cell area_ox=0.0676
X3602 rr3t3r_0[24|8]/a_460_290# WL24 SL8 VSS sky130_fd_pr__nfet_g5v0d10v5 ad=0.65 pd=3.3 as=0 ps=0 w=1 l=0.5
X3603 BLN8 rr3t3r_0[24|8]/a_860_290# sky130_fd_pr_reram__reram_cell area_ox=0.0676
X3604 rr3t3r_0[24|8]/a_60_290# WL24 SL8 VSS sky130_fd_pr__nfet_g5v0d10v5 ad=0.65 pd=3.3 as=0 ps=0 w=1 l=0.5
X3605 rr3t3r_0[24|8]/a_860_290# WL24 SL8 VSS sky130_fd_pr__nfet_g5v0d10v5 ad=0.65 pd=3.3 as=0 ps=0 w=1 l=0.5
X3606 BLP8 rr3t3r_0[25|8]/a_60_290# sky130_fd_pr_reram__reram_cell area_ox=0.0676
X3607 BLZ8 rr3t3r_0[25|8]/a_460_290# sky130_fd_pr_reram__reram_cell area_ox=0.0676
X3608 rr3t3r_0[25|8]/a_460_290# WL25 SL8 VSS sky130_fd_pr__nfet_g5v0d10v5 ad=0.65 pd=3.3 as=0 ps=0 w=1 l=0.5
X3609 BLN8 rr3t3r_0[25|8]/a_860_290# sky130_fd_pr_reram__reram_cell area_ox=0.0676
X3610 rr3t3r_0[25|8]/a_60_290# WL25 SL8 VSS sky130_fd_pr__nfet_g5v0d10v5 ad=0.65 pd=3.3 as=0 ps=0 w=1 l=0.5
X3611 rr3t3r_0[25|8]/a_860_290# WL25 SL8 VSS sky130_fd_pr__nfet_g5v0d10v5 ad=0.65 pd=3.3 as=0 ps=0 w=1 l=0.5
X3612 BLP8 rr3t3r_0[26|8]/a_60_290# sky130_fd_pr_reram__reram_cell area_ox=0.0676
X3613 BLZ8 rr3t3r_0[26|8]/a_460_290# sky130_fd_pr_reram__reram_cell area_ox=0.0676
X3614 rr3t3r_0[26|8]/a_460_290# WL26 SL8 VSS sky130_fd_pr__nfet_g5v0d10v5 ad=0.65 pd=3.3 as=0 ps=0 w=1 l=0.5
X3615 BLN8 rr3t3r_0[26|8]/a_860_290# sky130_fd_pr_reram__reram_cell area_ox=0.0676
X3616 rr3t3r_0[26|8]/a_60_290# WL26 SL8 VSS sky130_fd_pr__nfet_g5v0d10v5 ad=0.65 pd=3.3 as=0 ps=0 w=1 l=0.5
X3617 rr3t3r_0[26|8]/a_860_290# WL26 SL8 VSS sky130_fd_pr__nfet_g5v0d10v5 ad=0.65 pd=3.3 as=0 ps=0 w=1 l=0.5
X3618 BLP8 rr3t3r_0[27|8]/a_60_290# sky130_fd_pr_reram__reram_cell area_ox=0.0676
X3619 BLZ8 rr3t3r_0[27|8]/a_460_290# sky130_fd_pr_reram__reram_cell area_ox=0.0676
X3620 rr3t3r_0[27|8]/a_460_290# WL27 SL8 VSS sky130_fd_pr__nfet_g5v0d10v5 ad=0.65 pd=3.3 as=0 ps=0 w=1 l=0.5
X3621 BLN8 rr3t3r_0[27|8]/a_860_290# sky130_fd_pr_reram__reram_cell area_ox=0.0676
X3622 rr3t3r_0[27|8]/a_60_290# WL27 SL8 VSS sky130_fd_pr__nfet_g5v0d10v5 ad=0.65 pd=3.3 as=0 ps=0 w=1 l=0.5
X3623 rr3t3r_0[27|8]/a_860_290# WL27 SL8 VSS sky130_fd_pr__nfet_g5v0d10v5 ad=0.65 pd=3.3 as=0 ps=0 w=1 l=0.5
X3624 BLP8 rr3t3r_0[28|8]/a_60_290# sky130_fd_pr_reram__reram_cell area_ox=0.0676
X3625 BLZ8 rr3t3r_0[28|8]/a_460_290# sky130_fd_pr_reram__reram_cell area_ox=0.0676
X3626 rr3t3r_0[28|8]/a_460_290# WL28 SL8 VSS sky130_fd_pr__nfet_g5v0d10v5 ad=0.65 pd=3.3 as=0 ps=0 w=1 l=0.5
X3627 BLN8 rr3t3r_0[28|8]/a_860_290# sky130_fd_pr_reram__reram_cell area_ox=0.0676
X3628 rr3t3r_0[28|8]/a_60_290# WL28 SL8 VSS sky130_fd_pr__nfet_g5v0d10v5 ad=0.65 pd=3.3 as=0 ps=0 w=1 l=0.5
X3629 rr3t3r_0[28|8]/a_860_290# WL28 SL8 VSS sky130_fd_pr__nfet_g5v0d10v5 ad=0.65 pd=3.3 as=0 ps=0 w=1 l=0.5
X3630 BLP8 rr3t3r_0[29|8]/a_60_290# sky130_fd_pr_reram__reram_cell area_ox=0.0676
X3631 BLZ8 rr3t3r_0[29|8]/a_460_290# sky130_fd_pr_reram__reram_cell area_ox=0.0676
X3632 rr3t3r_0[29|8]/a_460_290# WL29 SL8 VSS sky130_fd_pr__nfet_g5v0d10v5 ad=0.65 pd=3.3 as=0 ps=0 w=1 l=0.5
X3633 BLN8 rr3t3r_0[29|8]/a_860_290# sky130_fd_pr_reram__reram_cell area_ox=0.0676
X3634 rr3t3r_0[29|8]/a_60_290# WL29 SL8 VSS sky130_fd_pr__nfet_g5v0d10v5 ad=0.65 pd=3.3 as=0 ps=0 w=1 l=0.5
X3635 rr3t3r_0[29|8]/a_860_290# WL29 SL8 VSS sky130_fd_pr__nfet_g5v0d10v5 ad=0.65 pd=3.3 as=0 ps=0 w=1 l=0.5
X3636 BLP8 rr3t3r_0[30|8]/a_60_290# sky130_fd_pr_reram__reram_cell area_ox=0.0676
X3637 BLZ8 rr3t3r_0[30|8]/a_460_290# sky130_fd_pr_reram__reram_cell area_ox=0.0676
X3638 rr3t3r_0[30|8]/a_460_290# WL30 SL8 VSS sky130_fd_pr__nfet_g5v0d10v5 ad=0.65 pd=3.3 as=0 ps=0 w=1 l=0.5
X3639 BLN8 rr3t3r_0[30|8]/a_860_290# sky130_fd_pr_reram__reram_cell area_ox=0.0676
X3640 rr3t3r_0[30|8]/a_60_290# WL30 SL8 VSS sky130_fd_pr__nfet_g5v0d10v5 ad=0.65 pd=3.3 as=0 ps=0 w=1 l=0.5
X3641 rr3t3r_0[30|8]/a_860_290# WL30 SL8 VSS sky130_fd_pr__nfet_g5v0d10v5 ad=0.65 pd=3.3 as=0 ps=0 w=1 l=0.5
X3642 BLP8 rr3t3r_0[31|8]/a_60_290# sky130_fd_pr_reram__reram_cell area_ox=0.0676
X3643 BLZ8 rr3t3r_0[31|8]/a_460_290# sky130_fd_pr_reram__reram_cell area_ox=0.0676
X3644 rr3t3r_0[31|8]/a_460_290# WL31 SL8 VSS sky130_fd_pr__nfet_g5v0d10v5 ad=0.65 pd=3.3 as=0 ps=0 w=1 l=0.5
X3645 BLN8 rr3t3r_0[31|8]/a_860_290# sky130_fd_pr_reram__reram_cell area_ox=0.0676
X3646 rr3t3r_0[31|8]/a_60_290# WL31 SL8 VSS sky130_fd_pr__nfet_g5v0d10v5 ad=0.65 pd=3.3 as=0 ps=0 w=1 l=0.5
X3647 rr3t3r_0[31|8]/a_860_290# WL31 SL8 VSS sky130_fd_pr__nfet_g5v0d10v5 ad=0.65 pd=3.3 as=0 ps=0 w=1 l=0.5
X3648 BLP8 rr3t3r_0[32|8]/a_60_290# sky130_fd_pr_reram__reram_cell area_ox=0.0676
X3649 BLZ8 rr3t3r_0[32|8]/a_460_290# sky130_fd_pr_reram__reram_cell area_ox=0.0676
X3650 rr3t3r_0[32|8]/a_460_290# WL32 SL8 VSS sky130_fd_pr__nfet_g5v0d10v5 ad=0.65 pd=3.3 as=0 ps=0 w=1 l=0.5
X3651 BLN8 rr3t3r_0[32|8]/a_860_290# sky130_fd_pr_reram__reram_cell area_ox=0.0676
X3652 rr3t3r_0[32|8]/a_60_290# WL32 SL8 VSS sky130_fd_pr__nfet_g5v0d10v5 ad=0.65 pd=3.3 as=0 ps=0 w=1 l=0.5
X3653 rr3t3r_0[32|8]/a_860_290# WL32 SL8 VSS sky130_fd_pr__nfet_g5v0d10v5 ad=0.65 pd=3.3 as=0 ps=0 w=1 l=0.5
X3654 BLP8 rr3t3r_0[33|8]/a_60_290# sky130_fd_pr_reram__reram_cell area_ox=0.0676
X3655 BLZ8 rr3t3r_0[33|8]/a_460_290# sky130_fd_pr_reram__reram_cell area_ox=0.0676
X3656 rr3t3r_0[33|8]/a_460_290# WL33 SL8 VSS sky130_fd_pr__nfet_g5v0d10v5 ad=0.65 pd=3.3 as=0 ps=0 w=1 l=0.5
X3657 BLN8 rr3t3r_0[33|8]/a_860_290# sky130_fd_pr_reram__reram_cell area_ox=0.0676
X3658 rr3t3r_0[33|8]/a_60_290# WL33 SL8 VSS sky130_fd_pr__nfet_g5v0d10v5 ad=0.65 pd=3.3 as=0 ps=0 w=1 l=0.5
X3659 rr3t3r_0[33|8]/a_860_290# WL33 SL8 VSS sky130_fd_pr__nfet_g5v0d10v5 ad=0.65 pd=3.3 as=0 ps=0 w=1 l=0.5
X3660 BLP8 rr3t3r_0[34|8]/a_60_290# sky130_fd_pr_reram__reram_cell area_ox=0.0676
X3661 BLZ8 rr3t3r_0[34|8]/a_460_290# sky130_fd_pr_reram__reram_cell area_ox=0.0676
X3662 rr3t3r_0[34|8]/a_460_290# WL34 SL8 VSS sky130_fd_pr__nfet_g5v0d10v5 ad=0.65 pd=3.3 as=0 ps=0 w=1 l=0.5
X3663 BLN8 rr3t3r_0[34|8]/a_860_290# sky130_fd_pr_reram__reram_cell area_ox=0.0676
X3664 rr3t3r_0[34|8]/a_60_290# WL34 SL8 VSS sky130_fd_pr__nfet_g5v0d10v5 ad=0.65 pd=3.3 as=0 ps=0 w=1 l=0.5
X3665 rr3t3r_0[34|8]/a_860_290# WL34 SL8 VSS sky130_fd_pr__nfet_g5v0d10v5 ad=0.65 pd=3.3 as=0 ps=0 w=1 l=0.5
X3666 BLP8 rr3t3r_0[35|8]/a_60_290# sky130_fd_pr_reram__reram_cell area_ox=0.0676
X3667 BLZ8 rr3t3r_0[35|8]/a_460_290# sky130_fd_pr_reram__reram_cell area_ox=0.0676
X3668 rr3t3r_0[35|8]/a_460_290# WL35 SL8 VSS sky130_fd_pr__nfet_g5v0d10v5 ad=0.65 pd=3.3 as=0 ps=0 w=1 l=0.5
X3669 BLN8 rr3t3r_0[35|8]/a_860_290# sky130_fd_pr_reram__reram_cell area_ox=0.0676
X3670 rr3t3r_0[35|8]/a_60_290# WL35 SL8 VSS sky130_fd_pr__nfet_g5v0d10v5 ad=0.65 pd=3.3 as=0 ps=0 w=1 l=0.5
X3671 rr3t3r_0[35|8]/a_860_290# WL35 SL8 VSS sky130_fd_pr__nfet_g5v0d10v5 ad=0.65 pd=3.3 as=0 ps=0 w=1 l=0.5
X3672 BLP8 rr3t3r_0[36|8]/a_60_290# sky130_fd_pr_reram__reram_cell area_ox=0.0676
X3673 BLZ8 rr3t3r_0[36|8]/a_460_290# sky130_fd_pr_reram__reram_cell area_ox=0.0676
X3674 rr3t3r_0[36|8]/a_460_290# WL36 SL8 VSS sky130_fd_pr__nfet_g5v0d10v5 ad=0.65 pd=3.3 as=0 ps=0 w=1 l=0.5
X3675 BLN8 rr3t3r_0[36|8]/a_860_290# sky130_fd_pr_reram__reram_cell area_ox=0.0676
X3676 rr3t3r_0[36|8]/a_60_290# WL36 SL8 VSS sky130_fd_pr__nfet_g5v0d10v5 ad=0.65 pd=3.3 as=0 ps=0 w=1 l=0.5
X3677 rr3t3r_0[36|8]/a_860_290# WL36 SL8 VSS sky130_fd_pr__nfet_g5v0d10v5 ad=0.65 pd=3.3 as=0 ps=0 w=1 l=0.5
X3678 BLP8 rr3t3r_0[37|8]/a_60_290# sky130_fd_pr_reram__reram_cell area_ox=0.0676
X3679 BLZ8 rr3t3r_0[37|8]/a_460_290# sky130_fd_pr_reram__reram_cell area_ox=0.0676
X3680 rr3t3r_0[37|8]/a_460_290# WL37 SL8 VSS sky130_fd_pr__nfet_g5v0d10v5 ad=0.65 pd=3.3 as=0 ps=0 w=1 l=0.5
X3681 BLN8 rr3t3r_0[37|8]/a_860_290# sky130_fd_pr_reram__reram_cell area_ox=0.0676
X3682 rr3t3r_0[37|8]/a_60_290# WL37 SL8 VSS sky130_fd_pr__nfet_g5v0d10v5 ad=0.65 pd=3.3 as=0 ps=0 w=1 l=0.5
X3683 rr3t3r_0[37|8]/a_860_290# WL37 SL8 VSS sky130_fd_pr__nfet_g5v0d10v5 ad=0.65 pd=3.3 as=0 ps=0 w=1 l=0.5
X3684 BLP8 rr3t3r_0[38|8]/a_60_290# sky130_fd_pr_reram__reram_cell area_ox=0.0676
X3685 BLZ8 rr3t3r_0[38|8]/a_460_290# sky130_fd_pr_reram__reram_cell area_ox=0.0676
X3686 rr3t3r_0[38|8]/a_460_290# WL38 SL8 VSS sky130_fd_pr__nfet_g5v0d10v5 ad=0.65 pd=3.3 as=0 ps=0 w=1 l=0.5
X3687 BLN8 rr3t3r_0[38|8]/a_860_290# sky130_fd_pr_reram__reram_cell area_ox=0.0676
X3688 rr3t3r_0[38|8]/a_60_290# WL38 SL8 VSS sky130_fd_pr__nfet_g5v0d10v5 ad=0.65 pd=3.3 as=0 ps=0 w=1 l=0.5
X3689 rr3t3r_0[38|8]/a_860_290# WL38 SL8 VSS sky130_fd_pr__nfet_g5v0d10v5 ad=0.65 pd=3.3 as=0 ps=0 w=1 l=0.5
X3690 BLP8 rr3t3r_0[39|8]/a_60_290# sky130_fd_pr_reram__reram_cell area_ox=0.0676
X3691 BLZ8 rr3t3r_0[39|8]/a_460_290# sky130_fd_pr_reram__reram_cell area_ox=0.0676
X3692 rr3t3r_0[39|8]/a_460_290# WL39 SL8 VSS sky130_fd_pr__nfet_g5v0d10v5 ad=0.65 pd=3.3 as=0 ps=0 w=1 l=0.5
X3693 BLN8 rr3t3r_0[39|8]/a_860_290# sky130_fd_pr_reram__reram_cell area_ox=0.0676
X3694 rr3t3r_0[39|8]/a_60_290# WL39 SL8 VSS sky130_fd_pr__nfet_g5v0d10v5 ad=0.65 pd=3.3 as=0 ps=0 w=1 l=0.5
X3695 rr3t3r_0[39|8]/a_860_290# WL39 SL8 VSS sky130_fd_pr__nfet_g5v0d10v5 ad=0.65 pd=3.3 as=0 ps=0 w=1 l=0.5
X3696 BLP8 rr3t3r_0[40|8]/a_60_290# sky130_fd_pr_reram__reram_cell area_ox=0.0676
X3697 BLZ8 rr3t3r_0[40|8]/a_460_290# sky130_fd_pr_reram__reram_cell area_ox=0.0676
X3698 rr3t3r_0[40|8]/a_460_290# WL40 SL8 VSS sky130_fd_pr__nfet_g5v0d10v5 ad=0.65 pd=3.3 as=0 ps=0 w=1 l=0.5
X3699 BLN8 rr3t3r_0[40|8]/a_860_290# sky130_fd_pr_reram__reram_cell area_ox=0.0676
X3700 rr3t3r_0[40|8]/a_60_290# WL40 SL8 VSS sky130_fd_pr__nfet_g5v0d10v5 ad=0.65 pd=3.3 as=0 ps=0 w=1 l=0.5
X3701 rr3t3r_0[40|8]/a_860_290# WL40 SL8 VSS sky130_fd_pr__nfet_g5v0d10v5 ad=0.65 pd=3.3 as=0 ps=0 w=1 l=0.5
X3702 BLP8 rr3t3r_0[41|8]/a_60_290# sky130_fd_pr_reram__reram_cell area_ox=0.0676
X3703 BLZ8 rr3t3r_0[41|8]/a_460_290# sky130_fd_pr_reram__reram_cell area_ox=0.0676
X3704 rr3t3r_0[41|8]/a_460_290# WL41 SL8 VSS sky130_fd_pr__nfet_g5v0d10v5 ad=0.65 pd=3.3 as=0 ps=0 w=1 l=0.5
X3705 BLN8 rr3t3r_0[41|8]/a_860_290# sky130_fd_pr_reram__reram_cell area_ox=0.0676
X3706 rr3t3r_0[41|8]/a_60_290# WL41 SL8 VSS sky130_fd_pr__nfet_g5v0d10v5 ad=0.65 pd=3.3 as=0 ps=0 w=1 l=0.5
X3707 rr3t3r_0[41|8]/a_860_290# WL41 SL8 VSS sky130_fd_pr__nfet_g5v0d10v5 ad=0.65 pd=3.3 as=0 ps=0 w=1 l=0.5
X3708 BLP8 rr3t3r_0[42|8]/a_60_290# sky130_fd_pr_reram__reram_cell area_ox=0.0676
X3709 BLZ8 rr3t3r_0[42|8]/a_460_290# sky130_fd_pr_reram__reram_cell area_ox=0.0676
X3710 rr3t3r_0[42|8]/a_460_290# WL42 SL8 VSS sky130_fd_pr__nfet_g5v0d10v5 ad=0.65 pd=3.3 as=0 ps=0 w=1 l=0.5
X3711 BLN8 rr3t3r_0[42|8]/a_860_290# sky130_fd_pr_reram__reram_cell area_ox=0.0676
X3712 rr3t3r_0[42|8]/a_60_290# WL42 SL8 VSS sky130_fd_pr__nfet_g5v0d10v5 ad=0.65 pd=3.3 as=0 ps=0 w=1 l=0.5
X3713 rr3t3r_0[42|8]/a_860_290# WL42 SL8 VSS sky130_fd_pr__nfet_g5v0d10v5 ad=0.65 pd=3.3 as=0 ps=0 w=1 l=0.5
X3714 BLP8 rr3t3r_0[43|8]/a_60_290# sky130_fd_pr_reram__reram_cell area_ox=0.0676
X3715 BLZ8 rr3t3r_0[43|8]/a_460_290# sky130_fd_pr_reram__reram_cell area_ox=0.0676
X3716 rr3t3r_0[43|8]/a_460_290# WL43 SL8 VSS sky130_fd_pr__nfet_g5v0d10v5 ad=0.65 pd=3.3 as=0 ps=0 w=1 l=0.5
X3717 BLN8 rr3t3r_0[43|8]/a_860_290# sky130_fd_pr_reram__reram_cell area_ox=0.0676
X3718 rr3t3r_0[43|8]/a_60_290# WL43 SL8 VSS sky130_fd_pr__nfet_g5v0d10v5 ad=0.65 pd=3.3 as=0 ps=0 w=1 l=0.5
X3719 rr3t3r_0[43|8]/a_860_290# WL43 SL8 VSS sky130_fd_pr__nfet_g5v0d10v5 ad=0.65 pd=3.3 as=0 ps=0 w=1 l=0.5
X3720 BLP8 rr3t3r_0[44|8]/a_60_290# sky130_fd_pr_reram__reram_cell area_ox=0.0676
X3721 BLZ8 rr3t3r_0[44|8]/a_460_290# sky130_fd_pr_reram__reram_cell area_ox=0.0676
X3722 rr3t3r_0[44|8]/a_460_290# WL44 SL8 VSS sky130_fd_pr__nfet_g5v0d10v5 ad=0.65 pd=3.3 as=0 ps=0 w=1 l=0.5
X3723 BLN8 rr3t3r_0[44|8]/a_860_290# sky130_fd_pr_reram__reram_cell area_ox=0.0676
X3724 rr3t3r_0[44|8]/a_60_290# WL44 SL8 VSS sky130_fd_pr__nfet_g5v0d10v5 ad=0.65 pd=3.3 as=0 ps=0 w=1 l=0.5
X3725 rr3t3r_0[44|8]/a_860_290# WL44 SL8 VSS sky130_fd_pr__nfet_g5v0d10v5 ad=0.65 pd=3.3 as=0 ps=0 w=1 l=0.5
X3726 BLP8 rr3t3r_0[45|8]/a_60_290# sky130_fd_pr_reram__reram_cell area_ox=0.0676
X3727 BLZ8 rr3t3r_0[45|8]/a_460_290# sky130_fd_pr_reram__reram_cell area_ox=0.0676
X3728 rr3t3r_0[45|8]/a_460_290# WL45 SL8 VSS sky130_fd_pr__nfet_g5v0d10v5 ad=0.65 pd=3.3 as=0 ps=0 w=1 l=0.5
X3729 BLN8 rr3t3r_0[45|8]/a_860_290# sky130_fd_pr_reram__reram_cell area_ox=0.0676
X3730 rr3t3r_0[45|8]/a_60_290# WL45 SL8 VSS sky130_fd_pr__nfet_g5v0d10v5 ad=0.65 pd=3.3 as=0 ps=0 w=1 l=0.5
X3731 rr3t3r_0[45|8]/a_860_290# WL45 SL8 VSS sky130_fd_pr__nfet_g5v0d10v5 ad=0.65 pd=3.3 as=0 ps=0 w=1 l=0.5
X3732 BLP8 rr3t3r_0[46|8]/a_60_290# sky130_fd_pr_reram__reram_cell area_ox=0.0676
X3733 BLZ8 rr3t3r_0[46|8]/a_460_290# sky130_fd_pr_reram__reram_cell area_ox=0.0676
X3734 rr3t3r_0[46|8]/a_460_290# WL46 SL8 VSS sky130_fd_pr__nfet_g5v0d10v5 ad=0.65 pd=3.3 as=0 ps=0 w=1 l=0.5
X3735 BLN8 rr3t3r_0[46|8]/a_860_290# sky130_fd_pr_reram__reram_cell area_ox=0.0676
X3736 rr3t3r_0[46|8]/a_60_290# WL46 SL8 VSS sky130_fd_pr__nfet_g5v0d10v5 ad=0.65 pd=3.3 as=0 ps=0 w=1 l=0.5
X3737 rr3t3r_0[46|8]/a_860_290# WL46 SL8 VSS sky130_fd_pr__nfet_g5v0d10v5 ad=0.65 pd=3.3 as=0 ps=0 w=1 l=0.5
X3738 BLP8 rr3t3r_0[47|8]/a_60_290# sky130_fd_pr_reram__reram_cell area_ox=0.0676
X3739 BLZ8 rr3t3r_0[47|8]/a_460_290# sky130_fd_pr_reram__reram_cell area_ox=0.0676
X3740 rr3t3r_0[47|8]/a_460_290# WL47 SL8 VSS sky130_fd_pr__nfet_g5v0d10v5 ad=0.65 pd=3.3 as=0 ps=0 w=1 l=0.5
X3741 BLN8 rr3t3r_0[47|8]/a_860_290# sky130_fd_pr_reram__reram_cell area_ox=0.0676
X3742 rr3t3r_0[47|8]/a_60_290# WL47 SL8 VSS sky130_fd_pr__nfet_g5v0d10v5 ad=0.65 pd=3.3 as=0 ps=0 w=1 l=0.5
X3743 rr3t3r_0[47|8]/a_860_290# WL47 SL8 VSS sky130_fd_pr__nfet_g5v0d10v5 ad=0.65 pd=3.3 as=0 ps=0 w=1 l=0.5
X3744 BLP8 rr3t3r_0[48|8]/a_60_290# sky130_fd_pr_reram__reram_cell area_ox=0.0676
X3745 BLZ8 rr3t3r_0[48|8]/a_460_290# sky130_fd_pr_reram__reram_cell area_ox=0.0676
X3746 rr3t3r_0[48|8]/a_460_290# WL48 SL8 VSS sky130_fd_pr__nfet_g5v0d10v5 ad=0.65 pd=3.3 as=0 ps=0 w=1 l=0.5
X3747 BLN8 rr3t3r_0[48|8]/a_860_290# sky130_fd_pr_reram__reram_cell area_ox=0.0676
X3748 rr3t3r_0[48|8]/a_60_290# WL48 SL8 VSS sky130_fd_pr__nfet_g5v0d10v5 ad=0.65 pd=3.3 as=0 ps=0 w=1 l=0.5
X3749 rr3t3r_0[48|8]/a_860_290# WL48 SL8 VSS sky130_fd_pr__nfet_g5v0d10v5 ad=0.65 pd=3.3 as=0 ps=0 w=1 l=0.5
X3750 BLP8 rr3t3r_0[49|8]/a_60_290# sky130_fd_pr_reram__reram_cell area_ox=0.0676
X3751 BLZ8 rr3t3r_0[49|8]/a_460_290# sky130_fd_pr_reram__reram_cell area_ox=0.0676
X3752 rr3t3r_0[49|8]/a_460_290# WL49 SL8 VSS sky130_fd_pr__nfet_g5v0d10v5 ad=0.65 pd=3.3 as=0 ps=0 w=1 l=0.5
X3753 BLN8 rr3t3r_0[49|8]/a_860_290# sky130_fd_pr_reram__reram_cell area_ox=0.0676
X3754 rr3t3r_0[49|8]/a_60_290# WL49 SL8 VSS sky130_fd_pr__nfet_g5v0d10v5 ad=0.65 pd=3.3 as=0 ps=0 w=1 l=0.5
X3755 rr3t3r_0[49|8]/a_860_290# WL49 SL8 VSS sky130_fd_pr__nfet_g5v0d10v5 ad=0.65 pd=3.3 as=0 ps=0 w=1 l=0.5
X3756 BLP8 rr3t3r_0[50|8]/a_60_290# sky130_fd_pr_reram__reram_cell area_ox=0.0676
X3757 BLZ8 rr3t3r_0[50|8]/a_460_290# sky130_fd_pr_reram__reram_cell area_ox=0.0676
X3758 rr3t3r_0[50|8]/a_460_290# WL50 SL8 VSS sky130_fd_pr__nfet_g5v0d10v5 ad=0.65 pd=3.3 as=0 ps=0 w=1 l=0.5
X3759 BLN8 rr3t3r_0[50|8]/a_860_290# sky130_fd_pr_reram__reram_cell area_ox=0.0676
X3760 rr3t3r_0[50|8]/a_60_290# WL50 SL8 VSS sky130_fd_pr__nfet_g5v0d10v5 ad=0.65 pd=3.3 as=0 ps=0 w=1 l=0.5
X3761 rr3t3r_0[50|8]/a_860_290# WL50 SL8 VSS sky130_fd_pr__nfet_g5v0d10v5 ad=0.65 pd=3.3 as=0 ps=0 w=1 l=0.5
X3762 BLP8 rr3t3r_0[51|8]/a_60_290# sky130_fd_pr_reram__reram_cell area_ox=0.0676
X3763 BLZ8 rr3t3r_0[51|8]/a_460_290# sky130_fd_pr_reram__reram_cell area_ox=0.0676
X3764 rr3t3r_0[51|8]/a_460_290# WL51 SL8 VSS sky130_fd_pr__nfet_g5v0d10v5 ad=0.65 pd=3.3 as=0 ps=0 w=1 l=0.5
X3765 BLN8 rr3t3r_0[51|8]/a_860_290# sky130_fd_pr_reram__reram_cell area_ox=0.0676
X3766 rr3t3r_0[51|8]/a_60_290# WL51 SL8 VSS sky130_fd_pr__nfet_g5v0d10v5 ad=0.65 pd=3.3 as=0 ps=0 w=1 l=0.5
X3767 rr3t3r_0[51|8]/a_860_290# WL51 SL8 VSS sky130_fd_pr__nfet_g5v0d10v5 ad=0.65 pd=3.3 as=0 ps=0 w=1 l=0.5
X3768 BLP8 rr3t3r_0[52|8]/a_60_290# sky130_fd_pr_reram__reram_cell area_ox=0.0676
X3769 BLZ8 rr3t3r_0[52|8]/a_460_290# sky130_fd_pr_reram__reram_cell area_ox=0.0676
X3770 rr3t3r_0[52|8]/a_460_290# WL52 SL8 VSS sky130_fd_pr__nfet_g5v0d10v5 ad=0.65 pd=3.3 as=0 ps=0 w=1 l=0.5
X3771 BLN8 rr3t3r_0[52|8]/a_860_290# sky130_fd_pr_reram__reram_cell area_ox=0.0676
X3772 rr3t3r_0[52|8]/a_60_290# WL52 SL8 VSS sky130_fd_pr__nfet_g5v0d10v5 ad=0.65 pd=3.3 as=0 ps=0 w=1 l=0.5
X3773 rr3t3r_0[52|8]/a_860_290# WL52 SL8 VSS sky130_fd_pr__nfet_g5v0d10v5 ad=0.65 pd=3.3 as=0 ps=0 w=1 l=0.5
X3774 BLP8 rr3t3r_0[53|8]/a_60_290# sky130_fd_pr_reram__reram_cell area_ox=0.0676
X3775 BLZ8 rr3t3r_0[53|8]/a_460_290# sky130_fd_pr_reram__reram_cell area_ox=0.0676
X3776 rr3t3r_0[53|8]/a_460_290# WL53 SL8 VSS sky130_fd_pr__nfet_g5v0d10v5 ad=0.65 pd=3.3 as=0 ps=0 w=1 l=0.5
X3777 BLN8 rr3t3r_0[53|8]/a_860_290# sky130_fd_pr_reram__reram_cell area_ox=0.0676
X3778 rr3t3r_0[53|8]/a_60_290# WL53 SL8 VSS sky130_fd_pr__nfet_g5v0d10v5 ad=0.65 pd=3.3 as=0 ps=0 w=1 l=0.5
X3779 rr3t3r_0[53|8]/a_860_290# WL53 SL8 VSS sky130_fd_pr__nfet_g5v0d10v5 ad=0.65 pd=3.3 as=0 ps=0 w=1 l=0.5
X3780 BLP8 rr3t3r_0[54|8]/a_60_290# sky130_fd_pr_reram__reram_cell area_ox=0.0676
X3781 BLZ8 rr3t3r_0[54|8]/a_460_290# sky130_fd_pr_reram__reram_cell area_ox=0.0676
X3782 rr3t3r_0[54|8]/a_460_290# WL54 SL8 VSS sky130_fd_pr__nfet_g5v0d10v5 ad=0.65 pd=3.3 as=0 ps=0 w=1 l=0.5
X3783 BLN8 rr3t3r_0[54|8]/a_860_290# sky130_fd_pr_reram__reram_cell area_ox=0.0676
X3784 rr3t3r_0[54|8]/a_60_290# WL54 SL8 VSS sky130_fd_pr__nfet_g5v0d10v5 ad=0.65 pd=3.3 as=0 ps=0 w=1 l=0.5
X3785 rr3t3r_0[54|8]/a_860_290# WL54 SL8 VSS sky130_fd_pr__nfet_g5v0d10v5 ad=0.65 pd=3.3 as=0 ps=0 w=1 l=0.5
X3786 BLP8 rr3t3r_0[55|8]/a_60_290# sky130_fd_pr_reram__reram_cell area_ox=0.0676
X3787 BLZ8 rr3t3r_0[55|8]/a_460_290# sky130_fd_pr_reram__reram_cell area_ox=0.0676
X3788 rr3t3r_0[55|8]/a_460_290# WL55 SL8 VSS sky130_fd_pr__nfet_g5v0d10v5 ad=0.65 pd=3.3 as=0 ps=0 w=1 l=0.5
X3789 BLN8 rr3t3r_0[55|8]/a_860_290# sky130_fd_pr_reram__reram_cell area_ox=0.0676
X3790 rr3t3r_0[55|8]/a_60_290# WL55 SL8 VSS sky130_fd_pr__nfet_g5v0d10v5 ad=0.65 pd=3.3 as=0 ps=0 w=1 l=0.5
X3791 rr3t3r_0[55|8]/a_860_290# WL55 SL8 VSS sky130_fd_pr__nfet_g5v0d10v5 ad=0.65 pd=3.3 as=0 ps=0 w=1 l=0.5
X3792 BLP8 rr3t3r_0[56|8]/a_60_290# sky130_fd_pr_reram__reram_cell area_ox=0.0676
X3793 BLZ8 rr3t3r_0[56|8]/a_460_290# sky130_fd_pr_reram__reram_cell area_ox=0.0676
X3794 rr3t3r_0[56|8]/a_460_290# WL56 SL8 VSS sky130_fd_pr__nfet_g5v0d10v5 ad=0.65 pd=3.3 as=0 ps=0 w=1 l=0.5
X3795 BLN8 rr3t3r_0[56|8]/a_860_290# sky130_fd_pr_reram__reram_cell area_ox=0.0676
X3796 rr3t3r_0[56|8]/a_60_290# WL56 SL8 VSS sky130_fd_pr__nfet_g5v0d10v5 ad=0.65 pd=3.3 as=0 ps=0 w=1 l=0.5
X3797 rr3t3r_0[56|8]/a_860_290# WL56 SL8 VSS sky130_fd_pr__nfet_g5v0d10v5 ad=0.65 pd=3.3 as=0 ps=0 w=1 l=0.5
X3798 BLP8 rr3t3r_0[57|8]/a_60_290# sky130_fd_pr_reram__reram_cell area_ox=0.0676
X3799 BLZ8 rr3t3r_0[57|8]/a_460_290# sky130_fd_pr_reram__reram_cell area_ox=0.0676
X3800 rr3t3r_0[57|8]/a_460_290# WL57 SL8 VSS sky130_fd_pr__nfet_g5v0d10v5 ad=0.65 pd=3.3 as=0 ps=0 w=1 l=0.5
X3801 BLN8 rr3t3r_0[57|8]/a_860_290# sky130_fd_pr_reram__reram_cell area_ox=0.0676
X3802 rr3t3r_0[57|8]/a_60_290# WL57 SL8 VSS sky130_fd_pr__nfet_g5v0d10v5 ad=0.65 pd=3.3 as=0 ps=0 w=1 l=0.5
X3803 rr3t3r_0[57|8]/a_860_290# WL57 SL8 VSS sky130_fd_pr__nfet_g5v0d10v5 ad=0.65 pd=3.3 as=0 ps=0 w=1 l=0.5
X3804 BLP8 rr3t3r_0[58|8]/a_60_290# sky130_fd_pr_reram__reram_cell area_ox=0.0676
X3805 BLZ8 rr3t3r_0[58|8]/a_460_290# sky130_fd_pr_reram__reram_cell area_ox=0.0676
X3806 rr3t3r_0[58|8]/a_460_290# WL58 SL8 VSS sky130_fd_pr__nfet_g5v0d10v5 ad=0.65 pd=3.3 as=0 ps=0 w=1 l=0.5
X3807 BLN8 rr3t3r_0[58|8]/a_860_290# sky130_fd_pr_reram__reram_cell area_ox=0.0676
X3808 rr3t3r_0[58|8]/a_60_290# WL58 SL8 VSS sky130_fd_pr__nfet_g5v0d10v5 ad=0.65 pd=3.3 as=0 ps=0 w=1 l=0.5
X3809 rr3t3r_0[58|8]/a_860_290# WL58 SL8 VSS sky130_fd_pr__nfet_g5v0d10v5 ad=0.65 pd=3.3 as=0 ps=0 w=1 l=0.5
X3810 BLP8 rr3t3r_0[59|8]/a_60_290# sky130_fd_pr_reram__reram_cell area_ox=0.0676
X3811 BLZ8 rr3t3r_0[59|8]/a_460_290# sky130_fd_pr_reram__reram_cell area_ox=0.0676
X3812 rr3t3r_0[59|8]/a_460_290# WL59 SL8 VSS sky130_fd_pr__nfet_g5v0d10v5 ad=0.65 pd=3.3 as=0 ps=0 w=1 l=0.5
X3813 BLN8 rr3t3r_0[59|8]/a_860_290# sky130_fd_pr_reram__reram_cell area_ox=0.0676
X3814 rr3t3r_0[59|8]/a_60_290# WL59 SL8 VSS sky130_fd_pr__nfet_g5v0d10v5 ad=0.65 pd=3.3 as=0 ps=0 w=1 l=0.5
X3815 rr3t3r_0[59|8]/a_860_290# WL59 SL8 VSS sky130_fd_pr__nfet_g5v0d10v5 ad=0.65 pd=3.3 as=0 ps=0 w=1 l=0.5
X3816 BLP8 rr3t3r_0[60|8]/a_60_290# sky130_fd_pr_reram__reram_cell area_ox=0.0676
X3817 BLZ8 rr3t3r_0[60|8]/a_460_290# sky130_fd_pr_reram__reram_cell area_ox=0.0676
X3818 rr3t3r_0[60|8]/a_460_290# WL60 SL8 VSS sky130_fd_pr__nfet_g5v0d10v5 ad=0.65 pd=3.3 as=0 ps=0 w=1 l=0.5
X3819 BLN8 rr3t3r_0[60|8]/a_860_290# sky130_fd_pr_reram__reram_cell area_ox=0.0676
X3820 rr3t3r_0[60|8]/a_60_290# WL60 SL8 VSS sky130_fd_pr__nfet_g5v0d10v5 ad=0.65 pd=3.3 as=0 ps=0 w=1 l=0.5
X3821 rr3t3r_0[60|8]/a_860_290# WL60 SL8 VSS sky130_fd_pr__nfet_g5v0d10v5 ad=0.65 pd=3.3 as=0 ps=0 w=1 l=0.5
X3822 BLP8 rr3t3r_0[61|8]/a_60_290# sky130_fd_pr_reram__reram_cell area_ox=0.0676
X3823 BLZ8 rr3t3r_0[61|8]/a_460_290# sky130_fd_pr_reram__reram_cell area_ox=0.0676
X3824 rr3t3r_0[61|8]/a_460_290# WL61 SL8 VSS sky130_fd_pr__nfet_g5v0d10v5 ad=0.65 pd=3.3 as=0 ps=0 w=1 l=0.5
X3825 BLN8 rr3t3r_0[61|8]/a_860_290# sky130_fd_pr_reram__reram_cell area_ox=0.0676
X3826 rr3t3r_0[61|8]/a_60_290# WL61 SL8 VSS sky130_fd_pr__nfet_g5v0d10v5 ad=0.65 pd=3.3 as=0 ps=0 w=1 l=0.5
X3827 rr3t3r_0[61|8]/a_860_290# WL61 SL8 VSS sky130_fd_pr__nfet_g5v0d10v5 ad=0.65 pd=3.3 as=0 ps=0 w=1 l=0.5
X3828 BLP8 rr3t3r_0[62|8]/a_60_290# sky130_fd_pr_reram__reram_cell area_ox=0.0676
X3829 BLZ8 rr3t3r_0[62|8]/a_460_290# sky130_fd_pr_reram__reram_cell area_ox=0.0676
X3830 rr3t3r_0[62|8]/a_460_290# WL62 SL8 VSS sky130_fd_pr__nfet_g5v0d10v5 ad=0.65 pd=3.3 as=0 ps=0 w=1 l=0.5
X3831 BLN8 rr3t3r_0[62|8]/a_860_290# sky130_fd_pr_reram__reram_cell area_ox=0.0676
X3832 rr3t3r_0[62|8]/a_60_290# WL62 SL8 VSS sky130_fd_pr__nfet_g5v0d10v5 ad=0.65 pd=3.3 as=0 ps=0 w=1 l=0.5
X3833 rr3t3r_0[62|8]/a_860_290# WL62 SL8 VSS sky130_fd_pr__nfet_g5v0d10v5 ad=0.65 pd=3.3 as=0 ps=0 w=1 l=0.5
X3834 BLP8 rr3t3r_0[63|8]/a_60_290# sky130_fd_pr_reram__reram_cell area_ox=0.0676
X3835 BLZ8 rr3t3r_0[63|8]/a_460_290# sky130_fd_pr_reram__reram_cell area_ox=0.0676
X3836 rr3t3r_0[63|8]/a_460_290# WL63 SL8 VSS sky130_fd_pr__nfet_g5v0d10v5 ad=0.65 pd=3.3 as=0 ps=0 w=1 l=0.5
X3837 BLN8 rr3t3r_0[63|8]/a_860_290# sky130_fd_pr_reram__reram_cell area_ox=0.0676
X3838 rr3t3r_0[63|8]/a_60_290# WL63 SL8 VSS sky130_fd_pr__nfet_g5v0d10v5 ad=0.65 pd=3.3 as=0 ps=0 w=1 l=0.5
X3839 rr3t3r_0[63|8]/a_860_290# WL63 SL8 VSS sky130_fd_pr__nfet_g5v0d10v5 ad=0.65 pd=3.3 as=0 ps=0 w=1 l=0.5
X3840 BLP8 rr3t3r_0[64|8]/a_60_290# sky130_fd_pr_reram__reram_cell area_ox=0.0676
X3841 BLZ8 rr3t3r_0[64|8]/a_460_290# sky130_fd_pr_reram__reram_cell area_ox=0.0676
X3842 rr3t3r_0[64|8]/a_460_290# WL64 SL8 VSS sky130_fd_pr__nfet_g5v0d10v5 ad=0.65 pd=3.3 as=0 ps=0 w=1 l=0.5
X3843 BLN8 rr3t3r_0[64|8]/a_860_290# sky130_fd_pr_reram__reram_cell area_ox=0.0676
X3844 rr3t3r_0[64|8]/a_60_290# WL64 SL8 VSS sky130_fd_pr__nfet_g5v0d10v5 ad=0.65 pd=3.3 as=0 ps=0 w=1 l=0.5
X3845 rr3t3r_0[64|8]/a_860_290# WL64 SL8 VSS sky130_fd_pr__nfet_g5v0d10v5 ad=0.65 pd=3.3 as=0 ps=0 w=1 l=0.5
X3846 BLP8 rr3t3r_0[65|8]/a_60_290# sky130_fd_pr_reram__reram_cell area_ox=0.0676
X3847 BLZ8 rr3t3r_0[65|8]/a_460_290# sky130_fd_pr_reram__reram_cell area_ox=0.0676
X3848 rr3t3r_0[65|8]/a_460_290# WL65 SL8 VSS sky130_fd_pr__nfet_g5v0d10v5 ad=0.65 pd=3.3 as=0 ps=0 w=1 l=0.5
X3849 BLN8 rr3t3r_0[65|8]/a_860_290# sky130_fd_pr_reram__reram_cell area_ox=0.0676
X3850 rr3t3r_0[65|8]/a_60_290# WL65 SL8 VSS sky130_fd_pr__nfet_g5v0d10v5 ad=0.65 pd=3.3 as=0 ps=0 w=1 l=0.5
X3851 rr3t3r_0[65|8]/a_860_290# WL65 SL8 VSS sky130_fd_pr__nfet_g5v0d10v5 ad=0.65 pd=3.3 as=0 ps=0 w=1 l=0.5
X3852 BLP8 rr3t3r_0[66|8]/a_60_290# sky130_fd_pr_reram__reram_cell area_ox=0.0676
X3853 BLZ8 rr3t3r_0[66|8]/a_460_290# sky130_fd_pr_reram__reram_cell area_ox=0.0676
X3854 rr3t3r_0[66|8]/a_460_290# WL66 SL8 VSS sky130_fd_pr__nfet_g5v0d10v5 ad=0.65 pd=3.3 as=0 ps=0 w=1 l=0.5
X3855 BLN8 rr3t3r_0[66|8]/a_860_290# sky130_fd_pr_reram__reram_cell area_ox=0.0676
X3856 rr3t3r_0[66|8]/a_60_290# WL66 SL8 VSS sky130_fd_pr__nfet_g5v0d10v5 ad=0.65 pd=3.3 as=0 ps=0 w=1 l=0.5
X3857 rr3t3r_0[66|8]/a_860_290# WL66 SL8 VSS sky130_fd_pr__nfet_g5v0d10v5 ad=0.65 pd=3.3 as=0 ps=0 w=1 l=0.5
X3858 BLP8 rr3t3r_0[67|8]/a_60_290# sky130_fd_pr_reram__reram_cell area_ox=0.0676
X3859 BLZ8 rr3t3r_0[67|8]/a_460_290# sky130_fd_pr_reram__reram_cell area_ox=0.0676
X3860 rr3t3r_0[67|8]/a_460_290# WL67 SL8 VSS sky130_fd_pr__nfet_g5v0d10v5 ad=0.65 pd=3.3 as=0 ps=0 w=1 l=0.5
X3861 BLN8 rr3t3r_0[67|8]/a_860_290# sky130_fd_pr_reram__reram_cell area_ox=0.0676
X3862 rr3t3r_0[67|8]/a_60_290# WL67 SL8 VSS sky130_fd_pr__nfet_g5v0d10v5 ad=0.65 pd=3.3 as=0 ps=0 w=1 l=0.5
X3863 rr3t3r_0[67|8]/a_860_290# WL67 SL8 VSS sky130_fd_pr__nfet_g5v0d10v5 ad=0.65 pd=3.3 as=0 ps=0 w=1 l=0.5
X3864 BLP8 rr3t3r_0[68|8]/a_60_290# sky130_fd_pr_reram__reram_cell area_ox=0.0676
X3865 BLZ8 rr3t3r_0[68|8]/a_460_290# sky130_fd_pr_reram__reram_cell area_ox=0.0676
X3866 rr3t3r_0[68|8]/a_460_290# WL68 SL8 VSS sky130_fd_pr__nfet_g5v0d10v5 ad=0.65 pd=3.3 as=0 ps=0 w=1 l=0.5
X3867 BLN8 rr3t3r_0[68|8]/a_860_290# sky130_fd_pr_reram__reram_cell area_ox=0.0676
X3868 rr3t3r_0[68|8]/a_60_290# WL68 SL8 VSS sky130_fd_pr__nfet_g5v0d10v5 ad=0.65 pd=3.3 as=0 ps=0 w=1 l=0.5
X3869 rr3t3r_0[68|8]/a_860_290# WL68 SL8 VSS sky130_fd_pr__nfet_g5v0d10v5 ad=0.65 pd=3.3 as=0 ps=0 w=1 l=0.5
X3870 BLP8 rr3t3r_0[69|8]/a_60_290# sky130_fd_pr_reram__reram_cell area_ox=0.0676
X3871 BLZ8 rr3t3r_0[69|8]/a_460_290# sky130_fd_pr_reram__reram_cell area_ox=0.0676
X3872 rr3t3r_0[69|8]/a_460_290# WL69 SL8 VSS sky130_fd_pr__nfet_g5v0d10v5 ad=0.65 pd=3.3 as=0 ps=0 w=1 l=0.5
X3873 BLN8 rr3t3r_0[69|8]/a_860_290# sky130_fd_pr_reram__reram_cell area_ox=0.0676
X3874 rr3t3r_0[69|8]/a_60_290# WL69 SL8 VSS sky130_fd_pr__nfet_g5v0d10v5 ad=0.65 pd=3.3 as=0 ps=0 w=1 l=0.5
X3875 rr3t3r_0[69|8]/a_860_290# WL69 SL8 VSS sky130_fd_pr__nfet_g5v0d10v5 ad=0.65 pd=3.3 as=0 ps=0 w=1 l=0.5
X3876 BLP8 rr3t3r_0[70|8]/a_60_290# sky130_fd_pr_reram__reram_cell area_ox=0.0676
X3877 BLZ8 rr3t3r_0[70|8]/a_460_290# sky130_fd_pr_reram__reram_cell area_ox=0.0676
X3878 rr3t3r_0[70|8]/a_460_290# WL70 SL8 VSS sky130_fd_pr__nfet_g5v0d10v5 ad=0.65 pd=3.3 as=0 ps=0 w=1 l=0.5
X3879 BLN8 rr3t3r_0[70|8]/a_860_290# sky130_fd_pr_reram__reram_cell area_ox=0.0676
X3880 rr3t3r_0[70|8]/a_60_290# WL70 SL8 VSS sky130_fd_pr__nfet_g5v0d10v5 ad=0.65 pd=3.3 as=0 ps=0 w=1 l=0.5
X3881 rr3t3r_0[70|8]/a_860_290# WL70 SL8 VSS sky130_fd_pr__nfet_g5v0d10v5 ad=0.65 pd=3.3 as=0 ps=0 w=1 l=0.5
X3882 BLP8 rr3t3r_0[71|8]/a_60_290# sky130_fd_pr_reram__reram_cell area_ox=0.0676
X3883 BLZ8 rr3t3r_0[71|8]/a_460_290# sky130_fd_pr_reram__reram_cell area_ox=0.0676
X3884 rr3t3r_0[71|8]/a_460_290# WL71 SL8 VSS sky130_fd_pr__nfet_g5v0d10v5 ad=0.65 pd=3.3 as=0 ps=0 w=1 l=0.5
X3885 BLN8 rr3t3r_0[71|8]/a_860_290# sky130_fd_pr_reram__reram_cell area_ox=0.0676
X3886 rr3t3r_0[71|8]/a_60_290# WL71 SL8 VSS sky130_fd_pr__nfet_g5v0d10v5 ad=0.65 pd=3.3 as=0 ps=0 w=1 l=0.5
X3887 rr3t3r_0[71|8]/a_860_290# WL71 SL8 VSS sky130_fd_pr__nfet_g5v0d10v5 ad=0.65 pd=3.3 as=0 ps=0 w=1 l=0.5
X3888 BLP9 rr3t3r_0[0|9]/a_60_290# sky130_fd_pr_reram__reram_cell area_ox=0.0676
X3889 BLZ9 rr3t3r_0[0|9]/a_460_290# sky130_fd_pr_reram__reram_cell area_ox=0.0676
X3890 rr3t3r_0[0|9]/a_460_290# WL0 SL9 VSS sky130_fd_pr__nfet_g5v0d10v5 ad=0.65 pd=3.3 as=162 ps=756 w=1 l=0.5
X3891 BLN9 rr3t3r_0[0|9]/a_860_290# sky130_fd_pr_reram__reram_cell area_ox=0.0676
X3892 rr3t3r_0[0|9]/a_60_290# WL0 SL9 VSS sky130_fd_pr__nfet_g5v0d10v5 ad=0.65 pd=3.3 as=0 ps=0 w=1 l=0.5
X3893 rr3t3r_0[0|9]/a_860_290# WL0 SL9 VSS sky130_fd_pr__nfet_g5v0d10v5 ad=0.65 pd=3.3 as=0 ps=0 w=1 l=0.5
X3894 BLP9 rr3t3r_0[1|9]/a_60_290# sky130_fd_pr_reram__reram_cell area_ox=0.0676
X3895 BLZ9 rr3t3r_0[1|9]/a_460_290# sky130_fd_pr_reram__reram_cell area_ox=0.0676
X3896 rr3t3r_0[1|9]/a_460_290# WL1 SL9 VSS sky130_fd_pr__nfet_g5v0d10v5 ad=0.65 pd=3.3 as=0 ps=0 w=1 l=0.5
X3897 BLN9 rr3t3r_0[1|9]/a_860_290# sky130_fd_pr_reram__reram_cell area_ox=0.0676
X3898 rr3t3r_0[1|9]/a_60_290# WL1 SL9 VSS sky130_fd_pr__nfet_g5v0d10v5 ad=0.65 pd=3.3 as=0 ps=0 w=1 l=0.5
X3899 rr3t3r_0[1|9]/a_860_290# WL1 SL9 VSS sky130_fd_pr__nfet_g5v0d10v5 ad=0.65 pd=3.3 as=0 ps=0 w=1 l=0.5
X3900 BLP9 rr3t3r_0[2|9]/a_60_290# sky130_fd_pr_reram__reram_cell area_ox=0.0676
X3901 BLZ9 rr3t3r_0[2|9]/a_460_290# sky130_fd_pr_reram__reram_cell area_ox=0.0676
X3902 rr3t3r_0[2|9]/a_460_290# WL2 SL9 VSS sky130_fd_pr__nfet_g5v0d10v5 ad=0.65 pd=3.3 as=0 ps=0 w=1 l=0.5
X3903 BLN9 rr3t3r_0[2|9]/a_860_290# sky130_fd_pr_reram__reram_cell area_ox=0.0676
X3904 rr3t3r_0[2|9]/a_60_290# WL2 SL9 VSS sky130_fd_pr__nfet_g5v0d10v5 ad=0.65 pd=3.3 as=0 ps=0 w=1 l=0.5
X3905 rr3t3r_0[2|9]/a_860_290# WL2 SL9 VSS sky130_fd_pr__nfet_g5v0d10v5 ad=0.65 pd=3.3 as=0 ps=0 w=1 l=0.5
X3906 BLP9 rr3t3r_0[3|9]/a_60_290# sky130_fd_pr_reram__reram_cell area_ox=0.0676
X3907 BLZ9 rr3t3r_0[3|9]/a_460_290# sky130_fd_pr_reram__reram_cell area_ox=0.0676
X3908 rr3t3r_0[3|9]/a_460_290# WL3 SL9 VSS sky130_fd_pr__nfet_g5v0d10v5 ad=0.65 pd=3.3 as=0 ps=0 w=1 l=0.5
X3909 BLN9 rr3t3r_0[3|9]/a_860_290# sky130_fd_pr_reram__reram_cell area_ox=0.0676
X3910 rr3t3r_0[3|9]/a_60_290# WL3 SL9 VSS sky130_fd_pr__nfet_g5v0d10v5 ad=0.65 pd=3.3 as=0 ps=0 w=1 l=0.5
X3911 rr3t3r_0[3|9]/a_860_290# WL3 SL9 VSS sky130_fd_pr__nfet_g5v0d10v5 ad=0.65 pd=3.3 as=0 ps=0 w=1 l=0.5
X3912 BLP9 rr3t3r_0[4|9]/a_60_290# sky130_fd_pr_reram__reram_cell area_ox=0.0676
X3913 BLZ9 rr3t3r_0[4|9]/a_460_290# sky130_fd_pr_reram__reram_cell area_ox=0.0676
X3914 rr3t3r_0[4|9]/a_460_290# WL4 SL9 VSS sky130_fd_pr__nfet_g5v0d10v5 ad=0.65 pd=3.3 as=0 ps=0 w=1 l=0.5
X3915 BLN9 rr3t3r_0[4|9]/a_860_290# sky130_fd_pr_reram__reram_cell area_ox=0.0676
X3916 rr3t3r_0[4|9]/a_60_290# WL4 SL9 VSS sky130_fd_pr__nfet_g5v0d10v5 ad=0.65 pd=3.3 as=0 ps=0 w=1 l=0.5
X3917 rr3t3r_0[4|9]/a_860_290# WL4 SL9 VSS sky130_fd_pr__nfet_g5v0d10v5 ad=0.65 pd=3.3 as=0 ps=0 w=1 l=0.5
X3918 BLP9 rr3t3r_0[5|9]/a_60_290# sky130_fd_pr_reram__reram_cell area_ox=0.0676
X3919 BLZ9 rr3t3r_0[5|9]/a_460_290# sky130_fd_pr_reram__reram_cell area_ox=0.0676
X3920 rr3t3r_0[5|9]/a_460_290# WL5 SL9 VSS sky130_fd_pr__nfet_g5v0d10v5 ad=0.65 pd=3.3 as=0 ps=0 w=1 l=0.5
X3921 BLN9 rr3t3r_0[5|9]/a_860_290# sky130_fd_pr_reram__reram_cell area_ox=0.0676
X3922 rr3t3r_0[5|9]/a_60_290# WL5 SL9 VSS sky130_fd_pr__nfet_g5v0d10v5 ad=0.65 pd=3.3 as=0 ps=0 w=1 l=0.5
X3923 rr3t3r_0[5|9]/a_860_290# WL5 SL9 VSS sky130_fd_pr__nfet_g5v0d10v5 ad=0.65 pd=3.3 as=0 ps=0 w=1 l=0.5
X3924 BLP9 rr3t3r_0[6|9]/a_60_290# sky130_fd_pr_reram__reram_cell area_ox=0.0676
X3925 BLZ9 rr3t3r_0[6|9]/a_460_290# sky130_fd_pr_reram__reram_cell area_ox=0.0676
X3926 rr3t3r_0[6|9]/a_460_290# WL6 SL9 VSS sky130_fd_pr__nfet_g5v0d10v5 ad=0.65 pd=3.3 as=0 ps=0 w=1 l=0.5
X3927 BLN9 rr3t3r_0[6|9]/a_860_290# sky130_fd_pr_reram__reram_cell area_ox=0.0676
X3928 rr3t3r_0[6|9]/a_60_290# WL6 SL9 VSS sky130_fd_pr__nfet_g5v0d10v5 ad=0.65 pd=3.3 as=0 ps=0 w=1 l=0.5
X3929 rr3t3r_0[6|9]/a_860_290# WL6 SL9 VSS sky130_fd_pr__nfet_g5v0d10v5 ad=0.65 pd=3.3 as=0 ps=0 w=1 l=0.5
X3930 BLP9 rr3t3r_0[7|9]/a_60_290# sky130_fd_pr_reram__reram_cell area_ox=0.0676
X3931 BLZ9 rr3t3r_0[7|9]/a_460_290# sky130_fd_pr_reram__reram_cell area_ox=0.0676
X3932 rr3t3r_0[7|9]/a_460_290# WL7 SL9 VSS sky130_fd_pr__nfet_g5v0d10v5 ad=0.65 pd=3.3 as=0 ps=0 w=1 l=0.5
X3933 BLN9 rr3t3r_0[7|9]/a_860_290# sky130_fd_pr_reram__reram_cell area_ox=0.0676
X3934 rr3t3r_0[7|9]/a_60_290# WL7 SL9 VSS sky130_fd_pr__nfet_g5v0d10v5 ad=0.65 pd=3.3 as=0 ps=0 w=1 l=0.5
X3935 rr3t3r_0[7|9]/a_860_290# WL7 SL9 VSS sky130_fd_pr__nfet_g5v0d10v5 ad=0.65 pd=3.3 as=0 ps=0 w=1 l=0.5
X3936 BLP9 rr3t3r_0[8|9]/a_60_290# sky130_fd_pr_reram__reram_cell area_ox=0.0676
X3937 BLZ9 rr3t3r_0[8|9]/a_460_290# sky130_fd_pr_reram__reram_cell area_ox=0.0676
X3938 rr3t3r_0[8|9]/a_460_290# WL8 SL9 VSS sky130_fd_pr__nfet_g5v0d10v5 ad=0.65 pd=3.3 as=0 ps=0 w=1 l=0.5
X3939 BLN9 rr3t3r_0[8|9]/a_860_290# sky130_fd_pr_reram__reram_cell area_ox=0.0676
X3940 rr3t3r_0[8|9]/a_60_290# WL8 SL9 VSS sky130_fd_pr__nfet_g5v0d10v5 ad=0.65 pd=3.3 as=0 ps=0 w=1 l=0.5
X3941 rr3t3r_0[8|9]/a_860_290# WL8 SL9 VSS sky130_fd_pr__nfet_g5v0d10v5 ad=0.65 pd=3.3 as=0 ps=0 w=1 l=0.5
X3942 BLP9 rr3t3r_0[9|9]/a_60_290# sky130_fd_pr_reram__reram_cell area_ox=0.0676
X3943 BLZ9 rr3t3r_0[9|9]/a_460_290# sky130_fd_pr_reram__reram_cell area_ox=0.0676
X3944 rr3t3r_0[9|9]/a_460_290# WL9 SL9 VSS sky130_fd_pr__nfet_g5v0d10v5 ad=0.65 pd=3.3 as=0 ps=0 w=1 l=0.5
X3945 BLN9 rr3t3r_0[9|9]/a_860_290# sky130_fd_pr_reram__reram_cell area_ox=0.0676
X3946 rr3t3r_0[9|9]/a_60_290# WL9 SL9 VSS sky130_fd_pr__nfet_g5v0d10v5 ad=0.65 pd=3.3 as=0 ps=0 w=1 l=0.5
X3947 rr3t3r_0[9|9]/a_860_290# WL9 SL9 VSS sky130_fd_pr__nfet_g5v0d10v5 ad=0.65 pd=3.3 as=0 ps=0 w=1 l=0.5
X3948 BLP9 rr3t3r_0[10|9]/a_60_290# sky130_fd_pr_reram__reram_cell area_ox=0.0676
X3949 BLZ9 rr3t3r_0[10|9]/a_460_290# sky130_fd_pr_reram__reram_cell area_ox=0.0676
X3950 rr3t3r_0[10|9]/a_460_290# WL10 SL9 VSS sky130_fd_pr__nfet_g5v0d10v5 ad=0.65 pd=3.3 as=0 ps=0 w=1 l=0.5
X3951 BLN9 rr3t3r_0[10|9]/a_860_290# sky130_fd_pr_reram__reram_cell area_ox=0.0676
X3952 rr3t3r_0[10|9]/a_60_290# WL10 SL9 VSS sky130_fd_pr__nfet_g5v0d10v5 ad=0.65 pd=3.3 as=0 ps=0 w=1 l=0.5
X3953 rr3t3r_0[10|9]/a_860_290# WL10 SL9 VSS sky130_fd_pr__nfet_g5v0d10v5 ad=0.65 pd=3.3 as=0 ps=0 w=1 l=0.5
X3954 BLP9 rr3t3r_0[11|9]/a_60_290# sky130_fd_pr_reram__reram_cell area_ox=0.0676
X3955 BLZ9 rr3t3r_0[11|9]/a_460_290# sky130_fd_pr_reram__reram_cell area_ox=0.0676
X3956 rr3t3r_0[11|9]/a_460_290# WL11 SL9 VSS sky130_fd_pr__nfet_g5v0d10v5 ad=0.65 pd=3.3 as=0 ps=0 w=1 l=0.5
X3957 BLN9 rr3t3r_0[11|9]/a_860_290# sky130_fd_pr_reram__reram_cell area_ox=0.0676
X3958 rr3t3r_0[11|9]/a_60_290# WL11 SL9 VSS sky130_fd_pr__nfet_g5v0d10v5 ad=0.65 pd=3.3 as=0 ps=0 w=1 l=0.5
X3959 rr3t3r_0[11|9]/a_860_290# WL11 SL9 VSS sky130_fd_pr__nfet_g5v0d10v5 ad=0.65 pd=3.3 as=0 ps=0 w=1 l=0.5
X3960 BLP9 rr3t3r_0[12|9]/a_60_290# sky130_fd_pr_reram__reram_cell area_ox=0.0676
X3961 BLZ9 rr3t3r_0[12|9]/a_460_290# sky130_fd_pr_reram__reram_cell area_ox=0.0676
X3962 rr3t3r_0[12|9]/a_460_290# WL12 SL9 VSS sky130_fd_pr__nfet_g5v0d10v5 ad=0.65 pd=3.3 as=0 ps=0 w=1 l=0.5
X3963 BLN9 rr3t3r_0[12|9]/a_860_290# sky130_fd_pr_reram__reram_cell area_ox=0.0676
X3964 rr3t3r_0[12|9]/a_60_290# WL12 SL9 VSS sky130_fd_pr__nfet_g5v0d10v5 ad=0.65 pd=3.3 as=0 ps=0 w=1 l=0.5
X3965 rr3t3r_0[12|9]/a_860_290# WL12 SL9 VSS sky130_fd_pr__nfet_g5v0d10v5 ad=0.65 pd=3.3 as=0 ps=0 w=1 l=0.5
X3966 BLP9 rr3t3r_0[13|9]/a_60_290# sky130_fd_pr_reram__reram_cell area_ox=0.0676
X3967 BLZ9 rr3t3r_0[13|9]/a_460_290# sky130_fd_pr_reram__reram_cell area_ox=0.0676
X3968 rr3t3r_0[13|9]/a_460_290# WL13 SL9 VSS sky130_fd_pr__nfet_g5v0d10v5 ad=0.65 pd=3.3 as=0 ps=0 w=1 l=0.5
X3969 BLN9 rr3t3r_0[13|9]/a_860_290# sky130_fd_pr_reram__reram_cell area_ox=0.0676
X3970 rr3t3r_0[13|9]/a_60_290# WL13 SL9 VSS sky130_fd_pr__nfet_g5v0d10v5 ad=0.65 pd=3.3 as=0 ps=0 w=1 l=0.5
X3971 rr3t3r_0[13|9]/a_860_290# WL13 SL9 VSS sky130_fd_pr__nfet_g5v0d10v5 ad=0.65 pd=3.3 as=0 ps=0 w=1 l=0.5
X3972 BLP9 rr3t3r_0[14|9]/a_60_290# sky130_fd_pr_reram__reram_cell area_ox=0.0676
X3973 BLZ9 rr3t3r_0[14|9]/a_460_290# sky130_fd_pr_reram__reram_cell area_ox=0.0676
X3974 rr3t3r_0[14|9]/a_460_290# WL14 SL9 VSS sky130_fd_pr__nfet_g5v0d10v5 ad=0.65 pd=3.3 as=0 ps=0 w=1 l=0.5
X3975 BLN9 rr3t3r_0[14|9]/a_860_290# sky130_fd_pr_reram__reram_cell area_ox=0.0676
X3976 rr3t3r_0[14|9]/a_60_290# WL14 SL9 VSS sky130_fd_pr__nfet_g5v0d10v5 ad=0.65 pd=3.3 as=0 ps=0 w=1 l=0.5
X3977 rr3t3r_0[14|9]/a_860_290# WL14 SL9 VSS sky130_fd_pr__nfet_g5v0d10v5 ad=0.65 pd=3.3 as=0 ps=0 w=1 l=0.5
X3978 BLP9 rr3t3r_0[15|9]/a_60_290# sky130_fd_pr_reram__reram_cell area_ox=0.0676
X3979 BLZ9 rr3t3r_0[15|9]/a_460_290# sky130_fd_pr_reram__reram_cell area_ox=0.0676
X3980 rr3t3r_0[15|9]/a_460_290# WL15 SL9 VSS sky130_fd_pr__nfet_g5v0d10v5 ad=0.65 pd=3.3 as=0 ps=0 w=1 l=0.5
X3981 BLN9 rr3t3r_0[15|9]/a_860_290# sky130_fd_pr_reram__reram_cell area_ox=0.0676
X3982 rr3t3r_0[15|9]/a_60_290# WL15 SL9 VSS sky130_fd_pr__nfet_g5v0d10v5 ad=0.65 pd=3.3 as=0 ps=0 w=1 l=0.5
X3983 rr3t3r_0[15|9]/a_860_290# WL15 SL9 VSS sky130_fd_pr__nfet_g5v0d10v5 ad=0.65 pd=3.3 as=0 ps=0 w=1 l=0.5
X3984 BLP9 rr3t3r_0[16|9]/a_60_290# sky130_fd_pr_reram__reram_cell area_ox=0.0676
X3985 BLZ9 rr3t3r_0[16|9]/a_460_290# sky130_fd_pr_reram__reram_cell area_ox=0.0676
X3986 rr3t3r_0[16|9]/a_460_290# WL16 SL9 VSS sky130_fd_pr__nfet_g5v0d10v5 ad=0.65 pd=3.3 as=0 ps=0 w=1 l=0.5
X3987 BLN9 rr3t3r_0[16|9]/a_860_290# sky130_fd_pr_reram__reram_cell area_ox=0.0676
X3988 rr3t3r_0[16|9]/a_60_290# WL16 SL9 VSS sky130_fd_pr__nfet_g5v0d10v5 ad=0.65 pd=3.3 as=0 ps=0 w=1 l=0.5
X3989 rr3t3r_0[16|9]/a_860_290# WL16 SL9 VSS sky130_fd_pr__nfet_g5v0d10v5 ad=0.65 pd=3.3 as=0 ps=0 w=1 l=0.5
X3990 BLP9 rr3t3r_0[17|9]/a_60_290# sky130_fd_pr_reram__reram_cell area_ox=0.0676
X3991 BLZ9 rr3t3r_0[17|9]/a_460_290# sky130_fd_pr_reram__reram_cell area_ox=0.0676
X3992 rr3t3r_0[17|9]/a_460_290# WL17 SL9 VSS sky130_fd_pr__nfet_g5v0d10v5 ad=0.65 pd=3.3 as=0 ps=0 w=1 l=0.5
X3993 BLN9 rr3t3r_0[17|9]/a_860_290# sky130_fd_pr_reram__reram_cell area_ox=0.0676
X3994 rr3t3r_0[17|9]/a_60_290# WL17 SL9 VSS sky130_fd_pr__nfet_g5v0d10v5 ad=0.65 pd=3.3 as=0 ps=0 w=1 l=0.5
X3995 rr3t3r_0[17|9]/a_860_290# WL17 SL9 VSS sky130_fd_pr__nfet_g5v0d10v5 ad=0.65 pd=3.3 as=0 ps=0 w=1 l=0.5
X3996 BLP9 rr3t3r_0[18|9]/a_60_290# sky130_fd_pr_reram__reram_cell area_ox=0.0676
X3997 BLZ9 rr3t3r_0[18|9]/a_460_290# sky130_fd_pr_reram__reram_cell area_ox=0.0676
X3998 rr3t3r_0[18|9]/a_460_290# WL18 SL9 VSS sky130_fd_pr__nfet_g5v0d10v5 ad=0.65 pd=3.3 as=0 ps=0 w=1 l=0.5
X3999 BLN9 rr3t3r_0[18|9]/a_860_290# sky130_fd_pr_reram__reram_cell area_ox=0.0676
X4000 rr3t3r_0[18|9]/a_60_290# WL18 SL9 VSS sky130_fd_pr__nfet_g5v0d10v5 ad=0.65 pd=3.3 as=0 ps=0 w=1 l=0.5
X4001 rr3t3r_0[18|9]/a_860_290# WL18 SL9 VSS sky130_fd_pr__nfet_g5v0d10v5 ad=0.65 pd=3.3 as=0 ps=0 w=1 l=0.5
X4002 BLP9 rr3t3r_0[19|9]/a_60_290# sky130_fd_pr_reram__reram_cell area_ox=0.0676
X4003 BLZ9 rr3t3r_0[19|9]/a_460_290# sky130_fd_pr_reram__reram_cell area_ox=0.0676
X4004 rr3t3r_0[19|9]/a_460_290# WL19 SL9 VSS sky130_fd_pr__nfet_g5v0d10v5 ad=0.65 pd=3.3 as=0 ps=0 w=1 l=0.5
X4005 BLN9 rr3t3r_0[19|9]/a_860_290# sky130_fd_pr_reram__reram_cell area_ox=0.0676
X4006 rr3t3r_0[19|9]/a_60_290# WL19 SL9 VSS sky130_fd_pr__nfet_g5v0d10v5 ad=0.65 pd=3.3 as=0 ps=0 w=1 l=0.5
X4007 rr3t3r_0[19|9]/a_860_290# WL19 SL9 VSS sky130_fd_pr__nfet_g5v0d10v5 ad=0.65 pd=3.3 as=0 ps=0 w=1 l=0.5
X4008 BLP9 rr3t3r_0[20|9]/a_60_290# sky130_fd_pr_reram__reram_cell area_ox=0.0676
X4009 BLZ9 rr3t3r_0[20|9]/a_460_290# sky130_fd_pr_reram__reram_cell area_ox=0.0676
X4010 rr3t3r_0[20|9]/a_460_290# WL20 SL9 VSS sky130_fd_pr__nfet_g5v0d10v5 ad=0.65 pd=3.3 as=0 ps=0 w=1 l=0.5
X4011 BLN9 rr3t3r_0[20|9]/a_860_290# sky130_fd_pr_reram__reram_cell area_ox=0.0676
X4012 rr3t3r_0[20|9]/a_60_290# WL20 SL9 VSS sky130_fd_pr__nfet_g5v0d10v5 ad=0.65 pd=3.3 as=0 ps=0 w=1 l=0.5
X4013 rr3t3r_0[20|9]/a_860_290# WL20 SL9 VSS sky130_fd_pr__nfet_g5v0d10v5 ad=0.65 pd=3.3 as=0 ps=0 w=1 l=0.5
X4014 BLP9 rr3t3r_0[21|9]/a_60_290# sky130_fd_pr_reram__reram_cell area_ox=0.0676
X4015 BLZ9 rr3t3r_0[21|9]/a_460_290# sky130_fd_pr_reram__reram_cell area_ox=0.0676
X4016 rr3t3r_0[21|9]/a_460_290# WL21 SL9 VSS sky130_fd_pr__nfet_g5v0d10v5 ad=0.65 pd=3.3 as=0 ps=0 w=1 l=0.5
X4017 BLN9 rr3t3r_0[21|9]/a_860_290# sky130_fd_pr_reram__reram_cell area_ox=0.0676
X4018 rr3t3r_0[21|9]/a_60_290# WL21 SL9 VSS sky130_fd_pr__nfet_g5v0d10v5 ad=0.65 pd=3.3 as=0 ps=0 w=1 l=0.5
X4019 rr3t3r_0[21|9]/a_860_290# WL21 SL9 VSS sky130_fd_pr__nfet_g5v0d10v5 ad=0.65 pd=3.3 as=0 ps=0 w=1 l=0.5
X4020 BLP9 rr3t3r_0[22|9]/a_60_290# sky130_fd_pr_reram__reram_cell area_ox=0.0676
X4021 BLZ9 rr3t3r_0[22|9]/a_460_290# sky130_fd_pr_reram__reram_cell area_ox=0.0676
X4022 rr3t3r_0[22|9]/a_460_290# WL22 SL9 VSS sky130_fd_pr__nfet_g5v0d10v5 ad=0.65 pd=3.3 as=0 ps=0 w=1 l=0.5
X4023 BLN9 rr3t3r_0[22|9]/a_860_290# sky130_fd_pr_reram__reram_cell area_ox=0.0676
X4024 rr3t3r_0[22|9]/a_60_290# WL22 SL9 VSS sky130_fd_pr__nfet_g5v0d10v5 ad=0.65 pd=3.3 as=0 ps=0 w=1 l=0.5
X4025 rr3t3r_0[22|9]/a_860_290# WL22 SL9 VSS sky130_fd_pr__nfet_g5v0d10v5 ad=0.65 pd=3.3 as=0 ps=0 w=1 l=0.5
X4026 BLP9 rr3t3r_0[23|9]/a_60_290# sky130_fd_pr_reram__reram_cell area_ox=0.0676
X4027 BLZ9 rr3t3r_0[23|9]/a_460_290# sky130_fd_pr_reram__reram_cell area_ox=0.0676
X4028 rr3t3r_0[23|9]/a_460_290# WL23 SL9 VSS sky130_fd_pr__nfet_g5v0d10v5 ad=0.65 pd=3.3 as=0 ps=0 w=1 l=0.5
X4029 BLN9 rr3t3r_0[23|9]/a_860_290# sky130_fd_pr_reram__reram_cell area_ox=0.0676
X4030 rr3t3r_0[23|9]/a_60_290# WL23 SL9 VSS sky130_fd_pr__nfet_g5v0d10v5 ad=0.65 pd=3.3 as=0 ps=0 w=1 l=0.5
X4031 rr3t3r_0[23|9]/a_860_290# WL23 SL9 VSS sky130_fd_pr__nfet_g5v0d10v5 ad=0.65 pd=3.3 as=0 ps=0 w=1 l=0.5
X4032 BLP9 rr3t3r_0[24|9]/a_60_290# sky130_fd_pr_reram__reram_cell area_ox=0.0676
X4033 BLZ9 rr3t3r_0[24|9]/a_460_290# sky130_fd_pr_reram__reram_cell area_ox=0.0676
X4034 rr3t3r_0[24|9]/a_460_290# WL24 SL9 VSS sky130_fd_pr__nfet_g5v0d10v5 ad=0.65 pd=3.3 as=0 ps=0 w=1 l=0.5
X4035 BLN9 rr3t3r_0[24|9]/a_860_290# sky130_fd_pr_reram__reram_cell area_ox=0.0676
X4036 rr3t3r_0[24|9]/a_60_290# WL24 SL9 VSS sky130_fd_pr__nfet_g5v0d10v5 ad=0.65 pd=3.3 as=0 ps=0 w=1 l=0.5
X4037 rr3t3r_0[24|9]/a_860_290# WL24 SL9 VSS sky130_fd_pr__nfet_g5v0d10v5 ad=0.65 pd=3.3 as=0 ps=0 w=1 l=0.5
X4038 BLP9 rr3t3r_0[25|9]/a_60_290# sky130_fd_pr_reram__reram_cell area_ox=0.0676
X4039 BLZ9 rr3t3r_0[25|9]/a_460_290# sky130_fd_pr_reram__reram_cell area_ox=0.0676
X4040 rr3t3r_0[25|9]/a_460_290# WL25 SL9 VSS sky130_fd_pr__nfet_g5v0d10v5 ad=0.65 pd=3.3 as=0 ps=0 w=1 l=0.5
X4041 BLN9 rr3t3r_0[25|9]/a_860_290# sky130_fd_pr_reram__reram_cell area_ox=0.0676
X4042 rr3t3r_0[25|9]/a_60_290# WL25 SL9 VSS sky130_fd_pr__nfet_g5v0d10v5 ad=0.65 pd=3.3 as=0 ps=0 w=1 l=0.5
X4043 rr3t3r_0[25|9]/a_860_290# WL25 SL9 VSS sky130_fd_pr__nfet_g5v0d10v5 ad=0.65 pd=3.3 as=0 ps=0 w=1 l=0.5
X4044 BLP9 rr3t3r_0[26|9]/a_60_290# sky130_fd_pr_reram__reram_cell area_ox=0.0676
X4045 BLZ9 rr3t3r_0[26|9]/a_460_290# sky130_fd_pr_reram__reram_cell area_ox=0.0676
X4046 rr3t3r_0[26|9]/a_460_290# WL26 SL9 VSS sky130_fd_pr__nfet_g5v0d10v5 ad=0.65 pd=3.3 as=0 ps=0 w=1 l=0.5
X4047 BLN9 rr3t3r_0[26|9]/a_860_290# sky130_fd_pr_reram__reram_cell area_ox=0.0676
X4048 rr3t3r_0[26|9]/a_60_290# WL26 SL9 VSS sky130_fd_pr__nfet_g5v0d10v5 ad=0.65 pd=3.3 as=0 ps=0 w=1 l=0.5
X4049 rr3t3r_0[26|9]/a_860_290# WL26 SL9 VSS sky130_fd_pr__nfet_g5v0d10v5 ad=0.65 pd=3.3 as=0 ps=0 w=1 l=0.5
X4050 BLP9 rr3t3r_0[27|9]/a_60_290# sky130_fd_pr_reram__reram_cell area_ox=0.0676
X4051 BLZ9 rr3t3r_0[27|9]/a_460_290# sky130_fd_pr_reram__reram_cell area_ox=0.0676
X4052 rr3t3r_0[27|9]/a_460_290# WL27 SL9 VSS sky130_fd_pr__nfet_g5v0d10v5 ad=0.65 pd=3.3 as=0 ps=0 w=1 l=0.5
X4053 BLN9 rr3t3r_0[27|9]/a_860_290# sky130_fd_pr_reram__reram_cell area_ox=0.0676
X4054 rr3t3r_0[27|9]/a_60_290# WL27 SL9 VSS sky130_fd_pr__nfet_g5v0d10v5 ad=0.65 pd=3.3 as=0 ps=0 w=1 l=0.5
X4055 rr3t3r_0[27|9]/a_860_290# WL27 SL9 VSS sky130_fd_pr__nfet_g5v0d10v5 ad=0.65 pd=3.3 as=0 ps=0 w=1 l=0.5
X4056 BLP9 rr3t3r_0[28|9]/a_60_290# sky130_fd_pr_reram__reram_cell area_ox=0.0676
X4057 BLZ9 rr3t3r_0[28|9]/a_460_290# sky130_fd_pr_reram__reram_cell area_ox=0.0676
X4058 rr3t3r_0[28|9]/a_460_290# WL28 SL9 VSS sky130_fd_pr__nfet_g5v0d10v5 ad=0.65 pd=3.3 as=0 ps=0 w=1 l=0.5
X4059 BLN9 rr3t3r_0[28|9]/a_860_290# sky130_fd_pr_reram__reram_cell area_ox=0.0676
X4060 rr3t3r_0[28|9]/a_60_290# WL28 SL9 VSS sky130_fd_pr__nfet_g5v0d10v5 ad=0.65 pd=3.3 as=0 ps=0 w=1 l=0.5
X4061 rr3t3r_0[28|9]/a_860_290# WL28 SL9 VSS sky130_fd_pr__nfet_g5v0d10v5 ad=0.65 pd=3.3 as=0 ps=0 w=1 l=0.5
X4062 BLP9 rr3t3r_0[29|9]/a_60_290# sky130_fd_pr_reram__reram_cell area_ox=0.0676
X4063 BLZ9 rr3t3r_0[29|9]/a_460_290# sky130_fd_pr_reram__reram_cell area_ox=0.0676
X4064 rr3t3r_0[29|9]/a_460_290# WL29 SL9 VSS sky130_fd_pr__nfet_g5v0d10v5 ad=0.65 pd=3.3 as=0 ps=0 w=1 l=0.5
X4065 BLN9 rr3t3r_0[29|9]/a_860_290# sky130_fd_pr_reram__reram_cell area_ox=0.0676
X4066 rr3t3r_0[29|9]/a_60_290# WL29 SL9 VSS sky130_fd_pr__nfet_g5v0d10v5 ad=0.65 pd=3.3 as=0 ps=0 w=1 l=0.5
X4067 rr3t3r_0[29|9]/a_860_290# WL29 SL9 VSS sky130_fd_pr__nfet_g5v0d10v5 ad=0.65 pd=3.3 as=0 ps=0 w=1 l=0.5
X4068 BLP9 rr3t3r_0[30|9]/a_60_290# sky130_fd_pr_reram__reram_cell area_ox=0.0676
X4069 BLZ9 rr3t3r_0[30|9]/a_460_290# sky130_fd_pr_reram__reram_cell area_ox=0.0676
X4070 rr3t3r_0[30|9]/a_460_290# WL30 SL9 VSS sky130_fd_pr__nfet_g5v0d10v5 ad=0.65 pd=3.3 as=0 ps=0 w=1 l=0.5
X4071 BLN9 rr3t3r_0[30|9]/a_860_290# sky130_fd_pr_reram__reram_cell area_ox=0.0676
X4072 rr3t3r_0[30|9]/a_60_290# WL30 SL9 VSS sky130_fd_pr__nfet_g5v0d10v5 ad=0.65 pd=3.3 as=0 ps=0 w=1 l=0.5
X4073 rr3t3r_0[30|9]/a_860_290# WL30 SL9 VSS sky130_fd_pr__nfet_g5v0d10v5 ad=0.65 pd=3.3 as=0 ps=0 w=1 l=0.5
X4074 BLP9 rr3t3r_0[31|9]/a_60_290# sky130_fd_pr_reram__reram_cell area_ox=0.0676
X4075 BLZ9 rr3t3r_0[31|9]/a_460_290# sky130_fd_pr_reram__reram_cell area_ox=0.0676
X4076 rr3t3r_0[31|9]/a_460_290# WL31 SL9 VSS sky130_fd_pr__nfet_g5v0d10v5 ad=0.65 pd=3.3 as=0 ps=0 w=1 l=0.5
X4077 BLN9 rr3t3r_0[31|9]/a_860_290# sky130_fd_pr_reram__reram_cell area_ox=0.0676
X4078 rr3t3r_0[31|9]/a_60_290# WL31 SL9 VSS sky130_fd_pr__nfet_g5v0d10v5 ad=0.65 pd=3.3 as=0 ps=0 w=1 l=0.5
X4079 rr3t3r_0[31|9]/a_860_290# WL31 SL9 VSS sky130_fd_pr__nfet_g5v0d10v5 ad=0.65 pd=3.3 as=0 ps=0 w=1 l=0.5
X4080 BLP9 rr3t3r_0[32|9]/a_60_290# sky130_fd_pr_reram__reram_cell area_ox=0.0676
X4081 BLZ9 rr3t3r_0[32|9]/a_460_290# sky130_fd_pr_reram__reram_cell area_ox=0.0676
X4082 rr3t3r_0[32|9]/a_460_290# WL32 SL9 VSS sky130_fd_pr__nfet_g5v0d10v5 ad=0.65 pd=3.3 as=0 ps=0 w=1 l=0.5
X4083 BLN9 rr3t3r_0[32|9]/a_860_290# sky130_fd_pr_reram__reram_cell area_ox=0.0676
X4084 rr3t3r_0[32|9]/a_60_290# WL32 SL9 VSS sky130_fd_pr__nfet_g5v0d10v5 ad=0.65 pd=3.3 as=0 ps=0 w=1 l=0.5
X4085 rr3t3r_0[32|9]/a_860_290# WL32 SL9 VSS sky130_fd_pr__nfet_g5v0d10v5 ad=0.65 pd=3.3 as=0 ps=0 w=1 l=0.5
X4086 BLP9 rr3t3r_0[33|9]/a_60_290# sky130_fd_pr_reram__reram_cell area_ox=0.0676
X4087 BLZ9 rr3t3r_0[33|9]/a_460_290# sky130_fd_pr_reram__reram_cell area_ox=0.0676
X4088 rr3t3r_0[33|9]/a_460_290# WL33 SL9 VSS sky130_fd_pr__nfet_g5v0d10v5 ad=0.65 pd=3.3 as=0 ps=0 w=1 l=0.5
X4089 BLN9 rr3t3r_0[33|9]/a_860_290# sky130_fd_pr_reram__reram_cell area_ox=0.0676
X4090 rr3t3r_0[33|9]/a_60_290# WL33 SL9 VSS sky130_fd_pr__nfet_g5v0d10v5 ad=0.65 pd=3.3 as=0 ps=0 w=1 l=0.5
X4091 rr3t3r_0[33|9]/a_860_290# WL33 SL9 VSS sky130_fd_pr__nfet_g5v0d10v5 ad=0.65 pd=3.3 as=0 ps=0 w=1 l=0.5
X4092 BLP9 rr3t3r_0[34|9]/a_60_290# sky130_fd_pr_reram__reram_cell area_ox=0.0676
X4093 BLZ9 rr3t3r_0[34|9]/a_460_290# sky130_fd_pr_reram__reram_cell area_ox=0.0676
X4094 rr3t3r_0[34|9]/a_460_290# WL34 SL9 VSS sky130_fd_pr__nfet_g5v0d10v5 ad=0.65 pd=3.3 as=0 ps=0 w=1 l=0.5
X4095 BLN9 rr3t3r_0[34|9]/a_860_290# sky130_fd_pr_reram__reram_cell area_ox=0.0676
X4096 rr3t3r_0[34|9]/a_60_290# WL34 SL9 VSS sky130_fd_pr__nfet_g5v0d10v5 ad=0.65 pd=3.3 as=0 ps=0 w=1 l=0.5
X4097 rr3t3r_0[34|9]/a_860_290# WL34 SL9 VSS sky130_fd_pr__nfet_g5v0d10v5 ad=0.65 pd=3.3 as=0 ps=0 w=1 l=0.5
X4098 BLP9 rr3t3r_0[35|9]/a_60_290# sky130_fd_pr_reram__reram_cell area_ox=0.0676
X4099 BLZ9 rr3t3r_0[35|9]/a_460_290# sky130_fd_pr_reram__reram_cell area_ox=0.0676
X4100 rr3t3r_0[35|9]/a_460_290# WL35 SL9 VSS sky130_fd_pr__nfet_g5v0d10v5 ad=0.65 pd=3.3 as=0 ps=0 w=1 l=0.5
X4101 BLN9 rr3t3r_0[35|9]/a_860_290# sky130_fd_pr_reram__reram_cell area_ox=0.0676
X4102 rr3t3r_0[35|9]/a_60_290# WL35 SL9 VSS sky130_fd_pr__nfet_g5v0d10v5 ad=0.65 pd=3.3 as=0 ps=0 w=1 l=0.5
X4103 rr3t3r_0[35|9]/a_860_290# WL35 SL9 VSS sky130_fd_pr__nfet_g5v0d10v5 ad=0.65 pd=3.3 as=0 ps=0 w=1 l=0.5
X4104 BLP9 rr3t3r_0[36|9]/a_60_290# sky130_fd_pr_reram__reram_cell area_ox=0.0676
X4105 BLZ9 rr3t3r_0[36|9]/a_460_290# sky130_fd_pr_reram__reram_cell area_ox=0.0676
X4106 rr3t3r_0[36|9]/a_460_290# WL36 SL9 VSS sky130_fd_pr__nfet_g5v0d10v5 ad=0.65 pd=3.3 as=0 ps=0 w=1 l=0.5
X4107 BLN9 rr3t3r_0[36|9]/a_860_290# sky130_fd_pr_reram__reram_cell area_ox=0.0676
X4108 rr3t3r_0[36|9]/a_60_290# WL36 SL9 VSS sky130_fd_pr__nfet_g5v0d10v5 ad=0.65 pd=3.3 as=0 ps=0 w=1 l=0.5
X4109 rr3t3r_0[36|9]/a_860_290# WL36 SL9 VSS sky130_fd_pr__nfet_g5v0d10v5 ad=0.65 pd=3.3 as=0 ps=0 w=1 l=0.5
X4110 BLP9 rr3t3r_0[37|9]/a_60_290# sky130_fd_pr_reram__reram_cell area_ox=0.0676
X4111 BLZ9 rr3t3r_0[37|9]/a_460_290# sky130_fd_pr_reram__reram_cell area_ox=0.0676
X4112 rr3t3r_0[37|9]/a_460_290# WL37 SL9 VSS sky130_fd_pr__nfet_g5v0d10v5 ad=0.65 pd=3.3 as=0 ps=0 w=1 l=0.5
X4113 BLN9 rr3t3r_0[37|9]/a_860_290# sky130_fd_pr_reram__reram_cell area_ox=0.0676
X4114 rr3t3r_0[37|9]/a_60_290# WL37 SL9 VSS sky130_fd_pr__nfet_g5v0d10v5 ad=0.65 pd=3.3 as=0 ps=0 w=1 l=0.5
X4115 rr3t3r_0[37|9]/a_860_290# WL37 SL9 VSS sky130_fd_pr__nfet_g5v0d10v5 ad=0.65 pd=3.3 as=0 ps=0 w=1 l=0.5
X4116 BLP9 rr3t3r_0[38|9]/a_60_290# sky130_fd_pr_reram__reram_cell area_ox=0.0676
X4117 BLZ9 rr3t3r_0[38|9]/a_460_290# sky130_fd_pr_reram__reram_cell area_ox=0.0676
X4118 rr3t3r_0[38|9]/a_460_290# WL38 SL9 VSS sky130_fd_pr__nfet_g5v0d10v5 ad=0.65 pd=3.3 as=0 ps=0 w=1 l=0.5
X4119 BLN9 rr3t3r_0[38|9]/a_860_290# sky130_fd_pr_reram__reram_cell area_ox=0.0676
X4120 rr3t3r_0[38|9]/a_60_290# WL38 SL9 VSS sky130_fd_pr__nfet_g5v0d10v5 ad=0.65 pd=3.3 as=0 ps=0 w=1 l=0.5
X4121 rr3t3r_0[38|9]/a_860_290# WL38 SL9 VSS sky130_fd_pr__nfet_g5v0d10v5 ad=0.65 pd=3.3 as=0 ps=0 w=1 l=0.5
X4122 BLP9 rr3t3r_0[39|9]/a_60_290# sky130_fd_pr_reram__reram_cell area_ox=0.0676
X4123 BLZ9 rr3t3r_0[39|9]/a_460_290# sky130_fd_pr_reram__reram_cell area_ox=0.0676
X4124 rr3t3r_0[39|9]/a_460_290# WL39 SL9 VSS sky130_fd_pr__nfet_g5v0d10v5 ad=0.65 pd=3.3 as=0 ps=0 w=1 l=0.5
X4125 BLN9 rr3t3r_0[39|9]/a_860_290# sky130_fd_pr_reram__reram_cell area_ox=0.0676
X4126 rr3t3r_0[39|9]/a_60_290# WL39 SL9 VSS sky130_fd_pr__nfet_g5v0d10v5 ad=0.65 pd=3.3 as=0 ps=0 w=1 l=0.5
X4127 rr3t3r_0[39|9]/a_860_290# WL39 SL9 VSS sky130_fd_pr__nfet_g5v0d10v5 ad=0.65 pd=3.3 as=0 ps=0 w=1 l=0.5
X4128 BLP9 rr3t3r_0[40|9]/a_60_290# sky130_fd_pr_reram__reram_cell area_ox=0.0676
X4129 BLZ9 rr3t3r_0[40|9]/a_460_290# sky130_fd_pr_reram__reram_cell area_ox=0.0676
X4130 rr3t3r_0[40|9]/a_460_290# WL40 SL9 VSS sky130_fd_pr__nfet_g5v0d10v5 ad=0.65 pd=3.3 as=0 ps=0 w=1 l=0.5
X4131 BLN9 rr3t3r_0[40|9]/a_860_290# sky130_fd_pr_reram__reram_cell area_ox=0.0676
X4132 rr3t3r_0[40|9]/a_60_290# WL40 SL9 VSS sky130_fd_pr__nfet_g5v0d10v5 ad=0.65 pd=3.3 as=0 ps=0 w=1 l=0.5
X4133 rr3t3r_0[40|9]/a_860_290# WL40 SL9 VSS sky130_fd_pr__nfet_g5v0d10v5 ad=0.65 pd=3.3 as=0 ps=0 w=1 l=0.5
X4134 BLP9 rr3t3r_0[41|9]/a_60_290# sky130_fd_pr_reram__reram_cell area_ox=0.0676
X4135 BLZ9 rr3t3r_0[41|9]/a_460_290# sky130_fd_pr_reram__reram_cell area_ox=0.0676
X4136 rr3t3r_0[41|9]/a_460_290# WL41 SL9 VSS sky130_fd_pr__nfet_g5v0d10v5 ad=0.65 pd=3.3 as=0 ps=0 w=1 l=0.5
X4137 BLN9 rr3t3r_0[41|9]/a_860_290# sky130_fd_pr_reram__reram_cell area_ox=0.0676
X4138 rr3t3r_0[41|9]/a_60_290# WL41 SL9 VSS sky130_fd_pr__nfet_g5v0d10v5 ad=0.65 pd=3.3 as=0 ps=0 w=1 l=0.5
X4139 rr3t3r_0[41|9]/a_860_290# WL41 SL9 VSS sky130_fd_pr__nfet_g5v0d10v5 ad=0.65 pd=3.3 as=0 ps=0 w=1 l=0.5
X4140 BLP9 rr3t3r_0[42|9]/a_60_290# sky130_fd_pr_reram__reram_cell area_ox=0.0676
X4141 BLZ9 rr3t3r_0[42|9]/a_460_290# sky130_fd_pr_reram__reram_cell area_ox=0.0676
X4142 rr3t3r_0[42|9]/a_460_290# WL42 SL9 VSS sky130_fd_pr__nfet_g5v0d10v5 ad=0.65 pd=3.3 as=0 ps=0 w=1 l=0.5
X4143 BLN9 rr3t3r_0[42|9]/a_860_290# sky130_fd_pr_reram__reram_cell area_ox=0.0676
X4144 rr3t3r_0[42|9]/a_60_290# WL42 SL9 VSS sky130_fd_pr__nfet_g5v0d10v5 ad=0.65 pd=3.3 as=0 ps=0 w=1 l=0.5
X4145 rr3t3r_0[42|9]/a_860_290# WL42 SL9 VSS sky130_fd_pr__nfet_g5v0d10v5 ad=0.65 pd=3.3 as=0 ps=0 w=1 l=0.5
X4146 BLP9 rr3t3r_0[43|9]/a_60_290# sky130_fd_pr_reram__reram_cell area_ox=0.0676
X4147 BLZ9 rr3t3r_0[43|9]/a_460_290# sky130_fd_pr_reram__reram_cell area_ox=0.0676
X4148 rr3t3r_0[43|9]/a_460_290# WL43 SL9 VSS sky130_fd_pr__nfet_g5v0d10v5 ad=0.65 pd=3.3 as=0 ps=0 w=1 l=0.5
X4149 BLN9 rr3t3r_0[43|9]/a_860_290# sky130_fd_pr_reram__reram_cell area_ox=0.0676
X4150 rr3t3r_0[43|9]/a_60_290# WL43 SL9 VSS sky130_fd_pr__nfet_g5v0d10v5 ad=0.65 pd=3.3 as=0 ps=0 w=1 l=0.5
X4151 rr3t3r_0[43|9]/a_860_290# WL43 SL9 VSS sky130_fd_pr__nfet_g5v0d10v5 ad=0.65 pd=3.3 as=0 ps=0 w=1 l=0.5
X4152 BLP9 rr3t3r_0[44|9]/a_60_290# sky130_fd_pr_reram__reram_cell area_ox=0.0676
X4153 BLZ9 rr3t3r_0[44|9]/a_460_290# sky130_fd_pr_reram__reram_cell area_ox=0.0676
X4154 rr3t3r_0[44|9]/a_460_290# WL44 SL9 VSS sky130_fd_pr__nfet_g5v0d10v5 ad=0.65 pd=3.3 as=0 ps=0 w=1 l=0.5
X4155 BLN9 rr3t3r_0[44|9]/a_860_290# sky130_fd_pr_reram__reram_cell area_ox=0.0676
X4156 rr3t3r_0[44|9]/a_60_290# WL44 SL9 VSS sky130_fd_pr__nfet_g5v0d10v5 ad=0.65 pd=3.3 as=0 ps=0 w=1 l=0.5
X4157 rr3t3r_0[44|9]/a_860_290# WL44 SL9 VSS sky130_fd_pr__nfet_g5v0d10v5 ad=0.65 pd=3.3 as=0 ps=0 w=1 l=0.5
X4158 BLP9 rr3t3r_0[45|9]/a_60_290# sky130_fd_pr_reram__reram_cell area_ox=0.0676
X4159 BLZ9 rr3t3r_0[45|9]/a_460_290# sky130_fd_pr_reram__reram_cell area_ox=0.0676
X4160 rr3t3r_0[45|9]/a_460_290# WL45 SL9 VSS sky130_fd_pr__nfet_g5v0d10v5 ad=0.65 pd=3.3 as=0 ps=0 w=1 l=0.5
X4161 BLN9 rr3t3r_0[45|9]/a_860_290# sky130_fd_pr_reram__reram_cell area_ox=0.0676
X4162 rr3t3r_0[45|9]/a_60_290# WL45 SL9 VSS sky130_fd_pr__nfet_g5v0d10v5 ad=0.65 pd=3.3 as=0 ps=0 w=1 l=0.5
X4163 rr3t3r_0[45|9]/a_860_290# WL45 SL9 VSS sky130_fd_pr__nfet_g5v0d10v5 ad=0.65 pd=3.3 as=0 ps=0 w=1 l=0.5
X4164 BLP9 rr3t3r_0[46|9]/a_60_290# sky130_fd_pr_reram__reram_cell area_ox=0.0676
X4165 BLZ9 rr3t3r_0[46|9]/a_460_290# sky130_fd_pr_reram__reram_cell area_ox=0.0676
X4166 rr3t3r_0[46|9]/a_460_290# WL46 SL9 VSS sky130_fd_pr__nfet_g5v0d10v5 ad=0.65 pd=3.3 as=0 ps=0 w=1 l=0.5
X4167 BLN9 rr3t3r_0[46|9]/a_860_290# sky130_fd_pr_reram__reram_cell area_ox=0.0676
X4168 rr3t3r_0[46|9]/a_60_290# WL46 SL9 VSS sky130_fd_pr__nfet_g5v0d10v5 ad=0.65 pd=3.3 as=0 ps=0 w=1 l=0.5
X4169 rr3t3r_0[46|9]/a_860_290# WL46 SL9 VSS sky130_fd_pr__nfet_g5v0d10v5 ad=0.65 pd=3.3 as=0 ps=0 w=1 l=0.5
X4170 BLP9 rr3t3r_0[47|9]/a_60_290# sky130_fd_pr_reram__reram_cell area_ox=0.0676
X4171 BLZ9 rr3t3r_0[47|9]/a_460_290# sky130_fd_pr_reram__reram_cell area_ox=0.0676
X4172 rr3t3r_0[47|9]/a_460_290# WL47 SL9 VSS sky130_fd_pr__nfet_g5v0d10v5 ad=0.65 pd=3.3 as=0 ps=0 w=1 l=0.5
X4173 BLN9 rr3t3r_0[47|9]/a_860_290# sky130_fd_pr_reram__reram_cell area_ox=0.0676
X4174 rr3t3r_0[47|9]/a_60_290# WL47 SL9 VSS sky130_fd_pr__nfet_g5v0d10v5 ad=0.65 pd=3.3 as=0 ps=0 w=1 l=0.5
X4175 rr3t3r_0[47|9]/a_860_290# WL47 SL9 VSS sky130_fd_pr__nfet_g5v0d10v5 ad=0.65 pd=3.3 as=0 ps=0 w=1 l=0.5
X4176 BLP9 rr3t3r_0[48|9]/a_60_290# sky130_fd_pr_reram__reram_cell area_ox=0.0676
X4177 BLZ9 rr3t3r_0[48|9]/a_460_290# sky130_fd_pr_reram__reram_cell area_ox=0.0676
X4178 rr3t3r_0[48|9]/a_460_290# WL48 SL9 VSS sky130_fd_pr__nfet_g5v0d10v5 ad=0.65 pd=3.3 as=0 ps=0 w=1 l=0.5
X4179 BLN9 rr3t3r_0[48|9]/a_860_290# sky130_fd_pr_reram__reram_cell area_ox=0.0676
X4180 rr3t3r_0[48|9]/a_60_290# WL48 SL9 VSS sky130_fd_pr__nfet_g5v0d10v5 ad=0.65 pd=3.3 as=0 ps=0 w=1 l=0.5
X4181 rr3t3r_0[48|9]/a_860_290# WL48 SL9 VSS sky130_fd_pr__nfet_g5v0d10v5 ad=0.65 pd=3.3 as=0 ps=0 w=1 l=0.5
X4182 BLP9 rr3t3r_0[49|9]/a_60_290# sky130_fd_pr_reram__reram_cell area_ox=0.0676
X4183 BLZ9 rr3t3r_0[49|9]/a_460_290# sky130_fd_pr_reram__reram_cell area_ox=0.0676
X4184 rr3t3r_0[49|9]/a_460_290# WL49 SL9 VSS sky130_fd_pr__nfet_g5v0d10v5 ad=0.65 pd=3.3 as=0 ps=0 w=1 l=0.5
X4185 BLN9 rr3t3r_0[49|9]/a_860_290# sky130_fd_pr_reram__reram_cell area_ox=0.0676
X4186 rr3t3r_0[49|9]/a_60_290# WL49 SL9 VSS sky130_fd_pr__nfet_g5v0d10v5 ad=0.65 pd=3.3 as=0 ps=0 w=1 l=0.5
X4187 rr3t3r_0[49|9]/a_860_290# WL49 SL9 VSS sky130_fd_pr__nfet_g5v0d10v5 ad=0.65 pd=3.3 as=0 ps=0 w=1 l=0.5
X4188 BLP9 rr3t3r_0[50|9]/a_60_290# sky130_fd_pr_reram__reram_cell area_ox=0.0676
X4189 BLZ9 rr3t3r_0[50|9]/a_460_290# sky130_fd_pr_reram__reram_cell area_ox=0.0676
X4190 rr3t3r_0[50|9]/a_460_290# WL50 SL9 VSS sky130_fd_pr__nfet_g5v0d10v5 ad=0.65 pd=3.3 as=0 ps=0 w=1 l=0.5
X4191 BLN9 rr3t3r_0[50|9]/a_860_290# sky130_fd_pr_reram__reram_cell area_ox=0.0676
X4192 rr3t3r_0[50|9]/a_60_290# WL50 SL9 VSS sky130_fd_pr__nfet_g5v0d10v5 ad=0.65 pd=3.3 as=0 ps=0 w=1 l=0.5
X4193 rr3t3r_0[50|9]/a_860_290# WL50 SL9 VSS sky130_fd_pr__nfet_g5v0d10v5 ad=0.65 pd=3.3 as=0 ps=0 w=1 l=0.5
X4194 BLP9 rr3t3r_0[51|9]/a_60_290# sky130_fd_pr_reram__reram_cell area_ox=0.0676
X4195 BLZ9 rr3t3r_0[51|9]/a_460_290# sky130_fd_pr_reram__reram_cell area_ox=0.0676
X4196 rr3t3r_0[51|9]/a_460_290# WL51 SL9 VSS sky130_fd_pr__nfet_g5v0d10v5 ad=0.65 pd=3.3 as=0 ps=0 w=1 l=0.5
X4197 BLN9 rr3t3r_0[51|9]/a_860_290# sky130_fd_pr_reram__reram_cell area_ox=0.0676
X4198 rr3t3r_0[51|9]/a_60_290# WL51 SL9 VSS sky130_fd_pr__nfet_g5v0d10v5 ad=0.65 pd=3.3 as=0 ps=0 w=1 l=0.5
X4199 rr3t3r_0[51|9]/a_860_290# WL51 SL9 VSS sky130_fd_pr__nfet_g5v0d10v5 ad=0.65 pd=3.3 as=0 ps=0 w=1 l=0.5
X4200 BLP9 rr3t3r_0[52|9]/a_60_290# sky130_fd_pr_reram__reram_cell area_ox=0.0676
X4201 BLZ9 rr3t3r_0[52|9]/a_460_290# sky130_fd_pr_reram__reram_cell area_ox=0.0676
X4202 rr3t3r_0[52|9]/a_460_290# WL52 SL9 VSS sky130_fd_pr__nfet_g5v0d10v5 ad=0.65 pd=3.3 as=0 ps=0 w=1 l=0.5
X4203 BLN9 rr3t3r_0[52|9]/a_860_290# sky130_fd_pr_reram__reram_cell area_ox=0.0676
X4204 rr3t3r_0[52|9]/a_60_290# WL52 SL9 VSS sky130_fd_pr__nfet_g5v0d10v5 ad=0.65 pd=3.3 as=0 ps=0 w=1 l=0.5
X4205 rr3t3r_0[52|9]/a_860_290# WL52 SL9 VSS sky130_fd_pr__nfet_g5v0d10v5 ad=0.65 pd=3.3 as=0 ps=0 w=1 l=0.5
X4206 BLP9 rr3t3r_0[53|9]/a_60_290# sky130_fd_pr_reram__reram_cell area_ox=0.0676
X4207 BLZ9 rr3t3r_0[53|9]/a_460_290# sky130_fd_pr_reram__reram_cell area_ox=0.0676
X4208 rr3t3r_0[53|9]/a_460_290# WL53 SL9 VSS sky130_fd_pr__nfet_g5v0d10v5 ad=0.65 pd=3.3 as=0 ps=0 w=1 l=0.5
X4209 BLN9 rr3t3r_0[53|9]/a_860_290# sky130_fd_pr_reram__reram_cell area_ox=0.0676
X4210 rr3t3r_0[53|9]/a_60_290# WL53 SL9 VSS sky130_fd_pr__nfet_g5v0d10v5 ad=0.65 pd=3.3 as=0 ps=0 w=1 l=0.5
X4211 rr3t3r_0[53|9]/a_860_290# WL53 SL9 VSS sky130_fd_pr__nfet_g5v0d10v5 ad=0.65 pd=3.3 as=0 ps=0 w=1 l=0.5
X4212 BLP9 rr3t3r_0[54|9]/a_60_290# sky130_fd_pr_reram__reram_cell area_ox=0.0676
X4213 BLZ9 rr3t3r_0[54|9]/a_460_290# sky130_fd_pr_reram__reram_cell area_ox=0.0676
X4214 rr3t3r_0[54|9]/a_460_290# WL54 SL9 VSS sky130_fd_pr__nfet_g5v0d10v5 ad=0.65 pd=3.3 as=0 ps=0 w=1 l=0.5
X4215 BLN9 rr3t3r_0[54|9]/a_860_290# sky130_fd_pr_reram__reram_cell area_ox=0.0676
X4216 rr3t3r_0[54|9]/a_60_290# WL54 SL9 VSS sky130_fd_pr__nfet_g5v0d10v5 ad=0.65 pd=3.3 as=0 ps=0 w=1 l=0.5
X4217 rr3t3r_0[54|9]/a_860_290# WL54 SL9 VSS sky130_fd_pr__nfet_g5v0d10v5 ad=0.65 pd=3.3 as=0 ps=0 w=1 l=0.5
X4218 BLP9 rr3t3r_0[55|9]/a_60_290# sky130_fd_pr_reram__reram_cell area_ox=0.0676
X4219 BLZ9 rr3t3r_0[55|9]/a_460_290# sky130_fd_pr_reram__reram_cell area_ox=0.0676
X4220 rr3t3r_0[55|9]/a_460_290# WL55 SL9 VSS sky130_fd_pr__nfet_g5v0d10v5 ad=0.65 pd=3.3 as=0 ps=0 w=1 l=0.5
X4221 BLN9 rr3t3r_0[55|9]/a_860_290# sky130_fd_pr_reram__reram_cell area_ox=0.0676
X4222 rr3t3r_0[55|9]/a_60_290# WL55 SL9 VSS sky130_fd_pr__nfet_g5v0d10v5 ad=0.65 pd=3.3 as=0 ps=0 w=1 l=0.5
X4223 rr3t3r_0[55|9]/a_860_290# WL55 SL9 VSS sky130_fd_pr__nfet_g5v0d10v5 ad=0.65 pd=3.3 as=0 ps=0 w=1 l=0.5
X4224 BLP9 rr3t3r_0[56|9]/a_60_290# sky130_fd_pr_reram__reram_cell area_ox=0.0676
X4225 BLZ9 rr3t3r_0[56|9]/a_460_290# sky130_fd_pr_reram__reram_cell area_ox=0.0676
X4226 rr3t3r_0[56|9]/a_460_290# WL56 SL9 VSS sky130_fd_pr__nfet_g5v0d10v5 ad=0.65 pd=3.3 as=0 ps=0 w=1 l=0.5
X4227 BLN9 rr3t3r_0[56|9]/a_860_290# sky130_fd_pr_reram__reram_cell area_ox=0.0676
X4228 rr3t3r_0[56|9]/a_60_290# WL56 SL9 VSS sky130_fd_pr__nfet_g5v0d10v5 ad=0.65 pd=3.3 as=0 ps=0 w=1 l=0.5
X4229 rr3t3r_0[56|9]/a_860_290# WL56 SL9 VSS sky130_fd_pr__nfet_g5v0d10v5 ad=0.65 pd=3.3 as=0 ps=0 w=1 l=0.5
X4230 BLP9 rr3t3r_0[57|9]/a_60_290# sky130_fd_pr_reram__reram_cell area_ox=0.0676
X4231 BLZ9 rr3t3r_0[57|9]/a_460_290# sky130_fd_pr_reram__reram_cell area_ox=0.0676
X4232 rr3t3r_0[57|9]/a_460_290# WL57 SL9 VSS sky130_fd_pr__nfet_g5v0d10v5 ad=0.65 pd=3.3 as=0 ps=0 w=1 l=0.5
X4233 BLN9 rr3t3r_0[57|9]/a_860_290# sky130_fd_pr_reram__reram_cell area_ox=0.0676
X4234 rr3t3r_0[57|9]/a_60_290# WL57 SL9 VSS sky130_fd_pr__nfet_g5v0d10v5 ad=0.65 pd=3.3 as=0 ps=0 w=1 l=0.5
X4235 rr3t3r_0[57|9]/a_860_290# WL57 SL9 VSS sky130_fd_pr__nfet_g5v0d10v5 ad=0.65 pd=3.3 as=0 ps=0 w=1 l=0.5
X4236 BLP9 rr3t3r_0[58|9]/a_60_290# sky130_fd_pr_reram__reram_cell area_ox=0.0676
X4237 BLZ9 rr3t3r_0[58|9]/a_460_290# sky130_fd_pr_reram__reram_cell area_ox=0.0676
X4238 rr3t3r_0[58|9]/a_460_290# WL58 SL9 VSS sky130_fd_pr__nfet_g5v0d10v5 ad=0.65 pd=3.3 as=0 ps=0 w=1 l=0.5
X4239 BLN9 rr3t3r_0[58|9]/a_860_290# sky130_fd_pr_reram__reram_cell area_ox=0.0676
X4240 rr3t3r_0[58|9]/a_60_290# WL58 SL9 VSS sky130_fd_pr__nfet_g5v0d10v5 ad=0.65 pd=3.3 as=0 ps=0 w=1 l=0.5
X4241 rr3t3r_0[58|9]/a_860_290# WL58 SL9 VSS sky130_fd_pr__nfet_g5v0d10v5 ad=0.65 pd=3.3 as=0 ps=0 w=1 l=0.5
X4242 BLP9 rr3t3r_0[59|9]/a_60_290# sky130_fd_pr_reram__reram_cell area_ox=0.0676
X4243 BLZ9 rr3t3r_0[59|9]/a_460_290# sky130_fd_pr_reram__reram_cell area_ox=0.0676
X4244 rr3t3r_0[59|9]/a_460_290# WL59 SL9 VSS sky130_fd_pr__nfet_g5v0d10v5 ad=0.65 pd=3.3 as=0 ps=0 w=1 l=0.5
X4245 BLN9 rr3t3r_0[59|9]/a_860_290# sky130_fd_pr_reram__reram_cell area_ox=0.0676
X4246 rr3t3r_0[59|9]/a_60_290# WL59 SL9 VSS sky130_fd_pr__nfet_g5v0d10v5 ad=0.65 pd=3.3 as=0 ps=0 w=1 l=0.5
X4247 rr3t3r_0[59|9]/a_860_290# WL59 SL9 VSS sky130_fd_pr__nfet_g5v0d10v5 ad=0.65 pd=3.3 as=0 ps=0 w=1 l=0.5
X4248 BLP9 rr3t3r_0[60|9]/a_60_290# sky130_fd_pr_reram__reram_cell area_ox=0.0676
X4249 BLZ9 rr3t3r_0[60|9]/a_460_290# sky130_fd_pr_reram__reram_cell area_ox=0.0676
X4250 rr3t3r_0[60|9]/a_460_290# WL60 SL9 VSS sky130_fd_pr__nfet_g5v0d10v5 ad=0.65 pd=3.3 as=0 ps=0 w=1 l=0.5
X4251 BLN9 rr3t3r_0[60|9]/a_860_290# sky130_fd_pr_reram__reram_cell area_ox=0.0676
X4252 rr3t3r_0[60|9]/a_60_290# WL60 SL9 VSS sky130_fd_pr__nfet_g5v0d10v5 ad=0.65 pd=3.3 as=0 ps=0 w=1 l=0.5
X4253 rr3t3r_0[60|9]/a_860_290# WL60 SL9 VSS sky130_fd_pr__nfet_g5v0d10v5 ad=0.65 pd=3.3 as=0 ps=0 w=1 l=0.5
X4254 BLP9 rr3t3r_0[61|9]/a_60_290# sky130_fd_pr_reram__reram_cell area_ox=0.0676
X4255 BLZ9 rr3t3r_0[61|9]/a_460_290# sky130_fd_pr_reram__reram_cell area_ox=0.0676
X4256 rr3t3r_0[61|9]/a_460_290# WL61 SL9 VSS sky130_fd_pr__nfet_g5v0d10v5 ad=0.65 pd=3.3 as=0 ps=0 w=1 l=0.5
X4257 BLN9 rr3t3r_0[61|9]/a_860_290# sky130_fd_pr_reram__reram_cell area_ox=0.0676
X4258 rr3t3r_0[61|9]/a_60_290# WL61 SL9 VSS sky130_fd_pr__nfet_g5v0d10v5 ad=0.65 pd=3.3 as=0 ps=0 w=1 l=0.5
X4259 rr3t3r_0[61|9]/a_860_290# WL61 SL9 VSS sky130_fd_pr__nfet_g5v0d10v5 ad=0.65 pd=3.3 as=0 ps=0 w=1 l=0.5
X4260 BLP9 rr3t3r_0[62|9]/a_60_290# sky130_fd_pr_reram__reram_cell area_ox=0.0676
X4261 BLZ9 rr3t3r_0[62|9]/a_460_290# sky130_fd_pr_reram__reram_cell area_ox=0.0676
X4262 rr3t3r_0[62|9]/a_460_290# WL62 SL9 VSS sky130_fd_pr__nfet_g5v0d10v5 ad=0.65 pd=3.3 as=0 ps=0 w=1 l=0.5
X4263 BLN9 rr3t3r_0[62|9]/a_860_290# sky130_fd_pr_reram__reram_cell area_ox=0.0676
X4264 rr3t3r_0[62|9]/a_60_290# WL62 SL9 VSS sky130_fd_pr__nfet_g5v0d10v5 ad=0.65 pd=3.3 as=0 ps=0 w=1 l=0.5
X4265 rr3t3r_0[62|9]/a_860_290# WL62 SL9 VSS sky130_fd_pr__nfet_g5v0d10v5 ad=0.65 pd=3.3 as=0 ps=0 w=1 l=0.5
X4266 BLP9 rr3t3r_0[63|9]/a_60_290# sky130_fd_pr_reram__reram_cell area_ox=0.0676
X4267 BLZ9 rr3t3r_0[63|9]/a_460_290# sky130_fd_pr_reram__reram_cell area_ox=0.0676
X4268 rr3t3r_0[63|9]/a_460_290# WL63 SL9 VSS sky130_fd_pr__nfet_g5v0d10v5 ad=0.65 pd=3.3 as=0 ps=0 w=1 l=0.5
X4269 BLN9 rr3t3r_0[63|9]/a_860_290# sky130_fd_pr_reram__reram_cell area_ox=0.0676
X4270 rr3t3r_0[63|9]/a_60_290# WL63 SL9 VSS sky130_fd_pr__nfet_g5v0d10v5 ad=0.65 pd=3.3 as=0 ps=0 w=1 l=0.5
X4271 rr3t3r_0[63|9]/a_860_290# WL63 SL9 VSS sky130_fd_pr__nfet_g5v0d10v5 ad=0.65 pd=3.3 as=0 ps=0 w=1 l=0.5
X4272 BLP9 rr3t3r_0[64|9]/a_60_290# sky130_fd_pr_reram__reram_cell area_ox=0.0676
X4273 BLZ9 rr3t3r_0[64|9]/a_460_290# sky130_fd_pr_reram__reram_cell area_ox=0.0676
X4274 rr3t3r_0[64|9]/a_460_290# WL64 SL9 VSS sky130_fd_pr__nfet_g5v0d10v5 ad=0.65 pd=3.3 as=0 ps=0 w=1 l=0.5
X4275 BLN9 rr3t3r_0[64|9]/a_860_290# sky130_fd_pr_reram__reram_cell area_ox=0.0676
X4276 rr3t3r_0[64|9]/a_60_290# WL64 SL9 VSS sky130_fd_pr__nfet_g5v0d10v5 ad=0.65 pd=3.3 as=0 ps=0 w=1 l=0.5
X4277 rr3t3r_0[64|9]/a_860_290# WL64 SL9 VSS sky130_fd_pr__nfet_g5v0d10v5 ad=0.65 pd=3.3 as=0 ps=0 w=1 l=0.5
X4278 BLP9 rr3t3r_0[65|9]/a_60_290# sky130_fd_pr_reram__reram_cell area_ox=0.0676
X4279 BLZ9 rr3t3r_0[65|9]/a_460_290# sky130_fd_pr_reram__reram_cell area_ox=0.0676
X4280 rr3t3r_0[65|9]/a_460_290# WL65 SL9 VSS sky130_fd_pr__nfet_g5v0d10v5 ad=0.65 pd=3.3 as=0 ps=0 w=1 l=0.5
X4281 BLN9 rr3t3r_0[65|9]/a_860_290# sky130_fd_pr_reram__reram_cell area_ox=0.0676
X4282 rr3t3r_0[65|9]/a_60_290# WL65 SL9 VSS sky130_fd_pr__nfet_g5v0d10v5 ad=0.65 pd=3.3 as=0 ps=0 w=1 l=0.5
X4283 rr3t3r_0[65|9]/a_860_290# WL65 SL9 VSS sky130_fd_pr__nfet_g5v0d10v5 ad=0.65 pd=3.3 as=0 ps=0 w=1 l=0.5
X4284 BLP9 rr3t3r_0[66|9]/a_60_290# sky130_fd_pr_reram__reram_cell area_ox=0.0676
X4285 BLZ9 rr3t3r_0[66|9]/a_460_290# sky130_fd_pr_reram__reram_cell area_ox=0.0676
X4286 rr3t3r_0[66|9]/a_460_290# WL66 SL9 VSS sky130_fd_pr__nfet_g5v0d10v5 ad=0.65 pd=3.3 as=0 ps=0 w=1 l=0.5
X4287 BLN9 rr3t3r_0[66|9]/a_860_290# sky130_fd_pr_reram__reram_cell area_ox=0.0676
X4288 rr3t3r_0[66|9]/a_60_290# WL66 SL9 VSS sky130_fd_pr__nfet_g5v0d10v5 ad=0.65 pd=3.3 as=0 ps=0 w=1 l=0.5
X4289 rr3t3r_0[66|9]/a_860_290# WL66 SL9 VSS sky130_fd_pr__nfet_g5v0d10v5 ad=0.65 pd=3.3 as=0 ps=0 w=1 l=0.5
X4290 BLP9 rr3t3r_0[67|9]/a_60_290# sky130_fd_pr_reram__reram_cell area_ox=0.0676
X4291 BLZ9 rr3t3r_0[67|9]/a_460_290# sky130_fd_pr_reram__reram_cell area_ox=0.0676
X4292 rr3t3r_0[67|9]/a_460_290# WL67 SL9 VSS sky130_fd_pr__nfet_g5v0d10v5 ad=0.65 pd=3.3 as=0 ps=0 w=1 l=0.5
X4293 BLN9 rr3t3r_0[67|9]/a_860_290# sky130_fd_pr_reram__reram_cell area_ox=0.0676
X4294 rr3t3r_0[67|9]/a_60_290# WL67 SL9 VSS sky130_fd_pr__nfet_g5v0d10v5 ad=0.65 pd=3.3 as=0 ps=0 w=1 l=0.5
X4295 rr3t3r_0[67|9]/a_860_290# WL67 SL9 VSS sky130_fd_pr__nfet_g5v0d10v5 ad=0.65 pd=3.3 as=0 ps=0 w=1 l=0.5
X4296 BLP9 rr3t3r_0[68|9]/a_60_290# sky130_fd_pr_reram__reram_cell area_ox=0.0676
X4297 BLZ9 rr3t3r_0[68|9]/a_460_290# sky130_fd_pr_reram__reram_cell area_ox=0.0676
X4298 rr3t3r_0[68|9]/a_460_290# WL68 SL9 VSS sky130_fd_pr__nfet_g5v0d10v5 ad=0.65 pd=3.3 as=0 ps=0 w=1 l=0.5
X4299 BLN9 rr3t3r_0[68|9]/a_860_290# sky130_fd_pr_reram__reram_cell area_ox=0.0676
X4300 rr3t3r_0[68|9]/a_60_290# WL68 SL9 VSS sky130_fd_pr__nfet_g5v0d10v5 ad=0.65 pd=3.3 as=0 ps=0 w=1 l=0.5
X4301 rr3t3r_0[68|9]/a_860_290# WL68 SL9 VSS sky130_fd_pr__nfet_g5v0d10v5 ad=0.65 pd=3.3 as=0 ps=0 w=1 l=0.5
X4302 BLP9 rr3t3r_0[69|9]/a_60_290# sky130_fd_pr_reram__reram_cell area_ox=0.0676
X4303 BLZ9 rr3t3r_0[69|9]/a_460_290# sky130_fd_pr_reram__reram_cell area_ox=0.0676
X4304 rr3t3r_0[69|9]/a_460_290# WL69 SL9 VSS sky130_fd_pr__nfet_g5v0d10v5 ad=0.65 pd=3.3 as=0 ps=0 w=1 l=0.5
X4305 BLN9 rr3t3r_0[69|9]/a_860_290# sky130_fd_pr_reram__reram_cell area_ox=0.0676
X4306 rr3t3r_0[69|9]/a_60_290# WL69 SL9 VSS sky130_fd_pr__nfet_g5v0d10v5 ad=0.65 pd=3.3 as=0 ps=0 w=1 l=0.5
X4307 rr3t3r_0[69|9]/a_860_290# WL69 SL9 VSS sky130_fd_pr__nfet_g5v0d10v5 ad=0.65 pd=3.3 as=0 ps=0 w=1 l=0.5
X4308 BLP9 rr3t3r_0[70|9]/a_60_290# sky130_fd_pr_reram__reram_cell area_ox=0.0676
X4309 BLZ9 rr3t3r_0[70|9]/a_460_290# sky130_fd_pr_reram__reram_cell area_ox=0.0676
X4310 rr3t3r_0[70|9]/a_460_290# WL70 SL9 VSS sky130_fd_pr__nfet_g5v0d10v5 ad=0.65 pd=3.3 as=0 ps=0 w=1 l=0.5
X4311 BLN9 rr3t3r_0[70|9]/a_860_290# sky130_fd_pr_reram__reram_cell area_ox=0.0676
X4312 rr3t3r_0[70|9]/a_60_290# WL70 SL9 VSS sky130_fd_pr__nfet_g5v0d10v5 ad=0.65 pd=3.3 as=0 ps=0 w=1 l=0.5
X4313 rr3t3r_0[70|9]/a_860_290# WL70 SL9 VSS sky130_fd_pr__nfet_g5v0d10v5 ad=0.65 pd=3.3 as=0 ps=0 w=1 l=0.5
X4314 BLP9 rr3t3r_0[71|9]/a_60_290# sky130_fd_pr_reram__reram_cell area_ox=0.0676
X4315 BLZ9 rr3t3r_0[71|9]/a_460_290# sky130_fd_pr_reram__reram_cell area_ox=0.0676
X4316 rr3t3r_0[71|9]/a_460_290# WL71 SL9 VSS sky130_fd_pr__nfet_g5v0d10v5 ad=0.65 pd=3.3 as=0 ps=0 w=1 l=0.5
X4317 BLN9 rr3t3r_0[71|9]/a_860_290# sky130_fd_pr_reram__reram_cell area_ox=0.0676
X4318 rr3t3r_0[71|9]/a_60_290# WL71 SL9 VSS sky130_fd_pr__nfet_g5v0d10v5 ad=0.65 pd=3.3 as=0 ps=0 w=1 l=0.5
X4319 rr3t3r_0[71|9]/a_860_290# WL71 SL9 VSS sky130_fd_pr__nfet_g5v0d10v5 ad=0.65 pd=3.3 as=0 ps=0 w=1 l=0.5
X4320 BLP10 rr3t3r_0[0|10]/a_60_290# sky130_fd_pr_reram__reram_cell area_ox=0.0676
X4321 BLZ10 rr3t3r_0[0|10]/a_460_290# sky130_fd_pr_reram__reram_cell area_ox=0.0676
X4322 rr3t3r_0[0|10]/a_460_290# WL0 SL10 VSS sky130_fd_pr__nfet_g5v0d10v5 ad=0.65 pd=3.3 as=162 ps=756 w=1 l=0.5
X4323 BLN10 rr3t3r_0[0|10]/a_860_290# sky130_fd_pr_reram__reram_cell area_ox=0.0676
X4324 rr3t3r_0[0|10]/a_60_290# WL0 SL10 VSS sky130_fd_pr__nfet_g5v0d10v5 ad=0.65 pd=3.3 as=0 ps=0 w=1 l=0.5
X4325 rr3t3r_0[0|10]/a_860_290# WL0 SL10 VSS sky130_fd_pr__nfet_g5v0d10v5 ad=0.65 pd=3.3 as=0 ps=0 w=1 l=0.5
X4326 BLP10 rr3t3r_0[1|10]/a_60_290# sky130_fd_pr_reram__reram_cell area_ox=0.0676
X4327 BLZ10 rr3t3r_0[1|10]/a_460_290# sky130_fd_pr_reram__reram_cell area_ox=0.0676
X4328 rr3t3r_0[1|10]/a_460_290# WL1 SL10 VSS sky130_fd_pr__nfet_g5v0d10v5 ad=0.65 pd=3.3 as=0 ps=0 w=1 l=0.5
X4329 BLN10 rr3t3r_0[1|10]/a_860_290# sky130_fd_pr_reram__reram_cell area_ox=0.0676
X4330 rr3t3r_0[1|10]/a_60_290# WL1 SL10 VSS sky130_fd_pr__nfet_g5v0d10v5 ad=0.65 pd=3.3 as=0 ps=0 w=1 l=0.5
X4331 rr3t3r_0[1|10]/a_860_290# WL1 SL10 VSS sky130_fd_pr__nfet_g5v0d10v5 ad=0.65 pd=3.3 as=0 ps=0 w=1 l=0.5
X4332 BLP10 rr3t3r_0[2|10]/a_60_290# sky130_fd_pr_reram__reram_cell area_ox=0.0676
X4333 BLZ10 rr3t3r_0[2|10]/a_460_290# sky130_fd_pr_reram__reram_cell area_ox=0.0676
X4334 rr3t3r_0[2|10]/a_460_290# WL2 SL10 VSS sky130_fd_pr__nfet_g5v0d10v5 ad=0.65 pd=3.3 as=0 ps=0 w=1 l=0.5
X4335 BLN10 rr3t3r_0[2|10]/a_860_290# sky130_fd_pr_reram__reram_cell area_ox=0.0676
X4336 rr3t3r_0[2|10]/a_60_290# WL2 SL10 VSS sky130_fd_pr__nfet_g5v0d10v5 ad=0.65 pd=3.3 as=0 ps=0 w=1 l=0.5
X4337 rr3t3r_0[2|10]/a_860_290# WL2 SL10 VSS sky130_fd_pr__nfet_g5v0d10v5 ad=0.65 pd=3.3 as=0 ps=0 w=1 l=0.5
X4338 BLP10 rr3t3r_0[3|10]/a_60_290# sky130_fd_pr_reram__reram_cell area_ox=0.0676
X4339 BLZ10 rr3t3r_0[3|10]/a_460_290# sky130_fd_pr_reram__reram_cell area_ox=0.0676
X4340 rr3t3r_0[3|10]/a_460_290# WL3 SL10 VSS sky130_fd_pr__nfet_g5v0d10v5 ad=0.65 pd=3.3 as=0 ps=0 w=1 l=0.5
X4341 BLN10 rr3t3r_0[3|10]/a_860_290# sky130_fd_pr_reram__reram_cell area_ox=0.0676
X4342 rr3t3r_0[3|10]/a_60_290# WL3 SL10 VSS sky130_fd_pr__nfet_g5v0d10v5 ad=0.65 pd=3.3 as=0 ps=0 w=1 l=0.5
X4343 rr3t3r_0[3|10]/a_860_290# WL3 SL10 VSS sky130_fd_pr__nfet_g5v0d10v5 ad=0.65 pd=3.3 as=0 ps=0 w=1 l=0.5
X4344 BLP10 rr3t3r_0[4|10]/a_60_290# sky130_fd_pr_reram__reram_cell area_ox=0.0676
X4345 BLZ10 rr3t3r_0[4|10]/a_460_290# sky130_fd_pr_reram__reram_cell area_ox=0.0676
X4346 rr3t3r_0[4|10]/a_460_290# WL4 SL10 VSS sky130_fd_pr__nfet_g5v0d10v5 ad=0.65 pd=3.3 as=0 ps=0 w=1 l=0.5
X4347 BLN10 rr3t3r_0[4|10]/a_860_290# sky130_fd_pr_reram__reram_cell area_ox=0.0676
X4348 rr3t3r_0[4|10]/a_60_290# WL4 SL10 VSS sky130_fd_pr__nfet_g5v0d10v5 ad=0.65 pd=3.3 as=0 ps=0 w=1 l=0.5
X4349 rr3t3r_0[4|10]/a_860_290# WL4 SL10 VSS sky130_fd_pr__nfet_g5v0d10v5 ad=0.65 pd=3.3 as=0 ps=0 w=1 l=0.5
X4350 BLP10 rr3t3r_0[5|10]/a_60_290# sky130_fd_pr_reram__reram_cell area_ox=0.0676
X4351 BLZ10 rr3t3r_0[5|10]/a_460_290# sky130_fd_pr_reram__reram_cell area_ox=0.0676
X4352 rr3t3r_0[5|10]/a_460_290# WL5 SL10 VSS sky130_fd_pr__nfet_g5v0d10v5 ad=0.65 pd=3.3 as=0 ps=0 w=1 l=0.5
X4353 BLN10 rr3t3r_0[5|10]/a_860_290# sky130_fd_pr_reram__reram_cell area_ox=0.0676
X4354 rr3t3r_0[5|10]/a_60_290# WL5 SL10 VSS sky130_fd_pr__nfet_g5v0d10v5 ad=0.65 pd=3.3 as=0 ps=0 w=1 l=0.5
X4355 rr3t3r_0[5|10]/a_860_290# WL5 SL10 VSS sky130_fd_pr__nfet_g5v0d10v5 ad=0.65 pd=3.3 as=0 ps=0 w=1 l=0.5
X4356 BLP10 rr3t3r_0[6|10]/a_60_290# sky130_fd_pr_reram__reram_cell area_ox=0.0676
X4357 BLZ10 rr3t3r_0[6|10]/a_460_290# sky130_fd_pr_reram__reram_cell area_ox=0.0676
X4358 rr3t3r_0[6|10]/a_460_290# WL6 SL10 VSS sky130_fd_pr__nfet_g5v0d10v5 ad=0.65 pd=3.3 as=0 ps=0 w=1 l=0.5
X4359 BLN10 rr3t3r_0[6|10]/a_860_290# sky130_fd_pr_reram__reram_cell area_ox=0.0676
X4360 rr3t3r_0[6|10]/a_60_290# WL6 SL10 VSS sky130_fd_pr__nfet_g5v0d10v5 ad=0.65 pd=3.3 as=0 ps=0 w=1 l=0.5
X4361 rr3t3r_0[6|10]/a_860_290# WL6 SL10 VSS sky130_fd_pr__nfet_g5v0d10v5 ad=0.65 pd=3.3 as=0 ps=0 w=1 l=0.5
X4362 BLP10 rr3t3r_0[7|10]/a_60_290# sky130_fd_pr_reram__reram_cell area_ox=0.0676
X4363 BLZ10 rr3t3r_0[7|10]/a_460_290# sky130_fd_pr_reram__reram_cell area_ox=0.0676
X4364 rr3t3r_0[7|10]/a_460_290# WL7 SL10 VSS sky130_fd_pr__nfet_g5v0d10v5 ad=0.65 pd=3.3 as=0 ps=0 w=1 l=0.5
X4365 BLN10 rr3t3r_0[7|10]/a_860_290# sky130_fd_pr_reram__reram_cell area_ox=0.0676
X4366 rr3t3r_0[7|10]/a_60_290# WL7 SL10 VSS sky130_fd_pr__nfet_g5v0d10v5 ad=0.65 pd=3.3 as=0 ps=0 w=1 l=0.5
X4367 rr3t3r_0[7|10]/a_860_290# WL7 SL10 VSS sky130_fd_pr__nfet_g5v0d10v5 ad=0.65 pd=3.3 as=0 ps=0 w=1 l=0.5
X4368 BLP10 rr3t3r_0[8|10]/a_60_290# sky130_fd_pr_reram__reram_cell area_ox=0.0676
X4369 BLZ10 rr3t3r_0[8|10]/a_460_290# sky130_fd_pr_reram__reram_cell area_ox=0.0676
X4370 rr3t3r_0[8|10]/a_460_290# WL8 SL10 VSS sky130_fd_pr__nfet_g5v0d10v5 ad=0.65 pd=3.3 as=0 ps=0 w=1 l=0.5
X4371 BLN10 rr3t3r_0[8|10]/a_860_290# sky130_fd_pr_reram__reram_cell area_ox=0.0676
X4372 rr3t3r_0[8|10]/a_60_290# WL8 SL10 VSS sky130_fd_pr__nfet_g5v0d10v5 ad=0.65 pd=3.3 as=0 ps=0 w=1 l=0.5
X4373 rr3t3r_0[8|10]/a_860_290# WL8 SL10 VSS sky130_fd_pr__nfet_g5v0d10v5 ad=0.65 pd=3.3 as=0 ps=0 w=1 l=0.5
X4374 BLP10 rr3t3r_0[9|10]/a_60_290# sky130_fd_pr_reram__reram_cell area_ox=0.0676
X4375 BLZ10 rr3t3r_0[9|10]/a_460_290# sky130_fd_pr_reram__reram_cell area_ox=0.0676
X4376 rr3t3r_0[9|10]/a_460_290# WL9 SL10 VSS sky130_fd_pr__nfet_g5v0d10v5 ad=0.65 pd=3.3 as=0 ps=0 w=1 l=0.5
X4377 BLN10 rr3t3r_0[9|10]/a_860_290# sky130_fd_pr_reram__reram_cell area_ox=0.0676
X4378 rr3t3r_0[9|10]/a_60_290# WL9 SL10 VSS sky130_fd_pr__nfet_g5v0d10v5 ad=0.65 pd=3.3 as=0 ps=0 w=1 l=0.5
X4379 rr3t3r_0[9|10]/a_860_290# WL9 SL10 VSS sky130_fd_pr__nfet_g5v0d10v5 ad=0.65 pd=3.3 as=0 ps=0 w=1 l=0.5
X4380 BLP10 rr3t3r_0[10|10]/a_60_290# sky130_fd_pr_reram__reram_cell area_ox=0.0676
X4381 BLZ10 rr3t3r_0[10|10]/a_460_290# sky130_fd_pr_reram__reram_cell area_ox=0.0676
X4382 rr3t3r_0[10|10]/a_460_290# WL10 SL10 VSS sky130_fd_pr__nfet_g5v0d10v5 ad=0.65 pd=3.3 as=0 ps=0 w=1 l=0.5
X4383 BLN10 rr3t3r_0[10|10]/a_860_290# sky130_fd_pr_reram__reram_cell area_ox=0.0676
X4384 rr3t3r_0[10|10]/a_60_290# WL10 SL10 VSS sky130_fd_pr__nfet_g5v0d10v5 ad=0.65 pd=3.3 as=0 ps=0 w=1 l=0.5
X4385 rr3t3r_0[10|10]/a_860_290# WL10 SL10 VSS sky130_fd_pr__nfet_g5v0d10v5 ad=0.65 pd=3.3 as=0 ps=0 w=1 l=0.5
X4386 BLP10 rr3t3r_0[11|10]/a_60_290# sky130_fd_pr_reram__reram_cell area_ox=0.0676
X4387 BLZ10 rr3t3r_0[11|10]/a_460_290# sky130_fd_pr_reram__reram_cell area_ox=0.0676
X4388 rr3t3r_0[11|10]/a_460_290# WL11 SL10 VSS sky130_fd_pr__nfet_g5v0d10v5 ad=0.65 pd=3.3 as=0 ps=0 w=1 l=0.5
X4389 BLN10 rr3t3r_0[11|10]/a_860_290# sky130_fd_pr_reram__reram_cell area_ox=0.0676
X4390 rr3t3r_0[11|10]/a_60_290# WL11 SL10 VSS sky130_fd_pr__nfet_g5v0d10v5 ad=0.65 pd=3.3 as=0 ps=0 w=1 l=0.5
X4391 rr3t3r_0[11|10]/a_860_290# WL11 SL10 VSS sky130_fd_pr__nfet_g5v0d10v5 ad=0.65 pd=3.3 as=0 ps=0 w=1 l=0.5
X4392 BLP10 rr3t3r_0[12|10]/a_60_290# sky130_fd_pr_reram__reram_cell area_ox=0.0676
X4393 BLZ10 rr3t3r_0[12|10]/a_460_290# sky130_fd_pr_reram__reram_cell area_ox=0.0676
X4394 rr3t3r_0[12|10]/a_460_290# WL12 SL10 VSS sky130_fd_pr__nfet_g5v0d10v5 ad=0.65 pd=3.3 as=0 ps=0 w=1 l=0.5
X4395 BLN10 rr3t3r_0[12|10]/a_860_290# sky130_fd_pr_reram__reram_cell area_ox=0.0676
X4396 rr3t3r_0[12|10]/a_60_290# WL12 SL10 VSS sky130_fd_pr__nfet_g5v0d10v5 ad=0.65 pd=3.3 as=0 ps=0 w=1 l=0.5
X4397 rr3t3r_0[12|10]/a_860_290# WL12 SL10 VSS sky130_fd_pr__nfet_g5v0d10v5 ad=0.65 pd=3.3 as=0 ps=0 w=1 l=0.5
X4398 BLP10 rr3t3r_0[13|10]/a_60_290# sky130_fd_pr_reram__reram_cell area_ox=0.0676
X4399 BLZ10 rr3t3r_0[13|10]/a_460_290# sky130_fd_pr_reram__reram_cell area_ox=0.0676
X4400 rr3t3r_0[13|10]/a_460_290# WL13 SL10 VSS sky130_fd_pr__nfet_g5v0d10v5 ad=0.65 pd=3.3 as=0 ps=0 w=1 l=0.5
X4401 BLN10 rr3t3r_0[13|10]/a_860_290# sky130_fd_pr_reram__reram_cell area_ox=0.0676
X4402 rr3t3r_0[13|10]/a_60_290# WL13 SL10 VSS sky130_fd_pr__nfet_g5v0d10v5 ad=0.65 pd=3.3 as=0 ps=0 w=1 l=0.5
X4403 rr3t3r_0[13|10]/a_860_290# WL13 SL10 VSS sky130_fd_pr__nfet_g5v0d10v5 ad=0.65 pd=3.3 as=0 ps=0 w=1 l=0.5
X4404 BLP10 rr3t3r_0[14|10]/a_60_290# sky130_fd_pr_reram__reram_cell area_ox=0.0676
X4405 BLZ10 rr3t3r_0[14|10]/a_460_290# sky130_fd_pr_reram__reram_cell area_ox=0.0676
X4406 rr3t3r_0[14|10]/a_460_290# WL14 SL10 VSS sky130_fd_pr__nfet_g5v0d10v5 ad=0.65 pd=3.3 as=0 ps=0 w=1 l=0.5
X4407 BLN10 rr3t3r_0[14|10]/a_860_290# sky130_fd_pr_reram__reram_cell area_ox=0.0676
X4408 rr3t3r_0[14|10]/a_60_290# WL14 SL10 VSS sky130_fd_pr__nfet_g5v0d10v5 ad=0.65 pd=3.3 as=0 ps=0 w=1 l=0.5
X4409 rr3t3r_0[14|10]/a_860_290# WL14 SL10 VSS sky130_fd_pr__nfet_g5v0d10v5 ad=0.65 pd=3.3 as=0 ps=0 w=1 l=0.5
X4410 BLP10 rr3t3r_0[15|10]/a_60_290# sky130_fd_pr_reram__reram_cell area_ox=0.0676
X4411 BLZ10 rr3t3r_0[15|10]/a_460_290# sky130_fd_pr_reram__reram_cell area_ox=0.0676
X4412 rr3t3r_0[15|10]/a_460_290# WL15 SL10 VSS sky130_fd_pr__nfet_g5v0d10v5 ad=0.65 pd=3.3 as=0 ps=0 w=1 l=0.5
X4413 BLN10 rr3t3r_0[15|10]/a_860_290# sky130_fd_pr_reram__reram_cell area_ox=0.0676
X4414 rr3t3r_0[15|10]/a_60_290# WL15 SL10 VSS sky130_fd_pr__nfet_g5v0d10v5 ad=0.65 pd=3.3 as=0 ps=0 w=1 l=0.5
X4415 rr3t3r_0[15|10]/a_860_290# WL15 SL10 VSS sky130_fd_pr__nfet_g5v0d10v5 ad=0.65 pd=3.3 as=0 ps=0 w=1 l=0.5
X4416 BLP10 rr3t3r_0[16|10]/a_60_290# sky130_fd_pr_reram__reram_cell area_ox=0.0676
X4417 BLZ10 rr3t3r_0[16|10]/a_460_290# sky130_fd_pr_reram__reram_cell area_ox=0.0676
X4418 rr3t3r_0[16|10]/a_460_290# WL16 SL10 VSS sky130_fd_pr__nfet_g5v0d10v5 ad=0.65 pd=3.3 as=0 ps=0 w=1 l=0.5
X4419 BLN10 rr3t3r_0[16|10]/a_860_290# sky130_fd_pr_reram__reram_cell area_ox=0.0676
X4420 rr3t3r_0[16|10]/a_60_290# WL16 SL10 VSS sky130_fd_pr__nfet_g5v0d10v5 ad=0.65 pd=3.3 as=0 ps=0 w=1 l=0.5
X4421 rr3t3r_0[16|10]/a_860_290# WL16 SL10 VSS sky130_fd_pr__nfet_g5v0d10v5 ad=0.65 pd=3.3 as=0 ps=0 w=1 l=0.5
X4422 BLP10 rr3t3r_0[17|10]/a_60_290# sky130_fd_pr_reram__reram_cell area_ox=0.0676
X4423 BLZ10 rr3t3r_0[17|10]/a_460_290# sky130_fd_pr_reram__reram_cell area_ox=0.0676
X4424 rr3t3r_0[17|10]/a_460_290# WL17 SL10 VSS sky130_fd_pr__nfet_g5v0d10v5 ad=0.65 pd=3.3 as=0 ps=0 w=1 l=0.5
X4425 BLN10 rr3t3r_0[17|10]/a_860_290# sky130_fd_pr_reram__reram_cell area_ox=0.0676
X4426 rr3t3r_0[17|10]/a_60_290# WL17 SL10 VSS sky130_fd_pr__nfet_g5v0d10v5 ad=0.65 pd=3.3 as=0 ps=0 w=1 l=0.5
X4427 rr3t3r_0[17|10]/a_860_290# WL17 SL10 VSS sky130_fd_pr__nfet_g5v0d10v5 ad=0.65 pd=3.3 as=0 ps=0 w=1 l=0.5
X4428 BLP10 rr3t3r_0[18|10]/a_60_290# sky130_fd_pr_reram__reram_cell area_ox=0.0676
X4429 BLZ10 rr3t3r_0[18|10]/a_460_290# sky130_fd_pr_reram__reram_cell area_ox=0.0676
X4430 rr3t3r_0[18|10]/a_460_290# WL18 SL10 VSS sky130_fd_pr__nfet_g5v0d10v5 ad=0.65 pd=3.3 as=0 ps=0 w=1 l=0.5
X4431 BLN10 rr3t3r_0[18|10]/a_860_290# sky130_fd_pr_reram__reram_cell area_ox=0.0676
X4432 rr3t3r_0[18|10]/a_60_290# WL18 SL10 VSS sky130_fd_pr__nfet_g5v0d10v5 ad=0.65 pd=3.3 as=0 ps=0 w=1 l=0.5
X4433 rr3t3r_0[18|10]/a_860_290# WL18 SL10 VSS sky130_fd_pr__nfet_g5v0d10v5 ad=0.65 pd=3.3 as=0 ps=0 w=1 l=0.5
X4434 BLP10 rr3t3r_0[19|10]/a_60_290# sky130_fd_pr_reram__reram_cell area_ox=0.0676
X4435 BLZ10 rr3t3r_0[19|10]/a_460_290# sky130_fd_pr_reram__reram_cell area_ox=0.0676
X4436 rr3t3r_0[19|10]/a_460_290# WL19 SL10 VSS sky130_fd_pr__nfet_g5v0d10v5 ad=0.65 pd=3.3 as=0 ps=0 w=1 l=0.5
X4437 BLN10 rr3t3r_0[19|10]/a_860_290# sky130_fd_pr_reram__reram_cell area_ox=0.0676
X4438 rr3t3r_0[19|10]/a_60_290# WL19 SL10 VSS sky130_fd_pr__nfet_g5v0d10v5 ad=0.65 pd=3.3 as=0 ps=0 w=1 l=0.5
X4439 rr3t3r_0[19|10]/a_860_290# WL19 SL10 VSS sky130_fd_pr__nfet_g5v0d10v5 ad=0.65 pd=3.3 as=0 ps=0 w=1 l=0.5
X4440 BLP10 rr3t3r_0[20|10]/a_60_290# sky130_fd_pr_reram__reram_cell area_ox=0.0676
X4441 BLZ10 rr3t3r_0[20|10]/a_460_290# sky130_fd_pr_reram__reram_cell area_ox=0.0676
X4442 rr3t3r_0[20|10]/a_460_290# WL20 SL10 VSS sky130_fd_pr__nfet_g5v0d10v5 ad=0.65 pd=3.3 as=0 ps=0 w=1 l=0.5
X4443 BLN10 rr3t3r_0[20|10]/a_860_290# sky130_fd_pr_reram__reram_cell area_ox=0.0676
X4444 rr3t3r_0[20|10]/a_60_290# WL20 SL10 VSS sky130_fd_pr__nfet_g5v0d10v5 ad=0.65 pd=3.3 as=0 ps=0 w=1 l=0.5
X4445 rr3t3r_0[20|10]/a_860_290# WL20 SL10 VSS sky130_fd_pr__nfet_g5v0d10v5 ad=0.65 pd=3.3 as=0 ps=0 w=1 l=0.5
X4446 BLP10 rr3t3r_0[21|10]/a_60_290# sky130_fd_pr_reram__reram_cell area_ox=0.0676
X4447 BLZ10 rr3t3r_0[21|10]/a_460_290# sky130_fd_pr_reram__reram_cell area_ox=0.0676
X4448 rr3t3r_0[21|10]/a_460_290# WL21 SL10 VSS sky130_fd_pr__nfet_g5v0d10v5 ad=0.65 pd=3.3 as=0 ps=0 w=1 l=0.5
X4449 BLN10 rr3t3r_0[21|10]/a_860_290# sky130_fd_pr_reram__reram_cell area_ox=0.0676
X4450 rr3t3r_0[21|10]/a_60_290# WL21 SL10 VSS sky130_fd_pr__nfet_g5v0d10v5 ad=0.65 pd=3.3 as=0 ps=0 w=1 l=0.5
X4451 rr3t3r_0[21|10]/a_860_290# WL21 SL10 VSS sky130_fd_pr__nfet_g5v0d10v5 ad=0.65 pd=3.3 as=0 ps=0 w=1 l=0.5
X4452 BLP10 rr3t3r_0[22|10]/a_60_290# sky130_fd_pr_reram__reram_cell area_ox=0.0676
X4453 BLZ10 rr3t3r_0[22|10]/a_460_290# sky130_fd_pr_reram__reram_cell area_ox=0.0676
X4454 rr3t3r_0[22|10]/a_460_290# WL22 SL10 VSS sky130_fd_pr__nfet_g5v0d10v5 ad=0.65 pd=3.3 as=0 ps=0 w=1 l=0.5
X4455 BLN10 rr3t3r_0[22|10]/a_860_290# sky130_fd_pr_reram__reram_cell area_ox=0.0676
X4456 rr3t3r_0[22|10]/a_60_290# WL22 SL10 VSS sky130_fd_pr__nfet_g5v0d10v5 ad=0.65 pd=3.3 as=0 ps=0 w=1 l=0.5
X4457 rr3t3r_0[22|10]/a_860_290# WL22 SL10 VSS sky130_fd_pr__nfet_g5v0d10v5 ad=0.65 pd=3.3 as=0 ps=0 w=1 l=0.5
X4458 BLP10 rr3t3r_0[23|10]/a_60_290# sky130_fd_pr_reram__reram_cell area_ox=0.0676
X4459 BLZ10 rr3t3r_0[23|10]/a_460_290# sky130_fd_pr_reram__reram_cell area_ox=0.0676
X4460 rr3t3r_0[23|10]/a_460_290# WL23 SL10 VSS sky130_fd_pr__nfet_g5v0d10v5 ad=0.65 pd=3.3 as=0 ps=0 w=1 l=0.5
X4461 BLN10 rr3t3r_0[23|10]/a_860_290# sky130_fd_pr_reram__reram_cell area_ox=0.0676
X4462 rr3t3r_0[23|10]/a_60_290# WL23 SL10 VSS sky130_fd_pr__nfet_g5v0d10v5 ad=0.65 pd=3.3 as=0 ps=0 w=1 l=0.5
X4463 rr3t3r_0[23|10]/a_860_290# WL23 SL10 VSS sky130_fd_pr__nfet_g5v0d10v5 ad=0.65 pd=3.3 as=0 ps=0 w=1 l=0.5
X4464 BLP10 rr3t3r_0[24|10]/a_60_290# sky130_fd_pr_reram__reram_cell area_ox=0.0676
X4465 BLZ10 rr3t3r_0[24|10]/a_460_290# sky130_fd_pr_reram__reram_cell area_ox=0.0676
X4466 rr3t3r_0[24|10]/a_460_290# WL24 SL10 VSS sky130_fd_pr__nfet_g5v0d10v5 ad=0.65 pd=3.3 as=0 ps=0 w=1 l=0.5
X4467 BLN10 rr3t3r_0[24|10]/a_860_290# sky130_fd_pr_reram__reram_cell area_ox=0.0676
X4468 rr3t3r_0[24|10]/a_60_290# WL24 SL10 VSS sky130_fd_pr__nfet_g5v0d10v5 ad=0.65 pd=3.3 as=0 ps=0 w=1 l=0.5
X4469 rr3t3r_0[24|10]/a_860_290# WL24 SL10 VSS sky130_fd_pr__nfet_g5v0d10v5 ad=0.65 pd=3.3 as=0 ps=0 w=1 l=0.5
X4470 BLP10 rr3t3r_0[25|10]/a_60_290# sky130_fd_pr_reram__reram_cell area_ox=0.0676
X4471 BLZ10 rr3t3r_0[25|10]/a_460_290# sky130_fd_pr_reram__reram_cell area_ox=0.0676
X4472 rr3t3r_0[25|10]/a_460_290# WL25 SL10 VSS sky130_fd_pr__nfet_g5v0d10v5 ad=0.65 pd=3.3 as=0 ps=0 w=1 l=0.5
X4473 BLN10 rr3t3r_0[25|10]/a_860_290# sky130_fd_pr_reram__reram_cell area_ox=0.0676
X4474 rr3t3r_0[25|10]/a_60_290# WL25 SL10 VSS sky130_fd_pr__nfet_g5v0d10v5 ad=0.65 pd=3.3 as=0 ps=0 w=1 l=0.5
X4475 rr3t3r_0[25|10]/a_860_290# WL25 SL10 VSS sky130_fd_pr__nfet_g5v0d10v5 ad=0.65 pd=3.3 as=0 ps=0 w=1 l=0.5
X4476 BLP10 rr3t3r_0[26|10]/a_60_290# sky130_fd_pr_reram__reram_cell area_ox=0.0676
X4477 BLZ10 rr3t3r_0[26|10]/a_460_290# sky130_fd_pr_reram__reram_cell area_ox=0.0676
X4478 rr3t3r_0[26|10]/a_460_290# WL26 SL10 VSS sky130_fd_pr__nfet_g5v0d10v5 ad=0.65 pd=3.3 as=0 ps=0 w=1 l=0.5
X4479 BLN10 rr3t3r_0[26|10]/a_860_290# sky130_fd_pr_reram__reram_cell area_ox=0.0676
X4480 rr3t3r_0[26|10]/a_60_290# WL26 SL10 VSS sky130_fd_pr__nfet_g5v0d10v5 ad=0.65 pd=3.3 as=0 ps=0 w=1 l=0.5
X4481 rr3t3r_0[26|10]/a_860_290# WL26 SL10 VSS sky130_fd_pr__nfet_g5v0d10v5 ad=0.65 pd=3.3 as=0 ps=0 w=1 l=0.5
X4482 BLP10 rr3t3r_0[27|10]/a_60_290# sky130_fd_pr_reram__reram_cell area_ox=0.0676
X4483 BLZ10 rr3t3r_0[27|10]/a_460_290# sky130_fd_pr_reram__reram_cell area_ox=0.0676
X4484 rr3t3r_0[27|10]/a_460_290# WL27 SL10 VSS sky130_fd_pr__nfet_g5v0d10v5 ad=0.65 pd=3.3 as=0 ps=0 w=1 l=0.5
X4485 BLN10 rr3t3r_0[27|10]/a_860_290# sky130_fd_pr_reram__reram_cell area_ox=0.0676
X4486 rr3t3r_0[27|10]/a_60_290# WL27 SL10 VSS sky130_fd_pr__nfet_g5v0d10v5 ad=0.65 pd=3.3 as=0 ps=0 w=1 l=0.5
X4487 rr3t3r_0[27|10]/a_860_290# WL27 SL10 VSS sky130_fd_pr__nfet_g5v0d10v5 ad=0.65 pd=3.3 as=0 ps=0 w=1 l=0.5
X4488 BLP10 rr3t3r_0[28|10]/a_60_290# sky130_fd_pr_reram__reram_cell area_ox=0.0676
X4489 BLZ10 rr3t3r_0[28|10]/a_460_290# sky130_fd_pr_reram__reram_cell area_ox=0.0676
X4490 rr3t3r_0[28|10]/a_460_290# WL28 SL10 VSS sky130_fd_pr__nfet_g5v0d10v5 ad=0.65 pd=3.3 as=0 ps=0 w=1 l=0.5
X4491 BLN10 rr3t3r_0[28|10]/a_860_290# sky130_fd_pr_reram__reram_cell area_ox=0.0676
X4492 rr3t3r_0[28|10]/a_60_290# WL28 SL10 VSS sky130_fd_pr__nfet_g5v0d10v5 ad=0.65 pd=3.3 as=0 ps=0 w=1 l=0.5
X4493 rr3t3r_0[28|10]/a_860_290# WL28 SL10 VSS sky130_fd_pr__nfet_g5v0d10v5 ad=0.65 pd=3.3 as=0 ps=0 w=1 l=0.5
X4494 BLP10 rr3t3r_0[29|10]/a_60_290# sky130_fd_pr_reram__reram_cell area_ox=0.0676
X4495 BLZ10 rr3t3r_0[29|10]/a_460_290# sky130_fd_pr_reram__reram_cell area_ox=0.0676
X4496 rr3t3r_0[29|10]/a_460_290# WL29 SL10 VSS sky130_fd_pr__nfet_g5v0d10v5 ad=0.65 pd=3.3 as=0 ps=0 w=1 l=0.5
X4497 BLN10 rr3t3r_0[29|10]/a_860_290# sky130_fd_pr_reram__reram_cell area_ox=0.0676
X4498 rr3t3r_0[29|10]/a_60_290# WL29 SL10 VSS sky130_fd_pr__nfet_g5v0d10v5 ad=0.65 pd=3.3 as=0 ps=0 w=1 l=0.5
X4499 rr3t3r_0[29|10]/a_860_290# WL29 SL10 VSS sky130_fd_pr__nfet_g5v0d10v5 ad=0.65 pd=3.3 as=0 ps=0 w=1 l=0.5
X4500 BLP10 rr3t3r_0[30|10]/a_60_290# sky130_fd_pr_reram__reram_cell area_ox=0.0676
X4501 BLZ10 rr3t3r_0[30|10]/a_460_290# sky130_fd_pr_reram__reram_cell area_ox=0.0676
X4502 rr3t3r_0[30|10]/a_460_290# WL30 SL10 VSS sky130_fd_pr__nfet_g5v0d10v5 ad=0.65 pd=3.3 as=0 ps=0 w=1 l=0.5
X4503 BLN10 rr3t3r_0[30|10]/a_860_290# sky130_fd_pr_reram__reram_cell area_ox=0.0676
X4504 rr3t3r_0[30|10]/a_60_290# WL30 SL10 VSS sky130_fd_pr__nfet_g5v0d10v5 ad=0.65 pd=3.3 as=0 ps=0 w=1 l=0.5
X4505 rr3t3r_0[30|10]/a_860_290# WL30 SL10 VSS sky130_fd_pr__nfet_g5v0d10v5 ad=0.65 pd=3.3 as=0 ps=0 w=1 l=0.5
X4506 BLP10 rr3t3r_0[31|10]/a_60_290# sky130_fd_pr_reram__reram_cell area_ox=0.0676
X4507 BLZ10 rr3t3r_0[31|10]/a_460_290# sky130_fd_pr_reram__reram_cell area_ox=0.0676
X4508 rr3t3r_0[31|10]/a_460_290# WL31 SL10 VSS sky130_fd_pr__nfet_g5v0d10v5 ad=0.65 pd=3.3 as=0 ps=0 w=1 l=0.5
X4509 BLN10 rr3t3r_0[31|10]/a_860_290# sky130_fd_pr_reram__reram_cell area_ox=0.0676
X4510 rr3t3r_0[31|10]/a_60_290# WL31 SL10 VSS sky130_fd_pr__nfet_g5v0d10v5 ad=0.65 pd=3.3 as=0 ps=0 w=1 l=0.5
X4511 rr3t3r_0[31|10]/a_860_290# WL31 SL10 VSS sky130_fd_pr__nfet_g5v0d10v5 ad=0.65 pd=3.3 as=0 ps=0 w=1 l=0.5
X4512 BLP10 rr3t3r_0[32|10]/a_60_290# sky130_fd_pr_reram__reram_cell area_ox=0.0676
X4513 BLZ10 rr3t3r_0[32|10]/a_460_290# sky130_fd_pr_reram__reram_cell area_ox=0.0676
X4514 rr3t3r_0[32|10]/a_460_290# WL32 SL10 VSS sky130_fd_pr__nfet_g5v0d10v5 ad=0.65 pd=3.3 as=0 ps=0 w=1 l=0.5
X4515 BLN10 rr3t3r_0[32|10]/a_860_290# sky130_fd_pr_reram__reram_cell area_ox=0.0676
X4516 rr3t3r_0[32|10]/a_60_290# WL32 SL10 VSS sky130_fd_pr__nfet_g5v0d10v5 ad=0.65 pd=3.3 as=0 ps=0 w=1 l=0.5
X4517 rr3t3r_0[32|10]/a_860_290# WL32 SL10 VSS sky130_fd_pr__nfet_g5v0d10v5 ad=0.65 pd=3.3 as=0 ps=0 w=1 l=0.5
X4518 BLP10 rr3t3r_0[33|10]/a_60_290# sky130_fd_pr_reram__reram_cell area_ox=0.0676
X4519 BLZ10 rr3t3r_0[33|10]/a_460_290# sky130_fd_pr_reram__reram_cell area_ox=0.0676
X4520 rr3t3r_0[33|10]/a_460_290# WL33 SL10 VSS sky130_fd_pr__nfet_g5v0d10v5 ad=0.65 pd=3.3 as=0 ps=0 w=1 l=0.5
X4521 BLN10 rr3t3r_0[33|10]/a_860_290# sky130_fd_pr_reram__reram_cell area_ox=0.0676
X4522 rr3t3r_0[33|10]/a_60_290# WL33 SL10 VSS sky130_fd_pr__nfet_g5v0d10v5 ad=0.65 pd=3.3 as=0 ps=0 w=1 l=0.5
X4523 rr3t3r_0[33|10]/a_860_290# WL33 SL10 VSS sky130_fd_pr__nfet_g5v0d10v5 ad=0.65 pd=3.3 as=0 ps=0 w=1 l=0.5
X4524 BLP10 rr3t3r_0[34|10]/a_60_290# sky130_fd_pr_reram__reram_cell area_ox=0.0676
X4525 BLZ10 rr3t3r_0[34|10]/a_460_290# sky130_fd_pr_reram__reram_cell area_ox=0.0676
X4526 rr3t3r_0[34|10]/a_460_290# WL34 SL10 VSS sky130_fd_pr__nfet_g5v0d10v5 ad=0.65 pd=3.3 as=0 ps=0 w=1 l=0.5
X4527 BLN10 rr3t3r_0[34|10]/a_860_290# sky130_fd_pr_reram__reram_cell area_ox=0.0676
X4528 rr3t3r_0[34|10]/a_60_290# WL34 SL10 VSS sky130_fd_pr__nfet_g5v0d10v5 ad=0.65 pd=3.3 as=0 ps=0 w=1 l=0.5
X4529 rr3t3r_0[34|10]/a_860_290# WL34 SL10 VSS sky130_fd_pr__nfet_g5v0d10v5 ad=0.65 pd=3.3 as=0 ps=0 w=1 l=0.5
X4530 BLP10 rr3t3r_0[35|10]/a_60_290# sky130_fd_pr_reram__reram_cell area_ox=0.0676
X4531 BLZ10 rr3t3r_0[35|10]/a_460_290# sky130_fd_pr_reram__reram_cell area_ox=0.0676
X4532 rr3t3r_0[35|10]/a_460_290# WL35 SL10 VSS sky130_fd_pr__nfet_g5v0d10v5 ad=0.65 pd=3.3 as=0 ps=0 w=1 l=0.5
X4533 BLN10 rr3t3r_0[35|10]/a_860_290# sky130_fd_pr_reram__reram_cell area_ox=0.0676
X4534 rr3t3r_0[35|10]/a_60_290# WL35 SL10 VSS sky130_fd_pr__nfet_g5v0d10v5 ad=0.65 pd=3.3 as=0 ps=0 w=1 l=0.5
X4535 rr3t3r_0[35|10]/a_860_290# WL35 SL10 VSS sky130_fd_pr__nfet_g5v0d10v5 ad=0.65 pd=3.3 as=0 ps=0 w=1 l=0.5
X4536 BLP10 rr3t3r_0[36|10]/a_60_290# sky130_fd_pr_reram__reram_cell area_ox=0.0676
X4537 BLZ10 rr3t3r_0[36|10]/a_460_290# sky130_fd_pr_reram__reram_cell area_ox=0.0676
X4538 rr3t3r_0[36|10]/a_460_290# WL36 SL10 VSS sky130_fd_pr__nfet_g5v0d10v5 ad=0.65 pd=3.3 as=0 ps=0 w=1 l=0.5
X4539 BLN10 rr3t3r_0[36|10]/a_860_290# sky130_fd_pr_reram__reram_cell area_ox=0.0676
X4540 rr3t3r_0[36|10]/a_60_290# WL36 SL10 VSS sky130_fd_pr__nfet_g5v0d10v5 ad=0.65 pd=3.3 as=0 ps=0 w=1 l=0.5
X4541 rr3t3r_0[36|10]/a_860_290# WL36 SL10 VSS sky130_fd_pr__nfet_g5v0d10v5 ad=0.65 pd=3.3 as=0 ps=0 w=1 l=0.5
X4542 BLP10 rr3t3r_0[37|10]/a_60_290# sky130_fd_pr_reram__reram_cell area_ox=0.0676
X4543 BLZ10 rr3t3r_0[37|10]/a_460_290# sky130_fd_pr_reram__reram_cell area_ox=0.0676
X4544 rr3t3r_0[37|10]/a_460_290# WL37 SL10 VSS sky130_fd_pr__nfet_g5v0d10v5 ad=0.65 pd=3.3 as=0 ps=0 w=1 l=0.5
X4545 BLN10 rr3t3r_0[37|10]/a_860_290# sky130_fd_pr_reram__reram_cell area_ox=0.0676
X4546 rr3t3r_0[37|10]/a_60_290# WL37 SL10 VSS sky130_fd_pr__nfet_g5v0d10v5 ad=0.65 pd=3.3 as=0 ps=0 w=1 l=0.5
X4547 rr3t3r_0[37|10]/a_860_290# WL37 SL10 VSS sky130_fd_pr__nfet_g5v0d10v5 ad=0.65 pd=3.3 as=0 ps=0 w=1 l=0.5
X4548 BLP10 rr3t3r_0[38|10]/a_60_290# sky130_fd_pr_reram__reram_cell area_ox=0.0676
X4549 BLZ10 rr3t3r_0[38|10]/a_460_290# sky130_fd_pr_reram__reram_cell area_ox=0.0676
X4550 rr3t3r_0[38|10]/a_460_290# WL38 SL10 VSS sky130_fd_pr__nfet_g5v0d10v5 ad=0.65 pd=3.3 as=0 ps=0 w=1 l=0.5
X4551 BLN10 rr3t3r_0[38|10]/a_860_290# sky130_fd_pr_reram__reram_cell area_ox=0.0676
X4552 rr3t3r_0[38|10]/a_60_290# WL38 SL10 VSS sky130_fd_pr__nfet_g5v0d10v5 ad=0.65 pd=3.3 as=0 ps=0 w=1 l=0.5
X4553 rr3t3r_0[38|10]/a_860_290# WL38 SL10 VSS sky130_fd_pr__nfet_g5v0d10v5 ad=0.65 pd=3.3 as=0 ps=0 w=1 l=0.5
X4554 BLP10 rr3t3r_0[39|10]/a_60_290# sky130_fd_pr_reram__reram_cell area_ox=0.0676
X4555 BLZ10 rr3t3r_0[39|10]/a_460_290# sky130_fd_pr_reram__reram_cell area_ox=0.0676
X4556 rr3t3r_0[39|10]/a_460_290# WL39 SL10 VSS sky130_fd_pr__nfet_g5v0d10v5 ad=0.65 pd=3.3 as=0 ps=0 w=1 l=0.5
X4557 BLN10 rr3t3r_0[39|10]/a_860_290# sky130_fd_pr_reram__reram_cell area_ox=0.0676
X4558 rr3t3r_0[39|10]/a_60_290# WL39 SL10 VSS sky130_fd_pr__nfet_g5v0d10v5 ad=0.65 pd=3.3 as=0 ps=0 w=1 l=0.5
X4559 rr3t3r_0[39|10]/a_860_290# WL39 SL10 VSS sky130_fd_pr__nfet_g5v0d10v5 ad=0.65 pd=3.3 as=0 ps=0 w=1 l=0.5
X4560 BLP10 rr3t3r_0[40|10]/a_60_290# sky130_fd_pr_reram__reram_cell area_ox=0.0676
X4561 BLZ10 rr3t3r_0[40|10]/a_460_290# sky130_fd_pr_reram__reram_cell area_ox=0.0676
X4562 rr3t3r_0[40|10]/a_460_290# WL40 SL10 VSS sky130_fd_pr__nfet_g5v0d10v5 ad=0.65 pd=3.3 as=0 ps=0 w=1 l=0.5
X4563 BLN10 rr3t3r_0[40|10]/a_860_290# sky130_fd_pr_reram__reram_cell area_ox=0.0676
X4564 rr3t3r_0[40|10]/a_60_290# WL40 SL10 VSS sky130_fd_pr__nfet_g5v0d10v5 ad=0.65 pd=3.3 as=0 ps=0 w=1 l=0.5
X4565 rr3t3r_0[40|10]/a_860_290# WL40 SL10 VSS sky130_fd_pr__nfet_g5v0d10v5 ad=0.65 pd=3.3 as=0 ps=0 w=1 l=0.5
X4566 BLP10 rr3t3r_0[41|10]/a_60_290# sky130_fd_pr_reram__reram_cell area_ox=0.0676
X4567 BLZ10 rr3t3r_0[41|10]/a_460_290# sky130_fd_pr_reram__reram_cell area_ox=0.0676
X4568 rr3t3r_0[41|10]/a_460_290# WL41 SL10 VSS sky130_fd_pr__nfet_g5v0d10v5 ad=0.65 pd=3.3 as=0 ps=0 w=1 l=0.5
X4569 BLN10 rr3t3r_0[41|10]/a_860_290# sky130_fd_pr_reram__reram_cell area_ox=0.0676
X4570 rr3t3r_0[41|10]/a_60_290# WL41 SL10 VSS sky130_fd_pr__nfet_g5v0d10v5 ad=0.65 pd=3.3 as=0 ps=0 w=1 l=0.5
X4571 rr3t3r_0[41|10]/a_860_290# WL41 SL10 VSS sky130_fd_pr__nfet_g5v0d10v5 ad=0.65 pd=3.3 as=0 ps=0 w=1 l=0.5
X4572 BLP10 rr3t3r_0[42|10]/a_60_290# sky130_fd_pr_reram__reram_cell area_ox=0.0676
X4573 BLZ10 rr3t3r_0[42|10]/a_460_290# sky130_fd_pr_reram__reram_cell area_ox=0.0676
X4574 rr3t3r_0[42|10]/a_460_290# WL42 SL10 VSS sky130_fd_pr__nfet_g5v0d10v5 ad=0.65 pd=3.3 as=0 ps=0 w=1 l=0.5
X4575 BLN10 rr3t3r_0[42|10]/a_860_290# sky130_fd_pr_reram__reram_cell area_ox=0.0676
X4576 rr3t3r_0[42|10]/a_60_290# WL42 SL10 VSS sky130_fd_pr__nfet_g5v0d10v5 ad=0.65 pd=3.3 as=0 ps=0 w=1 l=0.5
X4577 rr3t3r_0[42|10]/a_860_290# WL42 SL10 VSS sky130_fd_pr__nfet_g5v0d10v5 ad=0.65 pd=3.3 as=0 ps=0 w=1 l=0.5
X4578 BLP10 rr3t3r_0[43|10]/a_60_290# sky130_fd_pr_reram__reram_cell area_ox=0.0676
X4579 BLZ10 rr3t3r_0[43|10]/a_460_290# sky130_fd_pr_reram__reram_cell area_ox=0.0676
X4580 rr3t3r_0[43|10]/a_460_290# WL43 SL10 VSS sky130_fd_pr__nfet_g5v0d10v5 ad=0.65 pd=3.3 as=0 ps=0 w=1 l=0.5
X4581 BLN10 rr3t3r_0[43|10]/a_860_290# sky130_fd_pr_reram__reram_cell area_ox=0.0676
X4582 rr3t3r_0[43|10]/a_60_290# WL43 SL10 VSS sky130_fd_pr__nfet_g5v0d10v5 ad=0.65 pd=3.3 as=0 ps=0 w=1 l=0.5
X4583 rr3t3r_0[43|10]/a_860_290# WL43 SL10 VSS sky130_fd_pr__nfet_g5v0d10v5 ad=0.65 pd=3.3 as=0 ps=0 w=1 l=0.5
X4584 BLP10 rr3t3r_0[44|10]/a_60_290# sky130_fd_pr_reram__reram_cell area_ox=0.0676
X4585 BLZ10 rr3t3r_0[44|10]/a_460_290# sky130_fd_pr_reram__reram_cell area_ox=0.0676
X4586 rr3t3r_0[44|10]/a_460_290# WL44 SL10 VSS sky130_fd_pr__nfet_g5v0d10v5 ad=0.65 pd=3.3 as=0 ps=0 w=1 l=0.5
X4587 BLN10 rr3t3r_0[44|10]/a_860_290# sky130_fd_pr_reram__reram_cell area_ox=0.0676
X4588 rr3t3r_0[44|10]/a_60_290# WL44 SL10 VSS sky130_fd_pr__nfet_g5v0d10v5 ad=0.65 pd=3.3 as=0 ps=0 w=1 l=0.5
X4589 rr3t3r_0[44|10]/a_860_290# WL44 SL10 VSS sky130_fd_pr__nfet_g5v0d10v5 ad=0.65 pd=3.3 as=0 ps=0 w=1 l=0.5
X4590 BLP10 rr3t3r_0[45|10]/a_60_290# sky130_fd_pr_reram__reram_cell area_ox=0.0676
X4591 BLZ10 rr3t3r_0[45|10]/a_460_290# sky130_fd_pr_reram__reram_cell area_ox=0.0676
X4592 rr3t3r_0[45|10]/a_460_290# WL45 SL10 VSS sky130_fd_pr__nfet_g5v0d10v5 ad=0.65 pd=3.3 as=0 ps=0 w=1 l=0.5
X4593 BLN10 rr3t3r_0[45|10]/a_860_290# sky130_fd_pr_reram__reram_cell area_ox=0.0676
X4594 rr3t3r_0[45|10]/a_60_290# WL45 SL10 VSS sky130_fd_pr__nfet_g5v0d10v5 ad=0.65 pd=3.3 as=0 ps=0 w=1 l=0.5
X4595 rr3t3r_0[45|10]/a_860_290# WL45 SL10 VSS sky130_fd_pr__nfet_g5v0d10v5 ad=0.65 pd=3.3 as=0 ps=0 w=1 l=0.5
X4596 BLP10 rr3t3r_0[46|10]/a_60_290# sky130_fd_pr_reram__reram_cell area_ox=0.0676
X4597 BLZ10 rr3t3r_0[46|10]/a_460_290# sky130_fd_pr_reram__reram_cell area_ox=0.0676
X4598 rr3t3r_0[46|10]/a_460_290# WL46 SL10 VSS sky130_fd_pr__nfet_g5v0d10v5 ad=0.65 pd=3.3 as=0 ps=0 w=1 l=0.5
X4599 BLN10 rr3t3r_0[46|10]/a_860_290# sky130_fd_pr_reram__reram_cell area_ox=0.0676
X4600 rr3t3r_0[46|10]/a_60_290# WL46 SL10 VSS sky130_fd_pr__nfet_g5v0d10v5 ad=0.65 pd=3.3 as=0 ps=0 w=1 l=0.5
X4601 rr3t3r_0[46|10]/a_860_290# WL46 SL10 VSS sky130_fd_pr__nfet_g5v0d10v5 ad=0.65 pd=3.3 as=0 ps=0 w=1 l=0.5
X4602 BLP10 rr3t3r_0[47|10]/a_60_290# sky130_fd_pr_reram__reram_cell area_ox=0.0676
X4603 BLZ10 rr3t3r_0[47|10]/a_460_290# sky130_fd_pr_reram__reram_cell area_ox=0.0676
X4604 rr3t3r_0[47|10]/a_460_290# WL47 SL10 VSS sky130_fd_pr__nfet_g5v0d10v5 ad=0.65 pd=3.3 as=0 ps=0 w=1 l=0.5
X4605 BLN10 rr3t3r_0[47|10]/a_860_290# sky130_fd_pr_reram__reram_cell area_ox=0.0676
X4606 rr3t3r_0[47|10]/a_60_290# WL47 SL10 VSS sky130_fd_pr__nfet_g5v0d10v5 ad=0.65 pd=3.3 as=0 ps=0 w=1 l=0.5
X4607 rr3t3r_0[47|10]/a_860_290# WL47 SL10 VSS sky130_fd_pr__nfet_g5v0d10v5 ad=0.65 pd=3.3 as=0 ps=0 w=1 l=0.5
X4608 BLP10 rr3t3r_0[48|10]/a_60_290# sky130_fd_pr_reram__reram_cell area_ox=0.0676
X4609 BLZ10 rr3t3r_0[48|10]/a_460_290# sky130_fd_pr_reram__reram_cell area_ox=0.0676
X4610 rr3t3r_0[48|10]/a_460_290# WL48 SL10 VSS sky130_fd_pr__nfet_g5v0d10v5 ad=0.65 pd=3.3 as=0 ps=0 w=1 l=0.5
X4611 BLN10 rr3t3r_0[48|10]/a_860_290# sky130_fd_pr_reram__reram_cell area_ox=0.0676
X4612 rr3t3r_0[48|10]/a_60_290# WL48 SL10 VSS sky130_fd_pr__nfet_g5v0d10v5 ad=0.65 pd=3.3 as=0 ps=0 w=1 l=0.5
X4613 rr3t3r_0[48|10]/a_860_290# WL48 SL10 VSS sky130_fd_pr__nfet_g5v0d10v5 ad=0.65 pd=3.3 as=0 ps=0 w=1 l=0.5
X4614 BLP10 rr3t3r_0[49|10]/a_60_290# sky130_fd_pr_reram__reram_cell area_ox=0.0676
X4615 BLZ10 rr3t3r_0[49|10]/a_460_290# sky130_fd_pr_reram__reram_cell area_ox=0.0676
X4616 rr3t3r_0[49|10]/a_460_290# WL49 SL10 VSS sky130_fd_pr__nfet_g5v0d10v5 ad=0.65 pd=3.3 as=0 ps=0 w=1 l=0.5
X4617 BLN10 rr3t3r_0[49|10]/a_860_290# sky130_fd_pr_reram__reram_cell area_ox=0.0676
X4618 rr3t3r_0[49|10]/a_60_290# WL49 SL10 VSS sky130_fd_pr__nfet_g5v0d10v5 ad=0.65 pd=3.3 as=0 ps=0 w=1 l=0.5
X4619 rr3t3r_0[49|10]/a_860_290# WL49 SL10 VSS sky130_fd_pr__nfet_g5v0d10v5 ad=0.65 pd=3.3 as=0 ps=0 w=1 l=0.5
X4620 BLP10 rr3t3r_0[50|10]/a_60_290# sky130_fd_pr_reram__reram_cell area_ox=0.0676
X4621 BLZ10 rr3t3r_0[50|10]/a_460_290# sky130_fd_pr_reram__reram_cell area_ox=0.0676
X4622 rr3t3r_0[50|10]/a_460_290# WL50 SL10 VSS sky130_fd_pr__nfet_g5v0d10v5 ad=0.65 pd=3.3 as=0 ps=0 w=1 l=0.5
X4623 BLN10 rr3t3r_0[50|10]/a_860_290# sky130_fd_pr_reram__reram_cell area_ox=0.0676
X4624 rr3t3r_0[50|10]/a_60_290# WL50 SL10 VSS sky130_fd_pr__nfet_g5v0d10v5 ad=0.65 pd=3.3 as=0 ps=0 w=1 l=0.5
X4625 rr3t3r_0[50|10]/a_860_290# WL50 SL10 VSS sky130_fd_pr__nfet_g5v0d10v5 ad=0.65 pd=3.3 as=0 ps=0 w=1 l=0.5
X4626 BLP10 rr3t3r_0[51|10]/a_60_290# sky130_fd_pr_reram__reram_cell area_ox=0.0676
X4627 BLZ10 rr3t3r_0[51|10]/a_460_290# sky130_fd_pr_reram__reram_cell area_ox=0.0676
X4628 rr3t3r_0[51|10]/a_460_290# WL51 SL10 VSS sky130_fd_pr__nfet_g5v0d10v5 ad=0.65 pd=3.3 as=0 ps=0 w=1 l=0.5
X4629 BLN10 rr3t3r_0[51|10]/a_860_290# sky130_fd_pr_reram__reram_cell area_ox=0.0676
X4630 rr3t3r_0[51|10]/a_60_290# WL51 SL10 VSS sky130_fd_pr__nfet_g5v0d10v5 ad=0.65 pd=3.3 as=0 ps=0 w=1 l=0.5
X4631 rr3t3r_0[51|10]/a_860_290# WL51 SL10 VSS sky130_fd_pr__nfet_g5v0d10v5 ad=0.65 pd=3.3 as=0 ps=0 w=1 l=0.5
X4632 BLP10 rr3t3r_0[52|10]/a_60_290# sky130_fd_pr_reram__reram_cell area_ox=0.0676
X4633 BLZ10 rr3t3r_0[52|10]/a_460_290# sky130_fd_pr_reram__reram_cell area_ox=0.0676
X4634 rr3t3r_0[52|10]/a_460_290# WL52 SL10 VSS sky130_fd_pr__nfet_g5v0d10v5 ad=0.65 pd=3.3 as=0 ps=0 w=1 l=0.5
X4635 BLN10 rr3t3r_0[52|10]/a_860_290# sky130_fd_pr_reram__reram_cell area_ox=0.0676
X4636 rr3t3r_0[52|10]/a_60_290# WL52 SL10 VSS sky130_fd_pr__nfet_g5v0d10v5 ad=0.65 pd=3.3 as=0 ps=0 w=1 l=0.5
X4637 rr3t3r_0[52|10]/a_860_290# WL52 SL10 VSS sky130_fd_pr__nfet_g5v0d10v5 ad=0.65 pd=3.3 as=0 ps=0 w=1 l=0.5
X4638 BLP10 rr3t3r_0[53|10]/a_60_290# sky130_fd_pr_reram__reram_cell area_ox=0.0676
X4639 BLZ10 rr3t3r_0[53|10]/a_460_290# sky130_fd_pr_reram__reram_cell area_ox=0.0676
X4640 rr3t3r_0[53|10]/a_460_290# WL53 SL10 VSS sky130_fd_pr__nfet_g5v0d10v5 ad=0.65 pd=3.3 as=0 ps=0 w=1 l=0.5
X4641 BLN10 rr3t3r_0[53|10]/a_860_290# sky130_fd_pr_reram__reram_cell area_ox=0.0676
X4642 rr3t3r_0[53|10]/a_60_290# WL53 SL10 VSS sky130_fd_pr__nfet_g5v0d10v5 ad=0.65 pd=3.3 as=0 ps=0 w=1 l=0.5
X4643 rr3t3r_0[53|10]/a_860_290# WL53 SL10 VSS sky130_fd_pr__nfet_g5v0d10v5 ad=0.65 pd=3.3 as=0 ps=0 w=1 l=0.5
X4644 BLP10 rr3t3r_0[54|10]/a_60_290# sky130_fd_pr_reram__reram_cell area_ox=0.0676
X4645 BLZ10 rr3t3r_0[54|10]/a_460_290# sky130_fd_pr_reram__reram_cell area_ox=0.0676
X4646 rr3t3r_0[54|10]/a_460_290# WL54 SL10 VSS sky130_fd_pr__nfet_g5v0d10v5 ad=0.65 pd=3.3 as=0 ps=0 w=1 l=0.5
X4647 BLN10 rr3t3r_0[54|10]/a_860_290# sky130_fd_pr_reram__reram_cell area_ox=0.0676
X4648 rr3t3r_0[54|10]/a_60_290# WL54 SL10 VSS sky130_fd_pr__nfet_g5v0d10v5 ad=0.65 pd=3.3 as=0 ps=0 w=1 l=0.5
X4649 rr3t3r_0[54|10]/a_860_290# WL54 SL10 VSS sky130_fd_pr__nfet_g5v0d10v5 ad=0.65 pd=3.3 as=0 ps=0 w=1 l=0.5
X4650 BLP10 rr3t3r_0[55|10]/a_60_290# sky130_fd_pr_reram__reram_cell area_ox=0.0676
X4651 BLZ10 rr3t3r_0[55|10]/a_460_290# sky130_fd_pr_reram__reram_cell area_ox=0.0676
X4652 rr3t3r_0[55|10]/a_460_290# WL55 SL10 VSS sky130_fd_pr__nfet_g5v0d10v5 ad=0.65 pd=3.3 as=0 ps=0 w=1 l=0.5
X4653 BLN10 rr3t3r_0[55|10]/a_860_290# sky130_fd_pr_reram__reram_cell area_ox=0.0676
X4654 rr3t3r_0[55|10]/a_60_290# WL55 SL10 VSS sky130_fd_pr__nfet_g5v0d10v5 ad=0.65 pd=3.3 as=0 ps=0 w=1 l=0.5
X4655 rr3t3r_0[55|10]/a_860_290# WL55 SL10 VSS sky130_fd_pr__nfet_g5v0d10v5 ad=0.65 pd=3.3 as=0 ps=0 w=1 l=0.5
X4656 BLP10 rr3t3r_0[56|10]/a_60_290# sky130_fd_pr_reram__reram_cell area_ox=0.0676
X4657 BLZ10 rr3t3r_0[56|10]/a_460_290# sky130_fd_pr_reram__reram_cell area_ox=0.0676
X4658 rr3t3r_0[56|10]/a_460_290# WL56 SL10 VSS sky130_fd_pr__nfet_g5v0d10v5 ad=0.65 pd=3.3 as=0 ps=0 w=1 l=0.5
X4659 BLN10 rr3t3r_0[56|10]/a_860_290# sky130_fd_pr_reram__reram_cell area_ox=0.0676
X4660 rr3t3r_0[56|10]/a_60_290# WL56 SL10 VSS sky130_fd_pr__nfet_g5v0d10v5 ad=0.65 pd=3.3 as=0 ps=0 w=1 l=0.5
X4661 rr3t3r_0[56|10]/a_860_290# WL56 SL10 VSS sky130_fd_pr__nfet_g5v0d10v5 ad=0.65 pd=3.3 as=0 ps=0 w=1 l=0.5
X4662 BLP10 rr3t3r_0[57|10]/a_60_290# sky130_fd_pr_reram__reram_cell area_ox=0.0676
X4663 BLZ10 rr3t3r_0[57|10]/a_460_290# sky130_fd_pr_reram__reram_cell area_ox=0.0676
X4664 rr3t3r_0[57|10]/a_460_290# WL57 SL10 VSS sky130_fd_pr__nfet_g5v0d10v5 ad=0.65 pd=3.3 as=0 ps=0 w=1 l=0.5
X4665 BLN10 rr3t3r_0[57|10]/a_860_290# sky130_fd_pr_reram__reram_cell area_ox=0.0676
X4666 rr3t3r_0[57|10]/a_60_290# WL57 SL10 VSS sky130_fd_pr__nfet_g5v0d10v5 ad=0.65 pd=3.3 as=0 ps=0 w=1 l=0.5
X4667 rr3t3r_0[57|10]/a_860_290# WL57 SL10 VSS sky130_fd_pr__nfet_g5v0d10v5 ad=0.65 pd=3.3 as=0 ps=0 w=1 l=0.5
X4668 BLP10 rr3t3r_0[58|10]/a_60_290# sky130_fd_pr_reram__reram_cell area_ox=0.0676
X4669 BLZ10 rr3t3r_0[58|10]/a_460_290# sky130_fd_pr_reram__reram_cell area_ox=0.0676
X4670 rr3t3r_0[58|10]/a_460_290# WL58 SL10 VSS sky130_fd_pr__nfet_g5v0d10v5 ad=0.65 pd=3.3 as=0 ps=0 w=1 l=0.5
X4671 BLN10 rr3t3r_0[58|10]/a_860_290# sky130_fd_pr_reram__reram_cell area_ox=0.0676
X4672 rr3t3r_0[58|10]/a_60_290# WL58 SL10 VSS sky130_fd_pr__nfet_g5v0d10v5 ad=0.65 pd=3.3 as=0 ps=0 w=1 l=0.5
X4673 rr3t3r_0[58|10]/a_860_290# WL58 SL10 VSS sky130_fd_pr__nfet_g5v0d10v5 ad=0.65 pd=3.3 as=0 ps=0 w=1 l=0.5
X4674 BLP10 rr3t3r_0[59|10]/a_60_290# sky130_fd_pr_reram__reram_cell area_ox=0.0676
X4675 BLZ10 rr3t3r_0[59|10]/a_460_290# sky130_fd_pr_reram__reram_cell area_ox=0.0676
X4676 rr3t3r_0[59|10]/a_460_290# WL59 SL10 VSS sky130_fd_pr__nfet_g5v0d10v5 ad=0.65 pd=3.3 as=0 ps=0 w=1 l=0.5
X4677 BLN10 rr3t3r_0[59|10]/a_860_290# sky130_fd_pr_reram__reram_cell area_ox=0.0676
X4678 rr3t3r_0[59|10]/a_60_290# WL59 SL10 VSS sky130_fd_pr__nfet_g5v0d10v5 ad=0.65 pd=3.3 as=0 ps=0 w=1 l=0.5
X4679 rr3t3r_0[59|10]/a_860_290# WL59 SL10 VSS sky130_fd_pr__nfet_g5v0d10v5 ad=0.65 pd=3.3 as=0 ps=0 w=1 l=0.5
X4680 BLP10 rr3t3r_0[60|10]/a_60_290# sky130_fd_pr_reram__reram_cell area_ox=0.0676
X4681 BLZ10 rr3t3r_0[60|10]/a_460_290# sky130_fd_pr_reram__reram_cell area_ox=0.0676
X4682 rr3t3r_0[60|10]/a_460_290# WL60 SL10 VSS sky130_fd_pr__nfet_g5v0d10v5 ad=0.65 pd=3.3 as=0 ps=0 w=1 l=0.5
X4683 BLN10 rr3t3r_0[60|10]/a_860_290# sky130_fd_pr_reram__reram_cell area_ox=0.0676
X4684 rr3t3r_0[60|10]/a_60_290# WL60 SL10 VSS sky130_fd_pr__nfet_g5v0d10v5 ad=0.65 pd=3.3 as=0 ps=0 w=1 l=0.5
X4685 rr3t3r_0[60|10]/a_860_290# WL60 SL10 VSS sky130_fd_pr__nfet_g5v0d10v5 ad=0.65 pd=3.3 as=0 ps=0 w=1 l=0.5
X4686 BLP10 rr3t3r_0[61|10]/a_60_290# sky130_fd_pr_reram__reram_cell area_ox=0.0676
X4687 BLZ10 rr3t3r_0[61|10]/a_460_290# sky130_fd_pr_reram__reram_cell area_ox=0.0676
X4688 rr3t3r_0[61|10]/a_460_290# WL61 SL10 VSS sky130_fd_pr__nfet_g5v0d10v5 ad=0.65 pd=3.3 as=0 ps=0 w=1 l=0.5
X4689 BLN10 rr3t3r_0[61|10]/a_860_290# sky130_fd_pr_reram__reram_cell area_ox=0.0676
X4690 rr3t3r_0[61|10]/a_60_290# WL61 SL10 VSS sky130_fd_pr__nfet_g5v0d10v5 ad=0.65 pd=3.3 as=0 ps=0 w=1 l=0.5
X4691 rr3t3r_0[61|10]/a_860_290# WL61 SL10 VSS sky130_fd_pr__nfet_g5v0d10v5 ad=0.65 pd=3.3 as=0 ps=0 w=1 l=0.5
X4692 BLP10 rr3t3r_0[62|10]/a_60_290# sky130_fd_pr_reram__reram_cell area_ox=0.0676
X4693 BLZ10 rr3t3r_0[62|10]/a_460_290# sky130_fd_pr_reram__reram_cell area_ox=0.0676
X4694 rr3t3r_0[62|10]/a_460_290# WL62 SL10 VSS sky130_fd_pr__nfet_g5v0d10v5 ad=0.65 pd=3.3 as=0 ps=0 w=1 l=0.5
X4695 BLN10 rr3t3r_0[62|10]/a_860_290# sky130_fd_pr_reram__reram_cell area_ox=0.0676
X4696 rr3t3r_0[62|10]/a_60_290# WL62 SL10 VSS sky130_fd_pr__nfet_g5v0d10v5 ad=0.65 pd=3.3 as=0 ps=0 w=1 l=0.5
X4697 rr3t3r_0[62|10]/a_860_290# WL62 SL10 VSS sky130_fd_pr__nfet_g5v0d10v5 ad=0.65 pd=3.3 as=0 ps=0 w=1 l=0.5
X4698 BLP10 rr3t3r_0[63|10]/a_60_290# sky130_fd_pr_reram__reram_cell area_ox=0.0676
X4699 BLZ10 rr3t3r_0[63|10]/a_460_290# sky130_fd_pr_reram__reram_cell area_ox=0.0676
X4700 rr3t3r_0[63|10]/a_460_290# WL63 SL10 VSS sky130_fd_pr__nfet_g5v0d10v5 ad=0.65 pd=3.3 as=0 ps=0 w=1 l=0.5
X4701 BLN10 rr3t3r_0[63|10]/a_860_290# sky130_fd_pr_reram__reram_cell area_ox=0.0676
X4702 rr3t3r_0[63|10]/a_60_290# WL63 SL10 VSS sky130_fd_pr__nfet_g5v0d10v5 ad=0.65 pd=3.3 as=0 ps=0 w=1 l=0.5
X4703 rr3t3r_0[63|10]/a_860_290# WL63 SL10 VSS sky130_fd_pr__nfet_g5v0d10v5 ad=0.65 pd=3.3 as=0 ps=0 w=1 l=0.5
X4704 BLP10 rr3t3r_0[64|10]/a_60_290# sky130_fd_pr_reram__reram_cell area_ox=0.0676
X4705 BLZ10 rr3t3r_0[64|10]/a_460_290# sky130_fd_pr_reram__reram_cell area_ox=0.0676
X4706 rr3t3r_0[64|10]/a_460_290# WL64 SL10 VSS sky130_fd_pr__nfet_g5v0d10v5 ad=0.65 pd=3.3 as=0 ps=0 w=1 l=0.5
X4707 BLN10 rr3t3r_0[64|10]/a_860_290# sky130_fd_pr_reram__reram_cell area_ox=0.0676
X4708 rr3t3r_0[64|10]/a_60_290# WL64 SL10 VSS sky130_fd_pr__nfet_g5v0d10v5 ad=0.65 pd=3.3 as=0 ps=0 w=1 l=0.5
X4709 rr3t3r_0[64|10]/a_860_290# WL64 SL10 VSS sky130_fd_pr__nfet_g5v0d10v5 ad=0.65 pd=3.3 as=0 ps=0 w=1 l=0.5
X4710 BLP10 rr3t3r_0[65|10]/a_60_290# sky130_fd_pr_reram__reram_cell area_ox=0.0676
X4711 BLZ10 rr3t3r_0[65|10]/a_460_290# sky130_fd_pr_reram__reram_cell area_ox=0.0676
X4712 rr3t3r_0[65|10]/a_460_290# WL65 SL10 VSS sky130_fd_pr__nfet_g5v0d10v5 ad=0.65 pd=3.3 as=0 ps=0 w=1 l=0.5
X4713 BLN10 rr3t3r_0[65|10]/a_860_290# sky130_fd_pr_reram__reram_cell area_ox=0.0676
X4714 rr3t3r_0[65|10]/a_60_290# WL65 SL10 VSS sky130_fd_pr__nfet_g5v0d10v5 ad=0.65 pd=3.3 as=0 ps=0 w=1 l=0.5
X4715 rr3t3r_0[65|10]/a_860_290# WL65 SL10 VSS sky130_fd_pr__nfet_g5v0d10v5 ad=0.65 pd=3.3 as=0 ps=0 w=1 l=0.5
X4716 BLP10 rr3t3r_0[66|10]/a_60_290# sky130_fd_pr_reram__reram_cell area_ox=0.0676
X4717 BLZ10 rr3t3r_0[66|10]/a_460_290# sky130_fd_pr_reram__reram_cell area_ox=0.0676
X4718 rr3t3r_0[66|10]/a_460_290# WL66 SL10 VSS sky130_fd_pr__nfet_g5v0d10v5 ad=0.65 pd=3.3 as=0 ps=0 w=1 l=0.5
X4719 BLN10 rr3t3r_0[66|10]/a_860_290# sky130_fd_pr_reram__reram_cell area_ox=0.0676
X4720 rr3t3r_0[66|10]/a_60_290# WL66 SL10 VSS sky130_fd_pr__nfet_g5v0d10v5 ad=0.65 pd=3.3 as=0 ps=0 w=1 l=0.5
X4721 rr3t3r_0[66|10]/a_860_290# WL66 SL10 VSS sky130_fd_pr__nfet_g5v0d10v5 ad=0.65 pd=3.3 as=0 ps=0 w=1 l=0.5
X4722 BLP10 rr3t3r_0[67|10]/a_60_290# sky130_fd_pr_reram__reram_cell area_ox=0.0676
X4723 BLZ10 rr3t3r_0[67|10]/a_460_290# sky130_fd_pr_reram__reram_cell area_ox=0.0676
X4724 rr3t3r_0[67|10]/a_460_290# WL67 SL10 VSS sky130_fd_pr__nfet_g5v0d10v5 ad=0.65 pd=3.3 as=0 ps=0 w=1 l=0.5
X4725 BLN10 rr3t3r_0[67|10]/a_860_290# sky130_fd_pr_reram__reram_cell area_ox=0.0676
X4726 rr3t3r_0[67|10]/a_60_290# WL67 SL10 VSS sky130_fd_pr__nfet_g5v0d10v5 ad=0.65 pd=3.3 as=0 ps=0 w=1 l=0.5
X4727 rr3t3r_0[67|10]/a_860_290# WL67 SL10 VSS sky130_fd_pr__nfet_g5v0d10v5 ad=0.65 pd=3.3 as=0 ps=0 w=1 l=0.5
X4728 BLP10 rr3t3r_0[68|10]/a_60_290# sky130_fd_pr_reram__reram_cell area_ox=0.0676
X4729 BLZ10 rr3t3r_0[68|10]/a_460_290# sky130_fd_pr_reram__reram_cell area_ox=0.0676
X4730 rr3t3r_0[68|10]/a_460_290# WL68 SL10 VSS sky130_fd_pr__nfet_g5v0d10v5 ad=0.65 pd=3.3 as=0 ps=0 w=1 l=0.5
X4731 BLN10 rr3t3r_0[68|10]/a_860_290# sky130_fd_pr_reram__reram_cell area_ox=0.0676
X4732 rr3t3r_0[68|10]/a_60_290# WL68 SL10 VSS sky130_fd_pr__nfet_g5v0d10v5 ad=0.65 pd=3.3 as=0 ps=0 w=1 l=0.5
X4733 rr3t3r_0[68|10]/a_860_290# WL68 SL10 VSS sky130_fd_pr__nfet_g5v0d10v5 ad=0.65 pd=3.3 as=0 ps=0 w=1 l=0.5
X4734 BLP10 rr3t3r_0[69|10]/a_60_290# sky130_fd_pr_reram__reram_cell area_ox=0.0676
X4735 BLZ10 rr3t3r_0[69|10]/a_460_290# sky130_fd_pr_reram__reram_cell area_ox=0.0676
X4736 rr3t3r_0[69|10]/a_460_290# WL69 SL10 VSS sky130_fd_pr__nfet_g5v0d10v5 ad=0.65 pd=3.3 as=0 ps=0 w=1 l=0.5
X4737 BLN10 rr3t3r_0[69|10]/a_860_290# sky130_fd_pr_reram__reram_cell area_ox=0.0676
X4738 rr3t3r_0[69|10]/a_60_290# WL69 SL10 VSS sky130_fd_pr__nfet_g5v0d10v5 ad=0.65 pd=3.3 as=0 ps=0 w=1 l=0.5
X4739 rr3t3r_0[69|10]/a_860_290# WL69 SL10 VSS sky130_fd_pr__nfet_g5v0d10v5 ad=0.65 pd=3.3 as=0 ps=0 w=1 l=0.5
X4740 BLP10 rr3t3r_0[70|10]/a_60_290# sky130_fd_pr_reram__reram_cell area_ox=0.0676
X4741 BLZ10 rr3t3r_0[70|10]/a_460_290# sky130_fd_pr_reram__reram_cell area_ox=0.0676
X4742 rr3t3r_0[70|10]/a_460_290# WL70 SL10 VSS sky130_fd_pr__nfet_g5v0d10v5 ad=0.65 pd=3.3 as=0 ps=0 w=1 l=0.5
X4743 BLN10 rr3t3r_0[70|10]/a_860_290# sky130_fd_pr_reram__reram_cell area_ox=0.0676
X4744 rr3t3r_0[70|10]/a_60_290# WL70 SL10 VSS sky130_fd_pr__nfet_g5v0d10v5 ad=0.65 pd=3.3 as=0 ps=0 w=1 l=0.5
X4745 rr3t3r_0[70|10]/a_860_290# WL70 SL10 VSS sky130_fd_pr__nfet_g5v0d10v5 ad=0.65 pd=3.3 as=0 ps=0 w=1 l=0.5
X4746 BLP10 rr3t3r_0[71|10]/a_60_290# sky130_fd_pr_reram__reram_cell area_ox=0.0676
X4747 BLZ10 rr3t3r_0[71|10]/a_460_290# sky130_fd_pr_reram__reram_cell area_ox=0.0676
X4748 rr3t3r_0[71|10]/a_460_290# WL71 SL10 VSS sky130_fd_pr__nfet_g5v0d10v5 ad=0.65 pd=3.3 as=0 ps=0 w=1 l=0.5
X4749 BLN10 rr3t3r_0[71|10]/a_860_290# sky130_fd_pr_reram__reram_cell area_ox=0.0676
X4750 rr3t3r_0[71|10]/a_60_290# WL71 SL10 VSS sky130_fd_pr__nfet_g5v0d10v5 ad=0.65 pd=3.3 as=0 ps=0 w=1 l=0.5
X4751 rr3t3r_0[71|10]/a_860_290# WL71 SL10 VSS sky130_fd_pr__nfet_g5v0d10v5 ad=0.65 pd=3.3 as=0 ps=0 w=1 l=0.5
X4752 BLP11 rr3t3r_0[0|11]/a_60_290# sky130_fd_pr_reram__reram_cell area_ox=0.0676
X4753 BLZ11 rr3t3r_0[0|11]/a_460_290# sky130_fd_pr_reram__reram_cell area_ox=0.0676
X4754 rr3t3r_0[0|11]/a_460_290# WL0 SL11 VSS sky130_fd_pr__nfet_g5v0d10v5 ad=0.65 pd=3.3 as=162 ps=756 w=1 l=0.5
X4755 BLN11 rr3t3r_0[0|11]/a_860_290# sky130_fd_pr_reram__reram_cell area_ox=0.0676
X4756 rr3t3r_0[0|11]/a_60_290# WL0 SL11 VSS sky130_fd_pr__nfet_g5v0d10v5 ad=0.65 pd=3.3 as=0 ps=0 w=1 l=0.5
X4757 rr3t3r_0[0|11]/a_860_290# WL0 SL11 VSS sky130_fd_pr__nfet_g5v0d10v5 ad=0.65 pd=3.3 as=0 ps=0 w=1 l=0.5
X4758 BLP11 rr3t3r_0[1|11]/a_60_290# sky130_fd_pr_reram__reram_cell area_ox=0.0676
X4759 BLZ11 rr3t3r_0[1|11]/a_460_290# sky130_fd_pr_reram__reram_cell area_ox=0.0676
X4760 rr3t3r_0[1|11]/a_460_290# WL1 SL11 VSS sky130_fd_pr__nfet_g5v0d10v5 ad=0.65 pd=3.3 as=0 ps=0 w=1 l=0.5
X4761 BLN11 rr3t3r_0[1|11]/a_860_290# sky130_fd_pr_reram__reram_cell area_ox=0.0676
X4762 rr3t3r_0[1|11]/a_60_290# WL1 SL11 VSS sky130_fd_pr__nfet_g5v0d10v5 ad=0.65 pd=3.3 as=0 ps=0 w=1 l=0.5
X4763 rr3t3r_0[1|11]/a_860_290# WL1 SL11 VSS sky130_fd_pr__nfet_g5v0d10v5 ad=0.65 pd=3.3 as=0 ps=0 w=1 l=0.5
X4764 BLP11 rr3t3r_0[2|11]/a_60_290# sky130_fd_pr_reram__reram_cell area_ox=0.0676
X4765 BLZ11 rr3t3r_0[2|11]/a_460_290# sky130_fd_pr_reram__reram_cell area_ox=0.0676
X4766 rr3t3r_0[2|11]/a_460_290# WL2 SL11 VSS sky130_fd_pr__nfet_g5v0d10v5 ad=0.65 pd=3.3 as=0 ps=0 w=1 l=0.5
X4767 BLN11 rr3t3r_0[2|11]/a_860_290# sky130_fd_pr_reram__reram_cell area_ox=0.0676
X4768 rr3t3r_0[2|11]/a_60_290# WL2 SL11 VSS sky130_fd_pr__nfet_g5v0d10v5 ad=0.65 pd=3.3 as=0 ps=0 w=1 l=0.5
X4769 rr3t3r_0[2|11]/a_860_290# WL2 SL11 VSS sky130_fd_pr__nfet_g5v0d10v5 ad=0.65 pd=3.3 as=0 ps=0 w=1 l=0.5
X4770 BLP11 rr3t3r_0[3|11]/a_60_290# sky130_fd_pr_reram__reram_cell area_ox=0.0676
X4771 BLZ11 rr3t3r_0[3|11]/a_460_290# sky130_fd_pr_reram__reram_cell area_ox=0.0676
X4772 rr3t3r_0[3|11]/a_460_290# WL3 SL11 VSS sky130_fd_pr__nfet_g5v0d10v5 ad=0.65 pd=3.3 as=0 ps=0 w=1 l=0.5
X4773 BLN11 rr3t3r_0[3|11]/a_860_290# sky130_fd_pr_reram__reram_cell area_ox=0.0676
X4774 rr3t3r_0[3|11]/a_60_290# WL3 SL11 VSS sky130_fd_pr__nfet_g5v0d10v5 ad=0.65 pd=3.3 as=0 ps=0 w=1 l=0.5
X4775 rr3t3r_0[3|11]/a_860_290# WL3 SL11 VSS sky130_fd_pr__nfet_g5v0d10v5 ad=0.65 pd=3.3 as=0 ps=0 w=1 l=0.5
X4776 BLP11 rr3t3r_0[4|11]/a_60_290# sky130_fd_pr_reram__reram_cell area_ox=0.0676
X4777 BLZ11 rr3t3r_0[4|11]/a_460_290# sky130_fd_pr_reram__reram_cell area_ox=0.0676
X4778 rr3t3r_0[4|11]/a_460_290# WL4 SL11 VSS sky130_fd_pr__nfet_g5v0d10v5 ad=0.65 pd=3.3 as=0 ps=0 w=1 l=0.5
X4779 BLN11 rr3t3r_0[4|11]/a_860_290# sky130_fd_pr_reram__reram_cell area_ox=0.0676
X4780 rr3t3r_0[4|11]/a_60_290# WL4 SL11 VSS sky130_fd_pr__nfet_g5v0d10v5 ad=0.65 pd=3.3 as=0 ps=0 w=1 l=0.5
X4781 rr3t3r_0[4|11]/a_860_290# WL4 SL11 VSS sky130_fd_pr__nfet_g5v0d10v5 ad=0.65 pd=3.3 as=0 ps=0 w=1 l=0.5
X4782 BLP11 rr3t3r_0[5|11]/a_60_290# sky130_fd_pr_reram__reram_cell area_ox=0.0676
X4783 BLZ11 rr3t3r_0[5|11]/a_460_290# sky130_fd_pr_reram__reram_cell area_ox=0.0676
X4784 rr3t3r_0[5|11]/a_460_290# WL5 SL11 VSS sky130_fd_pr__nfet_g5v0d10v5 ad=0.65 pd=3.3 as=0 ps=0 w=1 l=0.5
X4785 BLN11 rr3t3r_0[5|11]/a_860_290# sky130_fd_pr_reram__reram_cell area_ox=0.0676
X4786 rr3t3r_0[5|11]/a_60_290# WL5 SL11 VSS sky130_fd_pr__nfet_g5v0d10v5 ad=0.65 pd=3.3 as=0 ps=0 w=1 l=0.5
X4787 rr3t3r_0[5|11]/a_860_290# WL5 SL11 VSS sky130_fd_pr__nfet_g5v0d10v5 ad=0.65 pd=3.3 as=0 ps=0 w=1 l=0.5
X4788 BLP11 rr3t3r_0[6|11]/a_60_290# sky130_fd_pr_reram__reram_cell area_ox=0.0676
X4789 BLZ11 rr3t3r_0[6|11]/a_460_290# sky130_fd_pr_reram__reram_cell area_ox=0.0676
X4790 rr3t3r_0[6|11]/a_460_290# WL6 SL11 VSS sky130_fd_pr__nfet_g5v0d10v5 ad=0.65 pd=3.3 as=0 ps=0 w=1 l=0.5
X4791 BLN11 rr3t3r_0[6|11]/a_860_290# sky130_fd_pr_reram__reram_cell area_ox=0.0676
X4792 rr3t3r_0[6|11]/a_60_290# WL6 SL11 VSS sky130_fd_pr__nfet_g5v0d10v5 ad=0.65 pd=3.3 as=0 ps=0 w=1 l=0.5
X4793 rr3t3r_0[6|11]/a_860_290# WL6 SL11 VSS sky130_fd_pr__nfet_g5v0d10v5 ad=0.65 pd=3.3 as=0 ps=0 w=1 l=0.5
X4794 BLP11 rr3t3r_0[7|11]/a_60_290# sky130_fd_pr_reram__reram_cell area_ox=0.0676
X4795 BLZ11 rr3t3r_0[7|11]/a_460_290# sky130_fd_pr_reram__reram_cell area_ox=0.0676
X4796 rr3t3r_0[7|11]/a_460_290# WL7 SL11 VSS sky130_fd_pr__nfet_g5v0d10v5 ad=0.65 pd=3.3 as=0 ps=0 w=1 l=0.5
X4797 BLN11 rr3t3r_0[7|11]/a_860_290# sky130_fd_pr_reram__reram_cell area_ox=0.0676
X4798 rr3t3r_0[7|11]/a_60_290# WL7 SL11 VSS sky130_fd_pr__nfet_g5v0d10v5 ad=0.65 pd=3.3 as=0 ps=0 w=1 l=0.5
X4799 rr3t3r_0[7|11]/a_860_290# WL7 SL11 VSS sky130_fd_pr__nfet_g5v0d10v5 ad=0.65 pd=3.3 as=0 ps=0 w=1 l=0.5
X4800 BLP11 rr3t3r_0[8|11]/a_60_290# sky130_fd_pr_reram__reram_cell area_ox=0.0676
X4801 BLZ11 rr3t3r_0[8|11]/a_460_290# sky130_fd_pr_reram__reram_cell area_ox=0.0676
X4802 rr3t3r_0[8|11]/a_460_290# WL8 SL11 VSS sky130_fd_pr__nfet_g5v0d10v5 ad=0.65 pd=3.3 as=0 ps=0 w=1 l=0.5
X4803 BLN11 rr3t3r_0[8|11]/a_860_290# sky130_fd_pr_reram__reram_cell area_ox=0.0676
X4804 rr3t3r_0[8|11]/a_60_290# WL8 SL11 VSS sky130_fd_pr__nfet_g5v0d10v5 ad=0.65 pd=3.3 as=0 ps=0 w=1 l=0.5
X4805 rr3t3r_0[8|11]/a_860_290# WL8 SL11 VSS sky130_fd_pr__nfet_g5v0d10v5 ad=0.65 pd=3.3 as=0 ps=0 w=1 l=0.5
X4806 BLP11 rr3t3r_0[9|11]/a_60_290# sky130_fd_pr_reram__reram_cell area_ox=0.0676
X4807 BLZ11 rr3t3r_0[9|11]/a_460_290# sky130_fd_pr_reram__reram_cell area_ox=0.0676
X4808 rr3t3r_0[9|11]/a_460_290# WL9 SL11 VSS sky130_fd_pr__nfet_g5v0d10v5 ad=0.65 pd=3.3 as=0 ps=0 w=1 l=0.5
X4809 BLN11 rr3t3r_0[9|11]/a_860_290# sky130_fd_pr_reram__reram_cell area_ox=0.0676
X4810 rr3t3r_0[9|11]/a_60_290# WL9 SL11 VSS sky130_fd_pr__nfet_g5v0d10v5 ad=0.65 pd=3.3 as=0 ps=0 w=1 l=0.5
X4811 rr3t3r_0[9|11]/a_860_290# WL9 SL11 VSS sky130_fd_pr__nfet_g5v0d10v5 ad=0.65 pd=3.3 as=0 ps=0 w=1 l=0.5
X4812 BLP11 rr3t3r_0[10|11]/a_60_290# sky130_fd_pr_reram__reram_cell area_ox=0.0676
X4813 BLZ11 rr3t3r_0[10|11]/a_460_290# sky130_fd_pr_reram__reram_cell area_ox=0.0676
X4814 rr3t3r_0[10|11]/a_460_290# WL10 SL11 VSS sky130_fd_pr__nfet_g5v0d10v5 ad=0.65 pd=3.3 as=0 ps=0 w=1 l=0.5
X4815 BLN11 rr3t3r_0[10|11]/a_860_290# sky130_fd_pr_reram__reram_cell area_ox=0.0676
X4816 rr3t3r_0[10|11]/a_60_290# WL10 SL11 VSS sky130_fd_pr__nfet_g5v0d10v5 ad=0.65 pd=3.3 as=0 ps=0 w=1 l=0.5
X4817 rr3t3r_0[10|11]/a_860_290# WL10 SL11 VSS sky130_fd_pr__nfet_g5v0d10v5 ad=0.65 pd=3.3 as=0 ps=0 w=1 l=0.5
X4818 BLP11 rr3t3r_0[11|11]/a_60_290# sky130_fd_pr_reram__reram_cell area_ox=0.0676
X4819 BLZ11 rr3t3r_0[11|11]/a_460_290# sky130_fd_pr_reram__reram_cell area_ox=0.0676
X4820 rr3t3r_0[11|11]/a_460_290# WL11 SL11 VSS sky130_fd_pr__nfet_g5v0d10v5 ad=0.65 pd=3.3 as=0 ps=0 w=1 l=0.5
X4821 BLN11 rr3t3r_0[11|11]/a_860_290# sky130_fd_pr_reram__reram_cell area_ox=0.0676
X4822 rr3t3r_0[11|11]/a_60_290# WL11 SL11 VSS sky130_fd_pr__nfet_g5v0d10v5 ad=0.65 pd=3.3 as=0 ps=0 w=1 l=0.5
X4823 rr3t3r_0[11|11]/a_860_290# WL11 SL11 VSS sky130_fd_pr__nfet_g5v0d10v5 ad=0.65 pd=3.3 as=0 ps=0 w=1 l=0.5
X4824 BLP11 rr3t3r_0[12|11]/a_60_290# sky130_fd_pr_reram__reram_cell area_ox=0.0676
X4825 BLZ11 rr3t3r_0[12|11]/a_460_290# sky130_fd_pr_reram__reram_cell area_ox=0.0676
X4826 rr3t3r_0[12|11]/a_460_290# WL12 SL11 VSS sky130_fd_pr__nfet_g5v0d10v5 ad=0.65 pd=3.3 as=0 ps=0 w=1 l=0.5
X4827 BLN11 rr3t3r_0[12|11]/a_860_290# sky130_fd_pr_reram__reram_cell area_ox=0.0676
X4828 rr3t3r_0[12|11]/a_60_290# WL12 SL11 VSS sky130_fd_pr__nfet_g5v0d10v5 ad=0.65 pd=3.3 as=0 ps=0 w=1 l=0.5
X4829 rr3t3r_0[12|11]/a_860_290# WL12 SL11 VSS sky130_fd_pr__nfet_g5v0d10v5 ad=0.65 pd=3.3 as=0 ps=0 w=1 l=0.5
X4830 BLP11 rr3t3r_0[13|11]/a_60_290# sky130_fd_pr_reram__reram_cell area_ox=0.0676
X4831 BLZ11 rr3t3r_0[13|11]/a_460_290# sky130_fd_pr_reram__reram_cell area_ox=0.0676
X4832 rr3t3r_0[13|11]/a_460_290# WL13 SL11 VSS sky130_fd_pr__nfet_g5v0d10v5 ad=0.65 pd=3.3 as=0 ps=0 w=1 l=0.5
X4833 BLN11 rr3t3r_0[13|11]/a_860_290# sky130_fd_pr_reram__reram_cell area_ox=0.0676
X4834 rr3t3r_0[13|11]/a_60_290# WL13 SL11 VSS sky130_fd_pr__nfet_g5v0d10v5 ad=0.65 pd=3.3 as=0 ps=0 w=1 l=0.5
X4835 rr3t3r_0[13|11]/a_860_290# WL13 SL11 VSS sky130_fd_pr__nfet_g5v0d10v5 ad=0.65 pd=3.3 as=0 ps=0 w=1 l=0.5
X4836 BLP11 rr3t3r_0[14|11]/a_60_290# sky130_fd_pr_reram__reram_cell area_ox=0.0676
X4837 BLZ11 rr3t3r_0[14|11]/a_460_290# sky130_fd_pr_reram__reram_cell area_ox=0.0676
X4838 rr3t3r_0[14|11]/a_460_290# WL14 SL11 VSS sky130_fd_pr__nfet_g5v0d10v5 ad=0.65 pd=3.3 as=0 ps=0 w=1 l=0.5
X4839 BLN11 rr3t3r_0[14|11]/a_860_290# sky130_fd_pr_reram__reram_cell area_ox=0.0676
X4840 rr3t3r_0[14|11]/a_60_290# WL14 SL11 VSS sky130_fd_pr__nfet_g5v0d10v5 ad=0.65 pd=3.3 as=0 ps=0 w=1 l=0.5
X4841 rr3t3r_0[14|11]/a_860_290# WL14 SL11 VSS sky130_fd_pr__nfet_g5v0d10v5 ad=0.65 pd=3.3 as=0 ps=0 w=1 l=0.5
X4842 BLP11 rr3t3r_0[15|11]/a_60_290# sky130_fd_pr_reram__reram_cell area_ox=0.0676
X4843 BLZ11 rr3t3r_0[15|11]/a_460_290# sky130_fd_pr_reram__reram_cell area_ox=0.0676
X4844 rr3t3r_0[15|11]/a_460_290# WL15 SL11 VSS sky130_fd_pr__nfet_g5v0d10v5 ad=0.65 pd=3.3 as=0 ps=0 w=1 l=0.5
X4845 BLN11 rr3t3r_0[15|11]/a_860_290# sky130_fd_pr_reram__reram_cell area_ox=0.0676
X4846 rr3t3r_0[15|11]/a_60_290# WL15 SL11 VSS sky130_fd_pr__nfet_g5v0d10v5 ad=0.65 pd=3.3 as=0 ps=0 w=1 l=0.5
X4847 rr3t3r_0[15|11]/a_860_290# WL15 SL11 VSS sky130_fd_pr__nfet_g5v0d10v5 ad=0.65 pd=3.3 as=0 ps=0 w=1 l=0.5
X4848 BLP11 rr3t3r_0[16|11]/a_60_290# sky130_fd_pr_reram__reram_cell area_ox=0.0676
X4849 BLZ11 rr3t3r_0[16|11]/a_460_290# sky130_fd_pr_reram__reram_cell area_ox=0.0676
X4850 rr3t3r_0[16|11]/a_460_290# WL16 SL11 VSS sky130_fd_pr__nfet_g5v0d10v5 ad=0.65 pd=3.3 as=0 ps=0 w=1 l=0.5
X4851 BLN11 rr3t3r_0[16|11]/a_860_290# sky130_fd_pr_reram__reram_cell area_ox=0.0676
X4852 rr3t3r_0[16|11]/a_60_290# WL16 SL11 VSS sky130_fd_pr__nfet_g5v0d10v5 ad=0.65 pd=3.3 as=0 ps=0 w=1 l=0.5
X4853 rr3t3r_0[16|11]/a_860_290# WL16 SL11 VSS sky130_fd_pr__nfet_g5v0d10v5 ad=0.65 pd=3.3 as=0 ps=0 w=1 l=0.5
X4854 BLP11 rr3t3r_0[17|11]/a_60_290# sky130_fd_pr_reram__reram_cell area_ox=0.0676
X4855 BLZ11 rr3t3r_0[17|11]/a_460_290# sky130_fd_pr_reram__reram_cell area_ox=0.0676
X4856 rr3t3r_0[17|11]/a_460_290# WL17 SL11 VSS sky130_fd_pr__nfet_g5v0d10v5 ad=0.65 pd=3.3 as=0 ps=0 w=1 l=0.5
X4857 BLN11 rr3t3r_0[17|11]/a_860_290# sky130_fd_pr_reram__reram_cell area_ox=0.0676
X4858 rr3t3r_0[17|11]/a_60_290# WL17 SL11 VSS sky130_fd_pr__nfet_g5v0d10v5 ad=0.65 pd=3.3 as=0 ps=0 w=1 l=0.5
X4859 rr3t3r_0[17|11]/a_860_290# WL17 SL11 VSS sky130_fd_pr__nfet_g5v0d10v5 ad=0.65 pd=3.3 as=0 ps=0 w=1 l=0.5
X4860 BLP11 rr3t3r_0[18|11]/a_60_290# sky130_fd_pr_reram__reram_cell area_ox=0.0676
X4861 BLZ11 rr3t3r_0[18|11]/a_460_290# sky130_fd_pr_reram__reram_cell area_ox=0.0676
X4862 rr3t3r_0[18|11]/a_460_290# WL18 SL11 VSS sky130_fd_pr__nfet_g5v0d10v5 ad=0.65 pd=3.3 as=0 ps=0 w=1 l=0.5
X4863 BLN11 rr3t3r_0[18|11]/a_860_290# sky130_fd_pr_reram__reram_cell area_ox=0.0676
X4864 rr3t3r_0[18|11]/a_60_290# WL18 SL11 VSS sky130_fd_pr__nfet_g5v0d10v5 ad=0.65 pd=3.3 as=0 ps=0 w=1 l=0.5
X4865 rr3t3r_0[18|11]/a_860_290# WL18 SL11 VSS sky130_fd_pr__nfet_g5v0d10v5 ad=0.65 pd=3.3 as=0 ps=0 w=1 l=0.5
X4866 BLP11 rr3t3r_0[19|11]/a_60_290# sky130_fd_pr_reram__reram_cell area_ox=0.0676
X4867 BLZ11 rr3t3r_0[19|11]/a_460_290# sky130_fd_pr_reram__reram_cell area_ox=0.0676
X4868 rr3t3r_0[19|11]/a_460_290# WL19 SL11 VSS sky130_fd_pr__nfet_g5v0d10v5 ad=0.65 pd=3.3 as=0 ps=0 w=1 l=0.5
X4869 BLN11 rr3t3r_0[19|11]/a_860_290# sky130_fd_pr_reram__reram_cell area_ox=0.0676
X4870 rr3t3r_0[19|11]/a_60_290# WL19 SL11 VSS sky130_fd_pr__nfet_g5v0d10v5 ad=0.65 pd=3.3 as=0 ps=0 w=1 l=0.5
X4871 rr3t3r_0[19|11]/a_860_290# WL19 SL11 VSS sky130_fd_pr__nfet_g5v0d10v5 ad=0.65 pd=3.3 as=0 ps=0 w=1 l=0.5
X4872 BLP11 rr3t3r_0[20|11]/a_60_290# sky130_fd_pr_reram__reram_cell area_ox=0.0676
X4873 BLZ11 rr3t3r_0[20|11]/a_460_290# sky130_fd_pr_reram__reram_cell area_ox=0.0676
X4874 rr3t3r_0[20|11]/a_460_290# WL20 SL11 VSS sky130_fd_pr__nfet_g5v0d10v5 ad=0.65 pd=3.3 as=0 ps=0 w=1 l=0.5
X4875 BLN11 rr3t3r_0[20|11]/a_860_290# sky130_fd_pr_reram__reram_cell area_ox=0.0676
X4876 rr3t3r_0[20|11]/a_60_290# WL20 SL11 VSS sky130_fd_pr__nfet_g5v0d10v5 ad=0.65 pd=3.3 as=0 ps=0 w=1 l=0.5
X4877 rr3t3r_0[20|11]/a_860_290# WL20 SL11 VSS sky130_fd_pr__nfet_g5v0d10v5 ad=0.65 pd=3.3 as=0 ps=0 w=1 l=0.5
X4878 BLP11 rr3t3r_0[21|11]/a_60_290# sky130_fd_pr_reram__reram_cell area_ox=0.0676
X4879 BLZ11 rr3t3r_0[21|11]/a_460_290# sky130_fd_pr_reram__reram_cell area_ox=0.0676
X4880 rr3t3r_0[21|11]/a_460_290# WL21 SL11 VSS sky130_fd_pr__nfet_g5v0d10v5 ad=0.65 pd=3.3 as=0 ps=0 w=1 l=0.5
X4881 BLN11 rr3t3r_0[21|11]/a_860_290# sky130_fd_pr_reram__reram_cell area_ox=0.0676
X4882 rr3t3r_0[21|11]/a_60_290# WL21 SL11 VSS sky130_fd_pr__nfet_g5v0d10v5 ad=0.65 pd=3.3 as=0 ps=0 w=1 l=0.5
X4883 rr3t3r_0[21|11]/a_860_290# WL21 SL11 VSS sky130_fd_pr__nfet_g5v0d10v5 ad=0.65 pd=3.3 as=0 ps=0 w=1 l=0.5
X4884 BLP11 rr3t3r_0[22|11]/a_60_290# sky130_fd_pr_reram__reram_cell area_ox=0.0676
X4885 BLZ11 rr3t3r_0[22|11]/a_460_290# sky130_fd_pr_reram__reram_cell area_ox=0.0676
X4886 rr3t3r_0[22|11]/a_460_290# WL22 SL11 VSS sky130_fd_pr__nfet_g5v0d10v5 ad=0.65 pd=3.3 as=0 ps=0 w=1 l=0.5
X4887 BLN11 rr3t3r_0[22|11]/a_860_290# sky130_fd_pr_reram__reram_cell area_ox=0.0676
X4888 rr3t3r_0[22|11]/a_60_290# WL22 SL11 VSS sky130_fd_pr__nfet_g5v0d10v5 ad=0.65 pd=3.3 as=0 ps=0 w=1 l=0.5
X4889 rr3t3r_0[22|11]/a_860_290# WL22 SL11 VSS sky130_fd_pr__nfet_g5v0d10v5 ad=0.65 pd=3.3 as=0 ps=0 w=1 l=0.5
X4890 BLP11 rr3t3r_0[23|11]/a_60_290# sky130_fd_pr_reram__reram_cell area_ox=0.0676
X4891 BLZ11 rr3t3r_0[23|11]/a_460_290# sky130_fd_pr_reram__reram_cell area_ox=0.0676
X4892 rr3t3r_0[23|11]/a_460_290# WL23 SL11 VSS sky130_fd_pr__nfet_g5v0d10v5 ad=0.65 pd=3.3 as=0 ps=0 w=1 l=0.5
X4893 BLN11 rr3t3r_0[23|11]/a_860_290# sky130_fd_pr_reram__reram_cell area_ox=0.0676
X4894 rr3t3r_0[23|11]/a_60_290# WL23 SL11 VSS sky130_fd_pr__nfet_g5v0d10v5 ad=0.65 pd=3.3 as=0 ps=0 w=1 l=0.5
X4895 rr3t3r_0[23|11]/a_860_290# WL23 SL11 VSS sky130_fd_pr__nfet_g5v0d10v5 ad=0.65 pd=3.3 as=0 ps=0 w=1 l=0.5
X4896 BLP11 rr3t3r_0[24|11]/a_60_290# sky130_fd_pr_reram__reram_cell area_ox=0.0676
X4897 BLZ11 rr3t3r_0[24|11]/a_460_290# sky130_fd_pr_reram__reram_cell area_ox=0.0676
X4898 rr3t3r_0[24|11]/a_460_290# WL24 SL11 VSS sky130_fd_pr__nfet_g5v0d10v5 ad=0.65 pd=3.3 as=0 ps=0 w=1 l=0.5
X4899 BLN11 rr3t3r_0[24|11]/a_860_290# sky130_fd_pr_reram__reram_cell area_ox=0.0676
X4900 rr3t3r_0[24|11]/a_60_290# WL24 SL11 VSS sky130_fd_pr__nfet_g5v0d10v5 ad=0.65 pd=3.3 as=0 ps=0 w=1 l=0.5
X4901 rr3t3r_0[24|11]/a_860_290# WL24 SL11 VSS sky130_fd_pr__nfet_g5v0d10v5 ad=0.65 pd=3.3 as=0 ps=0 w=1 l=0.5
X4902 BLP11 rr3t3r_0[25|11]/a_60_290# sky130_fd_pr_reram__reram_cell area_ox=0.0676
X4903 BLZ11 rr3t3r_0[25|11]/a_460_290# sky130_fd_pr_reram__reram_cell area_ox=0.0676
X4904 rr3t3r_0[25|11]/a_460_290# WL25 SL11 VSS sky130_fd_pr__nfet_g5v0d10v5 ad=0.65 pd=3.3 as=0 ps=0 w=1 l=0.5
X4905 BLN11 rr3t3r_0[25|11]/a_860_290# sky130_fd_pr_reram__reram_cell area_ox=0.0676
X4906 rr3t3r_0[25|11]/a_60_290# WL25 SL11 VSS sky130_fd_pr__nfet_g5v0d10v5 ad=0.65 pd=3.3 as=0 ps=0 w=1 l=0.5
X4907 rr3t3r_0[25|11]/a_860_290# WL25 SL11 VSS sky130_fd_pr__nfet_g5v0d10v5 ad=0.65 pd=3.3 as=0 ps=0 w=1 l=0.5
X4908 BLP11 rr3t3r_0[26|11]/a_60_290# sky130_fd_pr_reram__reram_cell area_ox=0.0676
X4909 BLZ11 rr3t3r_0[26|11]/a_460_290# sky130_fd_pr_reram__reram_cell area_ox=0.0676
X4910 rr3t3r_0[26|11]/a_460_290# WL26 SL11 VSS sky130_fd_pr__nfet_g5v0d10v5 ad=0.65 pd=3.3 as=0 ps=0 w=1 l=0.5
X4911 BLN11 rr3t3r_0[26|11]/a_860_290# sky130_fd_pr_reram__reram_cell area_ox=0.0676
X4912 rr3t3r_0[26|11]/a_60_290# WL26 SL11 VSS sky130_fd_pr__nfet_g5v0d10v5 ad=0.65 pd=3.3 as=0 ps=0 w=1 l=0.5
X4913 rr3t3r_0[26|11]/a_860_290# WL26 SL11 VSS sky130_fd_pr__nfet_g5v0d10v5 ad=0.65 pd=3.3 as=0 ps=0 w=1 l=0.5
X4914 BLP11 rr3t3r_0[27|11]/a_60_290# sky130_fd_pr_reram__reram_cell area_ox=0.0676
X4915 BLZ11 rr3t3r_0[27|11]/a_460_290# sky130_fd_pr_reram__reram_cell area_ox=0.0676
X4916 rr3t3r_0[27|11]/a_460_290# WL27 SL11 VSS sky130_fd_pr__nfet_g5v0d10v5 ad=0.65 pd=3.3 as=0 ps=0 w=1 l=0.5
X4917 BLN11 rr3t3r_0[27|11]/a_860_290# sky130_fd_pr_reram__reram_cell area_ox=0.0676
X4918 rr3t3r_0[27|11]/a_60_290# WL27 SL11 VSS sky130_fd_pr__nfet_g5v0d10v5 ad=0.65 pd=3.3 as=0 ps=0 w=1 l=0.5
X4919 rr3t3r_0[27|11]/a_860_290# WL27 SL11 VSS sky130_fd_pr__nfet_g5v0d10v5 ad=0.65 pd=3.3 as=0 ps=0 w=1 l=0.5
X4920 BLP11 rr3t3r_0[28|11]/a_60_290# sky130_fd_pr_reram__reram_cell area_ox=0.0676
X4921 BLZ11 rr3t3r_0[28|11]/a_460_290# sky130_fd_pr_reram__reram_cell area_ox=0.0676
X4922 rr3t3r_0[28|11]/a_460_290# WL28 SL11 VSS sky130_fd_pr__nfet_g5v0d10v5 ad=0.65 pd=3.3 as=0 ps=0 w=1 l=0.5
X4923 BLN11 rr3t3r_0[28|11]/a_860_290# sky130_fd_pr_reram__reram_cell area_ox=0.0676
X4924 rr3t3r_0[28|11]/a_60_290# WL28 SL11 VSS sky130_fd_pr__nfet_g5v0d10v5 ad=0.65 pd=3.3 as=0 ps=0 w=1 l=0.5
X4925 rr3t3r_0[28|11]/a_860_290# WL28 SL11 VSS sky130_fd_pr__nfet_g5v0d10v5 ad=0.65 pd=3.3 as=0 ps=0 w=1 l=0.5
X4926 BLP11 rr3t3r_0[29|11]/a_60_290# sky130_fd_pr_reram__reram_cell area_ox=0.0676
X4927 BLZ11 rr3t3r_0[29|11]/a_460_290# sky130_fd_pr_reram__reram_cell area_ox=0.0676
X4928 rr3t3r_0[29|11]/a_460_290# WL29 SL11 VSS sky130_fd_pr__nfet_g5v0d10v5 ad=0.65 pd=3.3 as=0 ps=0 w=1 l=0.5
X4929 BLN11 rr3t3r_0[29|11]/a_860_290# sky130_fd_pr_reram__reram_cell area_ox=0.0676
X4930 rr3t3r_0[29|11]/a_60_290# WL29 SL11 VSS sky130_fd_pr__nfet_g5v0d10v5 ad=0.65 pd=3.3 as=0 ps=0 w=1 l=0.5
X4931 rr3t3r_0[29|11]/a_860_290# WL29 SL11 VSS sky130_fd_pr__nfet_g5v0d10v5 ad=0.65 pd=3.3 as=0 ps=0 w=1 l=0.5
X4932 BLP11 rr3t3r_0[30|11]/a_60_290# sky130_fd_pr_reram__reram_cell area_ox=0.0676
X4933 BLZ11 rr3t3r_0[30|11]/a_460_290# sky130_fd_pr_reram__reram_cell area_ox=0.0676
X4934 rr3t3r_0[30|11]/a_460_290# WL30 SL11 VSS sky130_fd_pr__nfet_g5v0d10v5 ad=0.65 pd=3.3 as=0 ps=0 w=1 l=0.5
X4935 BLN11 rr3t3r_0[30|11]/a_860_290# sky130_fd_pr_reram__reram_cell area_ox=0.0676
X4936 rr3t3r_0[30|11]/a_60_290# WL30 SL11 VSS sky130_fd_pr__nfet_g5v0d10v5 ad=0.65 pd=3.3 as=0 ps=0 w=1 l=0.5
X4937 rr3t3r_0[30|11]/a_860_290# WL30 SL11 VSS sky130_fd_pr__nfet_g5v0d10v5 ad=0.65 pd=3.3 as=0 ps=0 w=1 l=0.5
X4938 BLP11 rr3t3r_0[31|11]/a_60_290# sky130_fd_pr_reram__reram_cell area_ox=0.0676
X4939 BLZ11 rr3t3r_0[31|11]/a_460_290# sky130_fd_pr_reram__reram_cell area_ox=0.0676
X4940 rr3t3r_0[31|11]/a_460_290# WL31 SL11 VSS sky130_fd_pr__nfet_g5v0d10v5 ad=0.65 pd=3.3 as=0 ps=0 w=1 l=0.5
X4941 BLN11 rr3t3r_0[31|11]/a_860_290# sky130_fd_pr_reram__reram_cell area_ox=0.0676
X4942 rr3t3r_0[31|11]/a_60_290# WL31 SL11 VSS sky130_fd_pr__nfet_g5v0d10v5 ad=0.65 pd=3.3 as=0 ps=0 w=1 l=0.5
X4943 rr3t3r_0[31|11]/a_860_290# WL31 SL11 VSS sky130_fd_pr__nfet_g5v0d10v5 ad=0.65 pd=3.3 as=0 ps=0 w=1 l=0.5
X4944 BLP11 rr3t3r_0[32|11]/a_60_290# sky130_fd_pr_reram__reram_cell area_ox=0.0676
X4945 BLZ11 rr3t3r_0[32|11]/a_460_290# sky130_fd_pr_reram__reram_cell area_ox=0.0676
X4946 rr3t3r_0[32|11]/a_460_290# WL32 SL11 VSS sky130_fd_pr__nfet_g5v0d10v5 ad=0.65 pd=3.3 as=0 ps=0 w=1 l=0.5
X4947 BLN11 rr3t3r_0[32|11]/a_860_290# sky130_fd_pr_reram__reram_cell area_ox=0.0676
X4948 rr3t3r_0[32|11]/a_60_290# WL32 SL11 VSS sky130_fd_pr__nfet_g5v0d10v5 ad=0.65 pd=3.3 as=0 ps=0 w=1 l=0.5
X4949 rr3t3r_0[32|11]/a_860_290# WL32 SL11 VSS sky130_fd_pr__nfet_g5v0d10v5 ad=0.65 pd=3.3 as=0 ps=0 w=1 l=0.5
X4950 BLP11 rr3t3r_0[33|11]/a_60_290# sky130_fd_pr_reram__reram_cell area_ox=0.0676
X4951 BLZ11 rr3t3r_0[33|11]/a_460_290# sky130_fd_pr_reram__reram_cell area_ox=0.0676
X4952 rr3t3r_0[33|11]/a_460_290# WL33 SL11 VSS sky130_fd_pr__nfet_g5v0d10v5 ad=0.65 pd=3.3 as=0 ps=0 w=1 l=0.5
X4953 BLN11 rr3t3r_0[33|11]/a_860_290# sky130_fd_pr_reram__reram_cell area_ox=0.0676
X4954 rr3t3r_0[33|11]/a_60_290# WL33 SL11 VSS sky130_fd_pr__nfet_g5v0d10v5 ad=0.65 pd=3.3 as=0 ps=0 w=1 l=0.5
X4955 rr3t3r_0[33|11]/a_860_290# WL33 SL11 VSS sky130_fd_pr__nfet_g5v0d10v5 ad=0.65 pd=3.3 as=0 ps=0 w=1 l=0.5
X4956 BLP11 rr3t3r_0[34|11]/a_60_290# sky130_fd_pr_reram__reram_cell area_ox=0.0676
X4957 BLZ11 rr3t3r_0[34|11]/a_460_290# sky130_fd_pr_reram__reram_cell area_ox=0.0676
X4958 rr3t3r_0[34|11]/a_460_290# WL34 SL11 VSS sky130_fd_pr__nfet_g5v0d10v5 ad=0.65 pd=3.3 as=0 ps=0 w=1 l=0.5
X4959 BLN11 rr3t3r_0[34|11]/a_860_290# sky130_fd_pr_reram__reram_cell area_ox=0.0676
X4960 rr3t3r_0[34|11]/a_60_290# WL34 SL11 VSS sky130_fd_pr__nfet_g5v0d10v5 ad=0.65 pd=3.3 as=0 ps=0 w=1 l=0.5
X4961 rr3t3r_0[34|11]/a_860_290# WL34 SL11 VSS sky130_fd_pr__nfet_g5v0d10v5 ad=0.65 pd=3.3 as=0 ps=0 w=1 l=0.5
X4962 BLP11 rr3t3r_0[35|11]/a_60_290# sky130_fd_pr_reram__reram_cell area_ox=0.0676
X4963 BLZ11 rr3t3r_0[35|11]/a_460_290# sky130_fd_pr_reram__reram_cell area_ox=0.0676
X4964 rr3t3r_0[35|11]/a_460_290# WL35 SL11 VSS sky130_fd_pr__nfet_g5v0d10v5 ad=0.65 pd=3.3 as=0 ps=0 w=1 l=0.5
X4965 BLN11 rr3t3r_0[35|11]/a_860_290# sky130_fd_pr_reram__reram_cell area_ox=0.0676
X4966 rr3t3r_0[35|11]/a_60_290# WL35 SL11 VSS sky130_fd_pr__nfet_g5v0d10v5 ad=0.65 pd=3.3 as=0 ps=0 w=1 l=0.5
X4967 rr3t3r_0[35|11]/a_860_290# WL35 SL11 VSS sky130_fd_pr__nfet_g5v0d10v5 ad=0.65 pd=3.3 as=0 ps=0 w=1 l=0.5
X4968 BLP11 rr3t3r_0[36|11]/a_60_290# sky130_fd_pr_reram__reram_cell area_ox=0.0676
X4969 BLZ11 rr3t3r_0[36|11]/a_460_290# sky130_fd_pr_reram__reram_cell area_ox=0.0676
X4970 rr3t3r_0[36|11]/a_460_290# WL36 SL11 VSS sky130_fd_pr__nfet_g5v0d10v5 ad=0.65 pd=3.3 as=0 ps=0 w=1 l=0.5
X4971 BLN11 rr3t3r_0[36|11]/a_860_290# sky130_fd_pr_reram__reram_cell area_ox=0.0676
X4972 rr3t3r_0[36|11]/a_60_290# WL36 SL11 VSS sky130_fd_pr__nfet_g5v0d10v5 ad=0.65 pd=3.3 as=0 ps=0 w=1 l=0.5
X4973 rr3t3r_0[36|11]/a_860_290# WL36 SL11 VSS sky130_fd_pr__nfet_g5v0d10v5 ad=0.65 pd=3.3 as=0 ps=0 w=1 l=0.5
X4974 BLP11 rr3t3r_0[37|11]/a_60_290# sky130_fd_pr_reram__reram_cell area_ox=0.0676
X4975 BLZ11 rr3t3r_0[37|11]/a_460_290# sky130_fd_pr_reram__reram_cell area_ox=0.0676
X4976 rr3t3r_0[37|11]/a_460_290# WL37 SL11 VSS sky130_fd_pr__nfet_g5v0d10v5 ad=0.65 pd=3.3 as=0 ps=0 w=1 l=0.5
X4977 BLN11 rr3t3r_0[37|11]/a_860_290# sky130_fd_pr_reram__reram_cell area_ox=0.0676
X4978 rr3t3r_0[37|11]/a_60_290# WL37 SL11 VSS sky130_fd_pr__nfet_g5v0d10v5 ad=0.65 pd=3.3 as=0 ps=0 w=1 l=0.5
X4979 rr3t3r_0[37|11]/a_860_290# WL37 SL11 VSS sky130_fd_pr__nfet_g5v0d10v5 ad=0.65 pd=3.3 as=0 ps=0 w=1 l=0.5
X4980 BLP11 rr3t3r_0[38|11]/a_60_290# sky130_fd_pr_reram__reram_cell area_ox=0.0676
X4981 BLZ11 rr3t3r_0[38|11]/a_460_290# sky130_fd_pr_reram__reram_cell area_ox=0.0676
X4982 rr3t3r_0[38|11]/a_460_290# WL38 SL11 VSS sky130_fd_pr__nfet_g5v0d10v5 ad=0.65 pd=3.3 as=0 ps=0 w=1 l=0.5
X4983 BLN11 rr3t3r_0[38|11]/a_860_290# sky130_fd_pr_reram__reram_cell area_ox=0.0676
X4984 rr3t3r_0[38|11]/a_60_290# WL38 SL11 VSS sky130_fd_pr__nfet_g5v0d10v5 ad=0.65 pd=3.3 as=0 ps=0 w=1 l=0.5
X4985 rr3t3r_0[38|11]/a_860_290# WL38 SL11 VSS sky130_fd_pr__nfet_g5v0d10v5 ad=0.65 pd=3.3 as=0 ps=0 w=1 l=0.5
X4986 BLP11 rr3t3r_0[39|11]/a_60_290# sky130_fd_pr_reram__reram_cell area_ox=0.0676
X4987 BLZ11 rr3t3r_0[39|11]/a_460_290# sky130_fd_pr_reram__reram_cell area_ox=0.0676
X4988 rr3t3r_0[39|11]/a_460_290# WL39 SL11 VSS sky130_fd_pr__nfet_g5v0d10v5 ad=0.65 pd=3.3 as=0 ps=0 w=1 l=0.5
X4989 BLN11 rr3t3r_0[39|11]/a_860_290# sky130_fd_pr_reram__reram_cell area_ox=0.0676
X4990 rr3t3r_0[39|11]/a_60_290# WL39 SL11 VSS sky130_fd_pr__nfet_g5v0d10v5 ad=0.65 pd=3.3 as=0 ps=0 w=1 l=0.5
X4991 rr3t3r_0[39|11]/a_860_290# WL39 SL11 VSS sky130_fd_pr__nfet_g5v0d10v5 ad=0.65 pd=3.3 as=0 ps=0 w=1 l=0.5
X4992 BLP11 rr3t3r_0[40|11]/a_60_290# sky130_fd_pr_reram__reram_cell area_ox=0.0676
X4993 BLZ11 rr3t3r_0[40|11]/a_460_290# sky130_fd_pr_reram__reram_cell area_ox=0.0676
X4994 rr3t3r_0[40|11]/a_460_290# WL40 SL11 VSS sky130_fd_pr__nfet_g5v0d10v5 ad=0.65 pd=3.3 as=0 ps=0 w=1 l=0.5
X4995 BLN11 rr3t3r_0[40|11]/a_860_290# sky130_fd_pr_reram__reram_cell area_ox=0.0676
X4996 rr3t3r_0[40|11]/a_60_290# WL40 SL11 VSS sky130_fd_pr__nfet_g5v0d10v5 ad=0.65 pd=3.3 as=0 ps=0 w=1 l=0.5
X4997 rr3t3r_0[40|11]/a_860_290# WL40 SL11 VSS sky130_fd_pr__nfet_g5v0d10v5 ad=0.65 pd=3.3 as=0 ps=0 w=1 l=0.5
X4998 BLP11 rr3t3r_0[41|11]/a_60_290# sky130_fd_pr_reram__reram_cell area_ox=0.0676
X4999 BLZ11 rr3t3r_0[41|11]/a_460_290# sky130_fd_pr_reram__reram_cell area_ox=0.0676
X5000 rr3t3r_0[41|11]/a_460_290# WL41 SL11 VSS sky130_fd_pr__nfet_g5v0d10v5 ad=0.65 pd=3.3 as=0 ps=0 w=1 l=0.5
X5001 BLN11 rr3t3r_0[41|11]/a_860_290# sky130_fd_pr_reram__reram_cell area_ox=0.0676
X5002 rr3t3r_0[41|11]/a_60_290# WL41 SL11 VSS sky130_fd_pr__nfet_g5v0d10v5 ad=0.65 pd=3.3 as=0 ps=0 w=1 l=0.5
X5003 rr3t3r_0[41|11]/a_860_290# WL41 SL11 VSS sky130_fd_pr__nfet_g5v0d10v5 ad=0.65 pd=3.3 as=0 ps=0 w=1 l=0.5
X5004 BLP11 rr3t3r_0[42|11]/a_60_290# sky130_fd_pr_reram__reram_cell area_ox=0.0676
X5005 BLZ11 rr3t3r_0[42|11]/a_460_290# sky130_fd_pr_reram__reram_cell area_ox=0.0676
X5006 rr3t3r_0[42|11]/a_460_290# WL42 SL11 VSS sky130_fd_pr__nfet_g5v0d10v5 ad=0.65 pd=3.3 as=0 ps=0 w=1 l=0.5
X5007 BLN11 rr3t3r_0[42|11]/a_860_290# sky130_fd_pr_reram__reram_cell area_ox=0.0676
X5008 rr3t3r_0[42|11]/a_60_290# WL42 SL11 VSS sky130_fd_pr__nfet_g5v0d10v5 ad=0.65 pd=3.3 as=0 ps=0 w=1 l=0.5
X5009 rr3t3r_0[42|11]/a_860_290# WL42 SL11 VSS sky130_fd_pr__nfet_g5v0d10v5 ad=0.65 pd=3.3 as=0 ps=0 w=1 l=0.5
X5010 BLP11 rr3t3r_0[43|11]/a_60_290# sky130_fd_pr_reram__reram_cell area_ox=0.0676
X5011 BLZ11 rr3t3r_0[43|11]/a_460_290# sky130_fd_pr_reram__reram_cell area_ox=0.0676
X5012 rr3t3r_0[43|11]/a_460_290# WL43 SL11 VSS sky130_fd_pr__nfet_g5v0d10v5 ad=0.65 pd=3.3 as=0 ps=0 w=1 l=0.5
X5013 BLN11 rr3t3r_0[43|11]/a_860_290# sky130_fd_pr_reram__reram_cell area_ox=0.0676
X5014 rr3t3r_0[43|11]/a_60_290# WL43 SL11 VSS sky130_fd_pr__nfet_g5v0d10v5 ad=0.65 pd=3.3 as=0 ps=0 w=1 l=0.5
X5015 rr3t3r_0[43|11]/a_860_290# WL43 SL11 VSS sky130_fd_pr__nfet_g5v0d10v5 ad=0.65 pd=3.3 as=0 ps=0 w=1 l=0.5
X5016 BLP11 rr3t3r_0[44|11]/a_60_290# sky130_fd_pr_reram__reram_cell area_ox=0.0676
X5017 BLZ11 rr3t3r_0[44|11]/a_460_290# sky130_fd_pr_reram__reram_cell area_ox=0.0676
X5018 rr3t3r_0[44|11]/a_460_290# WL44 SL11 VSS sky130_fd_pr__nfet_g5v0d10v5 ad=0.65 pd=3.3 as=0 ps=0 w=1 l=0.5
X5019 BLN11 rr3t3r_0[44|11]/a_860_290# sky130_fd_pr_reram__reram_cell area_ox=0.0676
X5020 rr3t3r_0[44|11]/a_60_290# WL44 SL11 VSS sky130_fd_pr__nfet_g5v0d10v5 ad=0.65 pd=3.3 as=0 ps=0 w=1 l=0.5
X5021 rr3t3r_0[44|11]/a_860_290# WL44 SL11 VSS sky130_fd_pr__nfet_g5v0d10v5 ad=0.65 pd=3.3 as=0 ps=0 w=1 l=0.5
X5022 BLP11 rr3t3r_0[45|11]/a_60_290# sky130_fd_pr_reram__reram_cell area_ox=0.0676
X5023 BLZ11 rr3t3r_0[45|11]/a_460_290# sky130_fd_pr_reram__reram_cell area_ox=0.0676
X5024 rr3t3r_0[45|11]/a_460_290# WL45 SL11 VSS sky130_fd_pr__nfet_g5v0d10v5 ad=0.65 pd=3.3 as=0 ps=0 w=1 l=0.5
X5025 BLN11 rr3t3r_0[45|11]/a_860_290# sky130_fd_pr_reram__reram_cell area_ox=0.0676
X5026 rr3t3r_0[45|11]/a_60_290# WL45 SL11 VSS sky130_fd_pr__nfet_g5v0d10v5 ad=0.65 pd=3.3 as=0 ps=0 w=1 l=0.5
X5027 rr3t3r_0[45|11]/a_860_290# WL45 SL11 VSS sky130_fd_pr__nfet_g5v0d10v5 ad=0.65 pd=3.3 as=0 ps=0 w=1 l=0.5
X5028 BLP11 rr3t3r_0[46|11]/a_60_290# sky130_fd_pr_reram__reram_cell area_ox=0.0676
X5029 BLZ11 rr3t3r_0[46|11]/a_460_290# sky130_fd_pr_reram__reram_cell area_ox=0.0676
X5030 rr3t3r_0[46|11]/a_460_290# WL46 SL11 VSS sky130_fd_pr__nfet_g5v0d10v5 ad=0.65 pd=3.3 as=0 ps=0 w=1 l=0.5
X5031 BLN11 rr3t3r_0[46|11]/a_860_290# sky130_fd_pr_reram__reram_cell area_ox=0.0676
X5032 rr3t3r_0[46|11]/a_60_290# WL46 SL11 VSS sky130_fd_pr__nfet_g5v0d10v5 ad=0.65 pd=3.3 as=0 ps=0 w=1 l=0.5
X5033 rr3t3r_0[46|11]/a_860_290# WL46 SL11 VSS sky130_fd_pr__nfet_g5v0d10v5 ad=0.65 pd=3.3 as=0 ps=0 w=1 l=0.5
X5034 BLP11 rr3t3r_0[47|11]/a_60_290# sky130_fd_pr_reram__reram_cell area_ox=0.0676
X5035 BLZ11 rr3t3r_0[47|11]/a_460_290# sky130_fd_pr_reram__reram_cell area_ox=0.0676
X5036 rr3t3r_0[47|11]/a_460_290# WL47 SL11 VSS sky130_fd_pr__nfet_g5v0d10v5 ad=0.65 pd=3.3 as=0 ps=0 w=1 l=0.5
X5037 BLN11 rr3t3r_0[47|11]/a_860_290# sky130_fd_pr_reram__reram_cell area_ox=0.0676
X5038 rr3t3r_0[47|11]/a_60_290# WL47 SL11 VSS sky130_fd_pr__nfet_g5v0d10v5 ad=0.65 pd=3.3 as=0 ps=0 w=1 l=0.5
X5039 rr3t3r_0[47|11]/a_860_290# WL47 SL11 VSS sky130_fd_pr__nfet_g5v0d10v5 ad=0.65 pd=3.3 as=0 ps=0 w=1 l=0.5
X5040 BLP11 rr3t3r_0[48|11]/a_60_290# sky130_fd_pr_reram__reram_cell area_ox=0.0676
X5041 BLZ11 rr3t3r_0[48|11]/a_460_290# sky130_fd_pr_reram__reram_cell area_ox=0.0676
X5042 rr3t3r_0[48|11]/a_460_290# WL48 SL11 VSS sky130_fd_pr__nfet_g5v0d10v5 ad=0.65 pd=3.3 as=0 ps=0 w=1 l=0.5
X5043 BLN11 rr3t3r_0[48|11]/a_860_290# sky130_fd_pr_reram__reram_cell area_ox=0.0676
X5044 rr3t3r_0[48|11]/a_60_290# WL48 SL11 VSS sky130_fd_pr__nfet_g5v0d10v5 ad=0.65 pd=3.3 as=0 ps=0 w=1 l=0.5
X5045 rr3t3r_0[48|11]/a_860_290# WL48 SL11 VSS sky130_fd_pr__nfet_g5v0d10v5 ad=0.65 pd=3.3 as=0 ps=0 w=1 l=0.5
X5046 BLP11 rr3t3r_0[49|11]/a_60_290# sky130_fd_pr_reram__reram_cell area_ox=0.0676
X5047 BLZ11 rr3t3r_0[49|11]/a_460_290# sky130_fd_pr_reram__reram_cell area_ox=0.0676
X5048 rr3t3r_0[49|11]/a_460_290# WL49 SL11 VSS sky130_fd_pr__nfet_g5v0d10v5 ad=0.65 pd=3.3 as=0 ps=0 w=1 l=0.5
X5049 BLN11 rr3t3r_0[49|11]/a_860_290# sky130_fd_pr_reram__reram_cell area_ox=0.0676
X5050 rr3t3r_0[49|11]/a_60_290# WL49 SL11 VSS sky130_fd_pr__nfet_g5v0d10v5 ad=0.65 pd=3.3 as=0 ps=0 w=1 l=0.5
X5051 rr3t3r_0[49|11]/a_860_290# WL49 SL11 VSS sky130_fd_pr__nfet_g5v0d10v5 ad=0.65 pd=3.3 as=0 ps=0 w=1 l=0.5
X5052 BLP11 rr3t3r_0[50|11]/a_60_290# sky130_fd_pr_reram__reram_cell area_ox=0.0676
X5053 BLZ11 rr3t3r_0[50|11]/a_460_290# sky130_fd_pr_reram__reram_cell area_ox=0.0676
X5054 rr3t3r_0[50|11]/a_460_290# WL50 SL11 VSS sky130_fd_pr__nfet_g5v0d10v5 ad=0.65 pd=3.3 as=0 ps=0 w=1 l=0.5
X5055 BLN11 rr3t3r_0[50|11]/a_860_290# sky130_fd_pr_reram__reram_cell area_ox=0.0676
X5056 rr3t3r_0[50|11]/a_60_290# WL50 SL11 VSS sky130_fd_pr__nfet_g5v0d10v5 ad=0.65 pd=3.3 as=0 ps=0 w=1 l=0.5
X5057 rr3t3r_0[50|11]/a_860_290# WL50 SL11 VSS sky130_fd_pr__nfet_g5v0d10v5 ad=0.65 pd=3.3 as=0 ps=0 w=1 l=0.5
X5058 BLP11 rr3t3r_0[51|11]/a_60_290# sky130_fd_pr_reram__reram_cell area_ox=0.0676
X5059 BLZ11 rr3t3r_0[51|11]/a_460_290# sky130_fd_pr_reram__reram_cell area_ox=0.0676
X5060 rr3t3r_0[51|11]/a_460_290# WL51 SL11 VSS sky130_fd_pr__nfet_g5v0d10v5 ad=0.65 pd=3.3 as=0 ps=0 w=1 l=0.5
X5061 BLN11 rr3t3r_0[51|11]/a_860_290# sky130_fd_pr_reram__reram_cell area_ox=0.0676
X5062 rr3t3r_0[51|11]/a_60_290# WL51 SL11 VSS sky130_fd_pr__nfet_g5v0d10v5 ad=0.65 pd=3.3 as=0 ps=0 w=1 l=0.5
X5063 rr3t3r_0[51|11]/a_860_290# WL51 SL11 VSS sky130_fd_pr__nfet_g5v0d10v5 ad=0.65 pd=3.3 as=0 ps=0 w=1 l=0.5
X5064 BLP11 rr3t3r_0[52|11]/a_60_290# sky130_fd_pr_reram__reram_cell area_ox=0.0676
X5065 BLZ11 rr3t3r_0[52|11]/a_460_290# sky130_fd_pr_reram__reram_cell area_ox=0.0676
X5066 rr3t3r_0[52|11]/a_460_290# WL52 SL11 VSS sky130_fd_pr__nfet_g5v0d10v5 ad=0.65 pd=3.3 as=0 ps=0 w=1 l=0.5
X5067 BLN11 rr3t3r_0[52|11]/a_860_290# sky130_fd_pr_reram__reram_cell area_ox=0.0676
X5068 rr3t3r_0[52|11]/a_60_290# WL52 SL11 VSS sky130_fd_pr__nfet_g5v0d10v5 ad=0.65 pd=3.3 as=0 ps=0 w=1 l=0.5
X5069 rr3t3r_0[52|11]/a_860_290# WL52 SL11 VSS sky130_fd_pr__nfet_g5v0d10v5 ad=0.65 pd=3.3 as=0 ps=0 w=1 l=0.5
X5070 BLP11 rr3t3r_0[53|11]/a_60_290# sky130_fd_pr_reram__reram_cell area_ox=0.0676
X5071 BLZ11 rr3t3r_0[53|11]/a_460_290# sky130_fd_pr_reram__reram_cell area_ox=0.0676
X5072 rr3t3r_0[53|11]/a_460_290# WL53 SL11 VSS sky130_fd_pr__nfet_g5v0d10v5 ad=0.65 pd=3.3 as=0 ps=0 w=1 l=0.5
X5073 BLN11 rr3t3r_0[53|11]/a_860_290# sky130_fd_pr_reram__reram_cell area_ox=0.0676
X5074 rr3t3r_0[53|11]/a_60_290# WL53 SL11 VSS sky130_fd_pr__nfet_g5v0d10v5 ad=0.65 pd=3.3 as=0 ps=0 w=1 l=0.5
X5075 rr3t3r_0[53|11]/a_860_290# WL53 SL11 VSS sky130_fd_pr__nfet_g5v0d10v5 ad=0.65 pd=3.3 as=0 ps=0 w=1 l=0.5
X5076 BLP11 rr3t3r_0[54|11]/a_60_290# sky130_fd_pr_reram__reram_cell area_ox=0.0676
X5077 BLZ11 rr3t3r_0[54|11]/a_460_290# sky130_fd_pr_reram__reram_cell area_ox=0.0676
X5078 rr3t3r_0[54|11]/a_460_290# WL54 SL11 VSS sky130_fd_pr__nfet_g5v0d10v5 ad=0.65 pd=3.3 as=0 ps=0 w=1 l=0.5
X5079 BLN11 rr3t3r_0[54|11]/a_860_290# sky130_fd_pr_reram__reram_cell area_ox=0.0676
X5080 rr3t3r_0[54|11]/a_60_290# WL54 SL11 VSS sky130_fd_pr__nfet_g5v0d10v5 ad=0.65 pd=3.3 as=0 ps=0 w=1 l=0.5
X5081 rr3t3r_0[54|11]/a_860_290# WL54 SL11 VSS sky130_fd_pr__nfet_g5v0d10v5 ad=0.65 pd=3.3 as=0 ps=0 w=1 l=0.5
X5082 BLP11 rr3t3r_0[55|11]/a_60_290# sky130_fd_pr_reram__reram_cell area_ox=0.0676
X5083 BLZ11 rr3t3r_0[55|11]/a_460_290# sky130_fd_pr_reram__reram_cell area_ox=0.0676
X5084 rr3t3r_0[55|11]/a_460_290# WL55 SL11 VSS sky130_fd_pr__nfet_g5v0d10v5 ad=0.65 pd=3.3 as=0 ps=0 w=1 l=0.5
X5085 BLN11 rr3t3r_0[55|11]/a_860_290# sky130_fd_pr_reram__reram_cell area_ox=0.0676
X5086 rr3t3r_0[55|11]/a_60_290# WL55 SL11 VSS sky130_fd_pr__nfet_g5v0d10v5 ad=0.65 pd=3.3 as=0 ps=0 w=1 l=0.5
X5087 rr3t3r_0[55|11]/a_860_290# WL55 SL11 VSS sky130_fd_pr__nfet_g5v0d10v5 ad=0.65 pd=3.3 as=0 ps=0 w=1 l=0.5
X5088 BLP11 rr3t3r_0[56|11]/a_60_290# sky130_fd_pr_reram__reram_cell area_ox=0.0676
X5089 BLZ11 rr3t3r_0[56|11]/a_460_290# sky130_fd_pr_reram__reram_cell area_ox=0.0676
X5090 rr3t3r_0[56|11]/a_460_290# WL56 SL11 VSS sky130_fd_pr__nfet_g5v0d10v5 ad=0.65 pd=3.3 as=0 ps=0 w=1 l=0.5
X5091 BLN11 rr3t3r_0[56|11]/a_860_290# sky130_fd_pr_reram__reram_cell area_ox=0.0676
X5092 rr3t3r_0[56|11]/a_60_290# WL56 SL11 VSS sky130_fd_pr__nfet_g5v0d10v5 ad=0.65 pd=3.3 as=0 ps=0 w=1 l=0.5
X5093 rr3t3r_0[56|11]/a_860_290# WL56 SL11 VSS sky130_fd_pr__nfet_g5v0d10v5 ad=0.65 pd=3.3 as=0 ps=0 w=1 l=0.5
X5094 BLP11 rr3t3r_0[57|11]/a_60_290# sky130_fd_pr_reram__reram_cell area_ox=0.0676
X5095 BLZ11 rr3t3r_0[57|11]/a_460_290# sky130_fd_pr_reram__reram_cell area_ox=0.0676
X5096 rr3t3r_0[57|11]/a_460_290# WL57 SL11 VSS sky130_fd_pr__nfet_g5v0d10v5 ad=0.65 pd=3.3 as=0 ps=0 w=1 l=0.5
X5097 BLN11 rr3t3r_0[57|11]/a_860_290# sky130_fd_pr_reram__reram_cell area_ox=0.0676
X5098 rr3t3r_0[57|11]/a_60_290# WL57 SL11 VSS sky130_fd_pr__nfet_g5v0d10v5 ad=0.65 pd=3.3 as=0 ps=0 w=1 l=0.5
X5099 rr3t3r_0[57|11]/a_860_290# WL57 SL11 VSS sky130_fd_pr__nfet_g5v0d10v5 ad=0.65 pd=3.3 as=0 ps=0 w=1 l=0.5
X5100 BLP11 rr3t3r_0[58|11]/a_60_290# sky130_fd_pr_reram__reram_cell area_ox=0.0676
X5101 BLZ11 rr3t3r_0[58|11]/a_460_290# sky130_fd_pr_reram__reram_cell area_ox=0.0676
X5102 rr3t3r_0[58|11]/a_460_290# WL58 SL11 VSS sky130_fd_pr__nfet_g5v0d10v5 ad=0.65 pd=3.3 as=0 ps=0 w=1 l=0.5
X5103 BLN11 rr3t3r_0[58|11]/a_860_290# sky130_fd_pr_reram__reram_cell area_ox=0.0676
X5104 rr3t3r_0[58|11]/a_60_290# WL58 SL11 VSS sky130_fd_pr__nfet_g5v0d10v5 ad=0.65 pd=3.3 as=0 ps=0 w=1 l=0.5
X5105 rr3t3r_0[58|11]/a_860_290# WL58 SL11 VSS sky130_fd_pr__nfet_g5v0d10v5 ad=0.65 pd=3.3 as=0 ps=0 w=1 l=0.5
X5106 BLP11 rr3t3r_0[59|11]/a_60_290# sky130_fd_pr_reram__reram_cell area_ox=0.0676
X5107 BLZ11 rr3t3r_0[59|11]/a_460_290# sky130_fd_pr_reram__reram_cell area_ox=0.0676
X5108 rr3t3r_0[59|11]/a_460_290# WL59 SL11 VSS sky130_fd_pr__nfet_g5v0d10v5 ad=0.65 pd=3.3 as=0 ps=0 w=1 l=0.5
X5109 BLN11 rr3t3r_0[59|11]/a_860_290# sky130_fd_pr_reram__reram_cell area_ox=0.0676
X5110 rr3t3r_0[59|11]/a_60_290# WL59 SL11 VSS sky130_fd_pr__nfet_g5v0d10v5 ad=0.65 pd=3.3 as=0 ps=0 w=1 l=0.5
X5111 rr3t3r_0[59|11]/a_860_290# WL59 SL11 VSS sky130_fd_pr__nfet_g5v0d10v5 ad=0.65 pd=3.3 as=0 ps=0 w=1 l=0.5
X5112 BLP11 rr3t3r_0[60|11]/a_60_290# sky130_fd_pr_reram__reram_cell area_ox=0.0676
X5113 BLZ11 rr3t3r_0[60|11]/a_460_290# sky130_fd_pr_reram__reram_cell area_ox=0.0676
X5114 rr3t3r_0[60|11]/a_460_290# WL60 SL11 VSS sky130_fd_pr__nfet_g5v0d10v5 ad=0.65 pd=3.3 as=0 ps=0 w=1 l=0.5
X5115 BLN11 rr3t3r_0[60|11]/a_860_290# sky130_fd_pr_reram__reram_cell area_ox=0.0676
X5116 rr3t3r_0[60|11]/a_60_290# WL60 SL11 VSS sky130_fd_pr__nfet_g5v0d10v5 ad=0.65 pd=3.3 as=0 ps=0 w=1 l=0.5
X5117 rr3t3r_0[60|11]/a_860_290# WL60 SL11 VSS sky130_fd_pr__nfet_g5v0d10v5 ad=0.65 pd=3.3 as=0 ps=0 w=1 l=0.5
X5118 BLP11 rr3t3r_0[61|11]/a_60_290# sky130_fd_pr_reram__reram_cell area_ox=0.0676
X5119 BLZ11 rr3t3r_0[61|11]/a_460_290# sky130_fd_pr_reram__reram_cell area_ox=0.0676
X5120 rr3t3r_0[61|11]/a_460_290# WL61 SL11 VSS sky130_fd_pr__nfet_g5v0d10v5 ad=0.65 pd=3.3 as=0 ps=0 w=1 l=0.5
X5121 BLN11 rr3t3r_0[61|11]/a_860_290# sky130_fd_pr_reram__reram_cell area_ox=0.0676
X5122 rr3t3r_0[61|11]/a_60_290# WL61 SL11 VSS sky130_fd_pr__nfet_g5v0d10v5 ad=0.65 pd=3.3 as=0 ps=0 w=1 l=0.5
X5123 rr3t3r_0[61|11]/a_860_290# WL61 SL11 VSS sky130_fd_pr__nfet_g5v0d10v5 ad=0.65 pd=3.3 as=0 ps=0 w=1 l=0.5
X5124 BLP11 rr3t3r_0[62|11]/a_60_290# sky130_fd_pr_reram__reram_cell area_ox=0.0676
X5125 BLZ11 rr3t3r_0[62|11]/a_460_290# sky130_fd_pr_reram__reram_cell area_ox=0.0676
X5126 rr3t3r_0[62|11]/a_460_290# WL62 SL11 VSS sky130_fd_pr__nfet_g5v0d10v5 ad=0.65 pd=3.3 as=0 ps=0 w=1 l=0.5
X5127 BLN11 rr3t3r_0[62|11]/a_860_290# sky130_fd_pr_reram__reram_cell area_ox=0.0676
X5128 rr3t3r_0[62|11]/a_60_290# WL62 SL11 VSS sky130_fd_pr__nfet_g5v0d10v5 ad=0.65 pd=3.3 as=0 ps=0 w=1 l=0.5
X5129 rr3t3r_0[62|11]/a_860_290# WL62 SL11 VSS sky130_fd_pr__nfet_g5v0d10v5 ad=0.65 pd=3.3 as=0 ps=0 w=1 l=0.5
X5130 BLP11 rr3t3r_0[63|11]/a_60_290# sky130_fd_pr_reram__reram_cell area_ox=0.0676
X5131 BLZ11 rr3t3r_0[63|11]/a_460_290# sky130_fd_pr_reram__reram_cell area_ox=0.0676
X5132 rr3t3r_0[63|11]/a_460_290# WL63 SL11 VSS sky130_fd_pr__nfet_g5v0d10v5 ad=0.65 pd=3.3 as=0 ps=0 w=1 l=0.5
X5133 BLN11 rr3t3r_0[63|11]/a_860_290# sky130_fd_pr_reram__reram_cell area_ox=0.0676
X5134 rr3t3r_0[63|11]/a_60_290# WL63 SL11 VSS sky130_fd_pr__nfet_g5v0d10v5 ad=0.65 pd=3.3 as=0 ps=0 w=1 l=0.5
X5135 rr3t3r_0[63|11]/a_860_290# WL63 SL11 VSS sky130_fd_pr__nfet_g5v0d10v5 ad=0.65 pd=3.3 as=0 ps=0 w=1 l=0.5
X5136 BLP11 rr3t3r_0[64|11]/a_60_290# sky130_fd_pr_reram__reram_cell area_ox=0.0676
X5137 BLZ11 rr3t3r_0[64|11]/a_460_290# sky130_fd_pr_reram__reram_cell area_ox=0.0676
X5138 rr3t3r_0[64|11]/a_460_290# WL64 SL11 VSS sky130_fd_pr__nfet_g5v0d10v5 ad=0.65 pd=3.3 as=0 ps=0 w=1 l=0.5
X5139 BLN11 rr3t3r_0[64|11]/a_860_290# sky130_fd_pr_reram__reram_cell area_ox=0.0676
X5140 rr3t3r_0[64|11]/a_60_290# WL64 SL11 VSS sky130_fd_pr__nfet_g5v0d10v5 ad=0.65 pd=3.3 as=0 ps=0 w=1 l=0.5
X5141 rr3t3r_0[64|11]/a_860_290# WL64 SL11 VSS sky130_fd_pr__nfet_g5v0d10v5 ad=0.65 pd=3.3 as=0 ps=0 w=1 l=0.5
X5142 BLP11 rr3t3r_0[65|11]/a_60_290# sky130_fd_pr_reram__reram_cell area_ox=0.0676
X5143 BLZ11 rr3t3r_0[65|11]/a_460_290# sky130_fd_pr_reram__reram_cell area_ox=0.0676
X5144 rr3t3r_0[65|11]/a_460_290# WL65 SL11 VSS sky130_fd_pr__nfet_g5v0d10v5 ad=0.65 pd=3.3 as=0 ps=0 w=1 l=0.5
X5145 BLN11 rr3t3r_0[65|11]/a_860_290# sky130_fd_pr_reram__reram_cell area_ox=0.0676
X5146 rr3t3r_0[65|11]/a_60_290# WL65 SL11 VSS sky130_fd_pr__nfet_g5v0d10v5 ad=0.65 pd=3.3 as=0 ps=0 w=1 l=0.5
X5147 rr3t3r_0[65|11]/a_860_290# WL65 SL11 VSS sky130_fd_pr__nfet_g5v0d10v5 ad=0.65 pd=3.3 as=0 ps=0 w=1 l=0.5
X5148 BLP11 rr3t3r_0[66|11]/a_60_290# sky130_fd_pr_reram__reram_cell area_ox=0.0676
X5149 BLZ11 rr3t3r_0[66|11]/a_460_290# sky130_fd_pr_reram__reram_cell area_ox=0.0676
X5150 rr3t3r_0[66|11]/a_460_290# WL66 SL11 VSS sky130_fd_pr__nfet_g5v0d10v5 ad=0.65 pd=3.3 as=0 ps=0 w=1 l=0.5
X5151 BLN11 rr3t3r_0[66|11]/a_860_290# sky130_fd_pr_reram__reram_cell area_ox=0.0676
X5152 rr3t3r_0[66|11]/a_60_290# WL66 SL11 VSS sky130_fd_pr__nfet_g5v0d10v5 ad=0.65 pd=3.3 as=0 ps=0 w=1 l=0.5
X5153 rr3t3r_0[66|11]/a_860_290# WL66 SL11 VSS sky130_fd_pr__nfet_g5v0d10v5 ad=0.65 pd=3.3 as=0 ps=0 w=1 l=0.5
X5154 BLP11 rr3t3r_0[67|11]/a_60_290# sky130_fd_pr_reram__reram_cell area_ox=0.0676
X5155 BLZ11 rr3t3r_0[67|11]/a_460_290# sky130_fd_pr_reram__reram_cell area_ox=0.0676
X5156 rr3t3r_0[67|11]/a_460_290# WL67 SL11 VSS sky130_fd_pr__nfet_g5v0d10v5 ad=0.65 pd=3.3 as=0 ps=0 w=1 l=0.5
X5157 BLN11 rr3t3r_0[67|11]/a_860_290# sky130_fd_pr_reram__reram_cell area_ox=0.0676
X5158 rr3t3r_0[67|11]/a_60_290# WL67 SL11 VSS sky130_fd_pr__nfet_g5v0d10v5 ad=0.65 pd=3.3 as=0 ps=0 w=1 l=0.5
X5159 rr3t3r_0[67|11]/a_860_290# WL67 SL11 VSS sky130_fd_pr__nfet_g5v0d10v5 ad=0.65 pd=3.3 as=0 ps=0 w=1 l=0.5
X5160 BLP11 rr3t3r_0[68|11]/a_60_290# sky130_fd_pr_reram__reram_cell area_ox=0.0676
X5161 BLZ11 rr3t3r_0[68|11]/a_460_290# sky130_fd_pr_reram__reram_cell area_ox=0.0676
X5162 rr3t3r_0[68|11]/a_460_290# WL68 SL11 VSS sky130_fd_pr__nfet_g5v0d10v5 ad=0.65 pd=3.3 as=0 ps=0 w=1 l=0.5
X5163 BLN11 rr3t3r_0[68|11]/a_860_290# sky130_fd_pr_reram__reram_cell area_ox=0.0676
X5164 rr3t3r_0[68|11]/a_60_290# WL68 SL11 VSS sky130_fd_pr__nfet_g5v0d10v5 ad=0.65 pd=3.3 as=0 ps=0 w=1 l=0.5
X5165 rr3t3r_0[68|11]/a_860_290# WL68 SL11 VSS sky130_fd_pr__nfet_g5v0d10v5 ad=0.65 pd=3.3 as=0 ps=0 w=1 l=0.5
X5166 BLP11 rr3t3r_0[69|11]/a_60_290# sky130_fd_pr_reram__reram_cell area_ox=0.0676
X5167 BLZ11 rr3t3r_0[69|11]/a_460_290# sky130_fd_pr_reram__reram_cell area_ox=0.0676
X5168 rr3t3r_0[69|11]/a_460_290# WL69 SL11 VSS sky130_fd_pr__nfet_g5v0d10v5 ad=0.65 pd=3.3 as=0 ps=0 w=1 l=0.5
X5169 BLN11 rr3t3r_0[69|11]/a_860_290# sky130_fd_pr_reram__reram_cell area_ox=0.0676
X5170 rr3t3r_0[69|11]/a_60_290# WL69 SL11 VSS sky130_fd_pr__nfet_g5v0d10v5 ad=0.65 pd=3.3 as=0 ps=0 w=1 l=0.5
X5171 rr3t3r_0[69|11]/a_860_290# WL69 SL11 VSS sky130_fd_pr__nfet_g5v0d10v5 ad=0.65 pd=3.3 as=0 ps=0 w=1 l=0.5
X5172 BLP11 rr3t3r_0[70|11]/a_60_290# sky130_fd_pr_reram__reram_cell area_ox=0.0676
X5173 BLZ11 rr3t3r_0[70|11]/a_460_290# sky130_fd_pr_reram__reram_cell area_ox=0.0676
X5174 rr3t3r_0[70|11]/a_460_290# WL70 SL11 VSS sky130_fd_pr__nfet_g5v0d10v5 ad=0.65 pd=3.3 as=0 ps=0 w=1 l=0.5
X5175 BLN11 rr3t3r_0[70|11]/a_860_290# sky130_fd_pr_reram__reram_cell area_ox=0.0676
X5176 rr3t3r_0[70|11]/a_60_290# WL70 SL11 VSS sky130_fd_pr__nfet_g5v0d10v5 ad=0.65 pd=3.3 as=0 ps=0 w=1 l=0.5
X5177 rr3t3r_0[70|11]/a_860_290# WL70 SL11 VSS sky130_fd_pr__nfet_g5v0d10v5 ad=0.65 pd=3.3 as=0 ps=0 w=1 l=0.5
X5178 BLP11 rr3t3r_0[71|11]/a_60_290# sky130_fd_pr_reram__reram_cell area_ox=0.0676
X5179 BLZ11 rr3t3r_0[71|11]/a_460_290# sky130_fd_pr_reram__reram_cell area_ox=0.0676
X5180 rr3t3r_0[71|11]/a_460_290# WL71 SL11 VSS sky130_fd_pr__nfet_g5v0d10v5 ad=0.65 pd=3.3 as=0 ps=0 w=1 l=0.5
X5181 BLN11 rr3t3r_0[71|11]/a_860_290# sky130_fd_pr_reram__reram_cell area_ox=0.0676
X5182 rr3t3r_0[71|11]/a_60_290# WL71 SL11 VSS sky130_fd_pr__nfet_g5v0d10v5 ad=0.65 pd=3.3 as=0 ps=0 w=1 l=0.5
X5183 rr3t3r_0[71|11]/a_860_290# WL71 SL11 VSS sky130_fd_pr__nfet_g5v0d10v5 ad=0.65 pd=3.3 as=0 ps=0 w=1 l=0.5
X5184 BLP12 rr3t3r_0[0|12]/a_60_290# sky130_fd_pr_reram__reram_cell area_ox=0.0676
X5185 BLZ12 rr3t3r_0[0|12]/a_460_290# sky130_fd_pr_reram__reram_cell area_ox=0.0676
X5186 rr3t3r_0[0|12]/a_460_290# WL0 SL12 VSS sky130_fd_pr__nfet_g5v0d10v5 ad=0.65 pd=3.3 as=162 ps=756 w=1 l=0.5
X5187 BLN12 rr3t3r_0[0|12]/a_860_290# sky130_fd_pr_reram__reram_cell area_ox=0.0676
X5188 rr3t3r_0[0|12]/a_60_290# WL0 SL12 VSS sky130_fd_pr__nfet_g5v0d10v5 ad=0.65 pd=3.3 as=0 ps=0 w=1 l=0.5
X5189 rr3t3r_0[0|12]/a_860_290# WL0 SL12 VSS sky130_fd_pr__nfet_g5v0d10v5 ad=0.65 pd=3.3 as=0 ps=0 w=1 l=0.5
X5190 BLP12 rr3t3r_0[1|12]/a_60_290# sky130_fd_pr_reram__reram_cell area_ox=0.0676
X5191 BLZ12 rr3t3r_0[1|12]/a_460_290# sky130_fd_pr_reram__reram_cell area_ox=0.0676
X5192 rr3t3r_0[1|12]/a_460_290# WL1 SL12 VSS sky130_fd_pr__nfet_g5v0d10v5 ad=0.65 pd=3.3 as=0 ps=0 w=1 l=0.5
X5193 BLN12 rr3t3r_0[1|12]/a_860_290# sky130_fd_pr_reram__reram_cell area_ox=0.0676
X5194 rr3t3r_0[1|12]/a_60_290# WL1 SL12 VSS sky130_fd_pr__nfet_g5v0d10v5 ad=0.65 pd=3.3 as=0 ps=0 w=1 l=0.5
X5195 rr3t3r_0[1|12]/a_860_290# WL1 SL12 VSS sky130_fd_pr__nfet_g5v0d10v5 ad=0.65 pd=3.3 as=0 ps=0 w=1 l=0.5
X5196 BLP12 rr3t3r_0[2|12]/a_60_290# sky130_fd_pr_reram__reram_cell area_ox=0.0676
X5197 BLZ12 rr3t3r_0[2|12]/a_460_290# sky130_fd_pr_reram__reram_cell area_ox=0.0676
X5198 rr3t3r_0[2|12]/a_460_290# WL2 SL12 VSS sky130_fd_pr__nfet_g5v0d10v5 ad=0.65 pd=3.3 as=0 ps=0 w=1 l=0.5
X5199 BLN12 rr3t3r_0[2|12]/a_860_290# sky130_fd_pr_reram__reram_cell area_ox=0.0676
X5200 rr3t3r_0[2|12]/a_60_290# WL2 SL12 VSS sky130_fd_pr__nfet_g5v0d10v5 ad=0.65 pd=3.3 as=0 ps=0 w=1 l=0.5
X5201 rr3t3r_0[2|12]/a_860_290# WL2 SL12 VSS sky130_fd_pr__nfet_g5v0d10v5 ad=0.65 pd=3.3 as=0 ps=0 w=1 l=0.5
X5202 BLP12 rr3t3r_0[3|12]/a_60_290# sky130_fd_pr_reram__reram_cell area_ox=0.0676
X5203 BLZ12 rr3t3r_0[3|12]/a_460_290# sky130_fd_pr_reram__reram_cell area_ox=0.0676
X5204 rr3t3r_0[3|12]/a_460_290# WL3 SL12 VSS sky130_fd_pr__nfet_g5v0d10v5 ad=0.65 pd=3.3 as=0 ps=0 w=1 l=0.5
X5205 BLN12 rr3t3r_0[3|12]/a_860_290# sky130_fd_pr_reram__reram_cell area_ox=0.0676
X5206 rr3t3r_0[3|12]/a_60_290# WL3 SL12 VSS sky130_fd_pr__nfet_g5v0d10v5 ad=0.65 pd=3.3 as=0 ps=0 w=1 l=0.5
X5207 rr3t3r_0[3|12]/a_860_290# WL3 SL12 VSS sky130_fd_pr__nfet_g5v0d10v5 ad=0.65 pd=3.3 as=0 ps=0 w=1 l=0.5
X5208 BLP12 rr3t3r_0[4|12]/a_60_290# sky130_fd_pr_reram__reram_cell area_ox=0.0676
X5209 BLZ12 rr3t3r_0[4|12]/a_460_290# sky130_fd_pr_reram__reram_cell area_ox=0.0676
X5210 rr3t3r_0[4|12]/a_460_290# WL4 SL12 VSS sky130_fd_pr__nfet_g5v0d10v5 ad=0.65 pd=3.3 as=0 ps=0 w=1 l=0.5
X5211 BLN12 rr3t3r_0[4|12]/a_860_290# sky130_fd_pr_reram__reram_cell area_ox=0.0676
X5212 rr3t3r_0[4|12]/a_60_290# WL4 SL12 VSS sky130_fd_pr__nfet_g5v0d10v5 ad=0.65 pd=3.3 as=0 ps=0 w=1 l=0.5
X5213 rr3t3r_0[4|12]/a_860_290# WL4 SL12 VSS sky130_fd_pr__nfet_g5v0d10v5 ad=0.65 pd=3.3 as=0 ps=0 w=1 l=0.5
X5214 BLP12 rr3t3r_0[5|12]/a_60_290# sky130_fd_pr_reram__reram_cell area_ox=0.0676
X5215 BLZ12 rr3t3r_0[5|12]/a_460_290# sky130_fd_pr_reram__reram_cell area_ox=0.0676
X5216 rr3t3r_0[5|12]/a_460_290# WL5 SL12 VSS sky130_fd_pr__nfet_g5v0d10v5 ad=0.65 pd=3.3 as=0 ps=0 w=1 l=0.5
X5217 BLN12 rr3t3r_0[5|12]/a_860_290# sky130_fd_pr_reram__reram_cell area_ox=0.0676
X5218 rr3t3r_0[5|12]/a_60_290# WL5 SL12 VSS sky130_fd_pr__nfet_g5v0d10v5 ad=0.65 pd=3.3 as=0 ps=0 w=1 l=0.5
X5219 rr3t3r_0[5|12]/a_860_290# WL5 SL12 VSS sky130_fd_pr__nfet_g5v0d10v5 ad=0.65 pd=3.3 as=0 ps=0 w=1 l=0.5
X5220 BLP12 rr3t3r_0[6|12]/a_60_290# sky130_fd_pr_reram__reram_cell area_ox=0.0676
X5221 BLZ12 rr3t3r_0[6|12]/a_460_290# sky130_fd_pr_reram__reram_cell area_ox=0.0676
X5222 rr3t3r_0[6|12]/a_460_290# WL6 SL12 VSS sky130_fd_pr__nfet_g5v0d10v5 ad=0.65 pd=3.3 as=0 ps=0 w=1 l=0.5
X5223 BLN12 rr3t3r_0[6|12]/a_860_290# sky130_fd_pr_reram__reram_cell area_ox=0.0676
X5224 rr3t3r_0[6|12]/a_60_290# WL6 SL12 VSS sky130_fd_pr__nfet_g5v0d10v5 ad=0.65 pd=3.3 as=0 ps=0 w=1 l=0.5
X5225 rr3t3r_0[6|12]/a_860_290# WL6 SL12 VSS sky130_fd_pr__nfet_g5v0d10v5 ad=0.65 pd=3.3 as=0 ps=0 w=1 l=0.5
X5226 BLP12 rr3t3r_0[7|12]/a_60_290# sky130_fd_pr_reram__reram_cell area_ox=0.0676
X5227 BLZ12 rr3t3r_0[7|12]/a_460_290# sky130_fd_pr_reram__reram_cell area_ox=0.0676
X5228 rr3t3r_0[7|12]/a_460_290# WL7 SL12 VSS sky130_fd_pr__nfet_g5v0d10v5 ad=0.65 pd=3.3 as=0 ps=0 w=1 l=0.5
X5229 BLN12 rr3t3r_0[7|12]/a_860_290# sky130_fd_pr_reram__reram_cell area_ox=0.0676
X5230 rr3t3r_0[7|12]/a_60_290# WL7 SL12 VSS sky130_fd_pr__nfet_g5v0d10v5 ad=0.65 pd=3.3 as=0 ps=0 w=1 l=0.5
X5231 rr3t3r_0[7|12]/a_860_290# WL7 SL12 VSS sky130_fd_pr__nfet_g5v0d10v5 ad=0.65 pd=3.3 as=0 ps=0 w=1 l=0.5
X5232 BLP12 rr3t3r_0[8|12]/a_60_290# sky130_fd_pr_reram__reram_cell area_ox=0.0676
X5233 BLZ12 rr3t3r_0[8|12]/a_460_290# sky130_fd_pr_reram__reram_cell area_ox=0.0676
X5234 rr3t3r_0[8|12]/a_460_290# WL8 SL12 VSS sky130_fd_pr__nfet_g5v0d10v5 ad=0.65 pd=3.3 as=0 ps=0 w=1 l=0.5
X5235 BLN12 rr3t3r_0[8|12]/a_860_290# sky130_fd_pr_reram__reram_cell area_ox=0.0676
X5236 rr3t3r_0[8|12]/a_60_290# WL8 SL12 VSS sky130_fd_pr__nfet_g5v0d10v5 ad=0.65 pd=3.3 as=0 ps=0 w=1 l=0.5
X5237 rr3t3r_0[8|12]/a_860_290# WL8 SL12 VSS sky130_fd_pr__nfet_g5v0d10v5 ad=0.65 pd=3.3 as=0 ps=0 w=1 l=0.5
X5238 BLP12 rr3t3r_0[9|12]/a_60_290# sky130_fd_pr_reram__reram_cell area_ox=0.0676
X5239 BLZ12 rr3t3r_0[9|12]/a_460_290# sky130_fd_pr_reram__reram_cell area_ox=0.0676
X5240 rr3t3r_0[9|12]/a_460_290# WL9 SL12 VSS sky130_fd_pr__nfet_g5v0d10v5 ad=0.65 pd=3.3 as=0 ps=0 w=1 l=0.5
X5241 BLN12 rr3t3r_0[9|12]/a_860_290# sky130_fd_pr_reram__reram_cell area_ox=0.0676
X5242 rr3t3r_0[9|12]/a_60_290# WL9 SL12 VSS sky130_fd_pr__nfet_g5v0d10v5 ad=0.65 pd=3.3 as=0 ps=0 w=1 l=0.5
X5243 rr3t3r_0[9|12]/a_860_290# WL9 SL12 VSS sky130_fd_pr__nfet_g5v0d10v5 ad=0.65 pd=3.3 as=0 ps=0 w=1 l=0.5
X5244 BLP12 rr3t3r_0[10|12]/a_60_290# sky130_fd_pr_reram__reram_cell area_ox=0.0676
X5245 BLZ12 rr3t3r_0[10|12]/a_460_290# sky130_fd_pr_reram__reram_cell area_ox=0.0676
X5246 rr3t3r_0[10|12]/a_460_290# WL10 SL12 VSS sky130_fd_pr__nfet_g5v0d10v5 ad=0.65 pd=3.3 as=0 ps=0 w=1 l=0.5
X5247 BLN12 rr3t3r_0[10|12]/a_860_290# sky130_fd_pr_reram__reram_cell area_ox=0.0676
X5248 rr3t3r_0[10|12]/a_60_290# WL10 SL12 VSS sky130_fd_pr__nfet_g5v0d10v5 ad=0.65 pd=3.3 as=0 ps=0 w=1 l=0.5
X5249 rr3t3r_0[10|12]/a_860_290# WL10 SL12 VSS sky130_fd_pr__nfet_g5v0d10v5 ad=0.65 pd=3.3 as=0 ps=0 w=1 l=0.5
X5250 BLP12 rr3t3r_0[11|12]/a_60_290# sky130_fd_pr_reram__reram_cell area_ox=0.0676
X5251 BLZ12 rr3t3r_0[11|12]/a_460_290# sky130_fd_pr_reram__reram_cell area_ox=0.0676
X5252 rr3t3r_0[11|12]/a_460_290# WL11 SL12 VSS sky130_fd_pr__nfet_g5v0d10v5 ad=0.65 pd=3.3 as=0 ps=0 w=1 l=0.5
X5253 BLN12 rr3t3r_0[11|12]/a_860_290# sky130_fd_pr_reram__reram_cell area_ox=0.0676
X5254 rr3t3r_0[11|12]/a_60_290# WL11 SL12 VSS sky130_fd_pr__nfet_g5v0d10v5 ad=0.65 pd=3.3 as=0 ps=0 w=1 l=0.5
X5255 rr3t3r_0[11|12]/a_860_290# WL11 SL12 VSS sky130_fd_pr__nfet_g5v0d10v5 ad=0.65 pd=3.3 as=0 ps=0 w=1 l=0.5
X5256 BLP12 rr3t3r_0[12|12]/a_60_290# sky130_fd_pr_reram__reram_cell area_ox=0.0676
X5257 BLZ12 rr3t3r_0[12|12]/a_460_290# sky130_fd_pr_reram__reram_cell area_ox=0.0676
X5258 rr3t3r_0[12|12]/a_460_290# WL12 SL12 VSS sky130_fd_pr__nfet_g5v0d10v5 ad=0.65 pd=3.3 as=0 ps=0 w=1 l=0.5
X5259 BLN12 rr3t3r_0[12|12]/a_860_290# sky130_fd_pr_reram__reram_cell area_ox=0.0676
X5260 rr3t3r_0[12|12]/a_60_290# WL12 SL12 VSS sky130_fd_pr__nfet_g5v0d10v5 ad=0.65 pd=3.3 as=0 ps=0 w=1 l=0.5
X5261 rr3t3r_0[12|12]/a_860_290# WL12 SL12 VSS sky130_fd_pr__nfet_g5v0d10v5 ad=0.65 pd=3.3 as=0 ps=0 w=1 l=0.5
X5262 BLP12 rr3t3r_0[13|12]/a_60_290# sky130_fd_pr_reram__reram_cell area_ox=0.0676
X5263 BLZ12 rr3t3r_0[13|12]/a_460_290# sky130_fd_pr_reram__reram_cell area_ox=0.0676
X5264 rr3t3r_0[13|12]/a_460_290# WL13 SL12 VSS sky130_fd_pr__nfet_g5v0d10v5 ad=0.65 pd=3.3 as=0 ps=0 w=1 l=0.5
X5265 BLN12 rr3t3r_0[13|12]/a_860_290# sky130_fd_pr_reram__reram_cell area_ox=0.0676
X5266 rr3t3r_0[13|12]/a_60_290# WL13 SL12 VSS sky130_fd_pr__nfet_g5v0d10v5 ad=0.65 pd=3.3 as=0 ps=0 w=1 l=0.5
X5267 rr3t3r_0[13|12]/a_860_290# WL13 SL12 VSS sky130_fd_pr__nfet_g5v0d10v5 ad=0.65 pd=3.3 as=0 ps=0 w=1 l=0.5
X5268 BLP12 rr3t3r_0[14|12]/a_60_290# sky130_fd_pr_reram__reram_cell area_ox=0.0676
X5269 BLZ12 rr3t3r_0[14|12]/a_460_290# sky130_fd_pr_reram__reram_cell area_ox=0.0676
X5270 rr3t3r_0[14|12]/a_460_290# WL14 SL12 VSS sky130_fd_pr__nfet_g5v0d10v5 ad=0.65 pd=3.3 as=0 ps=0 w=1 l=0.5
X5271 BLN12 rr3t3r_0[14|12]/a_860_290# sky130_fd_pr_reram__reram_cell area_ox=0.0676
X5272 rr3t3r_0[14|12]/a_60_290# WL14 SL12 VSS sky130_fd_pr__nfet_g5v0d10v5 ad=0.65 pd=3.3 as=0 ps=0 w=1 l=0.5
X5273 rr3t3r_0[14|12]/a_860_290# WL14 SL12 VSS sky130_fd_pr__nfet_g5v0d10v5 ad=0.65 pd=3.3 as=0 ps=0 w=1 l=0.5
X5274 BLP12 rr3t3r_0[15|12]/a_60_290# sky130_fd_pr_reram__reram_cell area_ox=0.0676
X5275 BLZ12 rr3t3r_0[15|12]/a_460_290# sky130_fd_pr_reram__reram_cell area_ox=0.0676
X5276 rr3t3r_0[15|12]/a_460_290# WL15 SL12 VSS sky130_fd_pr__nfet_g5v0d10v5 ad=0.65 pd=3.3 as=0 ps=0 w=1 l=0.5
X5277 BLN12 rr3t3r_0[15|12]/a_860_290# sky130_fd_pr_reram__reram_cell area_ox=0.0676
X5278 rr3t3r_0[15|12]/a_60_290# WL15 SL12 VSS sky130_fd_pr__nfet_g5v0d10v5 ad=0.65 pd=3.3 as=0 ps=0 w=1 l=0.5
X5279 rr3t3r_0[15|12]/a_860_290# WL15 SL12 VSS sky130_fd_pr__nfet_g5v0d10v5 ad=0.65 pd=3.3 as=0 ps=0 w=1 l=0.5
X5280 BLP12 rr3t3r_0[16|12]/a_60_290# sky130_fd_pr_reram__reram_cell area_ox=0.0676
X5281 BLZ12 rr3t3r_0[16|12]/a_460_290# sky130_fd_pr_reram__reram_cell area_ox=0.0676
X5282 rr3t3r_0[16|12]/a_460_290# WL16 SL12 VSS sky130_fd_pr__nfet_g5v0d10v5 ad=0.65 pd=3.3 as=0 ps=0 w=1 l=0.5
X5283 BLN12 rr3t3r_0[16|12]/a_860_290# sky130_fd_pr_reram__reram_cell area_ox=0.0676
X5284 rr3t3r_0[16|12]/a_60_290# WL16 SL12 VSS sky130_fd_pr__nfet_g5v0d10v5 ad=0.65 pd=3.3 as=0 ps=0 w=1 l=0.5
X5285 rr3t3r_0[16|12]/a_860_290# WL16 SL12 VSS sky130_fd_pr__nfet_g5v0d10v5 ad=0.65 pd=3.3 as=0 ps=0 w=1 l=0.5
X5286 BLP12 rr3t3r_0[17|12]/a_60_290# sky130_fd_pr_reram__reram_cell area_ox=0.0676
X5287 BLZ12 rr3t3r_0[17|12]/a_460_290# sky130_fd_pr_reram__reram_cell area_ox=0.0676
X5288 rr3t3r_0[17|12]/a_460_290# WL17 SL12 VSS sky130_fd_pr__nfet_g5v0d10v5 ad=0.65 pd=3.3 as=0 ps=0 w=1 l=0.5
X5289 BLN12 rr3t3r_0[17|12]/a_860_290# sky130_fd_pr_reram__reram_cell area_ox=0.0676
X5290 rr3t3r_0[17|12]/a_60_290# WL17 SL12 VSS sky130_fd_pr__nfet_g5v0d10v5 ad=0.65 pd=3.3 as=0 ps=0 w=1 l=0.5
X5291 rr3t3r_0[17|12]/a_860_290# WL17 SL12 VSS sky130_fd_pr__nfet_g5v0d10v5 ad=0.65 pd=3.3 as=0 ps=0 w=1 l=0.5
X5292 BLP12 rr3t3r_0[18|12]/a_60_290# sky130_fd_pr_reram__reram_cell area_ox=0.0676
X5293 BLZ12 rr3t3r_0[18|12]/a_460_290# sky130_fd_pr_reram__reram_cell area_ox=0.0676
X5294 rr3t3r_0[18|12]/a_460_290# WL18 SL12 VSS sky130_fd_pr__nfet_g5v0d10v5 ad=0.65 pd=3.3 as=0 ps=0 w=1 l=0.5
X5295 BLN12 rr3t3r_0[18|12]/a_860_290# sky130_fd_pr_reram__reram_cell area_ox=0.0676
X5296 rr3t3r_0[18|12]/a_60_290# WL18 SL12 VSS sky130_fd_pr__nfet_g5v0d10v5 ad=0.65 pd=3.3 as=0 ps=0 w=1 l=0.5
X5297 rr3t3r_0[18|12]/a_860_290# WL18 SL12 VSS sky130_fd_pr__nfet_g5v0d10v5 ad=0.65 pd=3.3 as=0 ps=0 w=1 l=0.5
X5298 BLP12 rr3t3r_0[19|12]/a_60_290# sky130_fd_pr_reram__reram_cell area_ox=0.0676
X5299 BLZ12 rr3t3r_0[19|12]/a_460_290# sky130_fd_pr_reram__reram_cell area_ox=0.0676
X5300 rr3t3r_0[19|12]/a_460_290# WL19 SL12 VSS sky130_fd_pr__nfet_g5v0d10v5 ad=0.65 pd=3.3 as=0 ps=0 w=1 l=0.5
X5301 BLN12 rr3t3r_0[19|12]/a_860_290# sky130_fd_pr_reram__reram_cell area_ox=0.0676
X5302 rr3t3r_0[19|12]/a_60_290# WL19 SL12 VSS sky130_fd_pr__nfet_g5v0d10v5 ad=0.65 pd=3.3 as=0 ps=0 w=1 l=0.5
X5303 rr3t3r_0[19|12]/a_860_290# WL19 SL12 VSS sky130_fd_pr__nfet_g5v0d10v5 ad=0.65 pd=3.3 as=0 ps=0 w=1 l=0.5
X5304 BLP12 rr3t3r_0[20|12]/a_60_290# sky130_fd_pr_reram__reram_cell area_ox=0.0676
X5305 BLZ12 rr3t3r_0[20|12]/a_460_290# sky130_fd_pr_reram__reram_cell area_ox=0.0676
X5306 rr3t3r_0[20|12]/a_460_290# WL20 SL12 VSS sky130_fd_pr__nfet_g5v0d10v5 ad=0.65 pd=3.3 as=0 ps=0 w=1 l=0.5
X5307 BLN12 rr3t3r_0[20|12]/a_860_290# sky130_fd_pr_reram__reram_cell area_ox=0.0676
X5308 rr3t3r_0[20|12]/a_60_290# WL20 SL12 VSS sky130_fd_pr__nfet_g5v0d10v5 ad=0.65 pd=3.3 as=0 ps=0 w=1 l=0.5
X5309 rr3t3r_0[20|12]/a_860_290# WL20 SL12 VSS sky130_fd_pr__nfet_g5v0d10v5 ad=0.65 pd=3.3 as=0 ps=0 w=1 l=0.5
X5310 BLP12 rr3t3r_0[21|12]/a_60_290# sky130_fd_pr_reram__reram_cell area_ox=0.0676
X5311 BLZ12 rr3t3r_0[21|12]/a_460_290# sky130_fd_pr_reram__reram_cell area_ox=0.0676
X5312 rr3t3r_0[21|12]/a_460_290# WL21 SL12 VSS sky130_fd_pr__nfet_g5v0d10v5 ad=0.65 pd=3.3 as=0 ps=0 w=1 l=0.5
X5313 BLN12 rr3t3r_0[21|12]/a_860_290# sky130_fd_pr_reram__reram_cell area_ox=0.0676
X5314 rr3t3r_0[21|12]/a_60_290# WL21 SL12 VSS sky130_fd_pr__nfet_g5v0d10v5 ad=0.65 pd=3.3 as=0 ps=0 w=1 l=0.5
X5315 rr3t3r_0[21|12]/a_860_290# WL21 SL12 VSS sky130_fd_pr__nfet_g5v0d10v5 ad=0.65 pd=3.3 as=0 ps=0 w=1 l=0.5
X5316 BLP12 rr3t3r_0[22|12]/a_60_290# sky130_fd_pr_reram__reram_cell area_ox=0.0676
X5317 BLZ12 rr3t3r_0[22|12]/a_460_290# sky130_fd_pr_reram__reram_cell area_ox=0.0676
X5318 rr3t3r_0[22|12]/a_460_290# WL22 SL12 VSS sky130_fd_pr__nfet_g5v0d10v5 ad=0.65 pd=3.3 as=0 ps=0 w=1 l=0.5
X5319 BLN12 rr3t3r_0[22|12]/a_860_290# sky130_fd_pr_reram__reram_cell area_ox=0.0676
X5320 rr3t3r_0[22|12]/a_60_290# WL22 SL12 VSS sky130_fd_pr__nfet_g5v0d10v5 ad=0.65 pd=3.3 as=0 ps=0 w=1 l=0.5
X5321 rr3t3r_0[22|12]/a_860_290# WL22 SL12 VSS sky130_fd_pr__nfet_g5v0d10v5 ad=0.65 pd=3.3 as=0 ps=0 w=1 l=0.5
X5322 BLP12 rr3t3r_0[23|12]/a_60_290# sky130_fd_pr_reram__reram_cell area_ox=0.0676
X5323 BLZ12 rr3t3r_0[23|12]/a_460_290# sky130_fd_pr_reram__reram_cell area_ox=0.0676
X5324 rr3t3r_0[23|12]/a_460_290# WL23 SL12 VSS sky130_fd_pr__nfet_g5v0d10v5 ad=0.65 pd=3.3 as=0 ps=0 w=1 l=0.5
X5325 BLN12 rr3t3r_0[23|12]/a_860_290# sky130_fd_pr_reram__reram_cell area_ox=0.0676
X5326 rr3t3r_0[23|12]/a_60_290# WL23 SL12 VSS sky130_fd_pr__nfet_g5v0d10v5 ad=0.65 pd=3.3 as=0 ps=0 w=1 l=0.5
X5327 rr3t3r_0[23|12]/a_860_290# WL23 SL12 VSS sky130_fd_pr__nfet_g5v0d10v5 ad=0.65 pd=3.3 as=0 ps=0 w=1 l=0.5
X5328 BLP12 rr3t3r_0[24|12]/a_60_290# sky130_fd_pr_reram__reram_cell area_ox=0.0676
X5329 BLZ12 rr3t3r_0[24|12]/a_460_290# sky130_fd_pr_reram__reram_cell area_ox=0.0676
X5330 rr3t3r_0[24|12]/a_460_290# WL24 SL12 VSS sky130_fd_pr__nfet_g5v0d10v5 ad=0.65 pd=3.3 as=0 ps=0 w=1 l=0.5
X5331 BLN12 rr3t3r_0[24|12]/a_860_290# sky130_fd_pr_reram__reram_cell area_ox=0.0676
X5332 rr3t3r_0[24|12]/a_60_290# WL24 SL12 VSS sky130_fd_pr__nfet_g5v0d10v5 ad=0.65 pd=3.3 as=0 ps=0 w=1 l=0.5
X5333 rr3t3r_0[24|12]/a_860_290# WL24 SL12 VSS sky130_fd_pr__nfet_g5v0d10v5 ad=0.65 pd=3.3 as=0 ps=0 w=1 l=0.5
X5334 BLP12 rr3t3r_0[25|12]/a_60_290# sky130_fd_pr_reram__reram_cell area_ox=0.0676
X5335 BLZ12 rr3t3r_0[25|12]/a_460_290# sky130_fd_pr_reram__reram_cell area_ox=0.0676
X5336 rr3t3r_0[25|12]/a_460_290# WL25 SL12 VSS sky130_fd_pr__nfet_g5v0d10v5 ad=0.65 pd=3.3 as=0 ps=0 w=1 l=0.5
X5337 BLN12 rr3t3r_0[25|12]/a_860_290# sky130_fd_pr_reram__reram_cell area_ox=0.0676
X5338 rr3t3r_0[25|12]/a_60_290# WL25 SL12 VSS sky130_fd_pr__nfet_g5v0d10v5 ad=0.65 pd=3.3 as=0 ps=0 w=1 l=0.5
X5339 rr3t3r_0[25|12]/a_860_290# WL25 SL12 VSS sky130_fd_pr__nfet_g5v0d10v5 ad=0.65 pd=3.3 as=0 ps=0 w=1 l=0.5
X5340 BLP12 rr3t3r_0[26|12]/a_60_290# sky130_fd_pr_reram__reram_cell area_ox=0.0676
X5341 BLZ12 rr3t3r_0[26|12]/a_460_290# sky130_fd_pr_reram__reram_cell area_ox=0.0676
X5342 rr3t3r_0[26|12]/a_460_290# WL26 SL12 VSS sky130_fd_pr__nfet_g5v0d10v5 ad=0.65 pd=3.3 as=0 ps=0 w=1 l=0.5
X5343 BLN12 rr3t3r_0[26|12]/a_860_290# sky130_fd_pr_reram__reram_cell area_ox=0.0676
X5344 rr3t3r_0[26|12]/a_60_290# WL26 SL12 VSS sky130_fd_pr__nfet_g5v0d10v5 ad=0.65 pd=3.3 as=0 ps=0 w=1 l=0.5
X5345 rr3t3r_0[26|12]/a_860_290# WL26 SL12 VSS sky130_fd_pr__nfet_g5v0d10v5 ad=0.65 pd=3.3 as=0 ps=0 w=1 l=0.5
X5346 BLP12 rr3t3r_0[27|12]/a_60_290# sky130_fd_pr_reram__reram_cell area_ox=0.0676
X5347 BLZ12 rr3t3r_0[27|12]/a_460_290# sky130_fd_pr_reram__reram_cell area_ox=0.0676
X5348 rr3t3r_0[27|12]/a_460_290# WL27 SL12 VSS sky130_fd_pr__nfet_g5v0d10v5 ad=0.65 pd=3.3 as=0 ps=0 w=1 l=0.5
X5349 BLN12 rr3t3r_0[27|12]/a_860_290# sky130_fd_pr_reram__reram_cell area_ox=0.0676
X5350 rr3t3r_0[27|12]/a_60_290# WL27 SL12 VSS sky130_fd_pr__nfet_g5v0d10v5 ad=0.65 pd=3.3 as=0 ps=0 w=1 l=0.5
X5351 rr3t3r_0[27|12]/a_860_290# WL27 SL12 VSS sky130_fd_pr__nfet_g5v0d10v5 ad=0.65 pd=3.3 as=0 ps=0 w=1 l=0.5
X5352 BLP12 rr3t3r_0[28|12]/a_60_290# sky130_fd_pr_reram__reram_cell area_ox=0.0676
X5353 BLZ12 rr3t3r_0[28|12]/a_460_290# sky130_fd_pr_reram__reram_cell area_ox=0.0676
X5354 rr3t3r_0[28|12]/a_460_290# WL28 SL12 VSS sky130_fd_pr__nfet_g5v0d10v5 ad=0.65 pd=3.3 as=0 ps=0 w=1 l=0.5
X5355 BLN12 rr3t3r_0[28|12]/a_860_290# sky130_fd_pr_reram__reram_cell area_ox=0.0676
X5356 rr3t3r_0[28|12]/a_60_290# WL28 SL12 VSS sky130_fd_pr__nfet_g5v0d10v5 ad=0.65 pd=3.3 as=0 ps=0 w=1 l=0.5
X5357 rr3t3r_0[28|12]/a_860_290# WL28 SL12 VSS sky130_fd_pr__nfet_g5v0d10v5 ad=0.65 pd=3.3 as=0 ps=0 w=1 l=0.5
X5358 BLP12 rr3t3r_0[29|12]/a_60_290# sky130_fd_pr_reram__reram_cell area_ox=0.0676
X5359 BLZ12 rr3t3r_0[29|12]/a_460_290# sky130_fd_pr_reram__reram_cell area_ox=0.0676
X5360 rr3t3r_0[29|12]/a_460_290# WL29 SL12 VSS sky130_fd_pr__nfet_g5v0d10v5 ad=0.65 pd=3.3 as=0 ps=0 w=1 l=0.5
X5361 BLN12 rr3t3r_0[29|12]/a_860_290# sky130_fd_pr_reram__reram_cell area_ox=0.0676
X5362 rr3t3r_0[29|12]/a_60_290# WL29 SL12 VSS sky130_fd_pr__nfet_g5v0d10v5 ad=0.65 pd=3.3 as=0 ps=0 w=1 l=0.5
X5363 rr3t3r_0[29|12]/a_860_290# WL29 SL12 VSS sky130_fd_pr__nfet_g5v0d10v5 ad=0.65 pd=3.3 as=0 ps=0 w=1 l=0.5
X5364 BLP12 rr3t3r_0[30|12]/a_60_290# sky130_fd_pr_reram__reram_cell area_ox=0.0676
X5365 BLZ12 rr3t3r_0[30|12]/a_460_290# sky130_fd_pr_reram__reram_cell area_ox=0.0676
X5366 rr3t3r_0[30|12]/a_460_290# WL30 SL12 VSS sky130_fd_pr__nfet_g5v0d10v5 ad=0.65 pd=3.3 as=0 ps=0 w=1 l=0.5
X5367 BLN12 rr3t3r_0[30|12]/a_860_290# sky130_fd_pr_reram__reram_cell area_ox=0.0676
X5368 rr3t3r_0[30|12]/a_60_290# WL30 SL12 VSS sky130_fd_pr__nfet_g5v0d10v5 ad=0.65 pd=3.3 as=0 ps=0 w=1 l=0.5
X5369 rr3t3r_0[30|12]/a_860_290# WL30 SL12 VSS sky130_fd_pr__nfet_g5v0d10v5 ad=0.65 pd=3.3 as=0 ps=0 w=1 l=0.5
X5370 BLP12 rr3t3r_0[31|12]/a_60_290# sky130_fd_pr_reram__reram_cell area_ox=0.0676
X5371 BLZ12 rr3t3r_0[31|12]/a_460_290# sky130_fd_pr_reram__reram_cell area_ox=0.0676
X5372 rr3t3r_0[31|12]/a_460_290# WL31 SL12 VSS sky130_fd_pr__nfet_g5v0d10v5 ad=0.65 pd=3.3 as=0 ps=0 w=1 l=0.5
X5373 BLN12 rr3t3r_0[31|12]/a_860_290# sky130_fd_pr_reram__reram_cell area_ox=0.0676
X5374 rr3t3r_0[31|12]/a_60_290# WL31 SL12 VSS sky130_fd_pr__nfet_g5v0d10v5 ad=0.65 pd=3.3 as=0 ps=0 w=1 l=0.5
X5375 rr3t3r_0[31|12]/a_860_290# WL31 SL12 VSS sky130_fd_pr__nfet_g5v0d10v5 ad=0.65 pd=3.3 as=0 ps=0 w=1 l=0.5
X5376 BLP12 rr3t3r_0[32|12]/a_60_290# sky130_fd_pr_reram__reram_cell area_ox=0.0676
X5377 BLZ12 rr3t3r_0[32|12]/a_460_290# sky130_fd_pr_reram__reram_cell area_ox=0.0676
X5378 rr3t3r_0[32|12]/a_460_290# WL32 SL12 VSS sky130_fd_pr__nfet_g5v0d10v5 ad=0.65 pd=3.3 as=0 ps=0 w=1 l=0.5
X5379 BLN12 rr3t3r_0[32|12]/a_860_290# sky130_fd_pr_reram__reram_cell area_ox=0.0676
X5380 rr3t3r_0[32|12]/a_60_290# WL32 SL12 VSS sky130_fd_pr__nfet_g5v0d10v5 ad=0.65 pd=3.3 as=0 ps=0 w=1 l=0.5
X5381 rr3t3r_0[32|12]/a_860_290# WL32 SL12 VSS sky130_fd_pr__nfet_g5v0d10v5 ad=0.65 pd=3.3 as=0 ps=0 w=1 l=0.5
X5382 BLP12 rr3t3r_0[33|12]/a_60_290# sky130_fd_pr_reram__reram_cell area_ox=0.0676
X5383 BLZ12 rr3t3r_0[33|12]/a_460_290# sky130_fd_pr_reram__reram_cell area_ox=0.0676
X5384 rr3t3r_0[33|12]/a_460_290# WL33 SL12 VSS sky130_fd_pr__nfet_g5v0d10v5 ad=0.65 pd=3.3 as=0 ps=0 w=1 l=0.5
X5385 BLN12 rr3t3r_0[33|12]/a_860_290# sky130_fd_pr_reram__reram_cell area_ox=0.0676
X5386 rr3t3r_0[33|12]/a_60_290# WL33 SL12 VSS sky130_fd_pr__nfet_g5v0d10v5 ad=0.65 pd=3.3 as=0 ps=0 w=1 l=0.5
X5387 rr3t3r_0[33|12]/a_860_290# WL33 SL12 VSS sky130_fd_pr__nfet_g5v0d10v5 ad=0.65 pd=3.3 as=0 ps=0 w=1 l=0.5
X5388 BLP12 rr3t3r_0[34|12]/a_60_290# sky130_fd_pr_reram__reram_cell area_ox=0.0676
X5389 BLZ12 rr3t3r_0[34|12]/a_460_290# sky130_fd_pr_reram__reram_cell area_ox=0.0676
X5390 rr3t3r_0[34|12]/a_460_290# WL34 SL12 VSS sky130_fd_pr__nfet_g5v0d10v5 ad=0.65 pd=3.3 as=0 ps=0 w=1 l=0.5
X5391 BLN12 rr3t3r_0[34|12]/a_860_290# sky130_fd_pr_reram__reram_cell area_ox=0.0676
X5392 rr3t3r_0[34|12]/a_60_290# WL34 SL12 VSS sky130_fd_pr__nfet_g5v0d10v5 ad=0.65 pd=3.3 as=0 ps=0 w=1 l=0.5
X5393 rr3t3r_0[34|12]/a_860_290# WL34 SL12 VSS sky130_fd_pr__nfet_g5v0d10v5 ad=0.65 pd=3.3 as=0 ps=0 w=1 l=0.5
X5394 BLP12 rr3t3r_0[35|12]/a_60_290# sky130_fd_pr_reram__reram_cell area_ox=0.0676
X5395 BLZ12 rr3t3r_0[35|12]/a_460_290# sky130_fd_pr_reram__reram_cell area_ox=0.0676
X5396 rr3t3r_0[35|12]/a_460_290# WL35 SL12 VSS sky130_fd_pr__nfet_g5v0d10v5 ad=0.65 pd=3.3 as=0 ps=0 w=1 l=0.5
X5397 BLN12 rr3t3r_0[35|12]/a_860_290# sky130_fd_pr_reram__reram_cell area_ox=0.0676
X5398 rr3t3r_0[35|12]/a_60_290# WL35 SL12 VSS sky130_fd_pr__nfet_g5v0d10v5 ad=0.65 pd=3.3 as=0 ps=0 w=1 l=0.5
X5399 rr3t3r_0[35|12]/a_860_290# WL35 SL12 VSS sky130_fd_pr__nfet_g5v0d10v5 ad=0.65 pd=3.3 as=0 ps=0 w=1 l=0.5
X5400 BLP12 rr3t3r_0[36|12]/a_60_290# sky130_fd_pr_reram__reram_cell area_ox=0.0676
X5401 BLZ12 rr3t3r_0[36|12]/a_460_290# sky130_fd_pr_reram__reram_cell area_ox=0.0676
X5402 rr3t3r_0[36|12]/a_460_290# WL36 SL12 VSS sky130_fd_pr__nfet_g5v0d10v5 ad=0.65 pd=3.3 as=0 ps=0 w=1 l=0.5
X5403 BLN12 rr3t3r_0[36|12]/a_860_290# sky130_fd_pr_reram__reram_cell area_ox=0.0676
X5404 rr3t3r_0[36|12]/a_60_290# WL36 SL12 VSS sky130_fd_pr__nfet_g5v0d10v5 ad=0.65 pd=3.3 as=0 ps=0 w=1 l=0.5
X5405 rr3t3r_0[36|12]/a_860_290# WL36 SL12 VSS sky130_fd_pr__nfet_g5v0d10v5 ad=0.65 pd=3.3 as=0 ps=0 w=1 l=0.5
X5406 BLP12 rr3t3r_0[37|12]/a_60_290# sky130_fd_pr_reram__reram_cell area_ox=0.0676
X5407 BLZ12 rr3t3r_0[37|12]/a_460_290# sky130_fd_pr_reram__reram_cell area_ox=0.0676
X5408 rr3t3r_0[37|12]/a_460_290# WL37 SL12 VSS sky130_fd_pr__nfet_g5v0d10v5 ad=0.65 pd=3.3 as=0 ps=0 w=1 l=0.5
X5409 BLN12 rr3t3r_0[37|12]/a_860_290# sky130_fd_pr_reram__reram_cell area_ox=0.0676
X5410 rr3t3r_0[37|12]/a_60_290# WL37 SL12 VSS sky130_fd_pr__nfet_g5v0d10v5 ad=0.65 pd=3.3 as=0 ps=0 w=1 l=0.5
X5411 rr3t3r_0[37|12]/a_860_290# WL37 SL12 VSS sky130_fd_pr__nfet_g5v0d10v5 ad=0.65 pd=3.3 as=0 ps=0 w=1 l=0.5
X5412 BLP12 rr3t3r_0[38|12]/a_60_290# sky130_fd_pr_reram__reram_cell area_ox=0.0676
X5413 BLZ12 rr3t3r_0[38|12]/a_460_290# sky130_fd_pr_reram__reram_cell area_ox=0.0676
X5414 rr3t3r_0[38|12]/a_460_290# WL38 SL12 VSS sky130_fd_pr__nfet_g5v0d10v5 ad=0.65 pd=3.3 as=0 ps=0 w=1 l=0.5
X5415 BLN12 rr3t3r_0[38|12]/a_860_290# sky130_fd_pr_reram__reram_cell area_ox=0.0676
X5416 rr3t3r_0[38|12]/a_60_290# WL38 SL12 VSS sky130_fd_pr__nfet_g5v0d10v5 ad=0.65 pd=3.3 as=0 ps=0 w=1 l=0.5
X5417 rr3t3r_0[38|12]/a_860_290# WL38 SL12 VSS sky130_fd_pr__nfet_g5v0d10v5 ad=0.65 pd=3.3 as=0 ps=0 w=1 l=0.5
X5418 BLP12 rr3t3r_0[39|12]/a_60_290# sky130_fd_pr_reram__reram_cell area_ox=0.0676
X5419 BLZ12 rr3t3r_0[39|12]/a_460_290# sky130_fd_pr_reram__reram_cell area_ox=0.0676
X5420 rr3t3r_0[39|12]/a_460_290# WL39 SL12 VSS sky130_fd_pr__nfet_g5v0d10v5 ad=0.65 pd=3.3 as=0 ps=0 w=1 l=0.5
X5421 BLN12 rr3t3r_0[39|12]/a_860_290# sky130_fd_pr_reram__reram_cell area_ox=0.0676
X5422 rr3t3r_0[39|12]/a_60_290# WL39 SL12 VSS sky130_fd_pr__nfet_g5v0d10v5 ad=0.65 pd=3.3 as=0 ps=0 w=1 l=0.5
X5423 rr3t3r_0[39|12]/a_860_290# WL39 SL12 VSS sky130_fd_pr__nfet_g5v0d10v5 ad=0.65 pd=3.3 as=0 ps=0 w=1 l=0.5
X5424 BLP12 rr3t3r_0[40|12]/a_60_290# sky130_fd_pr_reram__reram_cell area_ox=0.0676
X5425 BLZ12 rr3t3r_0[40|12]/a_460_290# sky130_fd_pr_reram__reram_cell area_ox=0.0676
X5426 rr3t3r_0[40|12]/a_460_290# WL40 SL12 VSS sky130_fd_pr__nfet_g5v0d10v5 ad=0.65 pd=3.3 as=0 ps=0 w=1 l=0.5
X5427 BLN12 rr3t3r_0[40|12]/a_860_290# sky130_fd_pr_reram__reram_cell area_ox=0.0676
X5428 rr3t3r_0[40|12]/a_60_290# WL40 SL12 VSS sky130_fd_pr__nfet_g5v0d10v5 ad=0.65 pd=3.3 as=0 ps=0 w=1 l=0.5
X5429 rr3t3r_0[40|12]/a_860_290# WL40 SL12 VSS sky130_fd_pr__nfet_g5v0d10v5 ad=0.65 pd=3.3 as=0 ps=0 w=1 l=0.5
X5430 BLP12 rr3t3r_0[41|12]/a_60_290# sky130_fd_pr_reram__reram_cell area_ox=0.0676
X5431 BLZ12 rr3t3r_0[41|12]/a_460_290# sky130_fd_pr_reram__reram_cell area_ox=0.0676
X5432 rr3t3r_0[41|12]/a_460_290# WL41 SL12 VSS sky130_fd_pr__nfet_g5v0d10v5 ad=0.65 pd=3.3 as=0 ps=0 w=1 l=0.5
X5433 BLN12 rr3t3r_0[41|12]/a_860_290# sky130_fd_pr_reram__reram_cell area_ox=0.0676
X5434 rr3t3r_0[41|12]/a_60_290# WL41 SL12 VSS sky130_fd_pr__nfet_g5v0d10v5 ad=0.65 pd=3.3 as=0 ps=0 w=1 l=0.5
X5435 rr3t3r_0[41|12]/a_860_290# WL41 SL12 VSS sky130_fd_pr__nfet_g5v0d10v5 ad=0.65 pd=3.3 as=0 ps=0 w=1 l=0.5
X5436 BLP12 rr3t3r_0[42|12]/a_60_290# sky130_fd_pr_reram__reram_cell area_ox=0.0676
X5437 BLZ12 rr3t3r_0[42|12]/a_460_290# sky130_fd_pr_reram__reram_cell area_ox=0.0676
X5438 rr3t3r_0[42|12]/a_460_290# WL42 SL12 VSS sky130_fd_pr__nfet_g5v0d10v5 ad=0.65 pd=3.3 as=0 ps=0 w=1 l=0.5
X5439 BLN12 rr3t3r_0[42|12]/a_860_290# sky130_fd_pr_reram__reram_cell area_ox=0.0676
X5440 rr3t3r_0[42|12]/a_60_290# WL42 SL12 VSS sky130_fd_pr__nfet_g5v0d10v5 ad=0.65 pd=3.3 as=0 ps=0 w=1 l=0.5
X5441 rr3t3r_0[42|12]/a_860_290# WL42 SL12 VSS sky130_fd_pr__nfet_g5v0d10v5 ad=0.65 pd=3.3 as=0 ps=0 w=1 l=0.5
X5442 BLP12 rr3t3r_0[43|12]/a_60_290# sky130_fd_pr_reram__reram_cell area_ox=0.0676
X5443 BLZ12 rr3t3r_0[43|12]/a_460_290# sky130_fd_pr_reram__reram_cell area_ox=0.0676
X5444 rr3t3r_0[43|12]/a_460_290# WL43 SL12 VSS sky130_fd_pr__nfet_g5v0d10v5 ad=0.65 pd=3.3 as=0 ps=0 w=1 l=0.5
X5445 BLN12 rr3t3r_0[43|12]/a_860_290# sky130_fd_pr_reram__reram_cell area_ox=0.0676
X5446 rr3t3r_0[43|12]/a_60_290# WL43 SL12 VSS sky130_fd_pr__nfet_g5v0d10v5 ad=0.65 pd=3.3 as=0 ps=0 w=1 l=0.5
X5447 rr3t3r_0[43|12]/a_860_290# WL43 SL12 VSS sky130_fd_pr__nfet_g5v0d10v5 ad=0.65 pd=3.3 as=0 ps=0 w=1 l=0.5
X5448 BLP12 rr3t3r_0[44|12]/a_60_290# sky130_fd_pr_reram__reram_cell area_ox=0.0676
X5449 BLZ12 rr3t3r_0[44|12]/a_460_290# sky130_fd_pr_reram__reram_cell area_ox=0.0676
X5450 rr3t3r_0[44|12]/a_460_290# WL44 SL12 VSS sky130_fd_pr__nfet_g5v0d10v5 ad=0.65 pd=3.3 as=0 ps=0 w=1 l=0.5
X5451 BLN12 rr3t3r_0[44|12]/a_860_290# sky130_fd_pr_reram__reram_cell area_ox=0.0676
X5452 rr3t3r_0[44|12]/a_60_290# WL44 SL12 VSS sky130_fd_pr__nfet_g5v0d10v5 ad=0.65 pd=3.3 as=0 ps=0 w=1 l=0.5
X5453 rr3t3r_0[44|12]/a_860_290# WL44 SL12 VSS sky130_fd_pr__nfet_g5v0d10v5 ad=0.65 pd=3.3 as=0 ps=0 w=1 l=0.5
X5454 BLP12 rr3t3r_0[45|12]/a_60_290# sky130_fd_pr_reram__reram_cell area_ox=0.0676
X5455 BLZ12 rr3t3r_0[45|12]/a_460_290# sky130_fd_pr_reram__reram_cell area_ox=0.0676
X5456 rr3t3r_0[45|12]/a_460_290# WL45 SL12 VSS sky130_fd_pr__nfet_g5v0d10v5 ad=0.65 pd=3.3 as=0 ps=0 w=1 l=0.5
X5457 BLN12 rr3t3r_0[45|12]/a_860_290# sky130_fd_pr_reram__reram_cell area_ox=0.0676
X5458 rr3t3r_0[45|12]/a_60_290# WL45 SL12 VSS sky130_fd_pr__nfet_g5v0d10v5 ad=0.65 pd=3.3 as=0 ps=0 w=1 l=0.5
X5459 rr3t3r_0[45|12]/a_860_290# WL45 SL12 VSS sky130_fd_pr__nfet_g5v0d10v5 ad=0.65 pd=3.3 as=0 ps=0 w=1 l=0.5
X5460 BLP12 rr3t3r_0[46|12]/a_60_290# sky130_fd_pr_reram__reram_cell area_ox=0.0676
X5461 BLZ12 rr3t3r_0[46|12]/a_460_290# sky130_fd_pr_reram__reram_cell area_ox=0.0676
X5462 rr3t3r_0[46|12]/a_460_290# WL46 SL12 VSS sky130_fd_pr__nfet_g5v0d10v5 ad=0.65 pd=3.3 as=0 ps=0 w=1 l=0.5
X5463 BLN12 rr3t3r_0[46|12]/a_860_290# sky130_fd_pr_reram__reram_cell area_ox=0.0676
X5464 rr3t3r_0[46|12]/a_60_290# WL46 SL12 VSS sky130_fd_pr__nfet_g5v0d10v5 ad=0.65 pd=3.3 as=0 ps=0 w=1 l=0.5
X5465 rr3t3r_0[46|12]/a_860_290# WL46 SL12 VSS sky130_fd_pr__nfet_g5v0d10v5 ad=0.65 pd=3.3 as=0 ps=0 w=1 l=0.5
X5466 BLP12 rr3t3r_0[47|12]/a_60_290# sky130_fd_pr_reram__reram_cell area_ox=0.0676
X5467 BLZ12 rr3t3r_0[47|12]/a_460_290# sky130_fd_pr_reram__reram_cell area_ox=0.0676
X5468 rr3t3r_0[47|12]/a_460_290# WL47 SL12 VSS sky130_fd_pr__nfet_g5v0d10v5 ad=0.65 pd=3.3 as=0 ps=0 w=1 l=0.5
X5469 BLN12 rr3t3r_0[47|12]/a_860_290# sky130_fd_pr_reram__reram_cell area_ox=0.0676
X5470 rr3t3r_0[47|12]/a_60_290# WL47 SL12 VSS sky130_fd_pr__nfet_g5v0d10v5 ad=0.65 pd=3.3 as=0 ps=0 w=1 l=0.5
X5471 rr3t3r_0[47|12]/a_860_290# WL47 SL12 VSS sky130_fd_pr__nfet_g5v0d10v5 ad=0.65 pd=3.3 as=0 ps=0 w=1 l=0.5
X5472 BLP12 rr3t3r_0[48|12]/a_60_290# sky130_fd_pr_reram__reram_cell area_ox=0.0676
X5473 BLZ12 rr3t3r_0[48|12]/a_460_290# sky130_fd_pr_reram__reram_cell area_ox=0.0676
X5474 rr3t3r_0[48|12]/a_460_290# WL48 SL12 VSS sky130_fd_pr__nfet_g5v0d10v5 ad=0.65 pd=3.3 as=0 ps=0 w=1 l=0.5
X5475 BLN12 rr3t3r_0[48|12]/a_860_290# sky130_fd_pr_reram__reram_cell area_ox=0.0676
X5476 rr3t3r_0[48|12]/a_60_290# WL48 SL12 VSS sky130_fd_pr__nfet_g5v0d10v5 ad=0.65 pd=3.3 as=0 ps=0 w=1 l=0.5
X5477 rr3t3r_0[48|12]/a_860_290# WL48 SL12 VSS sky130_fd_pr__nfet_g5v0d10v5 ad=0.65 pd=3.3 as=0 ps=0 w=1 l=0.5
X5478 BLP12 rr3t3r_0[49|12]/a_60_290# sky130_fd_pr_reram__reram_cell area_ox=0.0676
X5479 BLZ12 rr3t3r_0[49|12]/a_460_290# sky130_fd_pr_reram__reram_cell area_ox=0.0676
X5480 rr3t3r_0[49|12]/a_460_290# WL49 SL12 VSS sky130_fd_pr__nfet_g5v0d10v5 ad=0.65 pd=3.3 as=0 ps=0 w=1 l=0.5
X5481 BLN12 rr3t3r_0[49|12]/a_860_290# sky130_fd_pr_reram__reram_cell area_ox=0.0676
X5482 rr3t3r_0[49|12]/a_60_290# WL49 SL12 VSS sky130_fd_pr__nfet_g5v0d10v5 ad=0.65 pd=3.3 as=0 ps=0 w=1 l=0.5
X5483 rr3t3r_0[49|12]/a_860_290# WL49 SL12 VSS sky130_fd_pr__nfet_g5v0d10v5 ad=0.65 pd=3.3 as=0 ps=0 w=1 l=0.5
X5484 BLP12 rr3t3r_0[50|12]/a_60_290# sky130_fd_pr_reram__reram_cell area_ox=0.0676
X5485 BLZ12 rr3t3r_0[50|12]/a_460_290# sky130_fd_pr_reram__reram_cell area_ox=0.0676
X5486 rr3t3r_0[50|12]/a_460_290# WL50 SL12 VSS sky130_fd_pr__nfet_g5v0d10v5 ad=0.65 pd=3.3 as=0 ps=0 w=1 l=0.5
X5487 BLN12 rr3t3r_0[50|12]/a_860_290# sky130_fd_pr_reram__reram_cell area_ox=0.0676
X5488 rr3t3r_0[50|12]/a_60_290# WL50 SL12 VSS sky130_fd_pr__nfet_g5v0d10v5 ad=0.65 pd=3.3 as=0 ps=0 w=1 l=0.5
X5489 rr3t3r_0[50|12]/a_860_290# WL50 SL12 VSS sky130_fd_pr__nfet_g5v0d10v5 ad=0.65 pd=3.3 as=0 ps=0 w=1 l=0.5
X5490 BLP12 rr3t3r_0[51|12]/a_60_290# sky130_fd_pr_reram__reram_cell area_ox=0.0676
X5491 BLZ12 rr3t3r_0[51|12]/a_460_290# sky130_fd_pr_reram__reram_cell area_ox=0.0676
X5492 rr3t3r_0[51|12]/a_460_290# WL51 SL12 VSS sky130_fd_pr__nfet_g5v0d10v5 ad=0.65 pd=3.3 as=0 ps=0 w=1 l=0.5
X5493 BLN12 rr3t3r_0[51|12]/a_860_290# sky130_fd_pr_reram__reram_cell area_ox=0.0676
X5494 rr3t3r_0[51|12]/a_60_290# WL51 SL12 VSS sky130_fd_pr__nfet_g5v0d10v5 ad=0.65 pd=3.3 as=0 ps=0 w=1 l=0.5
X5495 rr3t3r_0[51|12]/a_860_290# WL51 SL12 VSS sky130_fd_pr__nfet_g5v0d10v5 ad=0.65 pd=3.3 as=0 ps=0 w=1 l=0.5
X5496 BLP12 rr3t3r_0[52|12]/a_60_290# sky130_fd_pr_reram__reram_cell area_ox=0.0676
X5497 BLZ12 rr3t3r_0[52|12]/a_460_290# sky130_fd_pr_reram__reram_cell area_ox=0.0676
X5498 rr3t3r_0[52|12]/a_460_290# WL52 SL12 VSS sky130_fd_pr__nfet_g5v0d10v5 ad=0.65 pd=3.3 as=0 ps=0 w=1 l=0.5
X5499 BLN12 rr3t3r_0[52|12]/a_860_290# sky130_fd_pr_reram__reram_cell area_ox=0.0676
X5500 rr3t3r_0[52|12]/a_60_290# WL52 SL12 VSS sky130_fd_pr__nfet_g5v0d10v5 ad=0.65 pd=3.3 as=0 ps=0 w=1 l=0.5
X5501 rr3t3r_0[52|12]/a_860_290# WL52 SL12 VSS sky130_fd_pr__nfet_g5v0d10v5 ad=0.65 pd=3.3 as=0 ps=0 w=1 l=0.5
X5502 BLP12 rr3t3r_0[53|12]/a_60_290# sky130_fd_pr_reram__reram_cell area_ox=0.0676
X5503 BLZ12 rr3t3r_0[53|12]/a_460_290# sky130_fd_pr_reram__reram_cell area_ox=0.0676
X5504 rr3t3r_0[53|12]/a_460_290# WL53 SL12 VSS sky130_fd_pr__nfet_g5v0d10v5 ad=0.65 pd=3.3 as=0 ps=0 w=1 l=0.5
X5505 BLN12 rr3t3r_0[53|12]/a_860_290# sky130_fd_pr_reram__reram_cell area_ox=0.0676
X5506 rr3t3r_0[53|12]/a_60_290# WL53 SL12 VSS sky130_fd_pr__nfet_g5v0d10v5 ad=0.65 pd=3.3 as=0 ps=0 w=1 l=0.5
X5507 rr3t3r_0[53|12]/a_860_290# WL53 SL12 VSS sky130_fd_pr__nfet_g5v0d10v5 ad=0.65 pd=3.3 as=0 ps=0 w=1 l=0.5
X5508 BLP12 rr3t3r_0[54|12]/a_60_290# sky130_fd_pr_reram__reram_cell area_ox=0.0676
X5509 BLZ12 rr3t3r_0[54|12]/a_460_290# sky130_fd_pr_reram__reram_cell area_ox=0.0676
X5510 rr3t3r_0[54|12]/a_460_290# WL54 SL12 VSS sky130_fd_pr__nfet_g5v0d10v5 ad=0.65 pd=3.3 as=0 ps=0 w=1 l=0.5
X5511 BLN12 rr3t3r_0[54|12]/a_860_290# sky130_fd_pr_reram__reram_cell area_ox=0.0676
X5512 rr3t3r_0[54|12]/a_60_290# WL54 SL12 VSS sky130_fd_pr__nfet_g5v0d10v5 ad=0.65 pd=3.3 as=0 ps=0 w=1 l=0.5
X5513 rr3t3r_0[54|12]/a_860_290# WL54 SL12 VSS sky130_fd_pr__nfet_g5v0d10v5 ad=0.65 pd=3.3 as=0 ps=0 w=1 l=0.5
X5514 BLP12 rr3t3r_0[55|12]/a_60_290# sky130_fd_pr_reram__reram_cell area_ox=0.0676
X5515 BLZ12 rr3t3r_0[55|12]/a_460_290# sky130_fd_pr_reram__reram_cell area_ox=0.0676
X5516 rr3t3r_0[55|12]/a_460_290# WL55 SL12 VSS sky130_fd_pr__nfet_g5v0d10v5 ad=0.65 pd=3.3 as=0 ps=0 w=1 l=0.5
X5517 BLN12 rr3t3r_0[55|12]/a_860_290# sky130_fd_pr_reram__reram_cell area_ox=0.0676
X5518 rr3t3r_0[55|12]/a_60_290# WL55 SL12 VSS sky130_fd_pr__nfet_g5v0d10v5 ad=0.65 pd=3.3 as=0 ps=0 w=1 l=0.5
X5519 rr3t3r_0[55|12]/a_860_290# WL55 SL12 VSS sky130_fd_pr__nfet_g5v0d10v5 ad=0.65 pd=3.3 as=0 ps=0 w=1 l=0.5
X5520 BLP12 rr3t3r_0[56|12]/a_60_290# sky130_fd_pr_reram__reram_cell area_ox=0.0676
X5521 BLZ12 rr3t3r_0[56|12]/a_460_290# sky130_fd_pr_reram__reram_cell area_ox=0.0676
X5522 rr3t3r_0[56|12]/a_460_290# WL56 SL12 VSS sky130_fd_pr__nfet_g5v0d10v5 ad=0.65 pd=3.3 as=0 ps=0 w=1 l=0.5
X5523 BLN12 rr3t3r_0[56|12]/a_860_290# sky130_fd_pr_reram__reram_cell area_ox=0.0676
X5524 rr3t3r_0[56|12]/a_60_290# WL56 SL12 VSS sky130_fd_pr__nfet_g5v0d10v5 ad=0.65 pd=3.3 as=0 ps=0 w=1 l=0.5
X5525 rr3t3r_0[56|12]/a_860_290# WL56 SL12 VSS sky130_fd_pr__nfet_g5v0d10v5 ad=0.65 pd=3.3 as=0 ps=0 w=1 l=0.5
X5526 BLP12 rr3t3r_0[57|12]/a_60_290# sky130_fd_pr_reram__reram_cell area_ox=0.0676
X5527 BLZ12 rr3t3r_0[57|12]/a_460_290# sky130_fd_pr_reram__reram_cell area_ox=0.0676
X5528 rr3t3r_0[57|12]/a_460_290# WL57 SL12 VSS sky130_fd_pr__nfet_g5v0d10v5 ad=0.65 pd=3.3 as=0 ps=0 w=1 l=0.5
X5529 BLN12 rr3t3r_0[57|12]/a_860_290# sky130_fd_pr_reram__reram_cell area_ox=0.0676
X5530 rr3t3r_0[57|12]/a_60_290# WL57 SL12 VSS sky130_fd_pr__nfet_g5v0d10v5 ad=0.65 pd=3.3 as=0 ps=0 w=1 l=0.5
X5531 rr3t3r_0[57|12]/a_860_290# WL57 SL12 VSS sky130_fd_pr__nfet_g5v0d10v5 ad=0.65 pd=3.3 as=0 ps=0 w=1 l=0.5
X5532 BLP12 rr3t3r_0[58|12]/a_60_290# sky130_fd_pr_reram__reram_cell area_ox=0.0676
X5533 BLZ12 rr3t3r_0[58|12]/a_460_290# sky130_fd_pr_reram__reram_cell area_ox=0.0676
X5534 rr3t3r_0[58|12]/a_460_290# WL58 SL12 VSS sky130_fd_pr__nfet_g5v0d10v5 ad=0.65 pd=3.3 as=0 ps=0 w=1 l=0.5
X5535 BLN12 rr3t3r_0[58|12]/a_860_290# sky130_fd_pr_reram__reram_cell area_ox=0.0676
X5536 rr3t3r_0[58|12]/a_60_290# WL58 SL12 VSS sky130_fd_pr__nfet_g5v0d10v5 ad=0.65 pd=3.3 as=0 ps=0 w=1 l=0.5
X5537 rr3t3r_0[58|12]/a_860_290# WL58 SL12 VSS sky130_fd_pr__nfet_g5v0d10v5 ad=0.65 pd=3.3 as=0 ps=0 w=1 l=0.5
X5538 BLP12 rr3t3r_0[59|12]/a_60_290# sky130_fd_pr_reram__reram_cell area_ox=0.0676
X5539 BLZ12 rr3t3r_0[59|12]/a_460_290# sky130_fd_pr_reram__reram_cell area_ox=0.0676
X5540 rr3t3r_0[59|12]/a_460_290# WL59 SL12 VSS sky130_fd_pr__nfet_g5v0d10v5 ad=0.65 pd=3.3 as=0 ps=0 w=1 l=0.5
X5541 BLN12 rr3t3r_0[59|12]/a_860_290# sky130_fd_pr_reram__reram_cell area_ox=0.0676
X5542 rr3t3r_0[59|12]/a_60_290# WL59 SL12 VSS sky130_fd_pr__nfet_g5v0d10v5 ad=0.65 pd=3.3 as=0 ps=0 w=1 l=0.5
X5543 rr3t3r_0[59|12]/a_860_290# WL59 SL12 VSS sky130_fd_pr__nfet_g5v0d10v5 ad=0.65 pd=3.3 as=0 ps=0 w=1 l=0.5
X5544 BLP12 rr3t3r_0[60|12]/a_60_290# sky130_fd_pr_reram__reram_cell area_ox=0.0676
X5545 BLZ12 rr3t3r_0[60|12]/a_460_290# sky130_fd_pr_reram__reram_cell area_ox=0.0676
X5546 rr3t3r_0[60|12]/a_460_290# WL60 SL12 VSS sky130_fd_pr__nfet_g5v0d10v5 ad=0.65 pd=3.3 as=0 ps=0 w=1 l=0.5
X5547 BLN12 rr3t3r_0[60|12]/a_860_290# sky130_fd_pr_reram__reram_cell area_ox=0.0676
X5548 rr3t3r_0[60|12]/a_60_290# WL60 SL12 VSS sky130_fd_pr__nfet_g5v0d10v5 ad=0.65 pd=3.3 as=0 ps=0 w=1 l=0.5
X5549 rr3t3r_0[60|12]/a_860_290# WL60 SL12 VSS sky130_fd_pr__nfet_g5v0d10v5 ad=0.65 pd=3.3 as=0 ps=0 w=1 l=0.5
X5550 BLP12 rr3t3r_0[61|12]/a_60_290# sky130_fd_pr_reram__reram_cell area_ox=0.0676
X5551 BLZ12 rr3t3r_0[61|12]/a_460_290# sky130_fd_pr_reram__reram_cell area_ox=0.0676
X5552 rr3t3r_0[61|12]/a_460_290# WL61 SL12 VSS sky130_fd_pr__nfet_g5v0d10v5 ad=0.65 pd=3.3 as=0 ps=0 w=1 l=0.5
X5553 BLN12 rr3t3r_0[61|12]/a_860_290# sky130_fd_pr_reram__reram_cell area_ox=0.0676
X5554 rr3t3r_0[61|12]/a_60_290# WL61 SL12 VSS sky130_fd_pr__nfet_g5v0d10v5 ad=0.65 pd=3.3 as=0 ps=0 w=1 l=0.5
X5555 rr3t3r_0[61|12]/a_860_290# WL61 SL12 VSS sky130_fd_pr__nfet_g5v0d10v5 ad=0.65 pd=3.3 as=0 ps=0 w=1 l=0.5
X5556 BLP12 rr3t3r_0[62|12]/a_60_290# sky130_fd_pr_reram__reram_cell area_ox=0.0676
X5557 BLZ12 rr3t3r_0[62|12]/a_460_290# sky130_fd_pr_reram__reram_cell area_ox=0.0676
X5558 rr3t3r_0[62|12]/a_460_290# WL62 SL12 VSS sky130_fd_pr__nfet_g5v0d10v5 ad=0.65 pd=3.3 as=0 ps=0 w=1 l=0.5
X5559 BLN12 rr3t3r_0[62|12]/a_860_290# sky130_fd_pr_reram__reram_cell area_ox=0.0676
X5560 rr3t3r_0[62|12]/a_60_290# WL62 SL12 VSS sky130_fd_pr__nfet_g5v0d10v5 ad=0.65 pd=3.3 as=0 ps=0 w=1 l=0.5
X5561 rr3t3r_0[62|12]/a_860_290# WL62 SL12 VSS sky130_fd_pr__nfet_g5v0d10v5 ad=0.65 pd=3.3 as=0 ps=0 w=1 l=0.5
X5562 BLP12 rr3t3r_0[63|12]/a_60_290# sky130_fd_pr_reram__reram_cell area_ox=0.0676
X5563 BLZ12 rr3t3r_0[63|12]/a_460_290# sky130_fd_pr_reram__reram_cell area_ox=0.0676
X5564 rr3t3r_0[63|12]/a_460_290# WL63 SL12 VSS sky130_fd_pr__nfet_g5v0d10v5 ad=0.65 pd=3.3 as=0 ps=0 w=1 l=0.5
X5565 BLN12 rr3t3r_0[63|12]/a_860_290# sky130_fd_pr_reram__reram_cell area_ox=0.0676
X5566 rr3t3r_0[63|12]/a_60_290# WL63 SL12 VSS sky130_fd_pr__nfet_g5v0d10v5 ad=0.65 pd=3.3 as=0 ps=0 w=1 l=0.5
X5567 rr3t3r_0[63|12]/a_860_290# WL63 SL12 VSS sky130_fd_pr__nfet_g5v0d10v5 ad=0.65 pd=3.3 as=0 ps=0 w=1 l=0.5
X5568 BLP12 rr3t3r_0[64|12]/a_60_290# sky130_fd_pr_reram__reram_cell area_ox=0.0676
X5569 BLZ12 rr3t3r_0[64|12]/a_460_290# sky130_fd_pr_reram__reram_cell area_ox=0.0676
X5570 rr3t3r_0[64|12]/a_460_290# WL64 SL12 VSS sky130_fd_pr__nfet_g5v0d10v5 ad=0.65 pd=3.3 as=0 ps=0 w=1 l=0.5
X5571 BLN12 rr3t3r_0[64|12]/a_860_290# sky130_fd_pr_reram__reram_cell area_ox=0.0676
X5572 rr3t3r_0[64|12]/a_60_290# WL64 SL12 VSS sky130_fd_pr__nfet_g5v0d10v5 ad=0.65 pd=3.3 as=0 ps=0 w=1 l=0.5
X5573 rr3t3r_0[64|12]/a_860_290# WL64 SL12 VSS sky130_fd_pr__nfet_g5v0d10v5 ad=0.65 pd=3.3 as=0 ps=0 w=1 l=0.5
X5574 BLP12 rr3t3r_0[65|12]/a_60_290# sky130_fd_pr_reram__reram_cell area_ox=0.0676
X5575 BLZ12 rr3t3r_0[65|12]/a_460_290# sky130_fd_pr_reram__reram_cell area_ox=0.0676
X5576 rr3t3r_0[65|12]/a_460_290# WL65 SL12 VSS sky130_fd_pr__nfet_g5v0d10v5 ad=0.65 pd=3.3 as=0 ps=0 w=1 l=0.5
X5577 BLN12 rr3t3r_0[65|12]/a_860_290# sky130_fd_pr_reram__reram_cell area_ox=0.0676
X5578 rr3t3r_0[65|12]/a_60_290# WL65 SL12 VSS sky130_fd_pr__nfet_g5v0d10v5 ad=0.65 pd=3.3 as=0 ps=0 w=1 l=0.5
X5579 rr3t3r_0[65|12]/a_860_290# WL65 SL12 VSS sky130_fd_pr__nfet_g5v0d10v5 ad=0.65 pd=3.3 as=0 ps=0 w=1 l=0.5
X5580 BLP12 rr3t3r_0[66|12]/a_60_290# sky130_fd_pr_reram__reram_cell area_ox=0.0676
X5581 BLZ12 rr3t3r_0[66|12]/a_460_290# sky130_fd_pr_reram__reram_cell area_ox=0.0676
X5582 rr3t3r_0[66|12]/a_460_290# WL66 SL12 VSS sky130_fd_pr__nfet_g5v0d10v5 ad=0.65 pd=3.3 as=0 ps=0 w=1 l=0.5
X5583 BLN12 rr3t3r_0[66|12]/a_860_290# sky130_fd_pr_reram__reram_cell area_ox=0.0676
X5584 rr3t3r_0[66|12]/a_60_290# WL66 SL12 VSS sky130_fd_pr__nfet_g5v0d10v5 ad=0.65 pd=3.3 as=0 ps=0 w=1 l=0.5
X5585 rr3t3r_0[66|12]/a_860_290# WL66 SL12 VSS sky130_fd_pr__nfet_g5v0d10v5 ad=0.65 pd=3.3 as=0 ps=0 w=1 l=0.5
X5586 BLP12 rr3t3r_0[67|12]/a_60_290# sky130_fd_pr_reram__reram_cell area_ox=0.0676
X5587 BLZ12 rr3t3r_0[67|12]/a_460_290# sky130_fd_pr_reram__reram_cell area_ox=0.0676
X5588 rr3t3r_0[67|12]/a_460_290# WL67 SL12 VSS sky130_fd_pr__nfet_g5v0d10v5 ad=0.65 pd=3.3 as=0 ps=0 w=1 l=0.5
X5589 BLN12 rr3t3r_0[67|12]/a_860_290# sky130_fd_pr_reram__reram_cell area_ox=0.0676
X5590 rr3t3r_0[67|12]/a_60_290# WL67 SL12 VSS sky130_fd_pr__nfet_g5v0d10v5 ad=0.65 pd=3.3 as=0 ps=0 w=1 l=0.5
X5591 rr3t3r_0[67|12]/a_860_290# WL67 SL12 VSS sky130_fd_pr__nfet_g5v0d10v5 ad=0.65 pd=3.3 as=0 ps=0 w=1 l=0.5
X5592 BLP12 rr3t3r_0[68|12]/a_60_290# sky130_fd_pr_reram__reram_cell area_ox=0.0676
X5593 BLZ12 rr3t3r_0[68|12]/a_460_290# sky130_fd_pr_reram__reram_cell area_ox=0.0676
X5594 rr3t3r_0[68|12]/a_460_290# WL68 SL12 VSS sky130_fd_pr__nfet_g5v0d10v5 ad=0.65 pd=3.3 as=0 ps=0 w=1 l=0.5
X5595 BLN12 rr3t3r_0[68|12]/a_860_290# sky130_fd_pr_reram__reram_cell area_ox=0.0676
X5596 rr3t3r_0[68|12]/a_60_290# WL68 SL12 VSS sky130_fd_pr__nfet_g5v0d10v5 ad=0.65 pd=3.3 as=0 ps=0 w=1 l=0.5
X5597 rr3t3r_0[68|12]/a_860_290# WL68 SL12 VSS sky130_fd_pr__nfet_g5v0d10v5 ad=0.65 pd=3.3 as=0 ps=0 w=1 l=0.5
X5598 BLP12 rr3t3r_0[69|12]/a_60_290# sky130_fd_pr_reram__reram_cell area_ox=0.0676
X5599 BLZ12 rr3t3r_0[69|12]/a_460_290# sky130_fd_pr_reram__reram_cell area_ox=0.0676
X5600 rr3t3r_0[69|12]/a_460_290# WL69 SL12 VSS sky130_fd_pr__nfet_g5v0d10v5 ad=0.65 pd=3.3 as=0 ps=0 w=1 l=0.5
X5601 BLN12 rr3t3r_0[69|12]/a_860_290# sky130_fd_pr_reram__reram_cell area_ox=0.0676
X5602 rr3t3r_0[69|12]/a_60_290# WL69 SL12 VSS sky130_fd_pr__nfet_g5v0d10v5 ad=0.65 pd=3.3 as=0 ps=0 w=1 l=0.5
X5603 rr3t3r_0[69|12]/a_860_290# WL69 SL12 VSS sky130_fd_pr__nfet_g5v0d10v5 ad=0.65 pd=3.3 as=0 ps=0 w=1 l=0.5
X5604 BLP12 rr3t3r_0[70|12]/a_60_290# sky130_fd_pr_reram__reram_cell area_ox=0.0676
X5605 BLZ12 rr3t3r_0[70|12]/a_460_290# sky130_fd_pr_reram__reram_cell area_ox=0.0676
X5606 rr3t3r_0[70|12]/a_460_290# WL70 SL12 VSS sky130_fd_pr__nfet_g5v0d10v5 ad=0.65 pd=3.3 as=0 ps=0 w=1 l=0.5
X5607 BLN12 rr3t3r_0[70|12]/a_860_290# sky130_fd_pr_reram__reram_cell area_ox=0.0676
X5608 rr3t3r_0[70|12]/a_60_290# WL70 SL12 VSS sky130_fd_pr__nfet_g5v0d10v5 ad=0.65 pd=3.3 as=0 ps=0 w=1 l=0.5
X5609 rr3t3r_0[70|12]/a_860_290# WL70 SL12 VSS sky130_fd_pr__nfet_g5v0d10v5 ad=0.65 pd=3.3 as=0 ps=0 w=1 l=0.5
X5610 BLP12 rr3t3r_0[71|12]/a_60_290# sky130_fd_pr_reram__reram_cell area_ox=0.0676
X5611 BLZ12 rr3t3r_0[71|12]/a_460_290# sky130_fd_pr_reram__reram_cell area_ox=0.0676
X5612 rr3t3r_0[71|12]/a_460_290# WL71 SL12 VSS sky130_fd_pr__nfet_g5v0d10v5 ad=0.65 pd=3.3 as=0 ps=0 w=1 l=0.5
X5613 BLN12 rr3t3r_0[71|12]/a_860_290# sky130_fd_pr_reram__reram_cell area_ox=0.0676
X5614 rr3t3r_0[71|12]/a_60_290# WL71 SL12 VSS sky130_fd_pr__nfet_g5v0d10v5 ad=0.65 pd=3.3 as=0 ps=0 w=1 l=0.5
X5615 rr3t3r_0[71|12]/a_860_290# WL71 SL12 VSS sky130_fd_pr__nfet_g5v0d10v5 ad=0.65 pd=3.3 as=0 ps=0 w=1 l=0.5
X5616 BLP13 rr3t3r_0[0|13]/a_60_290# sky130_fd_pr_reram__reram_cell area_ox=0.0676
X5617 BLZ13 rr3t3r_0[0|13]/a_460_290# sky130_fd_pr_reram__reram_cell area_ox=0.0676
X5618 rr3t3r_0[0|13]/a_460_290# WL0 SL13 VSS sky130_fd_pr__nfet_g5v0d10v5 ad=0.65 pd=3.3 as=162 ps=756 w=1 l=0.5
X5619 BLN13 rr3t3r_0[0|13]/a_860_290# sky130_fd_pr_reram__reram_cell area_ox=0.0676
X5620 rr3t3r_0[0|13]/a_60_290# WL0 SL13 VSS sky130_fd_pr__nfet_g5v0d10v5 ad=0.65 pd=3.3 as=0 ps=0 w=1 l=0.5
X5621 rr3t3r_0[0|13]/a_860_290# WL0 SL13 VSS sky130_fd_pr__nfet_g5v0d10v5 ad=0.65 pd=3.3 as=0 ps=0 w=1 l=0.5
X5622 BLP13 rr3t3r_0[1|13]/a_60_290# sky130_fd_pr_reram__reram_cell area_ox=0.0676
X5623 BLZ13 rr3t3r_0[1|13]/a_460_290# sky130_fd_pr_reram__reram_cell area_ox=0.0676
X5624 rr3t3r_0[1|13]/a_460_290# WL1 SL13 VSS sky130_fd_pr__nfet_g5v0d10v5 ad=0.65 pd=3.3 as=0 ps=0 w=1 l=0.5
X5625 BLN13 rr3t3r_0[1|13]/a_860_290# sky130_fd_pr_reram__reram_cell area_ox=0.0676
X5626 rr3t3r_0[1|13]/a_60_290# WL1 SL13 VSS sky130_fd_pr__nfet_g5v0d10v5 ad=0.65 pd=3.3 as=0 ps=0 w=1 l=0.5
X5627 rr3t3r_0[1|13]/a_860_290# WL1 SL13 VSS sky130_fd_pr__nfet_g5v0d10v5 ad=0.65 pd=3.3 as=0 ps=0 w=1 l=0.5
X5628 BLP13 rr3t3r_0[2|13]/a_60_290# sky130_fd_pr_reram__reram_cell area_ox=0.0676
X5629 BLZ13 rr3t3r_0[2|13]/a_460_290# sky130_fd_pr_reram__reram_cell area_ox=0.0676
X5630 rr3t3r_0[2|13]/a_460_290# WL2 SL13 VSS sky130_fd_pr__nfet_g5v0d10v5 ad=0.65 pd=3.3 as=0 ps=0 w=1 l=0.5
X5631 BLN13 rr3t3r_0[2|13]/a_860_290# sky130_fd_pr_reram__reram_cell area_ox=0.0676
X5632 rr3t3r_0[2|13]/a_60_290# WL2 SL13 VSS sky130_fd_pr__nfet_g5v0d10v5 ad=0.65 pd=3.3 as=0 ps=0 w=1 l=0.5
X5633 rr3t3r_0[2|13]/a_860_290# WL2 SL13 VSS sky130_fd_pr__nfet_g5v0d10v5 ad=0.65 pd=3.3 as=0 ps=0 w=1 l=0.5
X5634 BLP13 rr3t3r_0[3|13]/a_60_290# sky130_fd_pr_reram__reram_cell area_ox=0.0676
X5635 BLZ13 rr3t3r_0[3|13]/a_460_290# sky130_fd_pr_reram__reram_cell area_ox=0.0676
X5636 rr3t3r_0[3|13]/a_460_290# WL3 SL13 VSS sky130_fd_pr__nfet_g5v0d10v5 ad=0.65 pd=3.3 as=0 ps=0 w=1 l=0.5
X5637 BLN13 rr3t3r_0[3|13]/a_860_290# sky130_fd_pr_reram__reram_cell area_ox=0.0676
X5638 rr3t3r_0[3|13]/a_60_290# WL3 SL13 VSS sky130_fd_pr__nfet_g5v0d10v5 ad=0.65 pd=3.3 as=0 ps=0 w=1 l=0.5
X5639 rr3t3r_0[3|13]/a_860_290# WL3 SL13 VSS sky130_fd_pr__nfet_g5v0d10v5 ad=0.65 pd=3.3 as=0 ps=0 w=1 l=0.5
X5640 BLP13 rr3t3r_0[4|13]/a_60_290# sky130_fd_pr_reram__reram_cell area_ox=0.0676
X5641 BLZ13 rr3t3r_0[4|13]/a_460_290# sky130_fd_pr_reram__reram_cell area_ox=0.0676
X5642 rr3t3r_0[4|13]/a_460_290# WL4 SL13 VSS sky130_fd_pr__nfet_g5v0d10v5 ad=0.65 pd=3.3 as=0 ps=0 w=1 l=0.5
X5643 BLN13 rr3t3r_0[4|13]/a_860_290# sky130_fd_pr_reram__reram_cell area_ox=0.0676
X5644 rr3t3r_0[4|13]/a_60_290# WL4 SL13 VSS sky130_fd_pr__nfet_g5v0d10v5 ad=0.65 pd=3.3 as=0 ps=0 w=1 l=0.5
X5645 rr3t3r_0[4|13]/a_860_290# WL4 SL13 VSS sky130_fd_pr__nfet_g5v0d10v5 ad=0.65 pd=3.3 as=0 ps=0 w=1 l=0.5
X5646 BLP13 rr3t3r_0[5|13]/a_60_290# sky130_fd_pr_reram__reram_cell area_ox=0.0676
X5647 BLZ13 rr3t3r_0[5|13]/a_460_290# sky130_fd_pr_reram__reram_cell area_ox=0.0676
X5648 rr3t3r_0[5|13]/a_460_290# WL5 SL13 VSS sky130_fd_pr__nfet_g5v0d10v5 ad=0.65 pd=3.3 as=0 ps=0 w=1 l=0.5
X5649 BLN13 rr3t3r_0[5|13]/a_860_290# sky130_fd_pr_reram__reram_cell area_ox=0.0676
X5650 rr3t3r_0[5|13]/a_60_290# WL5 SL13 VSS sky130_fd_pr__nfet_g5v0d10v5 ad=0.65 pd=3.3 as=0 ps=0 w=1 l=0.5
X5651 rr3t3r_0[5|13]/a_860_290# WL5 SL13 VSS sky130_fd_pr__nfet_g5v0d10v5 ad=0.65 pd=3.3 as=0 ps=0 w=1 l=0.5
X5652 BLP13 rr3t3r_0[6|13]/a_60_290# sky130_fd_pr_reram__reram_cell area_ox=0.0676
X5653 BLZ13 rr3t3r_0[6|13]/a_460_290# sky130_fd_pr_reram__reram_cell area_ox=0.0676
X5654 rr3t3r_0[6|13]/a_460_290# WL6 SL13 VSS sky130_fd_pr__nfet_g5v0d10v5 ad=0.65 pd=3.3 as=0 ps=0 w=1 l=0.5
X5655 BLN13 rr3t3r_0[6|13]/a_860_290# sky130_fd_pr_reram__reram_cell area_ox=0.0676
X5656 rr3t3r_0[6|13]/a_60_290# WL6 SL13 VSS sky130_fd_pr__nfet_g5v0d10v5 ad=0.65 pd=3.3 as=0 ps=0 w=1 l=0.5
X5657 rr3t3r_0[6|13]/a_860_290# WL6 SL13 VSS sky130_fd_pr__nfet_g5v0d10v5 ad=0.65 pd=3.3 as=0 ps=0 w=1 l=0.5
X5658 BLP13 rr3t3r_0[7|13]/a_60_290# sky130_fd_pr_reram__reram_cell area_ox=0.0676
X5659 BLZ13 rr3t3r_0[7|13]/a_460_290# sky130_fd_pr_reram__reram_cell area_ox=0.0676
X5660 rr3t3r_0[7|13]/a_460_290# WL7 SL13 VSS sky130_fd_pr__nfet_g5v0d10v5 ad=0.65 pd=3.3 as=0 ps=0 w=1 l=0.5
X5661 BLN13 rr3t3r_0[7|13]/a_860_290# sky130_fd_pr_reram__reram_cell area_ox=0.0676
X5662 rr3t3r_0[7|13]/a_60_290# WL7 SL13 VSS sky130_fd_pr__nfet_g5v0d10v5 ad=0.65 pd=3.3 as=0 ps=0 w=1 l=0.5
X5663 rr3t3r_0[7|13]/a_860_290# WL7 SL13 VSS sky130_fd_pr__nfet_g5v0d10v5 ad=0.65 pd=3.3 as=0 ps=0 w=1 l=0.5
X5664 BLP13 rr3t3r_0[8|13]/a_60_290# sky130_fd_pr_reram__reram_cell area_ox=0.0676
X5665 BLZ13 rr3t3r_0[8|13]/a_460_290# sky130_fd_pr_reram__reram_cell area_ox=0.0676
X5666 rr3t3r_0[8|13]/a_460_290# WL8 SL13 VSS sky130_fd_pr__nfet_g5v0d10v5 ad=0.65 pd=3.3 as=0 ps=0 w=1 l=0.5
X5667 BLN13 rr3t3r_0[8|13]/a_860_290# sky130_fd_pr_reram__reram_cell area_ox=0.0676
X5668 rr3t3r_0[8|13]/a_60_290# WL8 SL13 VSS sky130_fd_pr__nfet_g5v0d10v5 ad=0.65 pd=3.3 as=0 ps=0 w=1 l=0.5
X5669 rr3t3r_0[8|13]/a_860_290# WL8 SL13 VSS sky130_fd_pr__nfet_g5v0d10v5 ad=0.65 pd=3.3 as=0 ps=0 w=1 l=0.5
X5670 BLP13 rr3t3r_0[9|13]/a_60_290# sky130_fd_pr_reram__reram_cell area_ox=0.0676
X5671 BLZ13 rr3t3r_0[9|13]/a_460_290# sky130_fd_pr_reram__reram_cell area_ox=0.0676
X5672 rr3t3r_0[9|13]/a_460_290# WL9 SL13 VSS sky130_fd_pr__nfet_g5v0d10v5 ad=0.65 pd=3.3 as=0 ps=0 w=1 l=0.5
X5673 BLN13 rr3t3r_0[9|13]/a_860_290# sky130_fd_pr_reram__reram_cell area_ox=0.0676
X5674 rr3t3r_0[9|13]/a_60_290# WL9 SL13 VSS sky130_fd_pr__nfet_g5v0d10v5 ad=0.65 pd=3.3 as=0 ps=0 w=1 l=0.5
X5675 rr3t3r_0[9|13]/a_860_290# WL9 SL13 VSS sky130_fd_pr__nfet_g5v0d10v5 ad=0.65 pd=3.3 as=0 ps=0 w=1 l=0.5
X5676 BLP13 rr3t3r_0[10|13]/a_60_290# sky130_fd_pr_reram__reram_cell area_ox=0.0676
X5677 BLZ13 rr3t3r_0[10|13]/a_460_290# sky130_fd_pr_reram__reram_cell area_ox=0.0676
X5678 rr3t3r_0[10|13]/a_460_290# WL10 SL13 VSS sky130_fd_pr__nfet_g5v0d10v5 ad=0.65 pd=3.3 as=0 ps=0 w=1 l=0.5
X5679 BLN13 rr3t3r_0[10|13]/a_860_290# sky130_fd_pr_reram__reram_cell area_ox=0.0676
X5680 rr3t3r_0[10|13]/a_60_290# WL10 SL13 VSS sky130_fd_pr__nfet_g5v0d10v5 ad=0.65 pd=3.3 as=0 ps=0 w=1 l=0.5
X5681 rr3t3r_0[10|13]/a_860_290# WL10 SL13 VSS sky130_fd_pr__nfet_g5v0d10v5 ad=0.65 pd=3.3 as=0 ps=0 w=1 l=0.5
X5682 BLP13 rr3t3r_0[11|13]/a_60_290# sky130_fd_pr_reram__reram_cell area_ox=0.0676
X5683 BLZ13 rr3t3r_0[11|13]/a_460_290# sky130_fd_pr_reram__reram_cell area_ox=0.0676
X5684 rr3t3r_0[11|13]/a_460_290# WL11 SL13 VSS sky130_fd_pr__nfet_g5v0d10v5 ad=0.65 pd=3.3 as=0 ps=0 w=1 l=0.5
X5685 BLN13 rr3t3r_0[11|13]/a_860_290# sky130_fd_pr_reram__reram_cell area_ox=0.0676
X5686 rr3t3r_0[11|13]/a_60_290# WL11 SL13 VSS sky130_fd_pr__nfet_g5v0d10v5 ad=0.65 pd=3.3 as=0 ps=0 w=1 l=0.5
X5687 rr3t3r_0[11|13]/a_860_290# WL11 SL13 VSS sky130_fd_pr__nfet_g5v0d10v5 ad=0.65 pd=3.3 as=0 ps=0 w=1 l=0.5
X5688 BLP13 rr3t3r_0[12|13]/a_60_290# sky130_fd_pr_reram__reram_cell area_ox=0.0676
X5689 BLZ13 rr3t3r_0[12|13]/a_460_290# sky130_fd_pr_reram__reram_cell area_ox=0.0676
X5690 rr3t3r_0[12|13]/a_460_290# WL12 SL13 VSS sky130_fd_pr__nfet_g5v0d10v5 ad=0.65 pd=3.3 as=0 ps=0 w=1 l=0.5
X5691 BLN13 rr3t3r_0[12|13]/a_860_290# sky130_fd_pr_reram__reram_cell area_ox=0.0676
X5692 rr3t3r_0[12|13]/a_60_290# WL12 SL13 VSS sky130_fd_pr__nfet_g5v0d10v5 ad=0.65 pd=3.3 as=0 ps=0 w=1 l=0.5
X5693 rr3t3r_0[12|13]/a_860_290# WL12 SL13 VSS sky130_fd_pr__nfet_g5v0d10v5 ad=0.65 pd=3.3 as=0 ps=0 w=1 l=0.5
X5694 BLP13 rr3t3r_0[13|13]/a_60_290# sky130_fd_pr_reram__reram_cell area_ox=0.0676
X5695 BLZ13 rr3t3r_0[13|13]/a_460_290# sky130_fd_pr_reram__reram_cell area_ox=0.0676
X5696 rr3t3r_0[13|13]/a_460_290# WL13 SL13 VSS sky130_fd_pr__nfet_g5v0d10v5 ad=0.65 pd=3.3 as=0 ps=0 w=1 l=0.5
X5697 BLN13 rr3t3r_0[13|13]/a_860_290# sky130_fd_pr_reram__reram_cell area_ox=0.0676
X5698 rr3t3r_0[13|13]/a_60_290# WL13 SL13 VSS sky130_fd_pr__nfet_g5v0d10v5 ad=0.65 pd=3.3 as=0 ps=0 w=1 l=0.5
X5699 rr3t3r_0[13|13]/a_860_290# WL13 SL13 VSS sky130_fd_pr__nfet_g5v0d10v5 ad=0.65 pd=3.3 as=0 ps=0 w=1 l=0.5
X5700 BLP13 rr3t3r_0[14|13]/a_60_290# sky130_fd_pr_reram__reram_cell area_ox=0.0676
X5701 BLZ13 rr3t3r_0[14|13]/a_460_290# sky130_fd_pr_reram__reram_cell area_ox=0.0676
X5702 rr3t3r_0[14|13]/a_460_290# WL14 SL13 VSS sky130_fd_pr__nfet_g5v0d10v5 ad=0.65 pd=3.3 as=0 ps=0 w=1 l=0.5
X5703 BLN13 rr3t3r_0[14|13]/a_860_290# sky130_fd_pr_reram__reram_cell area_ox=0.0676
X5704 rr3t3r_0[14|13]/a_60_290# WL14 SL13 VSS sky130_fd_pr__nfet_g5v0d10v5 ad=0.65 pd=3.3 as=0 ps=0 w=1 l=0.5
X5705 rr3t3r_0[14|13]/a_860_290# WL14 SL13 VSS sky130_fd_pr__nfet_g5v0d10v5 ad=0.65 pd=3.3 as=0 ps=0 w=1 l=0.5
X5706 BLP13 rr3t3r_0[15|13]/a_60_290# sky130_fd_pr_reram__reram_cell area_ox=0.0676
X5707 BLZ13 rr3t3r_0[15|13]/a_460_290# sky130_fd_pr_reram__reram_cell area_ox=0.0676
X5708 rr3t3r_0[15|13]/a_460_290# WL15 SL13 VSS sky130_fd_pr__nfet_g5v0d10v5 ad=0.65 pd=3.3 as=0 ps=0 w=1 l=0.5
X5709 BLN13 rr3t3r_0[15|13]/a_860_290# sky130_fd_pr_reram__reram_cell area_ox=0.0676
X5710 rr3t3r_0[15|13]/a_60_290# WL15 SL13 VSS sky130_fd_pr__nfet_g5v0d10v5 ad=0.65 pd=3.3 as=0 ps=0 w=1 l=0.5
X5711 rr3t3r_0[15|13]/a_860_290# WL15 SL13 VSS sky130_fd_pr__nfet_g5v0d10v5 ad=0.65 pd=3.3 as=0 ps=0 w=1 l=0.5
X5712 BLP13 rr3t3r_0[16|13]/a_60_290# sky130_fd_pr_reram__reram_cell area_ox=0.0676
X5713 BLZ13 rr3t3r_0[16|13]/a_460_290# sky130_fd_pr_reram__reram_cell area_ox=0.0676
X5714 rr3t3r_0[16|13]/a_460_290# WL16 SL13 VSS sky130_fd_pr__nfet_g5v0d10v5 ad=0.65 pd=3.3 as=0 ps=0 w=1 l=0.5
X5715 BLN13 rr3t3r_0[16|13]/a_860_290# sky130_fd_pr_reram__reram_cell area_ox=0.0676
X5716 rr3t3r_0[16|13]/a_60_290# WL16 SL13 VSS sky130_fd_pr__nfet_g5v0d10v5 ad=0.65 pd=3.3 as=0 ps=0 w=1 l=0.5
X5717 rr3t3r_0[16|13]/a_860_290# WL16 SL13 VSS sky130_fd_pr__nfet_g5v0d10v5 ad=0.65 pd=3.3 as=0 ps=0 w=1 l=0.5
X5718 BLP13 rr3t3r_0[17|13]/a_60_290# sky130_fd_pr_reram__reram_cell area_ox=0.0676
X5719 BLZ13 rr3t3r_0[17|13]/a_460_290# sky130_fd_pr_reram__reram_cell area_ox=0.0676
X5720 rr3t3r_0[17|13]/a_460_290# WL17 SL13 VSS sky130_fd_pr__nfet_g5v0d10v5 ad=0.65 pd=3.3 as=0 ps=0 w=1 l=0.5
X5721 BLN13 rr3t3r_0[17|13]/a_860_290# sky130_fd_pr_reram__reram_cell area_ox=0.0676
X5722 rr3t3r_0[17|13]/a_60_290# WL17 SL13 VSS sky130_fd_pr__nfet_g5v0d10v5 ad=0.65 pd=3.3 as=0 ps=0 w=1 l=0.5
X5723 rr3t3r_0[17|13]/a_860_290# WL17 SL13 VSS sky130_fd_pr__nfet_g5v0d10v5 ad=0.65 pd=3.3 as=0 ps=0 w=1 l=0.5
X5724 BLP13 rr3t3r_0[18|13]/a_60_290# sky130_fd_pr_reram__reram_cell area_ox=0.0676
X5725 BLZ13 rr3t3r_0[18|13]/a_460_290# sky130_fd_pr_reram__reram_cell area_ox=0.0676
X5726 rr3t3r_0[18|13]/a_460_290# WL18 SL13 VSS sky130_fd_pr__nfet_g5v0d10v5 ad=0.65 pd=3.3 as=0 ps=0 w=1 l=0.5
X5727 BLN13 rr3t3r_0[18|13]/a_860_290# sky130_fd_pr_reram__reram_cell area_ox=0.0676
X5728 rr3t3r_0[18|13]/a_60_290# WL18 SL13 VSS sky130_fd_pr__nfet_g5v0d10v5 ad=0.65 pd=3.3 as=0 ps=0 w=1 l=0.5
X5729 rr3t3r_0[18|13]/a_860_290# WL18 SL13 VSS sky130_fd_pr__nfet_g5v0d10v5 ad=0.65 pd=3.3 as=0 ps=0 w=1 l=0.5
X5730 BLP13 rr3t3r_0[19|13]/a_60_290# sky130_fd_pr_reram__reram_cell area_ox=0.0676
X5731 BLZ13 rr3t3r_0[19|13]/a_460_290# sky130_fd_pr_reram__reram_cell area_ox=0.0676
X5732 rr3t3r_0[19|13]/a_460_290# WL19 SL13 VSS sky130_fd_pr__nfet_g5v0d10v5 ad=0.65 pd=3.3 as=0 ps=0 w=1 l=0.5
X5733 BLN13 rr3t3r_0[19|13]/a_860_290# sky130_fd_pr_reram__reram_cell area_ox=0.0676
X5734 rr3t3r_0[19|13]/a_60_290# WL19 SL13 VSS sky130_fd_pr__nfet_g5v0d10v5 ad=0.65 pd=3.3 as=0 ps=0 w=1 l=0.5
X5735 rr3t3r_0[19|13]/a_860_290# WL19 SL13 VSS sky130_fd_pr__nfet_g5v0d10v5 ad=0.65 pd=3.3 as=0 ps=0 w=1 l=0.5
X5736 BLP13 rr3t3r_0[20|13]/a_60_290# sky130_fd_pr_reram__reram_cell area_ox=0.0676
X5737 BLZ13 rr3t3r_0[20|13]/a_460_290# sky130_fd_pr_reram__reram_cell area_ox=0.0676
X5738 rr3t3r_0[20|13]/a_460_290# WL20 SL13 VSS sky130_fd_pr__nfet_g5v0d10v5 ad=0.65 pd=3.3 as=0 ps=0 w=1 l=0.5
X5739 BLN13 rr3t3r_0[20|13]/a_860_290# sky130_fd_pr_reram__reram_cell area_ox=0.0676
X5740 rr3t3r_0[20|13]/a_60_290# WL20 SL13 VSS sky130_fd_pr__nfet_g5v0d10v5 ad=0.65 pd=3.3 as=0 ps=0 w=1 l=0.5
X5741 rr3t3r_0[20|13]/a_860_290# WL20 SL13 VSS sky130_fd_pr__nfet_g5v0d10v5 ad=0.65 pd=3.3 as=0 ps=0 w=1 l=0.5
X5742 BLP13 rr3t3r_0[21|13]/a_60_290# sky130_fd_pr_reram__reram_cell area_ox=0.0676
X5743 BLZ13 rr3t3r_0[21|13]/a_460_290# sky130_fd_pr_reram__reram_cell area_ox=0.0676
X5744 rr3t3r_0[21|13]/a_460_290# WL21 SL13 VSS sky130_fd_pr__nfet_g5v0d10v5 ad=0.65 pd=3.3 as=0 ps=0 w=1 l=0.5
X5745 BLN13 rr3t3r_0[21|13]/a_860_290# sky130_fd_pr_reram__reram_cell area_ox=0.0676
X5746 rr3t3r_0[21|13]/a_60_290# WL21 SL13 VSS sky130_fd_pr__nfet_g5v0d10v5 ad=0.65 pd=3.3 as=0 ps=0 w=1 l=0.5
X5747 rr3t3r_0[21|13]/a_860_290# WL21 SL13 VSS sky130_fd_pr__nfet_g5v0d10v5 ad=0.65 pd=3.3 as=0 ps=0 w=1 l=0.5
X5748 BLP13 rr3t3r_0[22|13]/a_60_290# sky130_fd_pr_reram__reram_cell area_ox=0.0676
X5749 BLZ13 rr3t3r_0[22|13]/a_460_290# sky130_fd_pr_reram__reram_cell area_ox=0.0676
X5750 rr3t3r_0[22|13]/a_460_290# WL22 SL13 VSS sky130_fd_pr__nfet_g5v0d10v5 ad=0.65 pd=3.3 as=0 ps=0 w=1 l=0.5
X5751 BLN13 rr3t3r_0[22|13]/a_860_290# sky130_fd_pr_reram__reram_cell area_ox=0.0676
X5752 rr3t3r_0[22|13]/a_60_290# WL22 SL13 VSS sky130_fd_pr__nfet_g5v0d10v5 ad=0.65 pd=3.3 as=0 ps=0 w=1 l=0.5
X5753 rr3t3r_0[22|13]/a_860_290# WL22 SL13 VSS sky130_fd_pr__nfet_g5v0d10v5 ad=0.65 pd=3.3 as=0 ps=0 w=1 l=0.5
X5754 BLP13 rr3t3r_0[23|13]/a_60_290# sky130_fd_pr_reram__reram_cell area_ox=0.0676
X5755 BLZ13 rr3t3r_0[23|13]/a_460_290# sky130_fd_pr_reram__reram_cell area_ox=0.0676
X5756 rr3t3r_0[23|13]/a_460_290# WL23 SL13 VSS sky130_fd_pr__nfet_g5v0d10v5 ad=0.65 pd=3.3 as=0 ps=0 w=1 l=0.5
X5757 BLN13 rr3t3r_0[23|13]/a_860_290# sky130_fd_pr_reram__reram_cell area_ox=0.0676
X5758 rr3t3r_0[23|13]/a_60_290# WL23 SL13 VSS sky130_fd_pr__nfet_g5v0d10v5 ad=0.65 pd=3.3 as=0 ps=0 w=1 l=0.5
X5759 rr3t3r_0[23|13]/a_860_290# WL23 SL13 VSS sky130_fd_pr__nfet_g5v0d10v5 ad=0.65 pd=3.3 as=0 ps=0 w=1 l=0.5
X5760 BLP13 rr3t3r_0[24|13]/a_60_290# sky130_fd_pr_reram__reram_cell area_ox=0.0676
X5761 BLZ13 rr3t3r_0[24|13]/a_460_290# sky130_fd_pr_reram__reram_cell area_ox=0.0676
X5762 rr3t3r_0[24|13]/a_460_290# WL24 SL13 VSS sky130_fd_pr__nfet_g5v0d10v5 ad=0.65 pd=3.3 as=0 ps=0 w=1 l=0.5
X5763 BLN13 rr3t3r_0[24|13]/a_860_290# sky130_fd_pr_reram__reram_cell area_ox=0.0676
X5764 rr3t3r_0[24|13]/a_60_290# WL24 SL13 VSS sky130_fd_pr__nfet_g5v0d10v5 ad=0.65 pd=3.3 as=0 ps=0 w=1 l=0.5
X5765 rr3t3r_0[24|13]/a_860_290# WL24 SL13 VSS sky130_fd_pr__nfet_g5v0d10v5 ad=0.65 pd=3.3 as=0 ps=0 w=1 l=0.5
X5766 BLP13 rr3t3r_0[25|13]/a_60_290# sky130_fd_pr_reram__reram_cell area_ox=0.0676
X5767 BLZ13 rr3t3r_0[25|13]/a_460_290# sky130_fd_pr_reram__reram_cell area_ox=0.0676
X5768 rr3t3r_0[25|13]/a_460_290# WL25 SL13 VSS sky130_fd_pr__nfet_g5v0d10v5 ad=0.65 pd=3.3 as=0 ps=0 w=1 l=0.5
X5769 BLN13 rr3t3r_0[25|13]/a_860_290# sky130_fd_pr_reram__reram_cell area_ox=0.0676
X5770 rr3t3r_0[25|13]/a_60_290# WL25 SL13 VSS sky130_fd_pr__nfet_g5v0d10v5 ad=0.65 pd=3.3 as=0 ps=0 w=1 l=0.5
X5771 rr3t3r_0[25|13]/a_860_290# WL25 SL13 VSS sky130_fd_pr__nfet_g5v0d10v5 ad=0.65 pd=3.3 as=0 ps=0 w=1 l=0.5
X5772 BLP13 rr3t3r_0[26|13]/a_60_290# sky130_fd_pr_reram__reram_cell area_ox=0.0676
X5773 BLZ13 rr3t3r_0[26|13]/a_460_290# sky130_fd_pr_reram__reram_cell area_ox=0.0676
X5774 rr3t3r_0[26|13]/a_460_290# WL26 SL13 VSS sky130_fd_pr__nfet_g5v0d10v5 ad=0.65 pd=3.3 as=0 ps=0 w=1 l=0.5
X5775 BLN13 rr3t3r_0[26|13]/a_860_290# sky130_fd_pr_reram__reram_cell area_ox=0.0676
X5776 rr3t3r_0[26|13]/a_60_290# WL26 SL13 VSS sky130_fd_pr__nfet_g5v0d10v5 ad=0.65 pd=3.3 as=0 ps=0 w=1 l=0.5
X5777 rr3t3r_0[26|13]/a_860_290# WL26 SL13 VSS sky130_fd_pr__nfet_g5v0d10v5 ad=0.65 pd=3.3 as=0 ps=0 w=1 l=0.5
X5778 BLP13 rr3t3r_0[27|13]/a_60_290# sky130_fd_pr_reram__reram_cell area_ox=0.0676
X5779 BLZ13 rr3t3r_0[27|13]/a_460_290# sky130_fd_pr_reram__reram_cell area_ox=0.0676
X5780 rr3t3r_0[27|13]/a_460_290# WL27 SL13 VSS sky130_fd_pr__nfet_g5v0d10v5 ad=0.65 pd=3.3 as=0 ps=0 w=1 l=0.5
X5781 BLN13 rr3t3r_0[27|13]/a_860_290# sky130_fd_pr_reram__reram_cell area_ox=0.0676
X5782 rr3t3r_0[27|13]/a_60_290# WL27 SL13 VSS sky130_fd_pr__nfet_g5v0d10v5 ad=0.65 pd=3.3 as=0 ps=0 w=1 l=0.5
X5783 rr3t3r_0[27|13]/a_860_290# WL27 SL13 VSS sky130_fd_pr__nfet_g5v0d10v5 ad=0.65 pd=3.3 as=0 ps=0 w=1 l=0.5
X5784 BLP13 rr3t3r_0[28|13]/a_60_290# sky130_fd_pr_reram__reram_cell area_ox=0.0676
X5785 BLZ13 rr3t3r_0[28|13]/a_460_290# sky130_fd_pr_reram__reram_cell area_ox=0.0676
X5786 rr3t3r_0[28|13]/a_460_290# WL28 SL13 VSS sky130_fd_pr__nfet_g5v0d10v5 ad=0.65 pd=3.3 as=0 ps=0 w=1 l=0.5
X5787 BLN13 rr3t3r_0[28|13]/a_860_290# sky130_fd_pr_reram__reram_cell area_ox=0.0676
X5788 rr3t3r_0[28|13]/a_60_290# WL28 SL13 VSS sky130_fd_pr__nfet_g5v0d10v5 ad=0.65 pd=3.3 as=0 ps=0 w=1 l=0.5
X5789 rr3t3r_0[28|13]/a_860_290# WL28 SL13 VSS sky130_fd_pr__nfet_g5v0d10v5 ad=0.65 pd=3.3 as=0 ps=0 w=1 l=0.5
X5790 BLP13 rr3t3r_0[29|13]/a_60_290# sky130_fd_pr_reram__reram_cell area_ox=0.0676
X5791 BLZ13 rr3t3r_0[29|13]/a_460_290# sky130_fd_pr_reram__reram_cell area_ox=0.0676
X5792 rr3t3r_0[29|13]/a_460_290# WL29 SL13 VSS sky130_fd_pr__nfet_g5v0d10v5 ad=0.65 pd=3.3 as=0 ps=0 w=1 l=0.5
X5793 BLN13 rr3t3r_0[29|13]/a_860_290# sky130_fd_pr_reram__reram_cell area_ox=0.0676
X5794 rr3t3r_0[29|13]/a_60_290# WL29 SL13 VSS sky130_fd_pr__nfet_g5v0d10v5 ad=0.65 pd=3.3 as=0 ps=0 w=1 l=0.5
X5795 rr3t3r_0[29|13]/a_860_290# WL29 SL13 VSS sky130_fd_pr__nfet_g5v0d10v5 ad=0.65 pd=3.3 as=0 ps=0 w=1 l=0.5
X5796 BLP13 rr3t3r_0[30|13]/a_60_290# sky130_fd_pr_reram__reram_cell area_ox=0.0676
X5797 BLZ13 rr3t3r_0[30|13]/a_460_290# sky130_fd_pr_reram__reram_cell area_ox=0.0676
X5798 rr3t3r_0[30|13]/a_460_290# WL30 SL13 VSS sky130_fd_pr__nfet_g5v0d10v5 ad=0.65 pd=3.3 as=0 ps=0 w=1 l=0.5
X5799 BLN13 rr3t3r_0[30|13]/a_860_290# sky130_fd_pr_reram__reram_cell area_ox=0.0676
X5800 rr3t3r_0[30|13]/a_60_290# WL30 SL13 VSS sky130_fd_pr__nfet_g5v0d10v5 ad=0.65 pd=3.3 as=0 ps=0 w=1 l=0.5
X5801 rr3t3r_0[30|13]/a_860_290# WL30 SL13 VSS sky130_fd_pr__nfet_g5v0d10v5 ad=0.65 pd=3.3 as=0 ps=0 w=1 l=0.5
X5802 BLP13 rr3t3r_0[31|13]/a_60_290# sky130_fd_pr_reram__reram_cell area_ox=0.0676
X5803 BLZ13 rr3t3r_0[31|13]/a_460_290# sky130_fd_pr_reram__reram_cell area_ox=0.0676
X5804 rr3t3r_0[31|13]/a_460_290# WL31 SL13 VSS sky130_fd_pr__nfet_g5v0d10v5 ad=0.65 pd=3.3 as=0 ps=0 w=1 l=0.5
X5805 BLN13 rr3t3r_0[31|13]/a_860_290# sky130_fd_pr_reram__reram_cell area_ox=0.0676
X5806 rr3t3r_0[31|13]/a_60_290# WL31 SL13 VSS sky130_fd_pr__nfet_g5v0d10v5 ad=0.65 pd=3.3 as=0 ps=0 w=1 l=0.5
X5807 rr3t3r_0[31|13]/a_860_290# WL31 SL13 VSS sky130_fd_pr__nfet_g5v0d10v5 ad=0.65 pd=3.3 as=0 ps=0 w=1 l=0.5
X5808 BLP13 rr3t3r_0[32|13]/a_60_290# sky130_fd_pr_reram__reram_cell area_ox=0.0676
X5809 BLZ13 rr3t3r_0[32|13]/a_460_290# sky130_fd_pr_reram__reram_cell area_ox=0.0676
X5810 rr3t3r_0[32|13]/a_460_290# WL32 SL13 VSS sky130_fd_pr__nfet_g5v0d10v5 ad=0.65 pd=3.3 as=0 ps=0 w=1 l=0.5
X5811 BLN13 rr3t3r_0[32|13]/a_860_290# sky130_fd_pr_reram__reram_cell area_ox=0.0676
X5812 rr3t3r_0[32|13]/a_60_290# WL32 SL13 VSS sky130_fd_pr__nfet_g5v0d10v5 ad=0.65 pd=3.3 as=0 ps=0 w=1 l=0.5
X5813 rr3t3r_0[32|13]/a_860_290# WL32 SL13 VSS sky130_fd_pr__nfet_g5v0d10v5 ad=0.65 pd=3.3 as=0 ps=0 w=1 l=0.5
X5814 BLP13 rr3t3r_0[33|13]/a_60_290# sky130_fd_pr_reram__reram_cell area_ox=0.0676
X5815 BLZ13 rr3t3r_0[33|13]/a_460_290# sky130_fd_pr_reram__reram_cell area_ox=0.0676
X5816 rr3t3r_0[33|13]/a_460_290# WL33 SL13 VSS sky130_fd_pr__nfet_g5v0d10v5 ad=0.65 pd=3.3 as=0 ps=0 w=1 l=0.5
X5817 BLN13 rr3t3r_0[33|13]/a_860_290# sky130_fd_pr_reram__reram_cell area_ox=0.0676
X5818 rr3t3r_0[33|13]/a_60_290# WL33 SL13 VSS sky130_fd_pr__nfet_g5v0d10v5 ad=0.65 pd=3.3 as=0 ps=0 w=1 l=0.5
X5819 rr3t3r_0[33|13]/a_860_290# WL33 SL13 VSS sky130_fd_pr__nfet_g5v0d10v5 ad=0.65 pd=3.3 as=0 ps=0 w=1 l=0.5
X5820 BLP13 rr3t3r_0[34|13]/a_60_290# sky130_fd_pr_reram__reram_cell area_ox=0.0676
X5821 BLZ13 rr3t3r_0[34|13]/a_460_290# sky130_fd_pr_reram__reram_cell area_ox=0.0676
X5822 rr3t3r_0[34|13]/a_460_290# WL34 SL13 VSS sky130_fd_pr__nfet_g5v0d10v5 ad=0.65 pd=3.3 as=0 ps=0 w=1 l=0.5
X5823 BLN13 rr3t3r_0[34|13]/a_860_290# sky130_fd_pr_reram__reram_cell area_ox=0.0676
X5824 rr3t3r_0[34|13]/a_60_290# WL34 SL13 VSS sky130_fd_pr__nfet_g5v0d10v5 ad=0.65 pd=3.3 as=0 ps=0 w=1 l=0.5
X5825 rr3t3r_0[34|13]/a_860_290# WL34 SL13 VSS sky130_fd_pr__nfet_g5v0d10v5 ad=0.65 pd=3.3 as=0 ps=0 w=1 l=0.5
X5826 BLP13 rr3t3r_0[35|13]/a_60_290# sky130_fd_pr_reram__reram_cell area_ox=0.0676
X5827 BLZ13 rr3t3r_0[35|13]/a_460_290# sky130_fd_pr_reram__reram_cell area_ox=0.0676
X5828 rr3t3r_0[35|13]/a_460_290# WL35 SL13 VSS sky130_fd_pr__nfet_g5v0d10v5 ad=0.65 pd=3.3 as=0 ps=0 w=1 l=0.5
X5829 BLN13 rr3t3r_0[35|13]/a_860_290# sky130_fd_pr_reram__reram_cell area_ox=0.0676
X5830 rr3t3r_0[35|13]/a_60_290# WL35 SL13 VSS sky130_fd_pr__nfet_g5v0d10v5 ad=0.65 pd=3.3 as=0 ps=0 w=1 l=0.5
X5831 rr3t3r_0[35|13]/a_860_290# WL35 SL13 VSS sky130_fd_pr__nfet_g5v0d10v5 ad=0.65 pd=3.3 as=0 ps=0 w=1 l=0.5
X5832 BLP13 rr3t3r_0[36|13]/a_60_290# sky130_fd_pr_reram__reram_cell area_ox=0.0676
X5833 BLZ13 rr3t3r_0[36|13]/a_460_290# sky130_fd_pr_reram__reram_cell area_ox=0.0676
X5834 rr3t3r_0[36|13]/a_460_290# WL36 SL13 VSS sky130_fd_pr__nfet_g5v0d10v5 ad=0.65 pd=3.3 as=0 ps=0 w=1 l=0.5
X5835 BLN13 rr3t3r_0[36|13]/a_860_290# sky130_fd_pr_reram__reram_cell area_ox=0.0676
X5836 rr3t3r_0[36|13]/a_60_290# WL36 SL13 VSS sky130_fd_pr__nfet_g5v0d10v5 ad=0.65 pd=3.3 as=0 ps=0 w=1 l=0.5
X5837 rr3t3r_0[36|13]/a_860_290# WL36 SL13 VSS sky130_fd_pr__nfet_g5v0d10v5 ad=0.65 pd=3.3 as=0 ps=0 w=1 l=0.5
X5838 BLP13 rr3t3r_0[37|13]/a_60_290# sky130_fd_pr_reram__reram_cell area_ox=0.0676
X5839 BLZ13 rr3t3r_0[37|13]/a_460_290# sky130_fd_pr_reram__reram_cell area_ox=0.0676
X5840 rr3t3r_0[37|13]/a_460_290# WL37 SL13 VSS sky130_fd_pr__nfet_g5v0d10v5 ad=0.65 pd=3.3 as=0 ps=0 w=1 l=0.5
X5841 BLN13 rr3t3r_0[37|13]/a_860_290# sky130_fd_pr_reram__reram_cell area_ox=0.0676
X5842 rr3t3r_0[37|13]/a_60_290# WL37 SL13 VSS sky130_fd_pr__nfet_g5v0d10v5 ad=0.65 pd=3.3 as=0 ps=0 w=1 l=0.5
X5843 rr3t3r_0[37|13]/a_860_290# WL37 SL13 VSS sky130_fd_pr__nfet_g5v0d10v5 ad=0.65 pd=3.3 as=0 ps=0 w=1 l=0.5
X5844 BLP13 rr3t3r_0[38|13]/a_60_290# sky130_fd_pr_reram__reram_cell area_ox=0.0676
X5845 BLZ13 rr3t3r_0[38|13]/a_460_290# sky130_fd_pr_reram__reram_cell area_ox=0.0676
X5846 rr3t3r_0[38|13]/a_460_290# WL38 SL13 VSS sky130_fd_pr__nfet_g5v0d10v5 ad=0.65 pd=3.3 as=0 ps=0 w=1 l=0.5
X5847 BLN13 rr3t3r_0[38|13]/a_860_290# sky130_fd_pr_reram__reram_cell area_ox=0.0676
X5848 rr3t3r_0[38|13]/a_60_290# WL38 SL13 VSS sky130_fd_pr__nfet_g5v0d10v5 ad=0.65 pd=3.3 as=0 ps=0 w=1 l=0.5
X5849 rr3t3r_0[38|13]/a_860_290# WL38 SL13 VSS sky130_fd_pr__nfet_g5v0d10v5 ad=0.65 pd=3.3 as=0 ps=0 w=1 l=0.5
X5850 BLP13 rr3t3r_0[39|13]/a_60_290# sky130_fd_pr_reram__reram_cell area_ox=0.0676
X5851 BLZ13 rr3t3r_0[39|13]/a_460_290# sky130_fd_pr_reram__reram_cell area_ox=0.0676
X5852 rr3t3r_0[39|13]/a_460_290# WL39 SL13 VSS sky130_fd_pr__nfet_g5v0d10v5 ad=0.65 pd=3.3 as=0 ps=0 w=1 l=0.5
X5853 BLN13 rr3t3r_0[39|13]/a_860_290# sky130_fd_pr_reram__reram_cell area_ox=0.0676
X5854 rr3t3r_0[39|13]/a_60_290# WL39 SL13 VSS sky130_fd_pr__nfet_g5v0d10v5 ad=0.65 pd=3.3 as=0 ps=0 w=1 l=0.5
X5855 rr3t3r_0[39|13]/a_860_290# WL39 SL13 VSS sky130_fd_pr__nfet_g5v0d10v5 ad=0.65 pd=3.3 as=0 ps=0 w=1 l=0.5
X5856 BLP13 rr3t3r_0[40|13]/a_60_290# sky130_fd_pr_reram__reram_cell area_ox=0.0676
X5857 BLZ13 rr3t3r_0[40|13]/a_460_290# sky130_fd_pr_reram__reram_cell area_ox=0.0676
X5858 rr3t3r_0[40|13]/a_460_290# WL40 SL13 VSS sky130_fd_pr__nfet_g5v0d10v5 ad=0.65 pd=3.3 as=0 ps=0 w=1 l=0.5
X5859 BLN13 rr3t3r_0[40|13]/a_860_290# sky130_fd_pr_reram__reram_cell area_ox=0.0676
X5860 rr3t3r_0[40|13]/a_60_290# WL40 SL13 VSS sky130_fd_pr__nfet_g5v0d10v5 ad=0.65 pd=3.3 as=0 ps=0 w=1 l=0.5
X5861 rr3t3r_0[40|13]/a_860_290# WL40 SL13 VSS sky130_fd_pr__nfet_g5v0d10v5 ad=0.65 pd=3.3 as=0 ps=0 w=1 l=0.5
X5862 BLP13 rr3t3r_0[41|13]/a_60_290# sky130_fd_pr_reram__reram_cell area_ox=0.0676
X5863 BLZ13 rr3t3r_0[41|13]/a_460_290# sky130_fd_pr_reram__reram_cell area_ox=0.0676
X5864 rr3t3r_0[41|13]/a_460_290# WL41 SL13 VSS sky130_fd_pr__nfet_g5v0d10v5 ad=0.65 pd=3.3 as=0 ps=0 w=1 l=0.5
X5865 BLN13 rr3t3r_0[41|13]/a_860_290# sky130_fd_pr_reram__reram_cell area_ox=0.0676
X5866 rr3t3r_0[41|13]/a_60_290# WL41 SL13 VSS sky130_fd_pr__nfet_g5v0d10v5 ad=0.65 pd=3.3 as=0 ps=0 w=1 l=0.5
X5867 rr3t3r_0[41|13]/a_860_290# WL41 SL13 VSS sky130_fd_pr__nfet_g5v0d10v5 ad=0.65 pd=3.3 as=0 ps=0 w=1 l=0.5
X5868 BLP13 rr3t3r_0[42|13]/a_60_290# sky130_fd_pr_reram__reram_cell area_ox=0.0676
X5869 BLZ13 rr3t3r_0[42|13]/a_460_290# sky130_fd_pr_reram__reram_cell area_ox=0.0676
X5870 rr3t3r_0[42|13]/a_460_290# WL42 SL13 VSS sky130_fd_pr__nfet_g5v0d10v5 ad=0.65 pd=3.3 as=0 ps=0 w=1 l=0.5
X5871 BLN13 rr3t3r_0[42|13]/a_860_290# sky130_fd_pr_reram__reram_cell area_ox=0.0676
X5872 rr3t3r_0[42|13]/a_60_290# WL42 SL13 VSS sky130_fd_pr__nfet_g5v0d10v5 ad=0.65 pd=3.3 as=0 ps=0 w=1 l=0.5
X5873 rr3t3r_0[42|13]/a_860_290# WL42 SL13 VSS sky130_fd_pr__nfet_g5v0d10v5 ad=0.65 pd=3.3 as=0 ps=0 w=1 l=0.5
X5874 BLP13 rr3t3r_0[43|13]/a_60_290# sky130_fd_pr_reram__reram_cell area_ox=0.0676
X5875 BLZ13 rr3t3r_0[43|13]/a_460_290# sky130_fd_pr_reram__reram_cell area_ox=0.0676
X5876 rr3t3r_0[43|13]/a_460_290# WL43 SL13 VSS sky130_fd_pr__nfet_g5v0d10v5 ad=0.65 pd=3.3 as=0 ps=0 w=1 l=0.5
X5877 BLN13 rr3t3r_0[43|13]/a_860_290# sky130_fd_pr_reram__reram_cell area_ox=0.0676
X5878 rr3t3r_0[43|13]/a_60_290# WL43 SL13 VSS sky130_fd_pr__nfet_g5v0d10v5 ad=0.65 pd=3.3 as=0 ps=0 w=1 l=0.5
X5879 rr3t3r_0[43|13]/a_860_290# WL43 SL13 VSS sky130_fd_pr__nfet_g5v0d10v5 ad=0.65 pd=3.3 as=0 ps=0 w=1 l=0.5
X5880 BLP13 rr3t3r_0[44|13]/a_60_290# sky130_fd_pr_reram__reram_cell area_ox=0.0676
X5881 BLZ13 rr3t3r_0[44|13]/a_460_290# sky130_fd_pr_reram__reram_cell area_ox=0.0676
X5882 rr3t3r_0[44|13]/a_460_290# WL44 SL13 VSS sky130_fd_pr__nfet_g5v0d10v5 ad=0.65 pd=3.3 as=0 ps=0 w=1 l=0.5
X5883 BLN13 rr3t3r_0[44|13]/a_860_290# sky130_fd_pr_reram__reram_cell area_ox=0.0676
X5884 rr3t3r_0[44|13]/a_60_290# WL44 SL13 VSS sky130_fd_pr__nfet_g5v0d10v5 ad=0.65 pd=3.3 as=0 ps=0 w=1 l=0.5
X5885 rr3t3r_0[44|13]/a_860_290# WL44 SL13 VSS sky130_fd_pr__nfet_g5v0d10v5 ad=0.65 pd=3.3 as=0 ps=0 w=1 l=0.5
X5886 BLP13 rr3t3r_0[45|13]/a_60_290# sky130_fd_pr_reram__reram_cell area_ox=0.0676
X5887 BLZ13 rr3t3r_0[45|13]/a_460_290# sky130_fd_pr_reram__reram_cell area_ox=0.0676
X5888 rr3t3r_0[45|13]/a_460_290# WL45 SL13 VSS sky130_fd_pr__nfet_g5v0d10v5 ad=0.65 pd=3.3 as=0 ps=0 w=1 l=0.5
X5889 BLN13 rr3t3r_0[45|13]/a_860_290# sky130_fd_pr_reram__reram_cell area_ox=0.0676
X5890 rr3t3r_0[45|13]/a_60_290# WL45 SL13 VSS sky130_fd_pr__nfet_g5v0d10v5 ad=0.65 pd=3.3 as=0 ps=0 w=1 l=0.5
X5891 rr3t3r_0[45|13]/a_860_290# WL45 SL13 VSS sky130_fd_pr__nfet_g5v0d10v5 ad=0.65 pd=3.3 as=0 ps=0 w=1 l=0.5
X5892 BLP13 rr3t3r_0[46|13]/a_60_290# sky130_fd_pr_reram__reram_cell area_ox=0.0676
X5893 BLZ13 rr3t3r_0[46|13]/a_460_290# sky130_fd_pr_reram__reram_cell area_ox=0.0676
X5894 rr3t3r_0[46|13]/a_460_290# WL46 SL13 VSS sky130_fd_pr__nfet_g5v0d10v5 ad=0.65 pd=3.3 as=0 ps=0 w=1 l=0.5
X5895 BLN13 rr3t3r_0[46|13]/a_860_290# sky130_fd_pr_reram__reram_cell area_ox=0.0676
X5896 rr3t3r_0[46|13]/a_60_290# WL46 SL13 VSS sky130_fd_pr__nfet_g5v0d10v5 ad=0.65 pd=3.3 as=0 ps=0 w=1 l=0.5
X5897 rr3t3r_0[46|13]/a_860_290# WL46 SL13 VSS sky130_fd_pr__nfet_g5v0d10v5 ad=0.65 pd=3.3 as=0 ps=0 w=1 l=0.5
X5898 BLP13 rr3t3r_0[47|13]/a_60_290# sky130_fd_pr_reram__reram_cell area_ox=0.0676
X5899 BLZ13 rr3t3r_0[47|13]/a_460_290# sky130_fd_pr_reram__reram_cell area_ox=0.0676
X5900 rr3t3r_0[47|13]/a_460_290# WL47 SL13 VSS sky130_fd_pr__nfet_g5v0d10v5 ad=0.65 pd=3.3 as=0 ps=0 w=1 l=0.5
X5901 BLN13 rr3t3r_0[47|13]/a_860_290# sky130_fd_pr_reram__reram_cell area_ox=0.0676
X5902 rr3t3r_0[47|13]/a_60_290# WL47 SL13 VSS sky130_fd_pr__nfet_g5v0d10v5 ad=0.65 pd=3.3 as=0 ps=0 w=1 l=0.5
X5903 rr3t3r_0[47|13]/a_860_290# WL47 SL13 VSS sky130_fd_pr__nfet_g5v0d10v5 ad=0.65 pd=3.3 as=0 ps=0 w=1 l=0.5
X5904 BLP13 rr3t3r_0[48|13]/a_60_290# sky130_fd_pr_reram__reram_cell area_ox=0.0676
X5905 BLZ13 rr3t3r_0[48|13]/a_460_290# sky130_fd_pr_reram__reram_cell area_ox=0.0676
X5906 rr3t3r_0[48|13]/a_460_290# WL48 SL13 VSS sky130_fd_pr__nfet_g5v0d10v5 ad=0.65 pd=3.3 as=0 ps=0 w=1 l=0.5
X5907 BLN13 rr3t3r_0[48|13]/a_860_290# sky130_fd_pr_reram__reram_cell area_ox=0.0676
X5908 rr3t3r_0[48|13]/a_60_290# WL48 SL13 VSS sky130_fd_pr__nfet_g5v0d10v5 ad=0.65 pd=3.3 as=0 ps=0 w=1 l=0.5
X5909 rr3t3r_0[48|13]/a_860_290# WL48 SL13 VSS sky130_fd_pr__nfet_g5v0d10v5 ad=0.65 pd=3.3 as=0 ps=0 w=1 l=0.5
X5910 BLP13 rr3t3r_0[49|13]/a_60_290# sky130_fd_pr_reram__reram_cell area_ox=0.0676
X5911 BLZ13 rr3t3r_0[49|13]/a_460_290# sky130_fd_pr_reram__reram_cell area_ox=0.0676
X5912 rr3t3r_0[49|13]/a_460_290# WL49 SL13 VSS sky130_fd_pr__nfet_g5v0d10v5 ad=0.65 pd=3.3 as=0 ps=0 w=1 l=0.5
X5913 BLN13 rr3t3r_0[49|13]/a_860_290# sky130_fd_pr_reram__reram_cell area_ox=0.0676
X5914 rr3t3r_0[49|13]/a_60_290# WL49 SL13 VSS sky130_fd_pr__nfet_g5v0d10v5 ad=0.65 pd=3.3 as=0 ps=0 w=1 l=0.5
X5915 rr3t3r_0[49|13]/a_860_290# WL49 SL13 VSS sky130_fd_pr__nfet_g5v0d10v5 ad=0.65 pd=3.3 as=0 ps=0 w=1 l=0.5
X5916 BLP13 rr3t3r_0[50|13]/a_60_290# sky130_fd_pr_reram__reram_cell area_ox=0.0676
X5917 BLZ13 rr3t3r_0[50|13]/a_460_290# sky130_fd_pr_reram__reram_cell area_ox=0.0676
X5918 rr3t3r_0[50|13]/a_460_290# WL50 SL13 VSS sky130_fd_pr__nfet_g5v0d10v5 ad=0.65 pd=3.3 as=0 ps=0 w=1 l=0.5
X5919 BLN13 rr3t3r_0[50|13]/a_860_290# sky130_fd_pr_reram__reram_cell area_ox=0.0676
X5920 rr3t3r_0[50|13]/a_60_290# WL50 SL13 VSS sky130_fd_pr__nfet_g5v0d10v5 ad=0.65 pd=3.3 as=0 ps=0 w=1 l=0.5
X5921 rr3t3r_0[50|13]/a_860_290# WL50 SL13 VSS sky130_fd_pr__nfet_g5v0d10v5 ad=0.65 pd=3.3 as=0 ps=0 w=1 l=0.5
X5922 BLP13 rr3t3r_0[51|13]/a_60_290# sky130_fd_pr_reram__reram_cell area_ox=0.0676
X5923 BLZ13 rr3t3r_0[51|13]/a_460_290# sky130_fd_pr_reram__reram_cell area_ox=0.0676
X5924 rr3t3r_0[51|13]/a_460_290# WL51 SL13 VSS sky130_fd_pr__nfet_g5v0d10v5 ad=0.65 pd=3.3 as=0 ps=0 w=1 l=0.5
X5925 BLN13 rr3t3r_0[51|13]/a_860_290# sky130_fd_pr_reram__reram_cell area_ox=0.0676
X5926 rr3t3r_0[51|13]/a_60_290# WL51 SL13 VSS sky130_fd_pr__nfet_g5v0d10v5 ad=0.65 pd=3.3 as=0 ps=0 w=1 l=0.5
X5927 rr3t3r_0[51|13]/a_860_290# WL51 SL13 VSS sky130_fd_pr__nfet_g5v0d10v5 ad=0.65 pd=3.3 as=0 ps=0 w=1 l=0.5
X5928 BLP13 rr3t3r_0[52|13]/a_60_290# sky130_fd_pr_reram__reram_cell area_ox=0.0676
X5929 BLZ13 rr3t3r_0[52|13]/a_460_290# sky130_fd_pr_reram__reram_cell area_ox=0.0676
X5930 rr3t3r_0[52|13]/a_460_290# WL52 SL13 VSS sky130_fd_pr__nfet_g5v0d10v5 ad=0.65 pd=3.3 as=0 ps=0 w=1 l=0.5
X5931 BLN13 rr3t3r_0[52|13]/a_860_290# sky130_fd_pr_reram__reram_cell area_ox=0.0676
X5932 rr3t3r_0[52|13]/a_60_290# WL52 SL13 VSS sky130_fd_pr__nfet_g5v0d10v5 ad=0.65 pd=3.3 as=0 ps=0 w=1 l=0.5
X5933 rr3t3r_0[52|13]/a_860_290# WL52 SL13 VSS sky130_fd_pr__nfet_g5v0d10v5 ad=0.65 pd=3.3 as=0 ps=0 w=1 l=0.5
X5934 BLP13 rr3t3r_0[53|13]/a_60_290# sky130_fd_pr_reram__reram_cell area_ox=0.0676
X5935 BLZ13 rr3t3r_0[53|13]/a_460_290# sky130_fd_pr_reram__reram_cell area_ox=0.0676
X5936 rr3t3r_0[53|13]/a_460_290# WL53 SL13 VSS sky130_fd_pr__nfet_g5v0d10v5 ad=0.65 pd=3.3 as=0 ps=0 w=1 l=0.5
X5937 BLN13 rr3t3r_0[53|13]/a_860_290# sky130_fd_pr_reram__reram_cell area_ox=0.0676
X5938 rr3t3r_0[53|13]/a_60_290# WL53 SL13 VSS sky130_fd_pr__nfet_g5v0d10v5 ad=0.65 pd=3.3 as=0 ps=0 w=1 l=0.5
X5939 rr3t3r_0[53|13]/a_860_290# WL53 SL13 VSS sky130_fd_pr__nfet_g5v0d10v5 ad=0.65 pd=3.3 as=0 ps=0 w=1 l=0.5
X5940 BLP13 rr3t3r_0[54|13]/a_60_290# sky130_fd_pr_reram__reram_cell area_ox=0.0676
X5941 BLZ13 rr3t3r_0[54|13]/a_460_290# sky130_fd_pr_reram__reram_cell area_ox=0.0676
X5942 rr3t3r_0[54|13]/a_460_290# WL54 SL13 VSS sky130_fd_pr__nfet_g5v0d10v5 ad=0.65 pd=3.3 as=0 ps=0 w=1 l=0.5
X5943 BLN13 rr3t3r_0[54|13]/a_860_290# sky130_fd_pr_reram__reram_cell area_ox=0.0676
X5944 rr3t3r_0[54|13]/a_60_290# WL54 SL13 VSS sky130_fd_pr__nfet_g5v0d10v5 ad=0.65 pd=3.3 as=0 ps=0 w=1 l=0.5
X5945 rr3t3r_0[54|13]/a_860_290# WL54 SL13 VSS sky130_fd_pr__nfet_g5v0d10v5 ad=0.65 pd=3.3 as=0 ps=0 w=1 l=0.5
X5946 BLP13 rr3t3r_0[55|13]/a_60_290# sky130_fd_pr_reram__reram_cell area_ox=0.0676
X5947 BLZ13 rr3t3r_0[55|13]/a_460_290# sky130_fd_pr_reram__reram_cell area_ox=0.0676
X5948 rr3t3r_0[55|13]/a_460_290# WL55 SL13 VSS sky130_fd_pr__nfet_g5v0d10v5 ad=0.65 pd=3.3 as=0 ps=0 w=1 l=0.5
X5949 BLN13 rr3t3r_0[55|13]/a_860_290# sky130_fd_pr_reram__reram_cell area_ox=0.0676
X5950 rr3t3r_0[55|13]/a_60_290# WL55 SL13 VSS sky130_fd_pr__nfet_g5v0d10v5 ad=0.65 pd=3.3 as=0 ps=0 w=1 l=0.5
X5951 rr3t3r_0[55|13]/a_860_290# WL55 SL13 VSS sky130_fd_pr__nfet_g5v0d10v5 ad=0.65 pd=3.3 as=0 ps=0 w=1 l=0.5
X5952 BLP13 rr3t3r_0[56|13]/a_60_290# sky130_fd_pr_reram__reram_cell area_ox=0.0676
X5953 BLZ13 rr3t3r_0[56|13]/a_460_290# sky130_fd_pr_reram__reram_cell area_ox=0.0676
X5954 rr3t3r_0[56|13]/a_460_290# WL56 SL13 VSS sky130_fd_pr__nfet_g5v0d10v5 ad=0.65 pd=3.3 as=0 ps=0 w=1 l=0.5
X5955 BLN13 rr3t3r_0[56|13]/a_860_290# sky130_fd_pr_reram__reram_cell area_ox=0.0676
X5956 rr3t3r_0[56|13]/a_60_290# WL56 SL13 VSS sky130_fd_pr__nfet_g5v0d10v5 ad=0.65 pd=3.3 as=0 ps=0 w=1 l=0.5
X5957 rr3t3r_0[56|13]/a_860_290# WL56 SL13 VSS sky130_fd_pr__nfet_g5v0d10v5 ad=0.65 pd=3.3 as=0 ps=0 w=1 l=0.5
X5958 BLP13 rr3t3r_0[57|13]/a_60_290# sky130_fd_pr_reram__reram_cell area_ox=0.0676
X5959 BLZ13 rr3t3r_0[57|13]/a_460_290# sky130_fd_pr_reram__reram_cell area_ox=0.0676
X5960 rr3t3r_0[57|13]/a_460_290# WL57 SL13 VSS sky130_fd_pr__nfet_g5v0d10v5 ad=0.65 pd=3.3 as=0 ps=0 w=1 l=0.5
X5961 BLN13 rr3t3r_0[57|13]/a_860_290# sky130_fd_pr_reram__reram_cell area_ox=0.0676
X5962 rr3t3r_0[57|13]/a_60_290# WL57 SL13 VSS sky130_fd_pr__nfet_g5v0d10v5 ad=0.65 pd=3.3 as=0 ps=0 w=1 l=0.5
X5963 rr3t3r_0[57|13]/a_860_290# WL57 SL13 VSS sky130_fd_pr__nfet_g5v0d10v5 ad=0.65 pd=3.3 as=0 ps=0 w=1 l=0.5
X5964 BLP13 rr3t3r_0[58|13]/a_60_290# sky130_fd_pr_reram__reram_cell area_ox=0.0676
X5965 BLZ13 rr3t3r_0[58|13]/a_460_290# sky130_fd_pr_reram__reram_cell area_ox=0.0676
X5966 rr3t3r_0[58|13]/a_460_290# WL58 SL13 VSS sky130_fd_pr__nfet_g5v0d10v5 ad=0.65 pd=3.3 as=0 ps=0 w=1 l=0.5
X5967 BLN13 rr3t3r_0[58|13]/a_860_290# sky130_fd_pr_reram__reram_cell area_ox=0.0676
X5968 rr3t3r_0[58|13]/a_60_290# WL58 SL13 VSS sky130_fd_pr__nfet_g5v0d10v5 ad=0.65 pd=3.3 as=0 ps=0 w=1 l=0.5
X5969 rr3t3r_0[58|13]/a_860_290# WL58 SL13 VSS sky130_fd_pr__nfet_g5v0d10v5 ad=0.65 pd=3.3 as=0 ps=0 w=1 l=0.5
X5970 BLP13 rr3t3r_0[59|13]/a_60_290# sky130_fd_pr_reram__reram_cell area_ox=0.0676
X5971 BLZ13 rr3t3r_0[59|13]/a_460_290# sky130_fd_pr_reram__reram_cell area_ox=0.0676
X5972 rr3t3r_0[59|13]/a_460_290# WL59 SL13 VSS sky130_fd_pr__nfet_g5v0d10v5 ad=0.65 pd=3.3 as=0 ps=0 w=1 l=0.5
X5973 BLN13 rr3t3r_0[59|13]/a_860_290# sky130_fd_pr_reram__reram_cell area_ox=0.0676
X5974 rr3t3r_0[59|13]/a_60_290# WL59 SL13 VSS sky130_fd_pr__nfet_g5v0d10v5 ad=0.65 pd=3.3 as=0 ps=0 w=1 l=0.5
X5975 rr3t3r_0[59|13]/a_860_290# WL59 SL13 VSS sky130_fd_pr__nfet_g5v0d10v5 ad=0.65 pd=3.3 as=0 ps=0 w=1 l=0.5
X5976 BLP13 rr3t3r_0[60|13]/a_60_290# sky130_fd_pr_reram__reram_cell area_ox=0.0676
X5977 BLZ13 rr3t3r_0[60|13]/a_460_290# sky130_fd_pr_reram__reram_cell area_ox=0.0676
X5978 rr3t3r_0[60|13]/a_460_290# WL60 SL13 VSS sky130_fd_pr__nfet_g5v0d10v5 ad=0.65 pd=3.3 as=0 ps=0 w=1 l=0.5
X5979 BLN13 rr3t3r_0[60|13]/a_860_290# sky130_fd_pr_reram__reram_cell area_ox=0.0676
X5980 rr3t3r_0[60|13]/a_60_290# WL60 SL13 VSS sky130_fd_pr__nfet_g5v0d10v5 ad=0.65 pd=3.3 as=0 ps=0 w=1 l=0.5
X5981 rr3t3r_0[60|13]/a_860_290# WL60 SL13 VSS sky130_fd_pr__nfet_g5v0d10v5 ad=0.65 pd=3.3 as=0 ps=0 w=1 l=0.5
X5982 BLP13 rr3t3r_0[61|13]/a_60_290# sky130_fd_pr_reram__reram_cell area_ox=0.0676
X5983 BLZ13 rr3t3r_0[61|13]/a_460_290# sky130_fd_pr_reram__reram_cell area_ox=0.0676
X5984 rr3t3r_0[61|13]/a_460_290# WL61 SL13 VSS sky130_fd_pr__nfet_g5v0d10v5 ad=0.65 pd=3.3 as=0 ps=0 w=1 l=0.5
X5985 BLN13 rr3t3r_0[61|13]/a_860_290# sky130_fd_pr_reram__reram_cell area_ox=0.0676
X5986 rr3t3r_0[61|13]/a_60_290# WL61 SL13 VSS sky130_fd_pr__nfet_g5v0d10v5 ad=0.65 pd=3.3 as=0 ps=0 w=1 l=0.5
X5987 rr3t3r_0[61|13]/a_860_290# WL61 SL13 VSS sky130_fd_pr__nfet_g5v0d10v5 ad=0.65 pd=3.3 as=0 ps=0 w=1 l=0.5
X5988 BLP13 rr3t3r_0[62|13]/a_60_290# sky130_fd_pr_reram__reram_cell area_ox=0.0676
X5989 BLZ13 rr3t3r_0[62|13]/a_460_290# sky130_fd_pr_reram__reram_cell area_ox=0.0676
X5990 rr3t3r_0[62|13]/a_460_290# WL62 SL13 VSS sky130_fd_pr__nfet_g5v0d10v5 ad=0.65 pd=3.3 as=0 ps=0 w=1 l=0.5
X5991 BLN13 rr3t3r_0[62|13]/a_860_290# sky130_fd_pr_reram__reram_cell area_ox=0.0676
X5992 rr3t3r_0[62|13]/a_60_290# WL62 SL13 VSS sky130_fd_pr__nfet_g5v0d10v5 ad=0.65 pd=3.3 as=0 ps=0 w=1 l=0.5
X5993 rr3t3r_0[62|13]/a_860_290# WL62 SL13 VSS sky130_fd_pr__nfet_g5v0d10v5 ad=0.65 pd=3.3 as=0 ps=0 w=1 l=0.5
X5994 BLP13 rr3t3r_0[63|13]/a_60_290# sky130_fd_pr_reram__reram_cell area_ox=0.0676
X5995 BLZ13 rr3t3r_0[63|13]/a_460_290# sky130_fd_pr_reram__reram_cell area_ox=0.0676
X5996 rr3t3r_0[63|13]/a_460_290# WL63 SL13 VSS sky130_fd_pr__nfet_g5v0d10v5 ad=0.65 pd=3.3 as=0 ps=0 w=1 l=0.5
X5997 BLN13 rr3t3r_0[63|13]/a_860_290# sky130_fd_pr_reram__reram_cell area_ox=0.0676
X5998 rr3t3r_0[63|13]/a_60_290# WL63 SL13 VSS sky130_fd_pr__nfet_g5v0d10v5 ad=0.65 pd=3.3 as=0 ps=0 w=1 l=0.5
X5999 rr3t3r_0[63|13]/a_860_290# WL63 SL13 VSS sky130_fd_pr__nfet_g5v0d10v5 ad=0.65 pd=3.3 as=0 ps=0 w=1 l=0.5
X6000 BLP13 rr3t3r_0[64|13]/a_60_290# sky130_fd_pr_reram__reram_cell area_ox=0.0676
X6001 BLZ13 rr3t3r_0[64|13]/a_460_290# sky130_fd_pr_reram__reram_cell area_ox=0.0676
X6002 rr3t3r_0[64|13]/a_460_290# WL64 SL13 VSS sky130_fd_pr__nfet_g5v0d10v5 ad=0.65 pd=3.3 as=0 ps=0 w=1 l=0.5
X6003 BLN13 rr3t3r_0[64|13]/a_860_290# sky130_fd_pr_reram__reram_cell area_ox=0.0676
X6004 rr3t3r_0[64|13]/a_60_290# WL64 SL13 VSS sky130_fd_pr__nfet_g5v0d10v5 ad=0.65 pd=3.3 as=0 ps=0 w=1 l=0.5
X6005 rr3t3r_0[64|13]/a_860_290# WL64 SL13 VSS sky130_fd_pr__nfet_g5v0d10v5 ad=0.65 pd=3.3 as=0 ps=0 w=1 l=0.5
X6006 BLP13 rr3t3r_0[65|13]/a_60_290# sky130_fd_pr_reram__reram_cell area_ox=0.0676
X6007 BLZ13 rr3t3r_0[65|13]/a_460_290# sky130_fd_pr_reram__reram_cell area_ox=0.0676
X6008 rr3t3r_0[65|13]/a_460_290# WL65 SL13 VSS sky130_fd_pr__nfet_g5v0d10v5 ad=0.65 pd=3.3 as=0 ps=0 w=1 l=0.5
X6009 BLN13 rr3t3r_0[65|13]/a_860_290# sky130_fd_pr_reram__reram_cell area_ox=0.0676
X6010 rr3t3r_0[65|13]/a_60_290# WL65 SL13 VSS sky130_fd_pr__nfet_g5v0d10v5 ad=0.65 pd=3.3 as=0 ps=0 w=1 l=0.5
X6011 rr3t3r_0[65|13]/a_860_290# WL65 SL13 VSS sky130_fd_pr__nfet_g5v0d10v5 ad=0.65 pd=3.3 as=0 ps=0 w=1 l=0.5
X6012 BLP13 rr3t3r_0[66|13]/a_60_290# sky130_fd_pr_reram__reram_cell area_ox=0.0676
X6013 BLZ13 rr3t3r_0[66|13]/a_460_290# sky130_fd_pr_reram__reram_cell area_ox=0.0676
X6014 rr3t3r_0[66|13]/a_460_290# WL66 SL13 VSS sky130_fd_pr__nfet_g5v0d10v5 ad=0.65 pd=3.3 as=0 ps=0 w=1 l=0.5
X6015 BLN13 rr3t3r_0[66|13]/a_860_290# sky130_fd_pr_reram__reram_cell area_ox=0.0676
X6016 rr3t3r_0[66|13]/a_60_290# WL66 SL13 VSS sky130_fd_pr__nfet_g5v0d10v5 ad=0.65 pd=3.3 as=0 ps=0 w=1 l=0.5
X6017 rr3t3r_0[66|13]/a_860_290# WL66 SL13 VSS sky130_fd_pr__nfet_g5v0d10v5 ad=0.65 pd=3.3 as=0 ps=0 w=1 l=0.5
X6018 BLP13 rr3t3r_0[67|13]/a_60_290# sky130_fd_pr_reram__reram_cell area_ox=0.0676
X6019 BLZ13 rr3t3r_0[67|13]/a_460_290# sky130_fd_pr_reram__reram_cell area_ox=0.0676
X6020 rr3t3r_0[67|13]/a_460_290# WL67 SL13 VSS sky130_fd_pr__nfet_g5v0d10v5 ad=0.65 pd=3.3 as=0 ps=0 w=1 l=0.5
X6021 BLN13 rr3t3r_0[67|13]/a_860_290# sky130_fd_pr_reram__reram_cell area_ox=0.0676
X6022 rr3t3r_0[67|13]/a_60_290# WL67 SL13 VSS sky130_fd_pr__nfet_g5v0d10v5 ad=0.65 pd=3.3 as=0 ps=0 w=1 l=0.5
X6023 rr3t3r_0[67|13]/a_860_290# WL67 SL13 VSS sky130_fd_pr__nfet_g5v0d10v5 ad=0.65 pd=3.3 as=0 ps=0 w=1 l=0.5
X6024 BLP13 rr3t3r_0[68|13]/a_60_290# sky130_fd_pr_reram__reram_cell area_ox=0.0676
X6025 BLZ13 rr3t3r_0[68|13]/a_460_290# sky130_fd_pr_reram__reram_cell area_ox=0.0676
X6026 rr3t3r_0[68|13]/a_460_290# WL68 SL13 VSS sky130_fd_pr__nfet_g5v0d10v5 ad=0.65 pd=3.3 as=0 ps=0 w=1 l=0.5
X6027 BLN13 rr3t3r_0[68|13]/a_860_290# sky130_fd_pr_reram__reram_cell area_ox=0.0676
X6028 rr3t3r_0[68|13]/a_60_290# WL68 SL13 VSS sky130_fd_pr__nfet_g5v0d10v5 ad=0.65 pd=3.3 as=0 ps=0 w=1 l=0.5
X6029 rr3t3r_0[68|13]/a_860_290# WL68 SL13 VSS sky130_fd_pr__nfet_g5v0d10v5 ad=0.65 pd=3.3 as=0 ps=0 w=1 l=0.5
X6030 BLP13 rr3t3r_0[69|13]/a_60_290# sky130_fd_pr_reram__reram_cell area_ox=0.0676
X6031 BLZ13 rr3t3r_0[69|13]/a_460_290# sky130_fd_pr_reram__reram_cell area_ox=0.0676
X6032 rr3t3r_0[69|13]/a_460_290# WL69 SL13 VSS sky130_fd_pr__nfet_g5v0d10v5 ad=0.65 pd=3.3 as=0 ps=0 w=1 l=0.5
X6033 BLN13 rr3t3r_0[69|13]/a_860_290# sky130_fd_pr_reram__reram_cell area_ox=0.0676
X6034 rr3t3r_0[69|13]/a_60_290# WL69 SL13 VSS sky130_fd_pr__nfet_g5v0d10v5 ad=0.65 pd=3.3 as=0 ps=0 w=1 l=0.5
X6035 rr3t3r_0[69|13]/a_860_290# WL69 SL13 VSS sky130_fd_pr__nfet_g5v0d10v5 ad=0.65 pd=3.3 as=0 ps=0 w=1 l=0.5
X6036 BLP13 rr3t3r_0[70|13]/a_60_290# sky130_fd_pr_reram__reram_cell area_ox=0.0676
X6037 BLZ13 rr3t3r_0[70|13]/a_460_290# sky130_fd_pr_reram__reram_cell area_ox=0.0676
X6038 rr3t3r_0[70|13]/a_460_290# WL70 SL13 VSS sky130_fd_pr__nfet_g5v0d10v5 ad=0.65 pd=3.3 as=0 ps=0 w=1 l=0.5
X6039 BLN13 rr3t3r_0[70|13]/a_860_290# sky130_fd_pr_reram__reram_cell area_ox=0.0676
X6040 rr3t3r_0[70|13]/a_60_290# WL70 SL13 VSS sky130_fd_pr__nfet_g5v0d10v5 ad=0.65 pd=3.3 as=0 ps=0 w=1 l=0.5
X6041 rr3t3r_0[70|13]/a_860_290# WL70 SL13 VSS sky130_fd_pr__nfet_g5v0d10v5 ad=0.65 pd=3.3 as=0 ps=0 w=1 l=0.5
X6042 BLP13 rr3t3r_0[71|13]/a_60_290# sky130_fd_pr_reram__reram_cell area_ox=0.0676
X6043 BLZ13 rr3t3r_0[71|13]/a_460_290# sky130_fd_pr_reram__reram_cell area_ox=0.0676
X6044 rr3t3r_0[71|13]/a_460_290# WL71 SL13 VSS sky130_fd_pr__nfet_g5v0d10v5 ad=0.65 pd=3.3 as=0 ps=0 w=1 l=0.5
X6045 BLN13 rr3t3r_0[71|13]/a_860_290# sky130_fd_pr_reram__reram_cell area_ox=0.0676
X6046 rr3t3r_0[71|13]/a_60_290# WL71 SL13 VSS sky130_fd_pr__nfet_g5v0d10v5 ad=0.65 pd=3.3 as=0 ps=0 w=1 l=0.5
X6047 rr3t3r_0[71|13]/a_860_290# WL71 SL13 VSS sky130_fd_pr__nfet_g5v0d10v5 ad=0.65 pd=3.3 as=0 ps=0 w=1 l=0.5
X6048 BLP14 rr3t3r_0[0|14]/a_60_290# sky130_fd_pr_reram__reram_cell area_ox=0.0676
X6049 BLZ14 rr3t3r_0[0|14]/a_460_290# sky130_fd_pr_reram__reram_cell area_ox=0.0676
X6050 rr3t3r_0[0|14]/a_460_290# WL0 SL14 VSS sky130_fd_pr__nfet_g5v0d10v5 ad=0.65 pd=3.3 as=162 ps=756 w=1 l=0.5
X6051 BLN14 rr3t3r_0[0|14]/a_860_290# sky130_fd_pr_reram__reram_cell area_ox=0.0676
X6052 rr3t3r_0[0|14]/a_60_290# WL0 SL14 VSS sky130_fd_pr__nfet_g5v0d10v5 ad=0.65 pd=3.3 as=0 ps=0 w=1 l=0.5
X6053 rr3t3r_0[0|14]/a_860_290# WL0 SL14 VSS sky130_fd_pr__nfet_g5v0d10v5 ad=0.65 pd=3.3 as=0 ps=0 w=1 l=0.5
X6054 BLP14 rr3t3r_0[1|14]/a_60_290# sky130_fd_pr_reram__reram_cell area_ox=0.0676
X6055 BLZ14 rr3t3r_0[1|14]/a_460_290# sky130_fd_pr_reram__reram_cell area_ox=0.0676
X6056 rr3t3r_0[1|14]/a_460_290# WL1 SL14 VSS sky130_fd_pr__nfet_g5v0d10v5 ad=0.65 pd=3.3 as=0 ps=0 w=1 l=0.5
X6057 BLN14 rr3t3r_0[1|14]/a_860_290# sky130_fd_pr_reram__reram_cell area_ox=0.0676
X6058 rr3t3r_0[1|14]/a_60_290# WL1 SL14 VSS sky130_fd_pr__nfet_g5v0d10v5 ad=0.65 pd=3.3 as=0 ps=0 w=1 l=0.5
X6059 rr3t3r_0[1|14]/a_860_290# WL1 SL14 VSS sky130_fd_pr__nfet_g5v0d10v5 ad=0.65 pd=3.3 as=0 ps=0 w=1 l=0.5
X6060 BLP14 rr3t3r_0[2|14]/a_60_290# sky130_fd_pr_reram__reram_cell area_ox=0.0676
X6061 BLZ14 rr3t3r_0[2|14]/a_460_290# sky130_fd_pr_reram__reram_cell area_ox=0.0676
X6062 rr3t3r_0[2|14]/a_460_290# WL2 SL14 VSS sky130_fd_pr__nfet_g5v0d10v5 ad=0.65 pd=3.3 as=0 ps=0 w=1 l=0.5
X6063 BLN14 rr3t3r_0[2|14]/a_860_290# sky130_fd_pr_reram__reram_cell area_ox=0.0676
X6064 rr3t3r_0[2|14]/a_60_290# WL2 SL14 VSS sky130_fd_pr__nfet_g5v0d10v5 ad=0.65 pd=3.3 as=0 ps=0 w=1 l=0.5
X6065 rr3t3r_0[2|14]/a_860_290# WL2 SL14 VSS sky130_fd_pr__nfet_g5v0d10v5 ad=0.65 pd=3.3 as=0 ps=0 w=1 l=0.5
X6066 BLP14 rr3t3r_0[3|14]/a_60_290# sky130_fd_pr_reram__reram_cell area_ox=0.0676
X6067 BLZ14 rr3t3r_0[3|14]/a_460_290# sky130_fd_pr_reram__reram_cell area_ox=0.0676
X6068 rr3t3r_0[3|14]/a_460_290# WL3 SL14 VSS sky130_fd_pr__nfet_g5v0d10v5 ad=0.65 pd=3.3 as=0 ps=0 w=1 l=0.5
X6069 BLN14 rr3t3r_0[3|14]/a_860_290# sky130_fd_pr_reram__reram_cell area_ox=0.0676
X6070 rr3t3r_0[3|14]/a_60_290# WL3 SL14 VSS sky130_fd_pr__nfet_g5v0d10v5 ad=0.65 pd=3.3 as=0 ps=0 w=1 l=0.5
X6071 rr3t3r_0[3|14]/a_860_290# WL3 SL14 VSS sky130_fd_pr__nfet_g5v0d10v5 ad=0.65 pd=3.3 as=0 ps=0 w=1 l=0.5
X6072 BLP14 rr3t3r_0[4|14]/a_60_290# sky130_fd_pr_reram__reram_cell area_ox=0.0676
X6073 BLZ14 rr3t3r_0[4|14]/a_460_290# sky130_fd_pr_reram__reram_cell area_ox=0.0676
X6074 rr3t3r_0[4|14]/a_460_290# WL4 SL14 VSS sky130_fd_pr__nfet_g5v0d10v5 ad=0.65 pd=3.3 as=0 ps=0 w=1 l=0.5
X6075 BLN14 rr3t3r_0[4|14]/a_860_290# sky130_fd_pr_reram__reram_cell area_ox=0.0676
X6076 rr3t3r_0[4|14]/a_60_290# WL4 SL14 VSS sky130_fd_pr__nfet_g5v0d10v5 ad=0.65 pd=3.3 as=0 ps=0 w=1 l=0.5
X6077 rr3t3r_0[4|14]/a_860_290# WL4 SL14 VSS sky130_fd_pr__nfet_g5v0d10v5 ad=0.65 pd=3.3 as=0 ps=0 w=1 l=0.5
X6078 BLP14 rr3t3r_0[5|14]/a_60_290# sky130_fd_pr_reram__reram_cell area_ox=0.0676
X6079 BLZ14 rr3t3r_0[5|14]/a_460_290# sky130_fd_pr_reram__reram_cell area_ox=0.0676
X6080 rr3t3r_0[5|14]/a_460_290# WL5 SL14 VSS sky130_fd_pr__nfet_g5v0d10v5 ad=0.65 pd=3.3 as=0 ps=0 w=1 l=0.5
X6081 BLN14 rr3t3r_0[5|14]/a_860_290# sky130_fd_pr_reram__reram_cell area_ox=0.0676
X6082 rr3t3r_0[5|14]/a_60_290# WL5 SL14 VSS sky130_fd_pr__nfet_g5v0d10v5 ad=0.65 pd=3.3 as=0 ps=0 w=1 l=0.5
X6083 rr3t3r_0[5|14]/a_860_290# WL5 SL14 VSS sky130_fd_pr__nfet_g5v0d10v5 ad=0.65 pd=3.3 as=0 ps=0 w=1 l=0.5
X6084 BLP14 rr3t3r_0[6|14]/a_60_290# sky130_fd_pr_reram__reram_cell area_ox=0.0676
X6085 BLZ14 rr3t3r_0[6|14]/a_460_290# sky130_fd_pr_reram__reram_cell area_ox=0.0676
X6086 rr3t3r_0[6|14]/a_460_290# WL6 SL14 VSS sky130_fd_pr__nfet_g5v0d10v5 ad=0.65 pd=3.3 as=0 ps=0 w=1 l=0.5
X6087 BLN14 rr3t3r_0[6|14]/a_860_290# sky130_fd_pr_reram__reram_cell area_ox=0.0676
X6088 rr3t3r_0[6|14]/a_60_290# WL6 SL14 VSS sky130_fd_pr__nfet_g5v0d10v5 ad=0.65 pd=3.3 as=0 ps=0 w=1 l=0.5
X6089 rr3t3r_0[6|14]/a_860_290# WL6 SL14 VSS sky130_fd_pr__nfet_g5v0d10v5 ad=0.65 pd=3.3 as=0 ps=0 w=1 l=0.5
X6090 BLP14 rr3t3r_0[7|14]/a_60_290# sky130_fd_pr_reram__reram_cell area_ox=0.0676
X6091 BLZ14 rr3t3r_0[7|14]/a_460_290# sky130_fd_pr_reram__reram_cell area_ox=0.0676
X6092 rr3t3r_0[7|14]/a_460_290# WL7 SL14 VSS sky130_fd_pr__nfet_g5v0d10v5 ad=0.65 pd=3.3 as=0 ps=0 w=1 l=0.5
X6093 BLN14 rr3t3r_0[7|14]/a_860_290# sky130_fd_pr_reram__reram_cell area_ox=0.0676
X6094 rr3t3r_0[7|14]/a_60_290# WL7 SL14 VSS sky130_fd_pr__nfet_g5v0d10v5 ad=0.65 pd=3.3 as=0 ps=0 w=1 l=0.5
X6095 rr3t3r_0[7|14]/a_860_290# WL7 SL14 VSS sky130_fd_pr__nfet_g5v0d10v5 ad=0.65 pd=3.3 as=0 ps=0 w=1 l=0.5
X6096 BLP14 rr3t3r_0[8|14]/a_60_290# sky130_fd_pr_reram__reram_cell area_ox=0.0676
X6097 BLZ14 rr3t3r_0[8|14]/a_460_290# sky130_fd_pr_reram__reram_cell area_ox=0.0676
X6098 rr3t3r_0[8|14]/a_460_290# WL8 SL14 VSS sky130_fd_pr__nfet_g5v0d10v5 ad=0.65 pd=3.3 as=0 ps=0 w=1 l=0.5
X6099 BLN14 rr3t3r_0[8|14]/a_860_290# sky130_fd_pr_reram__reram_cell area_ox=0.0676
X6100 rr3t3r_0[8|14]/a_60_290# WL8 SL14 VSS sky130_fd_pr__nfet_g5v0d10v5 ad=0.65 pd=3.3 as=0 ps=0 w=1 l=0.5
X6101 rr3t3r_0[8|14]/a_860_290# WL8 SL14 VSS sky130_fd_pr__nfet_g5v0d10v5 ad=0.65 pd=3.3 as=0 ps=0 w=1 l=0.5
X6102 BLP14 rr3t3r_0[9|14]/a_60_290# sky130_fd_pr_reram__reram_cell area_ox=0.0676
X6103 BLZ14 rr3t3r_0[9|14]/a_460_290# sky130_fd_pr_reram__reram_cell area_ox=0.0676
X6104 rr3t3r_0[9|14]/a_460_290# WL9 SL14 VSS sky130_fd_pr__nfet_g5v0d10v5 ad=0.65 pd=3.3 as=0 ps=0 w=1 l=0.5
X6105 BLN14 rr3t3r_0[9|14]/a_860_290# sky130_fd_pr_reram__reram_cell area_ox=0.0676
X6106 rr3t3r_0[9|14]/a_60_290# WL9 SL14 VSS sky130_fd_pr__nfet_g5v0d10v5 ad=0.65 pd=3.3 as=0 ps=0 w=1 l=0.5
X6107 rr3t3r_0[9|14]/a_860_290# WL9 SL14 VSS sky130_fd_pr__nfet_g5v0d10v5 ad=0.65 pd=3.3 as=0 ps=0 w=1 l=0.5
X6108 BLP14 rr3t3r_0[10|14]/a_60_290# sky130_fd_pr_reram__reram_cell area_ox=0.0676
X6109 BLZ14 rr3t3r_0[10|14]/a_460_290# sky130_fd_pr_reram__reram_cell area_ox=0.0676
X6110 rr3t3r_0[10|14]/a_460_290# WL10 SL14 VSS sky130_fd_pr__nfet_g5v0d10v5 ad=0.65 pd=3.3 as=0 ps=0 w=1 l=0.5
X6111 BLN14 rr3t3r_0[10|14]/a_860_290# sky130_fd_pr_reram__reram_cell area_ox=0.0676
X6112 rr3t3r_0[10|14]/a_60_290# WL10 SL14 VSS sky130_fd_pr__nfet_g5v0d10v5 ad=0.65 pd=3.3 as=0 ps=0 w=1 l=0.5
X6113 rr3t3r_0[10|14]/a_860_290# WL10 SL14 VSS sky130_fd_pr__nfet_g5v0d10v5 ad=0.65 pd=3.3 as=0 ps=0 w=1 l=0.5
X6114 BLP14 rr3t3r_0[11|14]/a_60_290# sky130_fd_pr_reram__reram_cell area_ox=0.0676
X6115 BLZ14 rr3t3r_0[11|14]/a_460_290# sky130_fd_pr_reram__reram_cell area_ox=0.0676
X6116 rr3t3r_0[11|14]/a_460_290# WL11 SL14 VSS sky130_fd_pr__nfet_g5v0d10v5 ad=0.65 pd=3.3 as=0 ps=0 w=1 l=0.5
X6117 BLN14 rr3t3r_0[11|14]/a_860_290# sky130_fd_pr_reram__reram_cell area_ox=0.0676
X6118 rr3t3r_0[11|14]/a_60_290# WL11 SL14 VSS sky130_fd_pr__nfet_g5v0d10v5 ad=0.65 pd=3.3 as=0 ps=0 w=1 l=0.5
X6119 rr3t3r_0[11|14]/a_860_290# WL11 SL14 VSS sky130_fd_pr__nfet_g5v0d10v5 ad=0.65 pd=3.3 as=0 ps=0 w=1 l=0.5
X6120 BLP14 rr3t3r_0[12|14]/a_60_290# sky130_fd_pr_reram__reram_cell area_ox=0.0676
X6121 BLZ14 rr3t3r_0[12|14]/a_460_290# sky130_fd_pr_reram__reram_cell area_ox=0.0676
X6122 rr3t3r_0[12|14]/a_460_290# WL12 SL14 VSS sky130_fd_pr__nfet_g5v0d10v5 ad=0.65 pd=3.3 as=0 ps=0 w=1 l=0.5
X6123 BLN14 rr3t3r_0[12|14]/a_860_290# sky130_fd_pr_reram__reram_cell area_ox=0.0676
X6124 rr3t3r_0[12|14]/a_60_290# WL12 SL14 VSS sky130_fd_pr__nfet_g5v0d10v5 ad=0.65 pd=3.3 as=0 ps=0 w=1 l=0.5
X6125 rr3t3r_0[12|14]/a_860_290# WL12 SL14 VSS sky130_fd_pr__nfet_g5v0d10v5 ad=0.65 pd=3.3 as=0 ps=0 w=1 l=0.5
X6126 BLP14 rr3t3r_0[13|14]/a_60_290# sky130_fd_pr_reram__reram_cell area_ox=0.0676
X6127 BLZ14 rr3t3r_0[13|14]/a_460_290# sky130_fd_pr_reram__reram_cell area_ox=0.0676
X6128 rr3t3r_0[13|14]/a_460_290# WL13 SL14 VSS sky130_fd_pr__nfet_g5v0d10v5 ad=0.65 pd=3.3 as=0 ps=0 w=1 l=0.5
X6129 BLN14 rr3t3r_0[13|14]/a_860_290# sky130_fd_pr_reram__reram_cell area_ox=0.0676
X6130 rr3t3r_0[13|14]/a_60_290# WL13 SL14 VSS sky130_fd_pr__nfet_g5v0d10v5 ad=0.65 pd=3.3 as=0 ps=0 w=1 l=0.5
X6131 rr3t3r_0[13|14]/a_860_290# WL13 SL14 VSS sky130_fd_pr__nfet_g5v0d10v5 ad=0.65 pd=3.3 as=0 ps=0 w=1 l=0.5
X6132 BLP14 rr3t3r_0[14|14]/a_60_290# sky130_fd_pr_reram__reram_cell area_ox=0.0676
X6133 BLZ14 rr3t3r_0[14|14]/a_460_290# sky130_fd_pr_reram__reram_cell area_ox=0.0676
X6134 rr3t3r_0[14|14]/a_460_290# WL14 SL14 VSS sky130_fd_pr__nfet_g5v0d10v5 ad=0.65 pd=3.3 as=0 ps=0 w=1 l=0.5
X6135 BLN14 rr3t3r_0[14|14]/a_860_290# sky130_fd_pr_reram__reram_cell area_ox=0.0676
X6136 rr3t3r_0[14|14]/a_60_290# WL14 SL14 VSS sky130_fd_pr__nfet_g5v0d10v5 ad=0.65 pd=3.3 as=0 ps=0 w=1 l=0.5
X6137 rr3t3r_0[14|14]/a_860_290# WL14 SL14 VSS sky130_fd_pr__nfet_g5v0d10v5 ad=0.65 pd=3.3 as=0 ps=0 w=1 l=0.5
X6138 BLP14 rr3t3r_0[15|14]/a_60_290# sky130_fd_pr_reram__reram_cell area_ox=0.0676
X6139 BLZ14 rr3t3r_0[15|14]/a_460_290# sky130_fd_pr_reram__reram_cell area_ox=0.0676
X6140 rr3t3r_0[15|14]/a_460_290# WL15 SL14 VSS sky130_fd_pr__nfet_g5v0d10v5 ad=0.65 pd=3.3 as=0 ps=0 w=1 l=0.5
X6141 BLN14 rr3t3r_0[15|14]/a_860_290# sky130_fd_pr_reram__reram_cell area_ox=0.0676
X6142 rr3t3r_0[15|14]/a_60_290# WL15 SL14 VSS sky130_fd_pr__nfet_g5v0d10v5 ad=0.65 pd=3.3 as=0 ps=0 w=1 l=0.5
X6143 rr3t3r_0[15|14]/a_860_290# WL15 SL14 VSS sky130_fd_pr__nfet_g5v0d10v5 ad=0.65 pd=3.3 as=0 ps=0 w=1 l=0.5
X6144 BLP14 rr3t3r_0[16|14]/a_60_290# sky130_fd_pr_reram__reram_cell area_ox=0.0676
X6145 BLZ14 rr3t3r_0[16|14]/a_460_290# sky130_fd_pr_reram__reram_cell area_ox=0.0676
X6146 rr3t3r_0[16|14]/a_460_290# WL16 SL14 VSS sky130_fd_pr__nfet_g5v0d10v5 ad=0.65 pd=3.3 as=0 ps=0 w=1 l=0.5
X6147 BLN14 rr3t3r_0[16|14]/a_860_290# sky130_fd_pr_reram__reram_cell area_ox=0.0676
X6148 rr3t3r_0[16|14]/a_60_290# WL16 SL14 VSS sky130_fd_pr__nfet_g5v0d10v5 ad=0.65 pd=3.3 as=0 ps=0 w=1 l=0.5
X6149 rr3t3r_0[16|14]/a_860_290# WL16 SL14 VSS sky130_fd_pr__nfet_g5v0d10v5 ad=0.65 pd=3.3 as=0 ps=0 w=1 l=0.5
X6150 BLP14 rr3t3r_0[17|14]/a_60_290# sky130_fd_pr_reram__reram_cell area_ox=0.0676
X6151 BLZ14 rr3t3r_0[17|14]/a_460_290# sky130_fd_pr_reram__reram_cell area_ox=0.0676
X6152 rr3t3r_0[17|14]/a_460_290# WL17 SL14 VSS sky130_fd_pr__nfet_g5v0d10v5 ad=0.65 pd=3.3 as=0 ps=0 w=1 l=0.5
X6153 BLN14 rr3t3r_0[17|14]/a_860_290# sky130_fd_pr_reram__reram_cell area_ox=0.0676
X6154 rr3t3r_0[17|14]/a_60_290# WL17 SL14 VSS sky130_fd_pr__nfet_g5v0d10v5 ad=0.65 pd=3.3 as=0 ps=0 w=1 l=0.5
X6155 rr3t3r_0[17|14]/a_860_290# WL17 SL14 VSS sky130_fd_pr__nfet_g5v0d10v5 ad=0.65 pd=3.3 as=0 ps=0 w=1 l=0.5
X6156 BLP14 rr3t3r_0[18|14]/a_60_290# sky130_fd_pr_reram__reram_cell area_ox=0.0676
X6157 BLZ14 rr3t3r_0[18|14]/a_460_290# sky130_fd_pr_reram__reram_cell area_ox=0.0676
X6158 rr3t3r_0[18|14]/a_460_290# WL18 SL14 VSS sky130_fd_pr__nfet_g5v0d10v5 ad=0.65 pd=3.3 as=0 ps=0 w=1 l=0.5
X6159 BLN14 rr3t3r_0[18|14]/a_860_290# sky130_fd_pr_reram__reram_cell area_ox=0.0676
X6160 rr3t3r_0[18|14]/a_60_290# WL18 SL14 VSS sky130_fd_pr__nfet_g5v0d10v5 ad=0.65 pd=3.3 as=0 ps=0 w=1 l=0.5
X6161 rr3t3r_0[18|14]/a_860_290# WL18 SL14 VSS sky130_fd_pr__nfet_g5v0d10v5 ad=0.65 pd=3.3 as=0 ps=0 w=1 l=0.5
X6162 BLP14 rr3t3r_0[19|14]/a_60_290# sky130_fd_pr_reram__reram_cell area_ox=0.0676
X6163 BLZ14 rr3t3r_0[19|14]/a_460_290# sky130_fd_pr_reram__reram_cell area_ox=0.0676
X6164 rr3t3r_0[19|14]/a_460_290# WL19 SL14 VSS sky130_fd_pr__nfet_g5v0d10v5 ad=0.65 pd=3.3 as=0 ps=0 w=1 l=0.5
X6165 BLN14 rr3t3r_0[19|14]/a_860_290# sky130_fd_pr_reram__reram_cell area_ox=0.0676
X6166 rr3t3r_0[19|14]/a_60_290# WL19 SL14 VSS sky130_fd_pr__nfet_g5v0d10v5 ad=0.65 pd=3.3 as=0 ps=0 w=1 l=0.5
X6167 rr3t3r_0[19|14]/a_860_290# WL19 SL14 VSS sky130_fd_pr__nfet_g5v0d10v5 ad=0.65 pd=3.3 as=0 ps=0 w=1 l=0.5
X6168 BLP14 rr3t3r_0[20|14]/a_60_290# sky130_fd_pr_reram__reram_cell area_ox=0.0676
X6169 BLZ14 rr3t3r_0[20|14]/a_460_290# sky130_fd_pr_reram__reram_cell area_ox=0.0676
X6170 rr3t3r_0[20|14]/a_460_290# WL20 SL14 VSS sky130_fd_pr__nfet_g5v0d10v5 ad=0.65 pd=3.3 as=0 ps=0 w=1 l=0.5
X6171 BLN14 rr3t3r_0[20|14]/a_860_290# sky130_fd_pr_reram__reram_cell area_ox=0.0676
X6172 rr3t3r_0[20|14]/a_60_290# WL20 SL14 VSS sky130_fd_pr__nfet_g5v0d10v5 ad=0.65 pd=3.3 as=0 ps=0 w=1 l=0.5
X6173 rr3t3r_0[20|14]/a_860_290# WL20 SL14 VSS sky130_fd_pr__nfet_g5v0d10v5 ad=0.65 pd=3.3 as=0 ps=0 w=1 l=0.5
X6174 BLP14 rr3t3r_0[21|14]/a_60_290# sky130_fd_pr_reram__reram_cell area_ox=0.0676
X6175 BLZ14 rr3t3r_0[21|14]/a_460_290# sky130_fd_pr_reram__reram_cell area_ox=0.0676
X6176 rr3t3r_0[21|14]/a_460_290# WL21 SL14 VSS sky130_fd_pr__nfet_g5v0d10v5 ad=0.65 pd=3.3 as=0 ps=0 w=1 l=0.5
X6177 BLN14 rr3t3r_0[21|14]/a_860_290# sky130_fd_pr_reram__reram_cell area_ox=0.0676
X6178 rr3t3r_0[21|14]/a_60_290# WL21 SL14 VSS sky130_fd_pr__nfet_g5v0d10v5 ad=0.65 pd=3.3 as=0 ps=0 w=1 l=0.5
X6179 rr3t3r_0[21|14]/a_860_290# WL21 SL14 VSS sky130_fd_pr__nfet_g5v0d10v5 ad=0.65 pd=3.3 as=0 ps=0 w=1 l=0.5
X6180 BLP14 rr3t3r_0[22|14]/a_60_290# sky130_fd_pr_reram__reram_cell area_ox=0.0676
X6181 BLZ14 rr3t3r_0[22|14]/a_460_290# sky130_fd_pr_reram__reram_cell area_ox=0.0676
X6182 rr3t3r_0[22|14]/a_460_290# WL22 SL14 VSS sky130_fd_pr__nfet_g5v0d10v5 ad=0.65 pd=3.3 as=0 ps=0 w=1 l=0.5
X6183 BLN14 rr3t3r_0[22|14]/a_860_290# sky130_fd_pr_reram__reram_cell area_ox=0.0676
X6184 rr3t3r_0[22|14]/a_60_290# WL22 SL14 VSS sky130_fd_pr__nfet_g5v0d10v5 ad=0.65 pd=3.3 as=0 ps=0 w=1 l=0.5
X6185 rr3t3r_0[22|14]/a_860_290# WL22 SL14 VSS sky130_fd_pr__nfet_g5v0d10v5 ad=0.65 pd=3.3 as=0 ps=0 w=1 l=0.5
X6186 BLP14 rr3t3r_0[23|14]/a_60_290# sky130_fd_pr_reram__reram_cell area_ox=0.0676
X6187 BLZ14 rr3t3r_0[23|14]/a_460_290# sky130_fd_pr_reram__reram_cell area_ox=0.0676
X6188 rr3t3r_0[23|14]/a_460_290# WL23 SL14 VSS sky130_fd_pr__nfet_g5v0d10v5 ad=0.65 pd=3.3 as=0 ps=0 w=1 l=0.5
X6189 BLN14 rr3t3r_0[23|14]/a_860_290# sky130_fd_pr_reram__reram_cell area_ox=0.0676
X6190 rr3t3r_0[23|14]/a_60_290# WL23 SL14 VSS sky130_fd_pr__nfet_g5v0d10v5 ad=0.65 pd=3.3 as=0 ps=0 w=1 l=0.5
X6191 rr3t3r_0[23|14]/a_860_290# WL23 SL14 VSS sky130_fd_pr__nfet_g5v0d10v5 ad=0.65 pd=3.3 as=0 ps=0 w=1 l=0.5
X6192 BLP14 rr3t3r_0[24|14]/a_60_290# sky130_fd_pr_reram__reram_cell area_ox=0.0676
X6193 BLZ14 rr3t3r_0[24|14]/a_460_290# sky130_fd_pr_reram__reram_cell area_ox=0.0676
X6194 rr3t3r_0[24|14]/a_460_290# WL24 SL14 VSS sky130_fd_pr__nfet_g5v0d10v5 ad=0.65 pd=3.3 as=0 ps=0 w=1 l=0.5
X6195 BLN14 rr3t3r_0[24|14]/a_860_290# sky130_fd_pr_reram__reram_cell area_ox=0.0676
X6196 rr3t3r_0[24|14]/a_60_290# WL24 SL14 VSS sky130_fd_pr__nfet_g5v0d10v5 ad=0.65 pd=3.3 as=0 ps=0 w=1 l=0.5
X6197 rr3t3r_0[24|14]/a_860_290# WL24 SL14 VSS sky130_fd_pr__nfet_g5v0d10v5 ad=0.65 pd=3.3 as=0 ps=0 w=1 l=0.5
X6198 BLP14 rr3t3r_0[25|14]/a_60_290# sky130_fd_pr_reram__reram_cell area_ox=0.0676
X6199 BLZ14 rr3t3r_0[25|14]/a_460_290# sky130_fd_pr_reram__reram_cell area_ox=0.0676
X6200 rr3t3r_0[25|14]/a_460_290# WL25 SL14 VSS sky130_fd_pr__nfet_g5v0d10v5 ad=0.65 pd=3.3 as=0 ps=0 w=1 l=0.5
X6201 BLN14 rr3t3r_0[25|14]/a_860_290# sky130_fd_pr_reram__reram_cell area_ox=0.0676
X6202 rr3t3r_0[25|14]/a_60_290# WL25 SL14 VSS sky130_fd_pr__nfet_g5v0d10v5 ad=0.65 pd=3.3 as=0 ps=0 w=1 l=0.5
X6203 rr3t3r_0[25|14]/a_860_290# WL25 SL14 VSS sky130_fd_pr__nfet_g5v0d10v5 ad=0.65 pd=3.3 as=0 ps=0 w=1 l=0.5
X6204 BLP14 rr3t3r_0[26|14]/a_60_290# sky130_fd_pr_reram__reram_cell area_ox=0.0676
X6205 BLZ14 rr3t3r_0[26|14]/a_460_290# sky130_fd_pr_reram__reram_cell area_ox=0.0676
X6206 rr3t3r_0[26|14]/a_460_290# WL26 SL14 VSS sky130_fd_pr__nfet_g5v0d10v5 ad=0.65 pd=3.3 as=0 ps=0 w=1 l=0.5
X6207 BLN14 rr3t3r_0[26|14]/a_860_290# sky130_fd_pr_reram__reram_cell area_ox=0.0676
X6208 rr3t3r_0[26|14]/a_60_290# WL26 SL14 VSS sky130_fd_pr__nfet_g5v0d10v5 ad=0.65 pd=3.3 as=0 ps=0 w=1 l=0.5
X6209 rr3t3r_0[26|14]/a_860_290# WL26 SL14 VSS sky130_fd_pr__nfet_g5v0d10v5 ad=0.65 pd=3.3 as=0 ps=0 w=1 l=0.5
X6210 BLP14 rr3t3r_0[27|14]/a_60_290# sky130_fd_pr_reram__reram_cell area_ox=0.0676
X6211 BLZ14 rr3t3r_0[27|14]/a_460_290# sky130_fd_pr_reram__reram_cell area_ox=0.0676
X6212 rr3t3r_0[27|14]/a_460_290# WL27 SL14 VSS sky130_fd_pr__nfet_g5v0d10v5 ad=0.65 pd=3.3 as=0 ps=0 w=1 l=0.5
X6213 BLN14 rr3t3r_0[27|14]/a_860_290# sky130_fd_pr_reram__reram_cell area_ox=0.0676
X6214 rr3t3r_0[27|14]/a_60_290# WL27 SL14 VSS sky130_fd_pr__nfet_g5v0d10v5 ad=0.65 pd=3.3 as=0 ps=0 w=1 l=0.5
X6215 rr3t3r_0[27|14]/a_860_290# WL27 SL14 VSS sky130_fd_pr__nfet_g5v0d10v5 ad=0.65 pd=3.3 as=0 ps=0 w=1 l=0.5
X6216 BLP14 rr3t3r_0[28|14]/a_60_290# sky130_fd_pr_reram__reram_cell area_ox=0.0676
X6217 BLZ14 rr3t3r_0[28|14]/a_460_290# sky130_fd_pr_reram__reram_cell area_ox=0.0676
X6218 rr3t3r_0[28|14]/a_460_290# WL28 SL14 VSS sky130_fd_pr__nfet_g5v0d10v5 ad=0.65 pd=3.3 as=0 ps=0 w=1 l=0.5
X6219 BLN14 rr3t3r_0[28|14]/a_860_290# sky130_fd_pr_reram__reram_cell area_ox=0.0676
X6220 rr3t3r_0[28|14]/a_60_290# WL28 SL14 VSS sky130_fd_pr__nfet_g5v0d10v5 ad=0.65 pd=3.3 as=0 ps=0 w=1 l=0.5
X6221 rr3t3r_0[28|14]/a_860_290# WL28 SL14 VSS sky130_fd_pr__nfet_g5v0d10v5 ad=0.65 pd=3.3 as=0 ps=0 w=1 l=0.5
X6222 BLP14 rr3t3r_0[29|14]/a_60_290# sky130_fd_pr_reram__reram_cell area_ox=0.0676
X6223 BLZ14 rr3t3r_0[29|14]/a_460_290# sky130_fd_pr_reram__reram_cell area_ox=0.0676
X6224 rr3t3r_0[29|14]/a_460_290# WL29 SL14 VSS sky130_fd_pr__nfet_g5v0d10v5 ad=0.65 pd=3.3 as=0 ps=0 w=1 l=0.5
X6225 BLN14 rr3t3r_0[29|14]/a_860_290# sky130_fd_pr_reram__reram_cell area_ox=0.0676
X6226 rr3t3r_0[29|14]/a_60_290# WL29 SL14 VSS sky130_fd_pr__nfet_g5v0d10v5 ad=0.65 pd=3.3 as=0 ps=0 w=1 l=0.5
X6227 rr3t3r_0[29|14]/a_860_290# WL29 SL14 VSS sky130_fd_pr__nfet_g5v0d10v5 ad=0.65 pd=3.3 as=0 ps=0 w=1 l=0.5
X6228 BLP14 rr3t3r_0[30|14]/a_60_290# sky130_fd_pr_reram__reram_cell area_ox=0.0676
X6229 BLZ14 rr3t3r_0[30|14]/a_460_290# sky130_fd_pr_reram__reram_cell area_ox=0.0676
X6230 rr3t3r_0[30|14]/a_460_290# WL30 SL14 VSS sky130_fd_pr__nfet_g5v0d10v5 ad=0.65 pd=3.3 as=0 ps=0 w=1 l=0.5
X6231 BLN14 rr3t3r_0[30|14]/a_860_290# sky130_fd_pr_reram__reram_cell area_ox=0.0676
X6232 rr3t3r_0[30|14]/a_60_290# WL30 SL14 VSS sky130_fd_pr__nfet_g5v0d10v5 ad=0.65 pd=3.3 as=0 ps=0 w=1 l=0.5
X6233 rr3t3r_0[30|14]/a_860_290# WL30 SL14 VSS sky130_fd_pr__nfet_g5v0d10v5 ad=0.65 pd=3.3 as=0 ps=0 w=1 l=0.5
X6234 BLP14 rr3t3r_0[31|14]/a_60_290# sky130_fd_pr_reram__reram_cell area_ox=0.0676
X6235 BLZ14 rr3t3r_0[31|14]/a_460_290# sky130_fd_pr_reram__reram_cell area_ox=0.0676
X6236 rr3t3r_0[31|14]/a_460_290# WL31 SL14 VSS sky130_fd_pr__nfet_g5v0d10v5 ad=0.65 pd=3.3 as=0 ps=0 w=1 l=0.5
X6237 BLN14 rr3t3r_0[31|14]/a_860_290# sky130_fd_pr_reram__reram_cell area_ox=0.0676
X6238 rr3t3r_0[31|14]/a_60_290# WL31 SL14 VSS sky130_fd_pr__nfet_g5v0d10v5 ad=0.65 pd=3.3 as=0 ps=0 w=1 l=0.5
X6239 rr3t3r_0[31|14]/a_860_290# WL31 SL14 VSS sky130_fd_pr__nfet_g5v0d10v5 ad=0.65 pd=3.3 as=0 ps=0 w=1 l=0.5
X6240 BLP14 rr3t3r_0[32|14]/a_60_290# sky130_fd_pr_reram__reram_cell area_ox=0.0676
X6241 BLZ14 rr3t3r_0[32|14]/a_460_290# sky130_fd_pr_reram__reram_cell area_ox=0.0676
X6242 rr3t3r_0[32|14]/a_460_290# WL32 SL14 VSS sky130_fd_pr__nfet_g5v0d10v5 ad=0.65 pd=3.3 as=0 ps=0 w=1 l=0.5
X6243 BLN14 rr3t3r_0[32|14]/a_860_290# sky130_fd_pr_reram__reram_cell area_ox=0.0676
X6244 rr3t3r_0[32|14]/a_60_290# WL32 SL14 VSS sky130_fd_pr__nfet_g5v0d10v5 ad=0.65 pd=3.3 as=0 ps=0 w=1 l=0.5
X6245 rr3t3r_0[32|14]/a_860_290# WL32 SL14 VSS sky130_fd_pr__nfet_g5v0d10v5 ad=0.65 pd=3.3 as=0 ps=0 w=1 l=0.5
X6246 BLP14 rr3t3r_0[33|14]/a_60_290# sky130_fd_pr_reram__reram_cell area_ox=0.0676
X6247 BLZ14 rr3t3r_0[33|14]/a_460_290# sky130_fd_pr_reram__reram_cell area_ox=0.0676
X6248 rr3t3r_0[33|14]/a_460_290# WL33 SL14 VSS sky130_fd_pr__nfet_g5v0d10v5 ad=0.65 pd=3.3 as=0 ps=0 w=1 l=0.5
X6249 BLN14 rr3t3r_0[33|14]/a_860_290# sky130_fd_pr_reram__reram_cell area_ox=0.0676
X6250 rr3t3r_0[33|14]/a_60_290# WL33 SL14 VSS sky130_fd_pr__nfet_g5v0d10v5 ad=0.65 pd=3.3 as=0 ps=0 w=1 l=0.5
X6251 rr3t3r_0[33|14]/a_860_290# WL33 SL14 VSS sky130_fd_pr__nfet_g5v0d10v5 ad=0.65 pd=3.3 as=0 ps=0 w=1 l=0.5
X6252 BLP14 rr3t3r_0[34|14]/a_60_290# sky130_fd_pr_reram__reram_cell area_ox=0.0676
X6253 BLZ14 rr3t3r_0[34|14]/a_460_290# sky130_fd_pr_reram__reram_cell area_ox=0.0676
X6254 rr3t3r_0[34|14]/a_460_290# WL34 SL14 VSS sky130_fd_pr__nfet_g5v0d10v5 ad=0.65 pd=3.3 as=0 ps=0 w=1 l=0.5
X6255 BLN14 rr3t3r_0[34|14]/a_860_290# sky130_fd_pr_reram__reram_cell area_ox=0.0676
X6256 rr3t3r_0[34|14]/a_60_290# WL34 SL14 VSS sky130_fd_pr__nfet_g5v0d10v5 ad=0.65 pd=3.3 as=0 ps=0 w=1 l=0.5
X6257 rr3t3r_0[34|14]/a_860_290# WL34 SL14 VSS sky130_fd_pr__nfet_g5v0d10v5 ad=0.65 pd=3.3 as=0 ps=0 w=1 l=0.5
X6258 BLP14 rr3t3r_0[35|14]/a_60_290# sky130_fd_pr_reram__reram_cell area_ox=0.0676
X6259 BLZ14 rr3t3r_0[35|14]/a_460_290# sky130_fd_pr_reram__reram_cell area_ox=0.0676
X6260 rr3t3r_0[35|14]/a_460_290# WL35 SL14 VSS sky130_fd_pr__nfet_g5v0d10v5 ad=0.65 pd=3.3 as=0 ps=0 w=1 l=0.5
X6261 BLN14 rr3t3r_0[35|14]/a_860_290# sky130_fd_pr_reram__reram_cell area_ox=0.0676
X6262 rr3t3r_0[35|14]/a_60_290# WL35 SL14 VSS sky130_fd_pr__nfet_g5v0d10v5 ad=0.65 pd=3.3 as=0 ps=0 w=1 l=0.5
X6263 rr3t3r_0[35|14]/a_860_290# WL35 SL14 VSS sky130_fd_pr__nfet_g5v0d10v5 ad=0.65 pd=3.3 as=0 ps=0 w=1 l=0.5
X6264 BLP14 rr3t3r_0[36|14]/a_60_290# sky130_fd_pr_reram__reram_cell area_ox=0.0676
X6265 BLZ14 rr3t3r_0[36|14]/a_460_290# sky130_fd_pr_reram__reram_cell area_ox=0.0676
X6266 rr3t3r_0[36|14]/a_460_290# WL36 SL14 VSS sky130_fd_pr__nfet_g5v0d10v5 ad=0.65 pd=3.3 as=0 ps=0 w=1 l=0.5
X6267 BLN14 rr3t3r_0[36|14]/a_860_290# sky130_fd_pr_reram__reram_cell area_ox=0.0676
X6268 rr3t3r_0[36|14]/a_60_290# WL36 SL14 VSS sky130_fd_pr__nfet_g5v0d10v5 ad=0.65 pd=3.3 as=0 ps=0 w=1 l=0.5
X6269 rr3t3r_0[36|14]/a_860_290# WL36 SL14 VSS sky130_fd_pr__nfet_g5v0d10v5 ad=0.65 pd=3.3 as=0 ps=0 w=1 l=0.5
X6270 BLP14 rr3t3r_0[37|14]/a_60_290# sky130_fd_pr_reram__reram_cell area_ox=0.0676
X6271 BLZ14 rr3t3r_0[37|14]/a_460_290# sky130_fd_pr_reram__reram_cell area_ox=0.0676
X6272 rr3t3r_0[37|14]/a_460_290# WL37 SL14 VSS sky130_fd_pr__nfet_g5v0d10v5 ad=0.65 pd=3.3 as=0 ps=0 w=1 l=0.5
X6273 BLN14 rr3t3r_0[37|14]/a_860_290# sky130_fd_pr_reram__reram_cell area_ox=0.0676
X6274 rr3t3r_0[37|14]/a_60_290# WL37 SL14 VSS sky130_fd_pr__nfet_g5v0d10v5 ad=0.65 pd=3.3 as=0 ps=0 w=1 l=0.5
X6275 rr3t3r_0[37|14]/a_860_290# WL37 SL14 VSS sky130_fd_pr__nfet_g5v0d10v5 ad=0.65 pd=3.3 as=0 ps=0 w=1 l=0.5
X6276 BLP14 rr3t3r_0[38|14]/a_60_290# sky130_fd_pr_reram__reram_cell area_ox=0.0676
X6277 BLZ14 rr3t3r_0[38|14]/a_460_290# sky130_fd_pr_reram__reram_cell area_ox=0.0676
X6278 rr3t3r_0[38|14]/a_460_290# WL38 SL14 VSS sky130_fd_pr__nfet_g5v0d10v5 ad=0.65 pd=3.3 as=0 ps=0 w=1 l=0.5
X6279 BLN14 rr3t3r_0[38|14]/a_860_290# sky130_fd_pr_reram__reram_cell area_ox=0.0676
X6280 rr3t3r_0[38|14]/a_60_290# WL38 SL14 VSS sky130_fd_pr__nfet_g5v0d10v5 ad=0.65 pd=3.3 as=0 ps=0 w=1 l=0.5
X6281 rr3t3r_0[38|14]/a_860_290# WL38 SL14 VSS sky130_fd_pr__nfet_g5v0d10v5 ad=0.65 pd=3.3 as=0 ps=0 w=1 l=0.5
X6282 BLP14 rr3t3r_0[39|14]/a_60_290# sky130_fd_pr_reram__reram_cell area_ox=0.0676
X6283 BLZ14 rr3t3r_0[39|14]/a_460_290# sky130_fd_pr_reram__reram_cell area_ox=0.0676
X6284 rr3t3r_0[39|14]/a_460_290# WL39 SL14 VSS sky130_fd_pr__nfet_g5v0d10v5 ad=0.65 pd=3.3 as=0 ps=0 w=1 l=0.5
X6285 BLN14 rr3t3r_0[39|14]/a_860_290# sky130_fd_pr_reram__reram_cell area_ox=0.0676
X6286 rr3t3r_0[39|14]/a_60_290# WL39 SL14 VSS sky130_fd_pr__nfet_g5v0d10v5 ad=0.65 pd=3.3 as=0 ps=0 w=1 l=0.5
X6287 rr3t3r_0[39|14]/a_860_290# WL39 SL14 VSS sky130_fd_pr__nfet_g5v0d10v5 ad=0.65 pd=3.3 as=0 ps=0 w=1 l=0.5
X6288 BLP14 rr3t3r_0[40|14]/a_60_290# sky130_fd_pr_reram__reram_cell area_ox=0.0676
X6289 BLZ14 rr3t3r_0[40|14]/a_460_290# sky130_fd_pr_reram__reram_cell area_ox=0.0676
X6290 rr3t3r_0[40|14]/a_460_290# WL40 SL14 VSS sky130_fd_pr__nfet_g5v0d10v5 ad=0.65 pd=3.3 as=0 ps=0 w=1 l=0.5
X6291 BLN14 rr3t3r_0[40|14]/a_860_290# sky130_fd_pr_reram__reram_cell area_ox=0.0676
X6292 rr3t3r_0[40|14]/a_60_290# WL40 SL14 VSS sky130_fd_pr__nfet_g5v0d10v5 ad=0.65 pd=3.3 as=0 ps=0 w=1 l=0.5
X6293 rr3t3r_0[40|14]/a_860_290# WL40 SL14 VSS sky130_fd_pr__nfet_g5v0d10v5 ad=0.65 pd=3.3 as=0 ps=0 w=1 l=0.5
X6294 BLP14 rr3t3r_0[41|14]/a_60_290# sky130_fd_pr_reram__reram_cell area_ox=0.0676
X6295 BLZ14 rr3t3r_0[41|14]/a_460_290# sky130_fd_pr_reram__reram_cell area_ox=0.0676
X6296 rr3t3r_0[41|14]/a_460_290# WL41 SL14 VSS sky130_fd_pr__nfet_g5v0d10v5 ad=0.65 pd=3.3 as=0 ps=0 w=1 l=0.5
X6297 BLN14 rr3t3r_0[41|14]/a_860_290# sky130_fd_pr_reram__reram_cell area_ox=0.0676
X6298 rr3t3r_0[41|14]/a_60_290# WL41 SL14 VSS sky130_fd_pr__nfet_g5v0d10v5 ad=0.65 pd=3.3 as=0 ps=0 w=1 l=0.5
X6299 rr3t3r_0[41|14]/a_860_290# WL41 SL14 VSS sky130_fd_pr__nfet_g5v0d10v5 ad=0.65 pd=3.3 as=0 ps=0 w=1 l=0.5
X6300 BLP14 rr3t3r_0[42|14]/a_60_290# sky130_fd_pr_reram__reram_cell area_ox=0.0676
X6301 BLZ14 rr3t3r_0[42|14]/a_460_290# sky130_fd_pr_reram__reram_cell area_ox=0.0676
X6302 rr3t3r_0[42|14]/a_460_290# WL42 SL14 VSS sky130_fd_pr__nfet_g5v0d10v5 ad=0.65 pd=3.3 as=0 ps=0 w=1 l=0.5
X6303 BLN14 rr3t3r_0[42|14]/a_860_290# sky130_fd_pr_reram__reram_cell area_ox=0.0676
X6304 rr3t3r_0[42|14]/a_60_290# WL42 SL14 VSS sky130_fd_pr__nfet_g5v0d10v5 ad=0.65 pd=3.3 as=0 ps=0 w=1 l=0.5
X6305 rr3t3r_0[42|14]/a_860_290# WL42 SL14 VSS sky130_fd_pr__nfet_g5v0d10v5 ad=0.65 pd=3.3 as=0 ps=0 w=1 l=0.5
X6306 BLP14 rr3t3r_0[43|14]/a_60_290# sky130_fd_pr_reram__reram_cell area_ox=0.0676
X6307 BLZ14 rr3t3r_0[43|14]/a_460_290# sky130_fd_pr_reram__reram_cell area_ox=0.0676
X6308 rr3t3r_0[43|14]/a_460_290# WL43 SL14 VSS sky130_fd_pr__nfet_g5v0d10v5 ad=0.65 pd=3.3 as=0 ps=0 w=1 l=0.5
X6309 BLN14 rr3t3r_0[43|14]/a_860_290# sky130_fd_pr_reram__reram_cell area_ox=0.0676
X6310 rr3t3r_0[43|14]/a_60_290# WL43 SL14 VSS sky130_fd_pr__nfet_g5v0d10v5 ad=0.65 pd=3.3 as=0 ps=0 w=1 l=0.5
X6311 rr3t3r_0[43|14]/a_860_290# WL43 SL14 VSS sky130_fd_pr__nfet_g5v0d10v5 ad=0.65 pd=3.3 as=0 ps=0 w=1 l=0.5
X6312 BLP14 rr3t3r_0[44|14]/a_60_290# sky130_fd_pr_reram__reram_cell area_ox=0.0676
X6313 BLZ14 rr3t3r_0[44|14]/a_460_290# sky130_fd_pr_reram__reram_cell area_ox=0.0676
X6314 rr3t3r_0[44|14]/a_460_290# WL44 SL14 VSS sky130_fd_pr__nfet_g5v0d10v5 ad=0.65 pd=3.3 as=0 ps=0 w=1 l=0.5
X6315 BLN14 rr3t3r_0[44|14]/a_860_290# sky130_fd_pr_reram__reram_cell area_ox=0.0676
X6316 rr3t3r_0[44|14]/a_60_290# WL44 SL14 VSS sky130_fd_pr__nfet_g5v0d10v5 ad=0.65 pd=3.3 as=0 ps=0 w=1 l=0.5
X6317 rr3t3r_0[44|14]/a_860_290# WL44 SL14 VSS sky130_fd_pr__nfet_g5v0d10v5 ad=0.65 pd=3.3 as=0 ps=0 w=1 l=0.5
X6318 BLP14 rr3t3r_0[45|14]/a_60_290# sky130_fd_pr_reram__reram_cell area_ox=0.0676
X6319 BLZ14 rr3t3r_0[45|14]/a_460_290# sky130_fd_pr_reram__reram_cell area_ox=0.0676
X6320 rr3t3r_0[45|14]/a_460_290# WL45 SL14 VSS sky130_fd_pr__nfet_g5v0d10v5 ad=0.65 pd=3.3 as=0 ps=0 w=1 l=0.5
X6321 BLN14 rr3t3r_0[45|14]/a_860_290# sky130_fd_pr_reram__reram_cell area_ox=0.0676
X6322 rr3t3r_0[45|14]/a_60_290# WL45 SL14 VSS sky130_fd_pr__nfet_g5v0d10v5 ad=0.65 pd=3.3 as=0 ps=0 w=1 l=0.5
X6323 rr3t3r_0[45|14]/a_860_290# WL45 SL14 VSS sky130_fd_pr__nfet_g5v0d10v5 ad=0.65 pd=3.3 as=0 ps=0 w=1 l=0.5
X6324 BLP14 rr3t3r_0[46|14]/a_60_290# sky130_fd_pr_reram__reram_cell area_ox=0.0676
X6325 BLZ14 rr3t3r_0[46|14]/a_460_290# sky130_fd_pr_reram__reram_cell area_ox=0.0676
X6326 rr3t3r_0[46|14]/a_460_290# WL46 SL14 VSS sky130_fd_pr__nfet_g5v0d10v5 ad=0.65 pd=3.3 as=0 ps=0 w=1 l=0.5
X6327 BLN14 rr3t3r_0[46|14]/a_860_290# sky130_fd_pr_reram__reram_cell area_ox=0.0676
X6328 rr3t3r_0[46|14]/a_60_290# WL46 SL14 VSS sky130_fd_pr__nfet_g5v0d10v5 ad=0.65 pd=3.3 as=0 ps=0 w=1 l=0.5
X6329 rr3t3r_0[46|14]/a_860_290# WL46 SL14 VSS sky130_fd_pr__nfet_g5v0d10v5 ad=0.65 pd=3.3 as=0 ps=0 w=1 l=0.5
X6330 BLP14 rr3t3r_0[47|14]/a_60_290# sky130_fd_pr_reram__reram_cell area_ox=0.0676
X6331 BLZ14 rr3t3r_0[47|14]/a_460_290# sky130_fd_pr_reram__reram_cell area_ox=0.0676
X6332 rr3t3r_0[47|14]/a_460_290# WL47 SL14 VSS sky130_fd_pr__nfet_g5v0d10v5 ad=0.65 pd=3.3 as=0 ps=0 w=1 l=0.5
X6333 BLN14 rr3t3r_0[47|14]/a_860_290# sky130_fd_pr_reram__reram_cell area_ox=0.0676
X6334 rr3t3r_0[47|14]/a_60_290# WL47 SL14 VSS sky130_fd_pr__nfet_g5v0d10v5 ad=0.65 pd=3.3 as=0 ps=0 w=1 l=0.5
X6335 rr3t3r_0[47|14]/a_860_290# WL47 SL14 VSS sky130_fd_pr__nfet_g5v0d10v5 ad=0.65 pd=3.3 as=0 ps=0 w=1 l=0.5
X6336 BLP14 rr3t3r_0[48|14]/a_60_290# sky130_fd_pr_reram__reram_cell area_ox=0.0676
X6337 BLZ14 rr3t3r_0[48|14]/a_460_290# sky130_fd_pr_reram__reram_cell area_ox=0.0676
X6338 rr3t3r_0[48|14]/a_460_290# WL48 SL14 VSS sky130_fd_pr__nfet_g5v0d10v5 ad=0.65 pd=3.3 as=0 ps=0 w=1 l=0.5
X6339 BLN14 rr3t3r_0[48|14]/a_860_290# sky130_fd_pr_reram__reram_cell area_ox=0.0676
X6340 rr3t3r_0[48|14]/a_60_290# WL48 SL14 VSS sky130_fd_pr__nfet_g5v0d10v5 ad=0.65 pd=3.3 as=0 ps=0 w=1 l=0.5
X6341 rr3t3r_0[48|14]/a_860_290# WL48 SL14 VSS sky130_fd_pr__nfet_g5v0d10v5 ad=0.65 pd=3.3 as=0 ps=0 w=1 l=0.5
X6342 BLP14 rr3t3r_0[49|14]/a_60_290# sky130_fd_pr_reram__reram_cell area_ox=0.0676
X6343 BLZ14 rr3t3r_0[49|14]/a_460_290# sky130_fd_pr_reram__reram_cell area_ox=0.0676
X6344 rr3t3r_0[49|14]/a_460_290# WL49 SL14 VSS sky130_fd_pr__nfet_g5v0d10v5 ad=0.65 pd=3.3 as=0 ps=0 w=1 l=0.5
X6345 BLN14 rr3t3r_0[49|14]/a_860_290# sky130_fd_pr_reram__reram_cell area_ox=0.0676
X6346 rr3t3r_0[49|14]/a_60_290# WL49 SL14 VSS sky130_fd_pr__nfet_g5v0d10v5 ad=0.65 pd=3.3 as=0 ps=0 w=1 l=0.5
X6347 rr3t3r_0[49|14]/a_860_290# WL49 SL14 VSS sky130_fd_pr__nfet_g5v0d10v5 ad=0.65 pd=3.3 as=0 ps=0 w=1 l=0.5
X6348 BLP14 rr3t3r_0[50|14]/a_60_290# sky130_fd_pr_reram__reram_cell area_ox=0.0676
X6349 BLZ14 rr3t3r_0[50|14]/a_460_290# sky130_fd_pr_reram__reram_cell area_ox=0.0676
X6350 rr3t3r_0[50|14]/a_460_290# WL50 SL14 VSS sky130_fd_pr__nfet_g5v0d10v5 ad=0.65 pd=3.3 as=0 ps=0 w=1 l=0.5
X6351 BLN14 rr3t3r_0[50|14]/a_860_290# sky130_fd_pr_reram__reram_cell area_ox=0.0676
X6352 rr3t3r_0[50|14]/a_60_290# WL50 SL14 VSS sky130_fd_pr__nfet_g5v0d10v5 ad=0.65 pd=3.3 as=0 ps=0 w=1 l=0.5
X6353 rr3t3r_0[50|14]/a_860_290# WL50 SL14 VSS sky130_fd_pr__nfet_g5v0d10v5 ad=0.65 pd=3.3 as=0 ps=0 w=1 l=0.5
X6354 BLP14 rr3t3r_0[51|14]/a_60_290# sky130_fd_pr_reram__reram_cell area_ox=0.0676
X6355 BLZ14 rr3t3r_0[51|14]/a_460_290# sky130_fd_pr_reram__reram_cell area_ox=0.0676
X6356 rr3t3r_0[51|14]/a_460_290# WL51 SL14 VSS sky130_fd_pr__nfet_g5v0d10v5 ad=0.65 pd=3.3 as=0 ps=0 w=1 l=0.5
X6357 BLN14 rr3t3r_0[51|14]/a_860_290# sky130_fd_pr_reram__reram_cell area_ox=0.0676
X6358 rr3t3r_0[51|14]/a_60_290# WL51 SL14 VSS sky130_fd_pr__nfet_g5v0d10v5 ad=0.65 pd=3.3 as=0 ps=0 w=1 l=0.5
X6359 rr3t3r_0[51|14]/a_860_290# WL51 SL14 VSS sky130_fd_pr__nfet_g5v0d10v5 ad=0.65 pd=3.3 as=0 ps=0 w=1 l=0.5
X6360 BLP14 rr3t3r_0[52|14]/a_60_290# sky130_fd_pr_reram__reram_cell area_ox=0.0676
X6361 BLZ14 rr3t3r_0[52|14]/a_460_290# sky130_fd_pr_reram__reram_cell area_ox=0.0676
X6362 rr3t3r_0[52|14]/a_460_290# WL52 SL14 VSS sky130_fd_pr__nfet_g5v0d10v5 ad=0.65 pd=3.3 as=0 ps=0 w=1 l=0.5
X6363 BLN14 rr3t3r_0[52|14]/a_860_290# sky130_fd_pr_reram__reram_cell area_ox=0.0676
X6364 rr3t3r_0[52|14]/a_60_290# WL52 SL14 VSS sky130_fd_pr__nfet_g5v0d10v5 ad=0.65 pd=3.3 as=0 ps=0 w=1 l=0.5
X6365 rr3t3r_0[52|14]/a_860_290# WL52 SL14 VSS sky130_fd_pr__nfet_g5v0d10v5 ad=0.65 pd=3.3 as=0 ps=0 w=1 l=0.5
X6366 BLP14 rr3t3r_0[53|14]/a_60_290# sky130_fd_pr_reram__reram_cell area_ox=0.0676
X6367 BLZ14 rr3t3r_0[53|14]/a_460_290# sky130_fd_pr_reram__reram_cell area_ox=0.0676
X6368 rr3t3r_0[53|14]/a_460_290# WL53 SL14 VSS sky130_fd_pr__nfet_g5v0d10v5 ad=0.65 pd=3.3 as=0 ps=0 w=1 l=0.5
X6369 BLN14 rr3t3r_0[53|14]/a_860_290# sky130_fd_pr_reram__reram_cell area_ox=0.0676
X6370 rr3t3r_0[53|14]/a_60_290# WL53 SL14 VSS sky130_fd_pr__nfet_g5v0d10v5 ad=0.65 pd=3.3 as=0 ps=0 w=1 l=0.5
X6371 rr3t3r_0[53|14]/a_860_290# WL53 SL14 VSS sky130_fd_pr__nfet_g5v0d10v5 ad=0.65 pd=3.3 as=0 ps=0 w=1 l=0.5
X6372 BLP14 rr3t3r_0[54|14]/a_60_290# sky130_fd_pr_reram__reram_cell area_ox=0.0676
X6373 BLZ14 rr3t3r_0[54|14]/a_460_290# sky130_fd_pr_reram__reram_cell area_ox=0.0676
X6374 rr3t3r_0[54|14]/a_460_290# WL54 SL14 VSS sky130_fd_pr__nfet_g5v0d10v5 ad=0.65 pd=3.3 as=0 ps=0 w=1 l=0.5
X6375 BLN14 rr3t3r_0[54|14]/a_860_290# sky130_fd_pr_reram__reram_cell area_ox=0.0676
X6376 rr3t3r_0[54|14]/a_60_290# WL54 SL14 VSS sky130_fd_pr__nfet_g5v0d10v5 ad=0.65 pd=3.3 as=0 ps=0 w=1 l=0.5
X6377 rr3t3r_0[54|14]/a_860_290# WL54 SL14 VSS sky130_fd_pr__nfet_g5v0d10v5 ad=0.65 pd=3.3 as=0 ps=0 w=1 l=0.5
X6378 BLP14 rr3t3r_0[55|14]/a_60_290# sky130_fd_pr_reram__reram_cell area_ox=0.0676
X6379 BLZ14 rr3t3r_0[55|14]/a_460_290# sky130_fd_pr_reram__reram_cell area_ox=0.0676
X6380 rr3t3r_0[55|14]/a_460_290# WL55 SL14 VSS sky130_fd_pr__nfet_g5v0d10v5 ad=0.65 pd=3.3 as=0 ps=0 w=1 l=0.5
X6381 BLN14 rr3t3r_0[55|14]/a_860_290# sky130_fd_pr_reram__reram_cell area_ox=0.0676
X6382 rr3t3r_0[55|14]/a_60_290# WL55 SL14 VSS sky130_fd_pr__nfet_g5v0d10v5 ad=0.65 pd=3.3 as=0 ps=0 w=1 l=0.5
X6383 rr3t3r_0[55|14]/a_860_290# WL55 SL14 VSS sky130_fd_pr__nfet_g5v0d10v5 ad=0.65 pd=3.3 as=0 ps=0 w=1 l=0.5
X6384 BLP14 rr3t3r_0[56|14]/a_60_290# sky130_fd_pr_reram__reram_cell area_ox=0.0676
X6385 BLZ14 rr3t3r_0[56|14]/a_460_290# sky130_fd_pr_reram__reram_cell area_ox=0.0676
X6386 rr3t3r_0[56|14]/a_460_290# WL56 SL14 VSS sky130_fd_pr__nfet_g5v0d10v5 ad=0.65 pd=3.3 as=0 ps=0 w=1 l=0.5
X6387 BLN14 rr3t3r_0[56|14]/a_860_290# sky130_fd_pr_reram__reram_cell area_ox=0.0676
X6388 rr3t3r_0[56|14]/a_60_290# WL56 SL14 VSS sky130_fd_pr__nfet_g5v0d10v5 ad=0.65 pd=3.3 as=0 ps=0 w=1 l=0.5
X6389 rr3t3r_0[56|14]/a_860_290# WL56 SL14 VSS sky130_fd_pr__nfet_g5v0d10v5 ad=0.65 pd=3.3 as=0 ps=0 w=1 l=0.5
X6390 BLP14 rr3t3r_0[57|14]/a_60_290# sky130_fd_pr_reram__reram_cell area_ox=0.0676
X6391 BLZ14 rr3t3r_0[57|14]/a_460_290# sky130_fd_pr_reram__reram_cell area_ox=0.0676
X6392 rr3t3r_0[57|14]/a_460_290# WL57 SL14 VSS sky130_fd_pr__nfet_g5v0d10v5 ad=0.65 pd=3.3 as=0 ps=0 w=1 l=0.5
X6393 BLN14 rr3t3r_0[57|14]/a_860_290# sky130_fd_pr_reram__reram_cell area_ox=0.0676
X6394 rr3t3r_0[57|14]/a_60_290# WL57 SL14 VSS sky130_fd_pr__nfet_g5v0d10v5 ad=0.65 pd=3.3 as=0 ps=0 w=1 l=0.5
X6395 rr3t3r_0[57|14]/a_860_290# WL57 SL14 VSS sky130_fd_pr__nfet_g5v0d10v5 ad=0.65 pd=3.3 as=0 ps=0 w=1 l=0.5
X6396 BLP14 rr3t3r_0[58|14]/a_60_290# sky130_fd_pr_reram__reram_cell area_ox=0.0676
X6397 BLZ14 rr3t3r_0[58|14]/a_460_290# sky130_fd_pr_reram__reram_cell area_ox=0.0676
X6398 rr3t3r_0[58|14]/a_460_290# WL58 SL14 VSS sky130_fd_pr__nfet_g5v0d10v5 ad=0.65 pd=3.3 as=0 ps=0 w=1 l=0.5
X6399 BLN14 rr3t3r_0[58|14]/a_860_290# sky130_fd_pr_reram__reram_cell area_ox=0.0676
X6400 rr3t3r_0[58|14]/a_60_290# WL58 SL14 VSS sky130_fd_pr__nfet_g5v0d10v5 ad=0.65 pd=3.3 as=0 ps=0 w=1 l=0.5
X6401 rr3t3r_0[58|14]/a_860_290# WL58 SL14 VSS sky130_fd_pr__nfet_g5v0d10v5 ad=0.65 pd=3.3 as=0 ps=0 w=1 l=0.5
X6402 BLP14 rr3t3r_0[59|14]/a_60_290# sky130_fd_pr_reram__reram_cell area_ox=0.0676
X6403 BLZ14 rr3t3r_0[59|14]/a_460_290# sky130_fd_pr_reram__reram_cell area_ox=0.0676
X6404 rr3t3r_0[59|14]/a_460_290# WL59 SL14 VSS sky130_fd_pr__nfet_g5v0d10v5 ad=0.65 pd=3.3 as=0 ps=0 w=1 l=0.5
X6405 BLN14 rr3t3r_0[59|14]/a_860_290# sky130_fd_pr_reram__reram_cell area_ox=0.0676
X6406 rr3t3r_0[59|14]/a_60_290# WL59 SL14 VSS sky130_fd_pr__nfet_g5v0d10v5 ad=0.65 pd=3.3 as=0 ps=0 w=1 l=0.5
X6407 rr3t3r_0[59|14]/a_860_290# WL59 SL14 VSS sky130_fd_pr__nfet_g5v0d10v5 ad=0.65 pd=3.3 as=0 ps=0 w=1 l=0.5
X6408 BLP14 rr3t3r_0[60|14]/a_60_290# sky130_fd_pr_reram__reram_cell area_ox=0.0676
X6409 BLZ14 rr3t3r_0[60|14]/a_460_290# sky130_fd_pr_reram__reram_cell area_ox=0.0676
X6410 rr3t3r_0[60|14]/a_460_290# WL60 SL14 VSS sky130_fd_pr__nfet_g5v0d10v5 ad=0.65 pd=3.3 as=0 ps=0 w=1 l=0.5
X6411 BLN14 rr3t3r_0[60|14]/a_860_290# sky130_fd_pr_reram__reram_cell area_ox=0.0676
X6412 rr3t3r_0[60|14]/a_60_290# WL60 SL14 VSS sky130_fd_pr__nfet_g5v0d10v5 ad=0.65 pd=3.3 as=0 ps=0 w=1 l=0.5
X6413 rr3t3r_0[60|14]/a_860_290# WL60 SL14 VSS sky130_fd_pr__nfet_g5v0d10v5 ad=0.65 pd=3.3 as=0 ps=0 w=1 l=0.5
X6414 BLP14 rr3t3r_0[61|14]/a_60_290# sky130_fd_pr_reram__reram_cell area_ox=0.0676
X6415 BLZ14 rr3t3r_0[61|14]/a_460_290# sky130_fd_pr_reram__reram_cell area_ox=0.0676
X6416 rr3t3r_0[61|14]/a_460_290# WL61 SL14 VSS sky130_fd_pr__nfet_g5v0d10v5 ad=0.65 pd=3.3 as=0 ps=0 w=1 l=0.5
X6417 BLN14 rr3t3r_0[61|14]/a_860_290# sky130_fd_pr_reram__reram_cell area_ox=0.0676
X6418 rr3t3r_0[61|14]/a_60_290# WL61 SL14 VSS sky130_fd_pr__nfet_g5v0d10v5 ad=0.65 pd=3.3 as=0 ps=0 w=1 l=0.5
X6419 rr3t3r_0[61|14]/a_860_290# WL61 SL14 VSS sky130_fd_pr__nfet_g5v0d10v5 ad=0.65 pd=3.3 as=0 ps=0 w=1 l=0.5
X6420 BLP14 rr3t3r_0[62|14]/a_60_290# sky130_fd_pr_reram__reram_cell area_ox=0.0676
X6421 BLZ14 rr3t3r_0[62|14]/a_460_290# sky130_fd_pr_reram__reram_cell area_ox=0.0676
X6422 rr3t3r_0[62|14]/a_460_290# WL62 SL14 VSS sky130_fd_pr__nfet_g5v0d10v5 ad=0.65 pd=3.3 as=0 ps=0 w=1 l=0.5
X6423 BLN14 rr3t3r_0[62|14]/a_860_290# sky130_fd_pr_reram__reram_cell area_ox=0.0676
X6424 rr3t3r_0[62|14]/a_60_290# WL62 SL14 VSS sky130_fd_pr__nfet_g5v0d10v5 ad=0.65 pd=3.3 as=0 ps=0 w=1 l=0.5
X6425 rr3t3r_0[62|14]/a_860_290# WL62 SL14 VSS sky130_fd_pr__nfet_g5v0d10v5 ad=0.65 pd=3.3 as=0 ps=0 w=1 l=0.5
X6426 BLP14 rr3t3r_0[63|14]/a_60_290# sky130_fd_pr_reram__reram_cell area_ox=0.0676
X6427 BLZ14 rr3t3r_0[63|14]/a_460_290# sky130_fd_pr_reram__reram_cell area_ox=0.0676
X6428 rr3t3r_0[63|14]/a_460_290# WL63 SL14 VSS sky130_fd_pr__nfet_g5v0d10v5 ad=0.65 pd=3.3 as=0 ps=0 w=1 l=0.5
X6429 BLN14 rr3t3r_0[63|14]/a_860_290# sky130_fd_pr_reram__reram_cell area_ox=0.0676
X6430 rr3t3r_0[63|14]/a_60_290# WL63 SL14 VSS sky130_fd_pr__nfet_g5v0d10v5 ad=0.65 pd=3.3 as=0 ps=0 w=1 l=0.5
X6431 rr3t3r_0[63|14]/a_860_290# WL63 SL14 VSS sky130_fd_pr__nfet_g5v0d10v5 ad=0.65 pd=3.3 as=0 ps=0 w=1 l=0.5
X6432 BLP14 rr3t3r_0[64|14]/a_60_290# sky130_fd_pr_reram__reram_cell area_ox=0.0676
X6433 BLZ14 rr3t3r_0[64|14]/a_460_290# sky130_fd_pr_reram__reram_cell area_ox=0.0676
X6434 rr3t3r_0[64|14]/a_460_290# WL64 SL14 VSS sky130_fd_pr__nfet_g5v0d10v5 ad=0.65 pd=3.3 as=0 ps=0 w=1 l=0.5
X6435 BLN14 rr3t3r_0[64|14]/a_860_290# sky130_fd_pr_reram__reram_cell area_ox=0.0676
X6436 rr3t3r_0[64|14]/a_60_290# WL64 SL14 VSS sky130_fd_pr__nfet_g5v0d10v5 ad=0.65 pd=3.3 as=0 ps=0 w=1 l=0.5
X6437 rr3t3r_0[64|14]/a_860_290# WL64 SL14 VSS sky130_fd_pr__nfet_g5v0d10v5 ad=0.65 pd=3.3 as=0 ps=0 w=1 l=0.5
X6438 BLP14 rr3t3r_0[65|14]/a_60_290# sky130_fd_pr_reram__reram_cell area_ox=0.0676
X6439 BLZ14 rr3t3r_0[65|14]/a_460_290# sky130_fd_pr_reram__reram_cell area_ox=0.0676
X6440 rr3t3r_0[65|14]/a_460_290# WL65 SL14 VSS sky130_fd_pr__nfet_g5v0d10v5 ad=0.65 pd=3.3 as=0 ps=0 w=1 l=0.5
X6441 BLN14 rr3t3r_0[65|14]/a_860_290# sky130_fd_pr_reram__reram_cell area_ox=0.0676
X6442 rr3t3r_0[65|14]/a_60_290# WL65 SL14 VSS sky130_fd_pr__nfet_g5v0d10v5 ad=0.65 pd=3.3 as=0 ps=0 w=1 l=0.5
X6443 rr3t3r_0[65|14]/a_860_290# WL65 SL14 VSS sky130_fd_pr__nfet_g5v0d10v5 ad=0.65 pd=3.3 as=0 ps=0 w=1 l=0.5
X6444 BLP14 rr3t3r_0[66|14]/a_60_290# sky130_fd_pr_reram__reram_cell area_ox=0.0676
X6445 BLZ14 rr3t3r_0[66|14]/a_460_290# sky130_fd_pr_reram__reram_cell area_ox=0.0676
X6446 rr3t3r_0[66|14]/a_460_290# WL66 SL14 VSS sky130_fd_pr__nfet_g5v0d10v5 ad=0.65 pd=3.3 as=0 ps=0 w=1 l=0.5
X6447 BLN14 rr3t3r_0[66|14]/a_860_290# sky130_fd_pr_reram__reram_cell area_ox=0.0676
X6448 rr3t3r_0[66|14]/a_60_290# WL66 SL14 VSS sky130_fd_pr__nfet_g5v0d10v5 ad=0.65 pd=3.3 as=0 ps=0 w=1 l=0.5
X6449 rr3t3r_0[66|14]/a_860_290# WL66 SL14 VSS sky130_fd_pr__nfet_g5v0d10v5 ad=0.65 pd=3.3 as=0 ps=0 w=1 l=0.5
X6450 BLP14 rr3t3r_0[67|14]/a_60_290# sky130_fd_pr_reram__reram_cell area_ox=0.0676
X6451 BLZ14 rr3t3r_0[67|14]/a_460_290# sky130_fd_pr_reram__reram_cell area_ox=0.0676
X6452 rr3t3r_0[67|14]/a_460_290# WL67 SL14 VSS sky130_fd_pr__nfet_g5v0d10v5 ad=0.65 pd=3.3 as=0 ps=0 w=1 l=0.5
X6453 BLN14 rr3t3r_0[67|14]/a_860_290# sky130_fd_pr_reram__reram_cell area_ox=0.0676
X6454 rr3t3r_0[67|14]/a_60_290# WL67 SL14 VSS sky130_fd_pr__nfet_g5v0d10v5 ad=0.65 pd=3.3 as=0 ps=0 w=1 l=0.5
X6455 rr3t3r_0[67|14]/a_860_290# WL67 SL14 VSS sky130_fd_pr__nfet_g5v0d10v5 ad=0.65 pd=3.3 as=0 ps=0 w=1 l=0.5
X6456 BLP14 rr3t3r_0[68|14]/a_60_290# sky130_fd_pr_reram__reram_cell area_ox=0.0676
X6457 BLZ14 rr3t3r_0[68|14]/a_460_290# sky130_fd_pr_reram__reram_cell area_ox=0.0676
X6458 rr3t3r_0[68|14]/a_460_290# WL68 SL14 VSS sky130_fd_pr__nfet_g5v0d10v5 ad=0.65 pd=3.3 as=0 ps=0 w=1 l=0.5
X6459 BLN14 rr3t3r_0[68|14]/a_860_290# sky130_fd_pr_reram__reram_cell area_ox=0.0676
X6460 rr3t3r_0[68|14]/a_60_290# WL68 SL14 VSS sky130_fd_pr__nfet_g5v0d10v5 ad=0.65 pd=3.3 as=0 ps=0 w=1 l=0.5
X6461 rr3t3r_0[68|14]/a_860_290# WL68 SL14 VSS sky130_fd_pr__nfet_g5v0d10v5 ad=0.65 pd=3.3 as=0 ps=0 w=1 l=0.5
X6462 BLP14 rr3t3r_0[69|14]/a_60_290# sky130_fd_pr_reram__reram_cell area_ox=0.0676
X6463 BLZ14 rr3t3r_0[69|14]/a_460_290# sky130_fd_pr_reram__reram_cell area_ox=0.0676
X6464 rr3t3r_0[69|14]/a_460_290# WL69 SL14 VSS sky130_fd_pr__nfet_g5v0d10v5 ad=0.65 pd=3.3 as=0 ps=0 w=1 l=0.5
X6465 BLN14 rr3t3r_0[69|14]/a_860_290# sky130_fd_pr_reram__reram_cell area_ox=0.0676
X6466 rr3t3r_0[69|14]/a_60_290# WL69 SL14 VSS sky130_fd_pr__nfet_g5v0d10v5 ad=0.65 pd=3.3 as=0 ps=0 w=1 l=0.5
X6467 rr3t3r_0[69|14]/a_860_290# WL69 SL14 VSS sky130_fd_pr__nfet_g5v0d10v5 ad=0.65 pd=3.3 as=0 ps=0 w=1 l=0.5
X6468 BLP14 rr3t3r_0[70|14]/a_60_290# sky130_fd_pr_reram__reram_cell area_ox=0.0676
X6469 BLZ14 rr3t3r_0[70|14]/a_460_290# sky130_fd_pr_reram__reram_cell area_ox=0.0676
X6470 rr3t3r_0[70|14]/a_460_290# WL70 SL14 VSS sky130_fd_pr__nfet_g5v0d10v5 ad=0.65 pd=3.3 as=0 ps=0 w=1 l=0.5
X6471 BLN14 rr3t3r_0[70|14]/a_860_290# sky130_fd_pr_reram__reram_cell area_ox=0.0676
X6472 rr3t3r_0[70|14]/a_60_290# WL70 SL14 VSS sky130_fd_pr__nfet_g5v0d10v5 ad=0.65 pd=3.3 as=0 ps=0 w=1 l=0.5
X6473 rr3t3r_0[70|14]/a_860_290# WL70 SL14 VSS sky130_fd_pr__nfet_g5v0d10v5 ad=0.65 pd=3.3 as=0 ps=0 w=1 l=0.5
X6474 BLP14 rr3t3r_0[71|14]/a_60_290# sky130_fd_pr_reram__reram_cell area_ox=0.0676
X6475 BLZ14 rr3t3r_0[71|14]/a_460_290# sky130_fd_pr_reram__reram_cell area_ox=0.0676
X6476 rr3t3r_0[71|14]/a_460_290# WL71 SL14 VSS sky130_fd_pr__nfet_g5v0d10v5 ad=0.65 pd=3.3 as=0 ps=0 w=1 l=0.5
X6477 BLN14 rr3t3r_0[71|14]/a_860_290# sky130_fd_pr_reram__reram_cell area_ox=0.0676
X6478 rr3t3r_0[71|14]/a_60_290# WL71 SL14 VSS sky130_fd_pr__nfet_g5v0d10v5 ad=0.65 pd=3.3 as=0 ps=0 w=1 l=0.5
X6479 rr3t3r_0[71|14]/a_860_290# WL71 SL14 VSS sky130_fd_pr__nfet_g5v0d10v5 ad=0.65 pd=3.3 as=0 ps=0 w=1 l=0.5
X6480 BLP15 rr3t3r_0[0|15]/a_60_290# sky130_fd_pr_reram__reram_cell area_ox=0.0676
X6481 BLZ15 rr3t3r_0[0|15]/a_460_290# sky130_fd_pr_reram__reram_cell area_ox=0.0676
X6482 rr3t3r_0[0|15]/a_460_290# WL0 SL15 VSS sky130_fd_pr__nfet_g5v0d10v5 ad=0.65 pd=3.3 as=162 ps=756 w=1 l=0.5
X6483 BLN15 rr3t3r_0[0|15]/a_860_290# sky130_fd_pr_reram__reram_cell area_ox=0.0676
X6484 rr3t3r_0[0|15]/a_60_290# WL0 SL15 VSS sky130_fd_pr__nfet_g5v0d10v5 ad=0.65 pd=3.3 as=0 ps=0 w=1 l=0.5
X6485 rr3t3r_0[0|15]/a_860_290# WL0 SL15 VSS sky130_fd_pr__nfet_g5v0d10v5 ad=0.65 pd=3.3 as=0 ps=0 w=1 l=0.5
X6486 BLP15 rr3t3r_0[1|15]/a_60_290# sky130_fd_pr_reram__reram_cell area_ox=0.0676
X6487 BLZ15 rr3t3r_0[1|15]/a_460_290# sky130_fd_pr_reram__reram_cell area_ox=0.0676
X6488 rr3t3r_0[1|15]/a_460_290# WL1 SL15 VSS sky130_fd_pr__nfet_g5v0d10v5 ad=0.65 pd=3.3 as=0 ps=0 w=1 l=0.5
X6489 BLN15 rr3t3r_0[1|15]/a_860_290# sky130_fd_pr_reram__reram_cell area_ox=0.0676
X6490 rr3t3r_0[1|15]/a_60_290# WL1 SL15 VSS sky130_fd_pr__nfet_g5v0d10v5 ad=0.65 pd=3.3 as=0 ps=0 w=1 l=0.5
X6491 rr3t3r_0[1|15]/a_860_290# WL1 SL15 VSS sky130_fd_pr__nfet_g5v0d10v5 ad=0.65 pd=3.3 as=0 ps=0 w=1 l=0.5
X6492 BLP15 rr3t3r_0[2|15]/a_60_290# sky130_fd_pr_reram__reram_cell area_ox=0.0676
X6493 BLZ15 rr3t3r_0[2|15]/a_460_290# sky130_fd_pr_reram__reram_cell area_ox=0.0676
X6494 rr3t3r_0[2|15]/a_460_290# WL2 SL15 VSS sky130_fd_pr__nfet_g5v0d10v5 ad=0.65 pd=3.3 as=0 ps=0 w=1 l=0.5
X6495 BLN15 rr3t3r_0[2|15]/a_860_290# sky130_fd_pr_reram__reram_cell area_ox=0.0676
X6496 rr3t3r_0[2|15]/a_60_290# WL2 SL15 VSS sky130_fd_pr__nfet_g5v0d10v5 ad=0.65 pd=3.3 as=0 ps=0 w=1 l=0.5
X6497 rr3t3r_0[2|15]/a_860_290# WL2 SL15 VSS sky130_fd_pr__nfet_g5v0d10v5 ad=0.65 pd=3.3 as=0 ps=0 w=1 l=0.5
X6498 BLP15 rr3t3r_0[3|15]/a_60_290# sky130_fd_pr_reram__reram_cell area_ox=0.0676
X6499 BLZ15 rr3t3r_0[3|15]/a_460_290# sky130_fd_pr_reram__reram_cell area_ox=0.0676
X6500 rr3t3r_0[3|15]/a_460_290# WL3 SL15 VSS sky130_fd_pr__nfet_g5v0d10v5 ad=0.65 pd=3.3 as=0 ps=0 w=1 l=0.5
X6501 BLN15 rr3t3r_0[3|15]/a_860_290# sky130_fd_pr_reram__reram_cell area_ox=0.0676
X6502 rr3t3r_0[3|15]/a_60_290# WL3 SL15 VSS sky130_fd_pr__nfet_g5v0d10v5 ad=0.65 pd=3.3 as=0 ps=0 w=1 l=0.5
X6503 rr3t3r_0[3|15]/a_860_290# WL3 SL15 VSS sky130_fd_pr__nfet_g5v0d10v5 ad=0.65 pd=3.3 as=0 ps=0 w=1 l=0.5
X6504 BLP15 rr3t3r_0[4|15]/a_60_290# sky130_fd_pr_reram__reram_cell area_ox=0.0676
X6505 BLZ15 rr3t3r_0[4|15]/a_460_290# sky130_fd_pr_reram__reram_cell area_ox=0.0676
X6506 rr3t3r_0[4|15]/a_460_290# WL4 SL15 VSS sky130_fd_pr__nfet_g5v0d10v5 ad=0.65 pd=3.3 as=0 ps=0 w=1 l=0.5
X6507 BLN15 rr3t3r_0[4|15]/a_860_290# sky130_fd_pr_reram__reram_cell area_ox=0.0676
X6508 rr3t3r_0[4|15]/a_60_290# WL4 SL15 VSS sky130_fd_pr__nfet_g5v0d10v5 ad=0.65 pd=3.3 as=0 ps=0 w=1 l=0.5
X6509 rr3t3r_0[4|15]/a_860_290# WL4 SL15 VSS sky130_fd_pr__nfet_g5v0d10v5 ad=0.65 pd=3.3 as=0 ps=0 w=1 l=0.5
X6510 BLP15 rr3t3r_0[5|15]/a_60_290# sky130_fd_pr_reram__reram_cell area_ox=0.0676
X6511 BLZ15 rr3t3r_0[5|15]/a_460_290# sky130_fd_pr_reram__reram_cell area_ox=0.0676
X6512 rr3t3r_0[5|15]/a_460_290# WL5 SL15 VSS sky130_fd_pr__nfet_g5v0d10v5 ad=0.65 pd=3.3 as=0 ps=0 w=1 l=0.5
X6513 BLN15 rr3t3r_0[5|15]/a_860_290# sky130_fd_pr_reram__reram_cell area_ox=0.0676
X6514 rr3t3r_0[5|15]/a_60_290# WL5 SL15 VSS sky130_fd_pr__nfet_g5v0d10v5 ad=0.65 pd=3.3 as=0 ps=0 w=1 l=0.5
X6515 rr3t3r_0[5|15]/a_860_290# WL5 SL15 VSS sky130_fd_pr__nfet_g5v0d10v5 ad=0.65 pd=3.3 as=0 ps=0 w=1 l=0.5
X6516 BLP15 rr3t3r_0[6|15]/a_60_290# sky130_fd_pr_reram__reram_cell area_ox=0.0676
X6517 BLZ15 rr3t3r_0[6|15]/a_460_290# sky130_fd_pr_reram__reram_cell area_ox=0.0676
X6518 rr3t3r_0[6|15]/a_460_290# WL6 SL15 VSS sky130_fd_pr__nfet_g5v0d10v5 ad=0.65 pd=3.3 as=0 ps=0 w=1 l=0.5
X6519 BLN15 rr3t3r_0[6|15]/a_860_290# sky130_fd_pr_reram__reram_cell area_ox=0.0676
X6520 rr3t3r_0[6|15]/a_60_290# WL6 SL15 VSS sky130_fd_pr__nfet_g5v0d10v5 ad=0.65 pd=3.3 as=0 ps=0 w=1 l=0.5
X6521 rr3t3r_0[6|15]/a_860_290# WL6 SL15 VSS sky130_fd_pr__nfet_g5v0d10v5 ad=0.65 pd=3.3 as=0 ps=0 w=1 l=0.5
X6522 BLP15 rr3t3r_0[7|15]/a_60_290# sky130_fd_pr_reram__reram_cell area_ox=0.0676
X6523 BLZ15 rr3t3r_0[7|15]/a_460_290# sky130_fd_pr_reram__reram_cell area_ox=0.0676
X6524 rr3t3r_0[7|15]/a_460_290# WL7 SL15 VSS sky130_fd_pr__nfet_g5v0d10v5 ad=0.65 pd=3.3 as=0 ps=0 w=1 l=0.5
X6525 BLN15 rr3t3r_0[7|15]/a_860_290# sky130_fd_pr_reram__reram_cell area_ox=0.0676
X6526 rr3t3r_0[7|15]/a_60_290# WL7 SL15 VSS sky130_fd_pr__nfet_g5v0d10v5 ad=0.65 pd=3.3 as=0 ps=0 w=1 l=0.5
X6527 rr3t3r_0[7|15]/a_860_290# WL7 SL15 VSS sky130_fd_pr__nfet_g5v0d10v5 ad=0.65 pd=3.3 as=0 ps=0 w=1 l=0.5
X6528 BLP15 rr3t3r_0[8|15]/a_60_290# sky130_fd_pr_reram__reram_cell area_ox=0.0676
X6529 BLZ15 rr3t3r_0[8|15]/a_460_290# sky130_fd_pr_reram__reram_cell area_ox=0.0676
X6530 rr3t3r_0[8|15]/a_460_290# WL8 SL15 VSS sky130_fd_pr__nfet_g5v0d10v5 ad=0.65 pd=3.3 as=0 ps=0 w=1 l=0.5
X6531 BLN15 rr3t3r_0[8|15]/a_860_290# sky130_fd_pr_reram__reram_cell area_ox=0.0676
X6532 rr3t3r_0[8|15]/a_60_290# WL8 SL15 VSS sky130_fd_pr__nfet_g5v0d10v5 ad=0.65 pd=3.3 as=0 ps=0 w=1 l=0.5
X6533 rr3t3r_0[8|15]/a_860_290# WL8 SL15 VSS sky130_fd_pr__nfet_g5v0d10v5 ad=0.65 pd=3.3 as=0 ps=0 w=1 l=0.5
X6534 BLP15 rr3t3r_0[9|15]/a_60_290# sky130_fd_pr_reram__reram_cell area_ox=0.0676
X6535 BLZ15 rr3t3r_0[9|15]/a_460_290# sky130_fd_pr_reram__reram_cell area_ox=0.0676
X6536 rr3t3r_0[9|15]/a_460_290# WL9 SL15 VSS sky130_fd_pr__nfet_g5v0d10v5 ad=0.65 pd=3.3 as=0 ps=0 w=1 l=0.5
X6537 BLN15 rr3t3r_0[9|15]/a_860_290# sky130_fd_pr_reram__reram_cell area_ox=0.0676
X6538 rr3t3r_0[9|15]/a_60_290# WL9 SL15 VSS sky130_fd_pr__nfet_g5v0d10v5 ad=0.65 pd=3.3 as=0 ps=0 w=1 l=0.5
X6539 rr3t3r_0[9|15]/a_860_290# WL9 SL15 VSS sky130_fd_pr__nfet_g5v0d10v5 ad=0.65 pd=3.3 as=0 ps=0 w=1 l=0.5
X6540 BLP15 rr3t3r_0[10|15]/a_60_290# sky130_fd_pr_reram__reram_cell area_ox=0.0676
X6541 BLZ15 rr3t3r_0[10|15]/a_460_290# sky130_fd_pr_reram__reram_cell area_ox=0.0676
X6542 rr3t3r_0[10|15]/a_460_290# WL10 SL15 VSS sky130_fd_pr__nfet_g5v0d10v5 ad=0.65 pd=3.3 as=0 ps=0 w=1 l=0.5
X6543 BLN15 rr3t3r_0[10|15]/a_860_290# sky130_fd_pr_reram__reram_cell area_ox=0.0676
X6544 rr3t3r_0[10|15]/a_60_290# WL10 SL15 VSS sky130_fd_pr__nfet_g5v0d10v5 ad=0.65 pd=3.3 as=0 ps=0 w=1 l=0.5
X6545 rr3t3r_0[10|15]/a_860_290# WL10 SL15 VSS sky130_fd_pr__nfet_g5v0d10v5 ad=0.65 pd=3.3 as=0 ps=0 w=1 l=0.5
X6546 BLP15 rr3t3r_0[11|15]/a_60_290# sky130_fd_pr_reram__reram_cell area_ox=0.0676
X6547 BLZ15 rr3t3r_0[11|15]/a_460_290# sky130_fd_pr_reram__reram_cell area_ox=0.0676
X6548 rr3t3r_0[11|15]/a_460_290# WL11 SL15 VSS sky130_fd_pr__nfet_g5v0d10v5 ad=0.65 pd=3.3 as=0 ps=0 w=1 l=0.5
X6549 BLN15 rr3t3r_0[11|15]/a_860_290# sky130_fd_pr_reram__reram_cell area_ox=0.0676
X6550 rr3t3r_0[11|15]/a_60_290# WL11 SL15 VSS sky130_fd_pr__nfet_g5v0d10v5 ad=0.65 pd=3.3 as=0 ps=0 w=1 l=0.5
X6551 rr3t3r_0[11|15]/a_860_290# WL11 SL15 VSS sky130_fd_pr__nfet_g5v0d10v5 ad=0.65 pd=3.3 as=0 ps=0 w=1 l=0.5
X6552 BLP15 rr3t3r_0[12|15]/a_60_290# sky130_fd_pr_reram__reram_cell area_ox=0.0676
X6553 BLZ15 rr3t3r_0[12|15]/a_460_290# sky130_fd_pr_reram__reram_cell area_ox=0.0676
X6554 rr3t3r_0[12|15]/a_460_290# WL12 SL15 VSS sky130_fd_pr__nfet_g5v0d10v5 ad=0.65 pd=3.3 as=0 ps=0 w=1 l=0.5
X6555 BLN15 rr3t3r_0[12|15]/a_860_290# sky130_fd_pr_reram__reram_cell area_ox=0.0676
X6556 rr3t3r_0[12|15]/a_60_290# WL12 SL15 VSS sky130_fd_pr__nfet_g5v0d10v5 ad=0.65 pd=3.3 as=0 ps=0 w=1 l=0.5
X6557 rr3t3r_0[12|15]/a_860_290# WL12 SL15 VSS sky130_fd_pr__nfet_g5v0d10v5 ad=0.65 pd=3.3 as=0 ps=0 w=1 l=0.5
X6558 BLP15 rr3t3r_0[13|15]/a_60_290# sky130_fd_pr_reram__reram_cell area_ox=0.0676
X6559 BLZ15 rr3t3r_0[13|15]/a_460_290# sky130_fd_pr_reram__reram_cell area_ox=0.0676
X6560 rr3t3r_0[13|15]/a_460_290# WL13 SL15 VSS sky130_fd_pr__nfet_g5v0d10v5 ad=0.65 pd=3.3 as=0 ps=0 w=1 l=0.5
X6561 BLN15 rr3t3r_0[13|15]/a_860_290# sky130_fd_pr_reram__reram_cell area_ox=0.0676
X6562 rr3t3r_0[13|15]/a_60_290# WL13 SL15 VSS sky130_fd_pr__nfet_g5v0d10v5 ad=0.65 pd=3.3 as=0 ps=0 w=1 l=0.5
X6563 rr3t3r_0[13|15]/a_860_290# WL13 SL15 VSS sky130_fd_pr__nfet_g5v0d10v5 ad=0.65 pd=3.3 as=0 ps=0 w=1 l=0.5
X6564 BLP15 rr3t3r_0[14|15]/a_60_290# sky130_fd_pr_reram__reram_cell area_ox=0.0676
X6565 BLZ15 rr3t3r_0[14|15]/a_460_290# sky130_fd_pr_reram__reram_cell area_ox=0.0676
X6566 rr3t3r_0[14|15]/a_460_290# WL14 SL15 VSS sky130_fd_pr__nfet_g5v0d10v5 ad=0.65 pd=3.3 as=0 ps=0 w=1 l=0.5
X6567 BLN15 rr3t3r_0[14|15]/a_860_290# sky130_fd_pr_reram__reram_cell area_ox=0.0676
X6568 rr3t3r_0[14|15]/a_60_290# WL14 SL15 VSS sky130_fd_pr__nfet_g5v0d10v5 ad=0.65 pd=3.3 as=0 ps=0 w=1 l=0.5
X6569 rr3t3r_0[14|15]/a_860_290# WL14 SL15 VSS sky130_fd_pr__nfet_g5v0d10v5 ad=0.65 pd=3.3 as=0 ps=0 w=1 l=0.5
X6570 BLP15 rr3t3r_0[15|15]/a_60_290# sky130_fd_pr_reram__reram_cell area_ox=0.0676
X6571 BLZ15 rr3t3r_0[15|15]/a_460_290# sky130_fd_pr_reram__reram_cell area_ox=0.0676
X6572 rr3t3r_0[15|15]/a_460_290# WL15 SL15 VSS sky130_fd_pr__nfet_g5v0d10v5 ad=0.65 pd=3.3 as=0 ps=0 w=1 l=0.5
X6573 BLN15 rr3t3r_0[15|15]/a_860_290# sky130_fd_pr_reram__reram_cell area_ox=0.0676
X6574 rr3t3r_0[15|15]/a_60_290# WL15 SL15 VSS sky130_fd_pr__nfet_g5v0d10v5 ad=0.65 pd=3.3 as=0 ps=0 w=1 l=0.5
X6575 rr3t3r_0[15|15]/a_860_290# WL15 SL15 VSS sky130_fd_pr__nfet_g5v0d10v5 ad=0.65 pd=3.3 as=0 ps=0 w=1 l=0.5
X6576 BLP15 rr3t3r_0[16|15]/a_60_290# sky130_fd_pr_reram__reram_cell area_ox=0.0676
X6577 BLZ15 rr3t3r_0[16|15]/a_460_290# sky130_fd_pr_reram__reram_cell area_ox=0.0676
X6578 rr3t3r_0[16|15]/a_460_290# WL16 SL15 VSS sky130_fd_pr__nfet_g5v0d10v5 ad=0.65 pd=3.3 as=0 ps=0 w=1 l=0.5
X6579 BLN15 rr3t3r_0[16|15]/a_860_290# sky130_fd_pr_reram__reram_cell area_ox=0.0676
X6580 rr3t3r_0[16|15]/a_60_290# WL16 SL15 VSS sky130_fd_pr__nfet_g5v0d10v5 ad=0.65 pd=3.3 as=0 ps=0 w=1 l=0.5
X6581 rr3t3r_0[16|15]/a_860_290# WL16 SL15 VSS sky130_fd_pr__nfet_g5v0d10v5 ad=0.65 pd=3.3 as=0 ps=0 w=1 l=0.5
X6582 BLP15 rr3t3r_0[17|15]/a_60_290# sky130_fd_pr_reram__reram_cell area_ox=0.0676
X6583 BLZ15 rr3t3r_0[17|15]/a_460_290# sky130_fd_pr_reram__reram_cell area_ox=0.0676
X6584 rr3t3r_0[17|15]/a_460_290# WL17 SL15 VSS sky130_fd_pr__nfet_g5v0d10v5 ad=0.65 pd=3.3 as=0 ps=0 w=1 l=0.5
X6585 BLN15 rr3t3r_0[17|15]/a_860_290# sky130_fd_pr_reram__reram_cell area_ox=0.0676
X6586 rr3t3r_0[17|15]/a_60_290# WL17 SL15 VSS sky130_fd_pr__nfet_g5v0d10v5 ad=0.65 pd=3.3 as=0 ps=0 w=1 l=0.5
X6587 rr3t3r_0[17|15]/a_860_290# WL17 SL15 VSS sky130_fd_pr__nfet_g5v0d10v5 ad=0.65 pd=3.3 as=0 ps=0 w=1 l=0.5
X6588 BLP15 rr3t3r_0[18|15]/a_60_290# sky130_fd_pr_reram__reram_cell area_ox=0.0676
X6589 BLZ15 rr3t3r_0[18|15]/a_460_290# sky130_fd_pr_reram__reram_cell area_ox=0.0676
X6590 rr3t3r_0[18|15]/a_460_290# WL18 SL15 VSS sky130_fd_pr__nfet_g5v0d10v5 ad=0.65 pd=3.3 as=0 ps=0 w=1 l=0.5
X6591 BLN15 rr3t3r_0[18|15]/a_860_290# sky130_fd_pr_reram__reram_cell area_ox=0.0676
X6592 rr3t3r_0[18|15]/a_60_290# WL18 SL15 VSS sky130_fd_pr__nfet_g5v0d10v5 ad=0.65 pd=3.3 as=0 ps=0 w=1 l=0.5
X6593 rr3t3r_0[18|15]/a_860_290# WL18 SL15 VSS sky130_fd_pr__nfet_g5v0d10v5 ad=0.65 pd=3.3 as=0 ps=0 w=1 l=0.5
X6594 BLP15 rr3t3r_0[19|15]/a_60_290# sky130_fd_pr_reram__reram_cell area_ox=0.0676
X6595 BLZ15 rr3t3r_0[19|15]/a_460_290# sky130_fd_pr_reram__reram_cell area_ox=0.0676
X6596 rr3t3r_0[19|15]/a_460_290# WL19 SL15 VSS sky130_fd_pr__nfet_g5v0d10v5 ad=0.65 pd=3.3 as=0 ps=0 w=1 l=0.5
X6597 BLN15 rr3t3r_0[19|15]/a_860_290# sky130_fd_pr_reram__reram_cell area_ox=0.0676
X6598 rr3t3r_0[19|15]/a_60_290# WL19 SL15 VSS sky130_fd_pr__nfet_g5v0d10v5 ad=0.65 pd=3.3 as=0 ps=0 w=1 l=0.5
X6599 rr3t3r_0[19|15]/a_860_290# WL19 SL15 VSS sky130_fd_pr__nfet_g5v0d10v5 ad=0.65 pd=3.3 as=0 ps=0 w=1 l=0.5
X6600 BLP15 rr3t3r_0[20|15]/a_60_290# sky130_fd_pr_reram__reram_cell area_ox=0.0676
X6601 BLZ15 rr3t3r_0[20|15]/a_460_290# sky130_fd_pr_reram__reram_cell area_ox=0.0676
X6602 rr3t3r_0[20|15]/a_460_290# WL20 SL15 VSS sky130_fd_pr__nfet_g5v0d10v5 ad=0.65 pd=3.3 as=0 ps=0 w=1 l=0.5
X6603 BLN15 rr3t3r_0[20|15]/a_860_290# sky130_fd_pr_reram__reram_cell area_ox=0.0676
X6604 rr3t3r_0[20|15]/a_60_290# WL20 SL15 VSS sky130_fd_pr__nfet_g5v0d10v5 ad=0.65 pd=3.3 as=0 ps=0 w=1 l=0.5
X6605 rr3t3r_0[20|15]/a_860_290# WL20 SL15 VSS sky130_fd_pr__nfet_g5v0d10v5 ad=0.65 pd=3.3 as=0 ps=0 w=1 l=0.5
X6606 BLP15 rr3t3r_0[21|15]/a_60_290# sky130_fd_pr_reram__reram_cell area_ox=0.0676
X6607 BLZ15 rr3t3r_0[21|15]/a_460_290# sky130_fd_pr_reram__reram_cell area_ox=0.0676
X6608 rr3t3r_0[21|15]/a_460_290# WL21 SL15 VSS sky130_fd_pr__nfet_g5v0d10v5 ad=0.65 pd=3.3 as=0 ps=0 w=1 l=0.5
X6609 BLN15 rr3t3r_0[21|15]/a_860_290# sky130_fd_pr_reram__reram_cell area_ox=0.0676
X6610 rr3t3r_0[21|15]/a_60_290# WL21 SL15 VSS sky130_fd_pr__nfet_g5v0d10v5 ad=0.65 pd=3.3 as=0 ps=0 w=1 l=0.5
X6611 rr3t3r_0[21|15]/a_860_290# WL21 SL15 VSS sky130_fd_pr__nfet_g5v0d10v5 ad=0.65 pd=3.3 as=0 ps=0 w=1 l=0.5
X6612 BLP15 rr3t3r_0[22|15]/a_60_290# sky130_fd_pr_reram__reram_cell area_ox=0.0676
X6613 BLZ15 rr3t3r_0[22|15]/a_460_290# sky130_fd_pr_reram__reram_cell area_ox=0.0676
X6614 rr3t3r_0[22|15]/a_460_290# WL22 SL15 VSS sky130_fd_pr__nfet_g5v0d10v5 ad=0.65 pd=3.3 as=0 ps=0 w=1 l=0.5
X6615 BLN15 rr3t3r_0[22|15]/a_860_290# sky130_fd_pr_reram__reram_cell area_ox=0.0676
X6616 rr3t3r_0[22|15]/a_60_290# WL22 SL15 VSS sky130_fd_pr__nfet_g5v0d10v5 ad=0.65 pd=3.3 as=0 ps=0 w=1 l=0.5
X6617 rr3t3r_0[22|15]/a_860_290# WL22 SL15 VSS sky130_fd_pr__nfet_g5v0d10v5 ad=0.65 pd=3.3 as=0 ps=0 w=1 l=0.5
X6618 BLP15 rr3t3r_0[23|15]/a_60_290# sky130_fd_pr_reram__reram_cell area_ox=0.0676
X6619 BLZ15 rr3t3r_0[23|15]/a_460_290# sky130_fd_pr_reram__reram_cell area_ox=0.0676
X6620 rr3t3r_0[23|15]/a_460_290# WL23 SL15 VSS sky130_fd_pr__nfet_g5v0d10v5 ad=0.65 pd=3.3 as=0 ps=0 w=1 l=0.5
X6621 BLN15 rr3t3r_0[23|15]/a_860_290# sky130_fd_pr_reram__reram_cell area_ox=0.0676
X6622 rr3t3r_0[23|15]/a_60_290# WL23 SL15 VSS sky130_fd_pr__nfet_g5v0d10v5 ad=0.65 pd=3.3 as=0 ps=0 w=1 l=0.5
X6623 rr3t3r_0[23|15]/a_860_290# WL23 SL15 VSS sky130_fd_pr__nfet_g5v0d10v5 ad=0.65 pd=3.3 as=0 ps=0 w=1 l=0.5
X6624 BLP15 rr3t3r_0[24|15]/a_60_290# sky130_fd_pr_reram__reram_cell area_ox=0.0676
X6625 BLZ15 rr3t3r_0[24|15]/a_460_290# sky130_fd_pr_reram__reram_cell area_ox=0.0676
X6626 rr3t3r_0[24|15]/a_460_290# WL24 SL15 VSS sky130_fd_pr__nfet_g5v0d10v5 ad=0.65 pd=3.3 as=0 ps=0 w=1 l=0.5
X6627 BLN15 rr3t3r_0[24|15]/a_860_290# sky130_fd_pr_reram__reram_cell area_ox=0.0676
X6628 rr3t3r_0[24|15]/a_60_290# WL24 SL15 VSS sky130_fd_pr__nfet_g5v0d10v5 ad=0.65 pd=3.3 as=0 ps=0 w=1 l=0.5
X6629 rr3t3r_0[24|15]/a_860_290# WL24 SL15 VSS sky130_fd_pr__nfet_g5v0d10v5 ad=0.65 pd=3.3 as=0 ps=0 w=1 l=0.5
X6630 BLP15 rr3t3r_0[25|15]/a_60_290# sky130_fd_pr_reram__reram_cell area_ox=0.0676
X6631 BLZ15 rr3t3r_0[25|15]/a_460_290# sky130_fd_pr_reram__reram_cell area_ox=0.0676
X6632 rr3t3r_0[25|15]/a_460_290# WL25 SL15 VSS sky130_fd_pr__nfet_g5v0d10v5 ad=0.65 pd=3.3 as=0 ps=0 w=1 l=0.5
X6633 BLN15 rr3t3r_0[25|15]/a_860_290# sky130_fd_pr_reram__reram_cell area_ox=0.0676
X6634 rr3t3r_0[25|15]/a_60_290# WL25 SL15 VSS sky130_fd_pr__nfet_g5v0d10v5 ad=0.65 pd=3.3 as=0 ps=0 w=1 l=0.5
X6635 rr3t3r_0[25|15]/a_860_290# WL25 SL15 VSS sky130_fd_pr__nfet_g5v0d10v5 ad=0.65 pd=3.3 as=0 ps=0 w=1 l=0.5
X6636 BLP15 rr3t3r_0[26|15]/a_60_290# sky130_fd_pr_reram__reram_cell area_ox=0.0676
X6637 BLZ15 rr3t3r_0[26|15]/a_460_290# sky130_fd_pr_reram__reram_cell area_ox=0.0676
X6638 rr3t3r_0[26|15]/a_460_290# WL26 SL15 VSS sky130_fd_pr__nfet_g5v0d10v5 ad=0.65 pd=3.3 as=0 ps=0 w=1 l=0.5
X6639 BLN15 rr3t3r_0[26|15]/a_860_290# sky130_fd_pr_reram__reram_cell area_ox=0.0676
X6640 rr3t3r_0[26|15]/a_60_290# WL26 SL15 VSS sky130_fd_pr__nfet_g5v0d10v5 ad=0.65 pd=3.3 as=0 ps=0 w=1 l=0.5
X6641 rr3t3r_0[26|15]/a_860_290# WL26 SL15 VSS sky130_fd_pr__nfet_g5v0d10v5 ad=0.65 pd=3.3 as=0 ps=0 w=1 l=0.5
X6642 BLP15 rr3t3r_0[27|15]/a_60_290# sky130_fd_pr_reram__reram_cell area_ox=0.0676
X6643 BLZ15 rr3t3r_0[27|15]/a_460_290# sky130_fd_pr_reram__reram_cell area_ox=0.0676
X6644 rr3t3r_0[27|15]/a_460_290# WL27 SL15 VSS sky130_fd_pr__nfet_g5v0d10v5 ad=0.65 pd=3.3 as=0 ps=0 w=1 l=0.5
X6645 BLN15 rr3t3r_0[27|15]/a_860_290# sky130_fd_pr_reram__reram_cell area_ox=0.0676
X6646 rr3t3r_0[27|15]/a_60_290# WL27 SL15 VSS sky130_fd_pr__nfet_g5v0d10v5 ad=0.65 pd=3.3 as=0 ps=0 w=1 l=0.5
X6647 rr3t3r_0[27|15]/a_860_290# WL27 SL15 VSS sky130_fd_pr__nfet_g5v0d10v5 ad=0.65 pd=3.3 as=0 ps=0 w=1 l=0.5
X6648 BLP15 rr3t3r_0[28|15]/a_60_290# sky130_fd_pr_reram__reram_cell area_ox=0.0676
X6649 BLZ15 rr3t3r_0[28|15]/a_460_290# sky130_fd_pr_reram__reram_cell area_ox=0.0676
X6650 rr3t3r_0[28|15]/a_460_290# WL28 SL15 VSS sky130_fd_pr__nfet_g5v0d10v5 ad=0.65 pd=3.3 as=0 ps=0 w=1 l=0.5
X6651 BLN15 rr3t3r_0[28|15]/a_860_290# sky130_fd_pr_reram__reram_cell area_ox=0.0676
X6652 rr3t3r_0[28|15]/a_60_290# WL28 SL15 VSS sky130_fd_pr__nfet_g5v0d10v5 ad=0.65 pd=3.3 as=0 ps=0 w=1 l=0.5
X6653 rr3t3r_0[28|15]/a_860_290# WL28 SL15 VSS sky130_fd_pr__nfet_g5v0d10v5 ad=0.65 pd=3.3 as=0 ps=0 w=1 l=0.5
X6654 BLP15 rr3t3r_0[29|15]/a_60_290# sky130_fd_pr_reram__reram_cell area_ox=0.0676
X6655 BLZ15 rr3t3r_0[29|15]/a_460_290# sky130_fd_pr_reram__reram_cell area_ox=0.0676
X6656 rr3t3r_0[29|15]/a_460_290# WL29 SL15 VSS sky130_fd_pr__nfet_g5v0d10v5 ad=0.65 pd=3.3 as=0 ps=0 w=1 l=0.5
X6657 BLN15 rr3t3r_0[29|15]/a_860_290# sky130_fd_pr_reram__reram_cell area_ox=0.0676
X6658 rr3t3r_0[29|15]/a_60_290# WL29 SL15 VSS sky130_fd_pr__nfet_g5v0d10v5 ad=0.65 pd=3.3 as=0 ps=0 w=1 l=0.5
X6659 rr3t3r_0[29|15]/a_860_290# WL29 SL15 VSS sky130_fd_pr__nfet_g5v0d10v5 ad=0.65 pd=3.3 as=0 ps=0 w=1 l=0.5
X6660 BLP15 rr3t3r_0[30|15]/a_60_290# sky130_fd_pr_reram__reram_cell area_ox=0.0676
X6661 BLZ15 rr3t3r_0[30|15]/a_460_290# sky130_fd_pr_reram__reram_cell area_ox=0.0676
X6662 rr3t3r_0[30|15]/a_460_290# WL30 SL15 VSS sky130_fd_pr__nfet_g5v0d10v5 ad=0.65 pd=3.3 as=0 ps=0 w=1 l=0.5
X6663 BLN15 rr3t3r_0[30|15]/a_860_290# sky130_fd_pr_reram__reram_cell area_ox=0.0676
X6664 rr3t3r_0[30|15]/a_60_290# WL30 SL15 VSS sky130_fd_pr__nfet_g5v0d10v5 ad=0.65 pd=3.3 as=0 ps=0 w=1 l=0.5
X6665 rr3t3r_0[30|15]/a_860_290# WL30 SL15 VSS sky130_fd_pr__nfet_g5v0d10v5 ad=0.65 pd=3.3 as=0 ps=0 w=1 l=0.5
X6666 BLP15 rr3t3r_0[31|15]/a_60_290# sky130_fd_pr_reram__reram_cell area_ox=0.0676
X6667 BLZ15 rr3t3r_0[31|15]/a_460_290# sky130_fd_pr_reram__reram_cell area_ox=0.0676
X6668 rr3t3r_0[31|15]/a_460_290# WL31 SL15 VSS sky130_fd_pr__nfet_g5v0d10v5 ad=0.65 pd=3.3 as=0 ps=0 w=1 l=0.5
X6669 BLN15 rr3t3r_0[31|15]/a_860_290# sky130_fd_pr_reram__reram_cell area_ox=0.0676
X6670 rr3t3r_0[31|15]/a_60_290# WL31 SL15 VSS sky130_fd_pr__nfet_g5v0d10v5 ad=0.65 pd=3.3 as=0 ps=0 w=1 l=0.5
X6671 rr3t3r_0[31|15]/a_860_290# WL31 SL15 VSS sky130_fd_pr__nfet_g5v0d10v5 ad=0.65 pd=3.3 as=0 ps=0 w=1 l=0.5
X6672 BLP15 rr3t3r_0[32|15]/a_60_290# sky130_fd_pr_reram__reram_cell area_ox=0.0676
X6673 BLZ15 rr3t3r_0[32|15]/a_460_290# sky130_fd_pr_reram__reram_cell area_ox=0.0676
X6674 rr3t3r_0[32|15]/a_460_290# WL32 SL15 VSS sky130_fd_pr__nfet_g5v0d10v5 ad=0.65 pd=3.3 as=0 ps=0 w=1 l=0.5
X6675 BLN15 rr3t3r_0[32|15]/a_860_290# sky130_fd_pr_reram__reram_cell area_ox=0.0676
X6676 rr3t3r_0[32|15]/a_60_290# WL32 SL15 VSS sky130_fd_pr__nfet_g5v0d10v5 ad=0.65 pd=3.3 as=0 ps=0 w=1 l=0.5
X6677 rr3t3r_0[32|15]/a_860_290# WL32 SL15 VSS sky130_fd_pr__nfet_g5v0d10v5 ad=0.65 pd=3.3 as=0 ps=0 w=1 l=0.5
X6678 BLP15 rr3t3r_0[33|15]/a_60_290# sky130_fd_pr_reram__reram_cell area_ox=0.0676
X6679 BLZ15 rr3t3r_0[33|15]/a_460_290# sky130_fd_pr_reram__reram_cell area_ox=0.0676
X6680 rr3t3r_0[33|15]/a_460_290# WL33 SL15 VSS sky130_fd_pr__nfet_g5v0d10v5 ad=0.65 pd=3.3 as=0 ps=0 w=1 l=0.5
X6681 BLN15 rr3t3r_0[33|15]/a_860_290# sky130_fd_pr_reram__reram_cell area_ox=0.0676
X6682 rr3t3r_0[33|15]/a_60_290# WL33 SL15 VSS sky130_fd_pr__nfet_g5v0d10v5 ad=0.65 pd=3.3 as=0 ps=0 w=1 l=0.5
X6683 rr3t3r_0[33|15]/a_860_290# WL33 SL15 VSS sky130_fd_pr__nfet_g5v0d10v5 ad=0.65 pd=3.3 as=0 ps=0 w=1 l=0.5
X6684 BLP15 rr3t3r_0[34|15]/a_60_290# sky130_fd_pr_reram__reram_cell area_ox=0.0676
X6685 BLZ15 rr3t3r_0[34|15]/a_460_290# sky130_fd_pr_reram__reram_cell area_ox=0.0676
X6686 rr3t3r_0[34|15]/a_460_290# WL34 SL15 VSS sky130_fd_pr__nfet_g5v0d10v5 ad=0.65 pd=3.3 as=0 ps=0 w=1 l=0.5
X6687 BLN15 rr3t3r_0[34|15]/a_860_290# sky130_fd_pr_reram__reram_cell area_ox=0.0676
X6688 rr3t3r_0[34|15]/a_60_290# WL34 SL15 VSS sky130_fd_pr__nfet_g5v0d10v5 ad=0.65 pd=3.3 as=0 ps=0 w=1 l=0.5
X6689 rr3t3r_0[34|15]/a_860_290# WL34 SL15 VSS sky130_fd_pr__nfet_g5v0d10v5 ad=0.65 pd=3.3 as=0 ps=0 w=1 l=0.5
X6690 BLP15 rr3t3r_0[35|15]/a_60_290# sky130_fd_pr_reram__reram_cell area_ox=0.0676
X6691 BLZ15 rr3t3r_0[35|15]/a_460_290# sky130_fd_pr_reram__reram_cell area_ox=0.0676
X6692 rr3t3r_0[35|15]/a_460_290# WL35 SL15 VSS sky130_fd_pr__nfet_g5v0d10v5 ad=0.65 pd=3.3 as=0 ps=0 w=1 l=0.5
X6693 BLN15 rr3t3r_0[35|15]/a_860_290# sky130_fd_pr_reram__reram_cell area_ox=0.0676
X6694 rr3t3r_0[35|15]/a_60_290# WL35 SL15 VSS sky130_fd_pr__nfet_g5v0d10v5 ad=0.65 pd=3.3 as=0 ps=0 w=1 l=0.5
X6695 rr3t3r_0[35|15]/a_860_290# WL35 SL15 VSS sky130_fd_pr__nfet_g5v0d10v5 ad=0.65 pd=3.3 as=0 ps=0 w=1 l=0.5
X6696 BLP15 rr3t3r_0[36|15]/a_60_290# sky130_fd_pr_reram__reram_cell area_ox=0.0676
X6697 BLZ15 rr3t3r_0[36|15]/a_460_290# sky130_fd_pr_reram__reram_cell area_ox=0.0676
X6698 rr3t3r_0[36|15]/a_460_290# WL36 SL15 VSS sky130_fd_pr__nfet_g5v0d10v5 ad=0.65 pd=3.3 as=0 ps=0 w=1 l=0.5
X6699 BLN15 rr3t3r_0[36|15]/a_860_290# sky130_fd_pr_reram__reram_cell area_ox=0.0676
X6700 rr3t3r_0[36|15]/a_60_290# WL36 SL15 VSS sky130_fd_pr__nfet_g5v0d10v5 ad=0.65 pd=3.3 as=0 ps=0 w=1 l=0.5
X6701 rr3t3r_0[36|15]/a_860_290# WL36 SL15 VSS sky130_fd_pr__nfet_g5v0d10v5 ad=0.65 pd=3.3 as=0 ps=0 w=1 l=0.5
X6702 BLP15 rr3t3r_0[37|15]/a_60_290# sky130_fd_pr_reram__reram_cell area_ox=0.0676
X6703 BLZ15 rr3t3r_0[37|15]/a_460_290# sky130_fd_pr_reram__reram_cell area_ox=0.0676
X6704 rr3t3r_0[37|15]/a_460_290# WL37 SL15 VSS sky130_fd_pr__nfet_g5v0d10v5 ad=0.65 pd=3.3 as=0 ps=0 w=1 l=0.5
X6705 BLN15 rr3t3r_0[37|15]/a_860_290# sky130_fd_pr_reram__reram_cell area_ox=0.0676
X6706 rr3t3r_0[37|15]/a_60_290# WL37 SL15 VSS sky130_fd_pr__nfet_g5v0d10v5 ad=0.65 pd=3.3 as=0 ps=0 w=1 l=0.5
X6707 rr3t3r_0[37|15]/a_860_290# WL37 SL15 VSS sky130_fd_pr__nfet_g5v0d10v5 ad=0.65 pd=3.3 as=0 ps=0 w=1 l=0.5
X6708 BLP15 rr3t3r_0[38|15]/a_60_290# sky130_fd_pr_reram__reram_cell area_ox=0.0676
X6709 BLZ15 rr3t3r_0[38|15]/a_460_290# sky130_fd_pr_reram__reram_cell area_ox=0.0676
X6710 rr3t3r_0[38|15]/a_460_290# WL38 SL15 VSS sky130_fd_pr__nfet_g5v0d10v5 ad=0.65 pd=3.3 as=0 ps=0 w=1 l=0.5
X6711 BLN15 rr3t3r_0[38|15]/a_860_290# sky130_fd_pr_reram__reram_cell area_ox=0.0676
X6712 rr3t3r_0[38|15]/a_60_290# WL38 SL15 VSS sky130_fd_pr__nfet_g5v0d10v5 ad=0.65 pd=3.3 as=0 ps=0 w=1 l=0.5
X6713 rr3t3r_0[38|15]/a_860_290# WL38 SL15 VSS sky130_fd_pr__nfet_g5v0d10v5 ad=0.65 pd=3.3 as=0 ps=0 w=1 l=0.5
X6714 BLP15 rr3t3r_0[39|15]/a_60_290# sky130_fd_pr_reram__reram_cell area_ox=0.0676
X6715 BLZ15 rr3t3r_0[39|15]/a_460_290# sky130_fd_pr_reram__reram_cell area_ox=0.0676
X6716 rr3t3r_0[39|15]/a_460_290# WL39 SL15 VSS sky130_fd_pr__nfet_g5v0d10v5 ad=0.65 pd=3.3 as=0 ps=0 w=1 l=0.5
X6717 BLN15 rr3t3r_0[39|15]/a_860_290# sky130_fd_pr_reram__reram_cell area_ox=0.0676
X6718 rr3t3r_0[39|15]/a_60_290# WL39 SL15 VSS sky130_fd_pr__nfet_g5v0d10v5 ad=0.65 pd=3.3 as=0 ps=0 w=1 l=0.5
X6719 rr3t3r_0[39|15]/a_860_290# WL39 SL15 VSS sky130_fd_pr__nfet_g5v0d10v5 ad=0.65 pd=3.3 as=0 ps=0 w=1 l=0.5
X6720 BLP15 rr3t3r_0[40|15]/a_60_290# sky130_fd_pr_reram__reram_cell area_ox=0.0676
X6721 BLZ15 rr3t3r_0[40|15]/a_460_290# sky130_fd_pr_reram__reram_cell area_ox=0.0676
X6722 rr3t3r_0[40|15]/a_460_290# WL40 SL15 VSS sky130_fd_pr__nfet_g5v0d10v5 ad=0.65 pd=3.3 as=0 ps=0 w=1 l=0.5
X6723 BLN15 rr3t3r_0[40|15]/a_860_290# sky130_fd_pr_reram__reram_cell area_ox=0.0676
X6724 rr3t3r_0[40|15]/a_60_290# WL40 SL15 VSS sky130_fd_pr__nfet_g5v0d10v5 ad=0.65 pd=3.3 as=0 ps=0 w=1 l=0.5
X6725 rr3t3r_0[40|15]/a_860_290# WL40 SL15 VSS sky130_fd_pr__nfet_g5v0d10v5 ad=0.65 pd=3.3 as=0 ps=0 w=1 l=0.5
X6726 BLP15 rr3t3r_0[41|15]/a_60_290# sky130_fd_pr_reram__reram_cell area_ox=0.0676
X6727 BLZ15 rr3t3r_0[41|15]/a_460_290# sky130_fd_pr_reram__reram_cell area_ox=0.0676
X6728 rr3t3r_0[41|15]/a_460_290# WL41 SL15 VSS sky130_fd_pr__nfet_g5v0d10v5 ad=0.65 pd=3.3 as=0 ps=0 w=1 l=0.5
X6729 BLN15 rr3t3r_0[41|15]/a_860_290# sky130_fd_pr_reram__reram_cell area_ox=0.0676
X6730 rr3t3r_0[41|15]/a_60_290# WL41 SL15 VSS sky130_fd_pr__nfet_g5v0d10v5 ad=0.65 pd=3.3 as=0 ps=0 w=1 l=0.5
X6731 rr3t3r_0[41|15]/a_860_290# WL41 SL15 VSS sky130_fd_pr__nfet_g5v0d10v5 ad=0.65 pd=3.3 as=0 ps=0 w=1 l=0.5
X6732 BLP15 rr3t3r_0[42|15]/a_60_290# sky130_fd_pr_reram__reram_cell area_ox=0.0676
X6733 BLZ15 rr3t3r_0[42|15]/a_460_290# sky130_fd_pr_reram__reram_cell area_ox=0.0676
X6734 rr3t3r_0[42|15]/a_460_290# WL42 SL15 VSS sky130_fd_pr__nfet_g5v0d10v5 ad=0.65 pd=3.3 as=0 ps=0 w=1 l=0.5
X6735 BLN15 rr3t3r_0[42|15]/a_860_290# sky130_fd_pr_reram__reram_cell area_ox=0.0676
X6736 rr3t3r_0[42|15]/a_60_290# WL42 SL15 VSS sky130_fd_pr__nfet_g5v0d10v5 ad=0.65 pd=3.3 as=0 ps=0 w=1 l=0.5
X6737 rr3t3r_0[42|15]/a_860_290# WL42 SL15 VSS sky130_fd_pr__nfet_g5v0d10v5 ad=0.65 pd=3.3 as=0 ps=0 w=1 l=0.5
X6738 BLP15 rr3t3r_0[43|15]/a_60_290# sky130_fd_pr_reram__reram_cell area_ox=0.0676
X6739 BLZ15 rr3t3r_0[43|15]/a_460_290# sky130_fd_pr_reram__reram_cell area_ox=0.0676
X6740 rr3t3r_0[43|15]/a_460_290# WL43 SL15 VSS sky130_fd_pr__nfet_g5v0d10v5 ad=0.65 pd=3.3 as=0 ps=0 w=1 l=0.5
X6741 BLN15 rr3t3r_0[43|15]/a_860_290# sky130_fd_pr_reram__reram_cell area_ox=0.0676
X6742 rr3t3r_0[43|15]/a_60_290# WL43 SL15 VSS sky130_fd_pr__nfet_g5v0d10v5 ad=0.65 pd=3.3 as=0 ps=0 w=1 l=0.5
X6743 rr3t3r_0[43|15]/a_860_290# WL43 SL15 VSS sky130_fd_pr__nfet_g5v0d10v5 ad=0.65 pd=3.3 as=0 ps=0 w=1 l=0.5
X6744 BLP15 rr3t3r_0[44|15]/a_60_290# sky130_fd_pr_reram__reram_cell area_ox=0.0676
X6745 BLZ15 rr3t3r_0[44|15]/a_460_290# sky130_fd_pr_reram__reram_cell area_ox=0.0676
X6746 rr3t3r_0[44|15]/a_460_290# WL44 SL15 VSS sky130_fd_pr__nfet_g5v0d10v5 ad=0.65 pd=3.3 as=0 ps=0 w=1 l=0.5
X6747 BLN15 rr3t3r_0[44|15]/a_860_290# sky130_fd_pr_reram__reram_cell area_ox=0.0676
X6748 rr3t3r_0[44|15]/a_60_290# WL44 SL15 VSS sky130_fd_pr__nfet_g5v0d10v5 ad=0.65 pd=3.3 as=0 ps=0 w=1 l=0.5
X6749 rr3t3r_0[44|15]/a_860_290# WL44 SL15 VSS sky130_fd_pr__nfet_g5v0d10v5 ad=0.65 pd=3.3 as=0 ps=0 w=1 l=0.5
X6750 BLP15 rr3t3r_0[45|15]/a_60_290# sky130_fd_pr_reram__reram_cell area_ox=0.0676
X6751 BLZ15 rr3t3r_0[45|15]/a_460_290# sky130_fd_pr_reram__reram_cell area_ox=0.0676
X6752 rr3t3r_0[45|15]/a_460_290# WL45 SL15 VSS sky130_fd_pr__nfet_g5v0d10v5 ad=0.65 pd=3.3 as=0 ps=0 w=1 l=0.5
X6753 BLN15 rr3t3r_0[45|15]/a_860_290# sky130_fd_pr_reram__reram_cell area_ox=0.0676
X6754 rr3t3r_0[45|15]/a_60_290# WL45 SL15 VSS sky130_fd_pr__nfet_g5v0d10v5 ad=0.65 pd=3.3 as=0 ps=0 w=1 l=0.5
X6755 rr3t3r_0[45|15]/a_860_290# WL45 SL15 VSS sky130_fd_pr__nfet_g5v0d10v5 ad=0.65 pd=3.3 as=0 ps=0 w=1 l=0.5
X6756 BLP15 rr3t3r_0[46|15]/a_60_290# sky130_fd_pr_reram__reram_cell area_ox=0.0676
X6757 BLZ15 rr3t3r_0[46|15]/a_460_290# sky130_fd_pr_reram__reram_cell area_ox=0.0676
X6758 rr3t3r_0[46|15]/a_460_290# WL46 SL15 VSS sky130_fd_pr__nfet_g5v0d10v5 ad=0.65 pd=3.3 as=0 ps=0 w=1 l=0.5
X6759 BLN15 rr3t3r_0[46|15]/a_860_290# sky130_fd_pr_reram__reram_cell area_ox=0.0676
X6760 rr3t3r_0[46|15]/a_60_290# WL46 SL15 VSS sky130_fd_pr__nfet_g5v0d10v5 ad=0.65 pd=3.3 as=0 ps=0 w=1 l=0.5
X6761 rr3t3r_0[46|15]/a_860_290# WL46 SL15 VSS sky130_fd_pr__nfet_g5v0d10v5 ad=0.65 pd=3.3 as=0 ps=0 w=1 l=0.5
X6762 BLP15 rr3t3r_0[47|15]/a_60_290# sky130_fd_pr_reram__reram_cell area_ox=0.0676
X6763 BLZ15 rr3t3r_0[47|15]/a_460_290# sky130_fd_pr_reram__reram_cell area_ox=0.0676
X6764 rr3t3r_0[47|15]/a_460_290# WL47 SL15 VSS sky130_fd_pr__nfet_g5v0d10v5 ad=0.65 pd=3.3 as=0 ps=0 w=1 l=0.5
X6765 BLN15 rr3t3r_0[47|15]/a_860_290# sky130_fd_pr_reram__reram_cell area_ox=0.0676
X6766 rr3t3r_0[47|15]/a_60_290# WL47 SL15 VSS sky130_fd_pr__nfet_g5v0d10v5 ad=0.65 pd=3.3 as=0 ps=0 w=1 l=0.5
X6767 rr3t3r_0[47|15]/a_860_290# WL47 SL15 VSS sky130_fd_pr__nfet_g5v0d10v5 ad=0.65 pd=3.3 as=0 ps=0 w=1 l=0.5
X6768 BLP15 rr3t3r_0[48|15]/a_60_290# sky130_fd_pr_reram__reram_cell area_ox=0.0676
X6769 BLZ15 rr3t3r_0[48|15]/a_460_290# sky130_fd_pr_reram__reram_cell area_ox=0.0676
X6770 rr3t3r_0[48|15]/a_460_290# WL48 SL15 VSS sky130_fd_pr__nfet_g5v0d10v5 ad=0.65 pd=3.3 as=0 ps=0 w=1 l=0.5
X6771 BLN15 rr3t3r_0[48|15]/a_860_290# sky130_fd_pr_reram__reram_cell area_ox=0.0676
X6772 rr3t3r_0[48|15]/a_60_290# WL48 SL15 VSS sky130_fd_pr__nfet_g5v0d10v5 ad=0.65 pd=3.3 as=0 ps=0 w=1 l=0.5
X6773 rr3t3r_0[48|15]/a_860_290# WL48 SL15 VSS sky130_fd_pr__nfet_g5v0d10v5 ad=0.65 pd=3.3 as=0 ps=0 w=1 l=0.5
X6774 BLP15 rr3t3r_0[49|15]/a_60_290# sky130_fd_pr_reram__reram_cell area_ox=0.0676
X6775 BLZ15 rr3t3r_0[49|15]/a_460_290# sky130_fd_pr_reram__reram_cell area_ox=0.0676
X6776 rr3t3r_0[49|15]/a_460_290# WL49 SL15 VSS sky130_fd_pr__nfet_g5v0d10v5 ad=0.65 pd=3.3 as=0 ps=0 w=1 l=0.5
X6777 BLN15 rr3t3r_0[49|15]/a_860_290# sky130_fd_pr_reram__reram_cell area_ox=0.0676
X6778 rr3t3r_0[49|15]/a_60_290# WL49 SL15 VSS sky130_fd_pr__nfet_g5v0d10v5 ad=0.65 pd=3.3 as=0 ps=0 w=1 l=0.5
X6779 rr3t3r_0[49|15]/a_860_290# WL49 SL15 VSS sky130_fd_pr__nfet_g5v0d10v5 ad=0.65 pd=3.3 as=0 ps=0 w=1 l=0.5
X6780 BLP15 rr3t3r_0[50|15]/a_60_290# sky130_fd_pr_reram__reram_cell area_ox=0.0676
X6781 BLZ15 rr3t3r_0[50|15]/a_460_290# sky130_fd_pr_reram__reram_cell area_ox=0.0676
X6782 rr3t3r_0[50|15]/a_460_290# WL50 SL15 VSS sky130_fd_pr__nfet_g5v0d10v5 ad=0.65 pd=3.3 as=0 ps=0 w=1 l=0.5
X6783 BLN15 rr3t3r_0[50|15]/a_860_290# sky130_fd_pr_reram__reram_cell area_ox=0.0676
X6784 rr3t3r_0[50|15]/a_60_290# WL50 SL15 VSS sky130_fd_pr__nfet_g5v0d10v5 ad=0.65 pd=3.3 as=0 ps=0 w=1 l=0.5
X6785 rr3t3r_0[50|15]/a_860_290# WL50 SL15 VSS sky130_fd_pr__nfet_g5v0d10v5 ad=0.65 pd=3.3 as=0 ps=0 w=1 l=0.5
X6786 BLP15 rr3t3r_0[51|15]/a_60_290# sky130_fd_pr_reram__reram_cell area_ox=0.0676
X6787 BLZ15 rr3t3r_0[51|15]/a_460_290# sky130_fd_pr_reram__reram_cell area_ox=0.0676
X6788 rr3t3r_0[51|15]/a_460_290# WL51 SL15 VSS sky130_fd_pr__nfet_g5v0d10v5 ad=0.65 pd=3.3 as=0 ps=0 w=1 l=0.5
X6789 BLN15 rr3t3r_0[51|15]/a_860_290# sky130_fd_pr_reram__reram_cell area_ox=0.0676
X6790 rr3t3r_0[51|15]/a_60_290# WL51 SL15 VSS sky130_fd_pr__nfet_g5v0d10v5 ad=0.65 pd=3.3 as=0 ps=0 w=1 l=0.5
X6791 rr3t3r_0[51|15]/a_860_290# WL51 SL15 VSS sky130_fd_pr__nfet_g5v0d10v5 ad=0.65 pd=3.3 as=0 ps=0 w=1 l=0.5
X6792 BLP15 rr3t3r_0[52|15]/a_60_290# sky130_fd_pr_reram__reram_cell area_ox=0.0676
X6793 BLZ15 rr3t3r_0[52|15]/a_460_290# sky130_fd_pr_reram__reram_cell area_ox=0.0676
X6794 rr3t3r_0[52|15]/a_460_290# WL52 SL15 VSS sky130_fd_pr__nfet_g5v0d10v5 ad=0.65 pd=3.3 as=0 ps=0 w=1 l=0.5
X6795 BLN15 rr3t3r_0[52|15]/a_860_290# sky130_fd_pr_reram__reram_cell area_ox=0.0676
X6796 rr3t3r_0[52|15]/a_60_290# WL52 SL15 VSS sky130_fd_pr__nfet_g5v0d10v5 ad=0.65 pd=3.3 as=0 ps=0 w=1 l=0.5
X6797 rr3t3r_0[52|15]/a_860_290# WL52 SL15 VSS sky130_fd_pr__nfet_g5v0d10v5 ad=0.65 pd=3.3 as=0 ps=0 w=1 l=0.5
X6798 BLP15 rr3t3r_0[53|15]/a_60_290# sky130_fd_pr_reram__reram_cell area_ox=0.0676
X6799 BLZ15 rr3t3r_0[53|15]/a_460_290# sky130_fd_pr_reram__reram_cell area_ox=0.0676
X6800 rr3t3r_0[53|15]/a_460_290# WL53 SL15 VSS sky130_fd_pr__nfet_g5v0d10v5 ad=0.65 pd=3.3 as=0 ps=0 w=1 l=0.5
X6801 BLN15 rr3t3r_0[53|15]/a_860_290# sky130_fd_pr_reram__reram_cell area_ox=0.0676
X6802 rr3t3r_0[53|15]/a_60_290# WL53 SL15 VSS sky130_fd_pr__nfet_g5v0d10v5 ad=0.65 pd=3.3 as=0 ps=0 w=1 l=0.5
X6803 rr3t3r_0[53|15]/a_860_290# WL53 SL15 VSS sky130_fd_pr__nfet_g5v0d10v5 ad=0.65 pd=3.3 as=0 ps=0 w=1 l=0.5
X6804 BLP15 rr3t3r_0[54|15]/a_60_290# sky130_fd_pr_reram__reram_cell area_ox=0.0676
X6805 BLZ15 rr3t3r_0[54|15]/a_460_290# sky130_fd_pr_reram__reram_cell area_ox=0.0676
X6806 rr3t3r_0[54|15]/a_460_290# WL54 SL15 VSS sky130_fd_pr__nfet_g5v0d10v5 ad=0.65 pd=3.3 as=0 ps=0 w=1 l=0.5
X6807 BLN15 rr3t3r_0[54|15]/a_860_290# sky130_fd_pr_reram__reram_cell area_ox=0.0676
X6808 rr3t3r_0[54|15]/a_60_290# WL54 SL15 VSS sky130_fd_pr__nfet_g5v0d10v5 ad=0.65 pd=3.3 as=0 ps=0 w=1 l=0.5
X6809 rr3t3r_0[54|15]/a_860_290# WL54 SL15 VSS sky130_fd_pr__nfet_g5v0d10v5 ad=0.65 pd=3.3 as=0 ps=0 w=1 l=0.5
X6810 BLP15 rr3t3r_0[55|15]/a_60_290# sky130_fd_pr_reram__reram_cell area_ox=0.0676
X6811 BLZ15 rr3t3r_0[55|15]/a_460_290# sky130_fd_pr_reram__reram_cell area_ox=0.0676
X6812 rr3t3r_0[55|15]/a_460_290# WL55 SL15 VSS sky130_fd_pr__nfet_g5v0d10v5 ad=0.65 pd=3.3 as=0 ps=0 w=1 l=0.5
X6813 BLN15 rr3t3r_0[55|15]/a_860_290# sky130_fd_pr_reram__reram_cell area_ox=0.0676
X6814 rr3t3r_0[55|15]/a_60_290# WL55 SL15 VSS sky130_fd_pr__nfet_g5v0d10v5 ad=0.65 pd=3.3 as=0 ps=0 w=1 l=0.5
X6815 rr3t3r_0[55|15]/a_860_290# WL55 SL15 VSS sky130_fd_pr__nfet_g5v0d10v5 ad=0.65 pd=3.3 as=0 ps=0 w=1 l=0.5
X6816 BLP15 rr3t3r_0[56|15]/a_60_290# sky130_fd_pr_reram__reram_cell area_ox=0.0676
X6817 BLZ15 rr3t3r_0[56|15]/a_460_290# sky130_fd_pr_reram__reram_cell area_ox=0.0676
X6818 rr3t3r_0[56|15]/a_460_290# WL56 SL15 VSS sky130_fd_pr__nfet_g5v0d10v5 ad=0.65 pd=3.3 as=0 ps=0 w=1 l=0.5
X6819 BLN15 rr3t3r_0[56|15]/a_860_290# sky130_fd_pr_reram__reram_cell area_ox=0.0676
X6820 rr3t3r_0[56|15]/a_60_290# WL56 SL15 VSS sky130_fd_pr__nfet_g5v0d10v5 ad=0.65 pd=3.3 as=0 ps=0 w=1 l=0.5
X6821 rr3t3r_0[56|15]/a_860_290# WL56 SL15 VSS sky130_fd_pr__nfet_g5v0d10v5 ad=0.65 pd=3.3 as=0 ps=0 w=1 l=0.5
X6822 BLP15 rr3t3r_0[57|15]/a_60_290# sky130_fd_pr_reram__reram_cell area_ox=0.0676
X6823 BLZ15 rr3t3r_0[57|15]/a_460_290# sky130_fd_pr_reram__reram_cell area_ox=0.0676
X6824 rr3t3r_0[57|15]/a_460_290# WL57 SL15 VSS sky130_fd_pr__nfet_g5v0d10v5 ad=0.65 pd=3.3 as=0 ps=0 w=1 l=0.5
X6825 BLN15 rr3t3r_0[57|15]/a_860_290# sky130_fd_pr_reram__reram_cell area_ox=0.0676
X6826 rr3t3r_0[57|15]/a_60_290# WL57 SL15 VSS sky130_fd_pr__nfet_g5v0d10v5 ad=0.65 pd=3.3 as=0 ps=0 w=1 l=0.5
X6827 rr3t3r_0[57|15]/a_860_290# WL57 SL15 VSS sky130_fd_pr__nfet_g5v0d10v5 ad=0.65 pd=3.3 as=0 ps=0 w=1 l=0.5
X6828 BLP15 rr3t3r_0[58|15]/a_60_290# sky130_fd_pr_reram__reram_cell area_ox=0.0676
X6829 BLZ15 rr3t3r_0[58|15]/a_460_290# sky130_fd_pr_reram__reram_cell area_ox=0.0676
X6830 rr3t3r_0[58|15]/a_460_290# WL58 SL15 VSS sky130_fd_pr__nfet_g5v0d10v5 ad=0.65 pd=3.3 as=0 ps=0 w=1 l=0.5
X6831 BLN15 rr3t3r_0[58|15]/a_860_290# sky130_fd_pr_reram__reram_cell area_ox=0.0676
X6832 rr3t3r_0[58|15]/a_60_290# WL58 SL15 VSS sky130_fd_pr__nfet_g5v0d10v5 ad=0.65 pd=3.3 as=0 ps=0 w=1 l=0.5
X6833 rr3t3r_0[58|15]/a_860_290# WL58 SL15 VSS sky130_fd_pr__nfet_g5v0d10v5 ad=0.65 pd=3.3 as=0 ps=0 w=1 l=0.5
X6834 BLP15 rr3t3r_0[59|15]/a_60_290# sky130_fd_pr_reram__reram_cell area_ox=0.0676
X6835 BLZ15 rr3t3r_0[59|15]/a_460_290# sky130_fd_pr_reram__reram_cell area_ox=0.0676
X6836 rr3t3r_0[59|15]/a_460_290# WL59 SL15 VSS sky130_fd_pr__nfet_g5v0d10v5 ad=0.65 pd=3.3 as=0 ps=0 w=1 l=0.5
X6837 BLN15 rr3t3r_0[59|15]/a_860_290# sky130_fd_pr_reram__reram_cell area_ox=0.0676
X6838 rr3t3r_0[59|15]/a_60_290# WL59 SL15 VSS sky130_fd_pr__nfet_g5v0d10v5 ad=0.65 pd=3.3 as=0 ps=0 w=1 l=0.5
X6839 rr3t3r_0[59|15]/a_860_290# WL59 SL15 VSS sky130_fd_pr__nfet_g5v0d10v5 ad=0.65 pd=3.3 as=0 ps=0 w=1 l=0.5
X6840 BLP15 rr3t3r_0[60|15]/a_60_290# sky130_fd_pr_reram__reram_cell area_ox=0.0676
X6841 BLZ15 rr3t3r_0[60|15]/a_460_290# sky130_fd_pr_reram__reram_cell area_ox=0.0676
X6842 rr3t3r_0[60|15]/a_460_290# WL60 SL15 VSS sky130_fd_pr__nfet_g5v0d10v5 ad=0.65 pd=3.3 as=0 ps=0 w=1 l=0.5
X6843 BLN15 rr3t3r_0[60|15]/a_860_290# sky130_fd_pr_reram__reram_cell area_ox=0.0676
X6844 rr3t3r_0[60|15]/a_60_290# WL60 SL15 VSS sky130_fd_pr__nfet_g5v0d10v5 ad=0.65 pd=3.3 as=0 ps=0 w=1 l=0.5
X6845 rr3t3r_0[60|15]/a_860_290# WL60 SL15 VSS sky130_fd_pr__nfet_g5v0d10v5 ad=0.65 pd=3.3 as=0 ps=0 w=1 l=0.5
X6846 BLP15 rr3t3r_0[61|15]/a_60_290# sky130_fd_pr_reram__reram_cell area_ox=0.0676
X6847 BLZ15 rr3t3r_0[61|15]/a_460_290# sky130_fd_pr_reram__reram_cell area_ox=0.0676
X6848 rr3t3r_0[61|15]/a_460_290# WL61 SL15 VSS sky130_fd_pr__nfet_g5v0d10v5 ad=0.65 pd=3.3 as=0 ps=0 w=1 l=0.5
X6849 BLN15 rr3t3r_0[61|15]/a_860_290# sky130_fd_pr_reram__reram_cell area_ox=0.0676
X6850 rr3t3r_0[61|15]/a_60_290# WL61 SL15 VSS sky130_fd_pr__nfet_g5v0d10v5 ad=0.65 pd=3.3 as=0 ps=0 w=1 l=0.5
X6851 rr3t3r_0[61|15]/a_860_290# WL61 SL15 VSS sky130_fd_pr__nfet_g5v0d10v5 ad=0.65 pd=3.3 as=0 ps=0 w=1 l=0.5
X6852 BLP15 rr3t3r_0[62|15]/a_60_290# sky130_fd_pr_reram__reram_cell area_ox=0.0676
X6853 BLZ15 rr3t3r_0[62|15]/a_460_290# sky130_fd_pr_reram__reram_cell area_ox=0.0676
X6854 rr3t3r_0[62|15]/a_460_290# WL62 SL15 VSS sky130_fd_pr__nfet_g5v0d10v5 ad=0.65 pd=3.3 as=0 ps=0 w=1 l=0.5
X6855 BLN15 rr3t3r_0[62|15]/a_860_290# sky130_fd_pr_reram__reram_cell area_ox=0.0676
X6856 rr3t3r_0[62|15]/a_60_290# WL62 SL15 VSS sky130_fd_pr__nfet_g5v0d10v5 ad=0.65 pd=3.3 as=0 ps=0 w=1 l=0.5
X6857 rr3t3r_0[62|15]/a_860_290# WL62 SL15 VSS sky130_fd_pr__nfet_g5v0d10v5 ad=0.65 pd=3.3 as=0 ps=0 w=1 l=0.5
X6858 BLP15 rr3t3r_0[63|15]/a_60_290# sky130_fd_pr_reram__reram_cell area_ox=0.0676
X6859 BLZ15 rr3t3r_0[63|15]/a_460_290# sky130_fd_pr_reram__reram_cell area_ox=0.0676
X6860 rr3t3r_0[63|15]/a_460_290# WL63 SL15 VSS sky130_fd_pr__nfet_g5v0d10v5 ad=0.65 pd=3.3 as=0 ps=0 w=1 l=0.5
X6861 BLN15 rr3t3r_0[63|15]/a_860_290# sky130_fd_pr_reram__reram_cell area_ox=0.0676
X6862 rr3t3r_0[63|15]/a_60_290# WL63 SL15 VSS sky130_fd_pr__nfet_g5v0d10v5 ad=0.65 pd=3.3 as=0 ps=0 w=1 l=0.5
X6863 rr3t3r_0[63|15]/a_860_290# WL63 SL15 VSS sky130_fd_pr__nfet_g5v0d10v5 ad=0.65 pd=3.3 as=0 ps=0 w=1 l=0.5
X6864 BLP15 rr3t3r_0[64|15]/a_60_290# sky130_fd_pr_reram__reram_cell area_ox=0.0676
X6865 BLZ15 rr3t3r_0[64|15]/a_460_290# sky130_fd_pr_reram__reram_cell area_ox=0.0676
X6866 rr3t3r_0[64|15]/a_460_290# WL64 SL15 VSS sky130_fd_pr__nfet_g5v0d10v5 ad=0.65 pd=3.3 as=0 ps=0 w=1 l=0.5
X6867 BLN15 rr3t3r_0[64|15]/a_860_290# sky130_fd_pr_reram__reram_cell area_ox=0.0676
X6868 rr3t3r_0[64|15]/a_60_290# WL64 SL15 VSS sky130_fd_pr__nfet_g5v0d10v5 ad=0.65 pd=3.3 as=0 ps=0 w=1 l=0.5
X6869 rr3t3r_0[64|15]/a_860_290# WL64 SL15 VSS sky130_fd_pr__nfet_g5v0d10v5 ad=0.65 pd=3.3 as=0 ps=0 w=1 l=0.5
X6870 BLP15 rr3t3r_0[65|15]/a_60_290# sky130_fd_pr_reram__reram_cell area_ox=0.0676
X6871 BLZ15 rr3t3r_0[65|15]/a_460_290# sky130_fd_pr_reram__reram_cell area_ox=0.0676
X6872 rr3t3r_0[65|15]/a_460_290# WL65 SL15 VSS sky130_fd_pr__nfet_g5v0d10v5 ad=0.65 pd=3.3 as=0 ps=0 w=1 l=0.5
X6873 BLN15 rr3t3r_0[65|15]/a_860_290# sky130_fd_pr_reram__reram_cell area_ox=0.0676
X6874 rr3t3r_0[65|15]/a_60_290# WL65 SL15 VSS sky130_fd_pr__nfet_g5v0d10v5 ad=0.65 pd=3.3 as=0 ps=0 w=1 l=0.5
X6875 rr3t3r_0[65|15]/a_860_290# WL65 SL15 VSS sky130_fd_pr__nfet_g5v0d10v5 ad=0.65 pd=3.3 as=0 ps=0 w=1 l=0.5
X6876 BLP15 rr3t3r_0[66|15]/a_60_290# sky130_fd_pr_reram__reram_cell area_ox=0.0676
X6877 BLZ15 rr3t3r_0[66|15]/a_460_290# sky130_fd_pr_reram__reram_cell area_ox=0.0676
X6878 rr3t3r_0[66|15]/a_460_290# WL66 SL15 VSS sky130_fd_pr__nfet_g5v0d10v5 ad=0.65 pd=3.3 as=0 ps=0 w=1 l=0.5
X6879 BLN15 rr3t3r_0[66|15]/a_860_290# sky130_fd_pr_reram__reram_cell area_ox=0.0676
X6880 rr3t3r_0[66|15]/a_60_290# WL66 SL15 VSS sky130_fd_pr__nfet_g5v0d10v5 ad=0.65 pd=3.3 as=0 ps=0 w=1 l=0.5
X6881 rr3t3r_0[66|15]/a_860_290# WL66 SL15 VSS sky130_fd_pr__nfet_g5v0d10v5 ad=0.65 pd=3.3 as=0 ps=0 w=1 l=0.5
X6882 BLP15 rr3t3r_0[67|15]/a_60_290# sky130_fd_pr_reram__reram_cell area_ox=0.0676
X6883 BLZ15 rr3t3r_0[67|15]/a_460_290# sky130_fd_pr_reram__reram_cell area_ox=0.0676
X6884 rr3t3r_0[67|15]/a_460_290# WL67 SL15 VSS sky130_fd_pr__nfet_g5v0d10v5 ad=0.65 pd=3.3 as=0 ps=0 w=1 l=0.5
X6885 BLN15 rr3t3r_0[67|15]/a_860_290# sky130_fd_pr_reram__reram_cell area_ox=0.0676
X6886 rr3t3r_0[67|15]/a_60_290# WL67 SL15 VSS sky130_fd_pr__nfet_g5v0d10v5 ad=0.65 pd=3.3 as=0 ps=0 w=1 l=0.5
X6887 rr3t3r_0[67|15]/a_860_290# WL67 SL15 VSS sky130_fd_pr__nfet_g5v0d10v5 ad=0.65 pd=3.3 as=0 ps=0 w=1 l=0.5
X6888 BLP15 rr3t3r_0[68|15]/a_60_290# sky130_fd_pr_reram__reram_cell area_ox=0.0676
X6889 BLZ15 rr3t3r_0[68|15]/a_460_290# sky130_fd_pr_reram__reram_cell area_ox=0.0676
X6890 rr3t3r_0[68|15]/a_460_290# WL68 SL15 VSS sky130_fd_pr__nfet_g5v0d10v5 ad=0.65 pd=3.3 as=0 ps=0 w=1 l=0.5
X6891 BLN15 rr3t3r_0[68|15]/a_860_290# sky130_fd_pr_reram__reram_cell area_ox=0.0676
X6892 rr3t3r_0[68|15]/a_60_290# WL68 SL15 VSS sky130_fd_pr__nfet_g5v0d10v5 ad=0.65 pd=3.3 as=0 ps=0 w=1 l=0.5
X6893 rr3t3r_0[68|15]/a_860_290# WL68 SL15 VSS sky130_fd_pr__nfet_g5v0d10v5 ad=0.65 pd=3.3 as=0 ps=0 w=1 l=0.5
X6894 BLP15 rr3t3r_0[69|15]/a_60_290# sky130_fd_pr_reram__reram_cell area_ox=0.0676
X6895 BLZ15 rr3t3r_0[69|15]/a_460_290# sky130_fd_pr_reram__reram_cell area_ox=0.0676
X6896 rr3t3r_0[69|15]/a_460_290# WL69 SL15 VSS sky130_fd_pr__nfet_g5v0d10v5 ad=0.65 pd=3.3 as=0 ps=0 w=1 l=0.5
X6897 BLN15 rr3t3r_0[69|15]/a_860_290# sky130_fd_pr_reram__reram_cell area_ox=0.0676
X6898 rr3t3r_0[69|15]/a_60_290# WL69 SL15 VSS sky130_fd_pr__nfet_g5v0d10v5 ad=0.65 pd=3.3 as=0 ps=0 w=1 l=0.5
X6899 rr3t3r_0[69|15]/a_860_290# WL69 SL15 VSS sky130_fd_pr__nfet_g5v0d10v5 ad=0.65 pd=3.3 as=0 ps=0 w=1 l=0.5
X6900 BLP15 rr3t3r_0[70|15]/a_60_290# sky130_fd_pr_reram__reram_cell area_ox=0.0676
X6901 BLZ15 rr3t3r_0[70|15]/a_460_290# sky130_fd_pr_reram__reram_cell area_ox=0.0676
X6902 rr3t3r_0[70|15]/a_460_290# WL70 SL15 VSS sky130_fd_pr__nfet_g5v0d10v5 ad=0.65 pd=3.3 as=0 ps=0 w=1 l=0.5
X6903 BLN15 rr3t3r_0[70|15]/a_860_290# sky130_fd_pr_reram__reram_cell area_ox=0.0676
X6904 rr3t3r_0[70|15]/a_60_290# WL70 SL15 VSS sky130_fd_pr__nfet_g5v0d10v5 ad=0.65 pd=3.3 as=0 ps=0 w=1 l=0.5
X6905 rr3t3r_0[70|15]/a_860_290# WL70 SL15 VSS sky130_fd_pr__nfet_g5v0d10v5 ad=0.65 pd=3.3 as=0 ps=0 w=1 l=0.5
X6906 BLP15 rr3t3r_0[71|15]/a_60_290# sky130_fd_pr_reram__reram_cell area_ox=0.0676
X6907 BLZ15 rr3t3r_0[71|15]/a_460_290# sky130_fd_pr_reram__reram_cell area_ox=0.0676
X6908 rr3t3r_0[71|15]/a_460_290# WL71 SL15 VSS sky130_fd_pr__nfet_g5v0d10v5 ad=0.65 pd=3.3 as=0 ps=0 w=1 l=0.5
X6909 BLN15 rr3t3r_0[71|15]/a_860_290# sky130_fd_pr_reram__reram_cell area_ox=0.0676
X6910 rr3t3r_0[71|15]/a_60_290# WL71 SL15 VSS sky130_fd_pr__nfet_g5v0d10v5 ad=0.65 pd=3.3 as=0 ps=0 w=1 l=0.5
X6911 rr3t3r_0[71|15]/a_860_290# WL71 SL15 VSS sky130_fd_pr__nfet_g5v0d10v5 ad=0.65 pd=3.3 as=0 ps=0 w=1 l=0.5
X6912 BLP16 rr3t3r_0[0|16]/a_60_290# sky130_fd_pr_reram__reram_cell area_ox=0.0676
X6913 BLZ16 rr3t3r_0[0|16]/a_460_290# sky130_fd_pr_reram__reram_cell area_ox=0.0676
X6914 rr3t3r_0[0|16]/a_460_290# WL0 SL16 VSS sky130_fd_pr__nfet_g5v0d10v5 ad=0.65 pd=3.3 as=162 ps=756 w=1 l=0.5
X6915 BLN16 rr3t3r_0[0|16]/a_860_290# sky130_fd_pr_reram__reram_cell area_ox=0.0676
X6916 rr3t3r_0[0|16]/a_60_290# WL0 SL16 VSS sky130_fd_pr__nfet_g5v0d10v5 ad=0.65 pd=3.3 as=0 ps=0 w=1 l=0.5
X6917 rr3t3r_0[0|16]/a_860_290# WL0 SL16 VSS sky130_fd_pr__nfet_g5v0d10v5 ad=0.65 pd=3.3 as=0 ps=0 w=1 l=0.5
X6918 BLP16 rr3t3r_0[1|16]/a_60_290# sky130_fd_pr_reram__reram_cell area_ox=0.0676
X6919 BLZ16 rr3t3r_0[1|16]/a_460_290# sky130_fd_pr_reram__reram_cell area_ox=0.0676
X6920 rr3t3r_0[1|16]/a_460_290# WL1 SL16 VSS sky130_fd_pr__nfet_g5v0d10v5 ad=0.65 pd=3.3 as=0 ps=0 w=1 l=0.5
X6921 BLN16 rr3t3r_0[1|16]/a_860_290# sky130_fd_pr_reram__reram_cell area_ox=0.0676
X6922 rr3t3r_0[1|16]/a_60_290# WL1 SL16 VSS sky130_fd_pr__nfet_g5v0d10v5 ad=0.65 pd=3.3 as=0 ps=0 w=1 l=0.5
X6923 rr3t3r_0[1|16]/a_860_290# WL1 SL16 VSS sky130_fd_pr__nfet_g5v0d10v5 ad=0.65 pd=3.3 as=0 ps=0 w=1 l=0.5
X6924 BLP16 rr3t3r_0[2|16]/a_60_290# sky130_fd_pr_reram__reram_cell area_ox=0.0676
X6925 BLZ16 rr3t3r_0[2|16]/a_460_290# sky130_fd_pr_reram__reram_cell area_ox=0.0676
X6926 rr3t3r_0[2|16]/a_460_290# WL2 SL16 VSS sky130_fd_pr__nfet_g5v0d10v5 ad=0.65 pd=3.3 as=0 ps=0 w=1 l=0.5
X6927 BLN16 rr3t3r_0[2|16]/a_860_290# sky130_fd_pr_reram__reram_cell area_ox=0.0676
X6928 rr3t3r_0[2|16]/a_60_290# WL2 SL16 VSS sky130_fd_pr__nfet_g5v0d10v5 ad=0.65 pd=3.3 as=0 ps=0 w=1 l=0.5
X6929 rr3t3r_0[2|16]/a_860_290# WL2 SL16 VSS sky130_fd_pr__nfet_g5v0d10v5 ad=0.65 pd=3.3 as=0 ps=0 w=1 l=0.5
X6930 BLP16 rr3t3r_0[3|16]/a_60_290# sky130_fd_pr_reram__reram_cell area_ox=0.0676
X6931 BLZ16 rr3t3r_0[3|16]/a_460_290# sky130_fd_pr_reram__reram_cell area_ox=0.0676
X6932 rr3t3r_0[3|16]/a_460_290# WL3 SL16 VSS sky130_fd_pr__nfet_g5v0d10v5 ad=0.65 pd=3.3 as=0 ps=0 w=1 l=0.5
X6933 BLN16 rr3t3r_0[3|16]/a_860_290# sky130_fd_pr_reram__reram_cell area_ox=0.0676
X6934 rr3t3r_0[3|16]/a_60_290# WL3 SL16 VSS sky130_fd_pr__nfet_g5v0d10v5 ad=0.65 pd=3.3 as=0 ps=0 w=1 l=0.5
X6935 rr3t3r_0[3|16]/a_860_290# WL3 SL16 VSS sky130_fd_pr__nfet_g5v0d10v5 ad=0.65 pd=3.3 as=0 ps=0 w=1 l=0.5
X6936 BLP16 rr3t3r_0[4|16]/a_60_290# sky130_fd_pr_reram__reram_cell area_ox=0.0676
X6937 BLZ16 rr3t3r_0[4|16]/a_460_290# sky130_fd_pr_reram__reram_cell area_ox=0.0676
X6938 rr3t3r_0[4|16]/a_460_290# WL4 SL16 VSS sky130_fd_pr__nfet_g5v0d10v5 ad=0.65 pd=3.3 as=0 ps=0 w=1 l=0.5
X6939 BLN16 rr3t3r_0[4|16]/a_860_290# sky130_fd_pr_reram__reram_cell area_ox=0.0676
X6940 rr3t3r_0[4|16]/a_60_290# WL4 SL16 VSS sky130_fd_pr__nfet_g5v0d10v5 ad=0.65 pd=3.3 as=0 ps=0 w=1 l=0.5
X6941 rr3t3r_0[4|16]/a_860_290# WL4 SL16 VSS sky130_fd_pr__nfet_g5v0d10v5 ad=0.65 pd=3.3 as=0 ps=0 w=1 l=0.5
X6942 BLP16 rr3t3r_0[5|16]/a_60_290# sky130_fd_pr_reram__reram_cell area_ox=0.0676
X6943 BLZ16 rr3t3r_0[5|16]/a_460_290# sky130_fd_pr_reram__reram_cell area_ox=0.0676
X6944 rr3t3r_0[5|16]/a_460_290# WL5 SL16 VSS sky130_fd_pr__nfet_g5v0d10v5 ad=0.65 pd=3.3 as=0 ps=0 w=1 l=0.5
X6945 BLN16 rr3t3r_0[5|16]/a_860_290# sky130_fd_pr_reram__reram_cell area_ox=0.0676
X6946 rr3t3r_0[5|16]/a_60_290# WL5 SL16 VSS sky130_fd_pr__nfet_g5v0d10v5 ad=0.65 pd=3.3 as=0 ps=0 w=1 l=0.5
X6947 rr3t3r_0[5|16]/a_860_290# WL5 SL16 VSS sky130_fd_pr__nfet_g5v0d10v5 ad=0.65 pd=3.3 as=0 ps=0 w=1 l=0.5
X6948 BLP16 rr3t3r_0[6|16]/a_60_290# sky130_fd_pr_reram__reram_cell area_ox=0.0676
X6949 BLZ16 rr3t3r_0[6|16]/a_460_290# sky130_fd_pr_reram__reram_cell area_ox=0.0676
X6950 rr3t3r_0[6|16]/a_460_290# WL6 SL16 VSS sky130_fd_pr__nfet_g5v0d10v5 ad=0.65 pd=3.3 as=0 ps=0 w=1 l=0.5
X6951 BLN16 rr3t3r_0[6|16]/a_860_290# sky130_fd_pr_reram__reram_cell area_ox=0.0676
X6952 rr3t3r_0[6|16]/a_60_290# WL6 SL16 VSS sky130_fd_pr__nfet_g5v0d10v5 ad=0.65 pd=3.3 as=0 ps=0 w=1 l=0.5
X6953 rr3t3r_0[6|16]/a_860_290# WL6 SL16 VSS sky130_fd_pr__nfet_g5v0d10v5 ad=0.65 pd=3.3 as=0 ps=0 w=1 l=0.5
X6954 BLP16 rr3t3r_0[7|16]/a_60_290# sky130_fd_pr_reram__reram_cell area_ox=0.0676
X6955 BLZ16 rr3t3r_0[7|16]/a_460_290# sky130_fd_pr_reram__reram_cell area_ox=0.0676
X6956 rr3t3r_0[7|16]/a_460_290# WL7 SL16 VSS sky130_fd_pr__nfet_g5v0d10v5 ad=0.65 pd=3.3 as=0 ps=0 w=1 l=0.5
X6957 BLN16 rr3t3r_0[7|16]/a_860_290# sky130_fd_pr_reram__reram_cell area_ox=0.0676
X6958 rr3t3r_0[7|16]/a_60_290# WL7 SL16 VSS sky130_fd_pr__nfet_g5v0d10v5 ad=0.65 pd=3.3 as=0 ps=0 w=1 l=0.5
X6959 rr3t3r_0[7|16]/a_860_290# WL7 SL16 VSS sky130_fd_pr__nfet_g5v0d10v5 ad=0.65 pd=3.3 as=0 ps=0 w=1 l=0.5
X6960 BLP16 rr3t3r_0[8|16]/a_60_290# sky130_fd_pr_reram__reram_cell area_ox=0.0676
X6961 BLZ16 rr3t3r_0[8|16]/a_460_290# sky130_fd_pr_reram__reram_cell area_ox=0.0676
X6962 rr3t3r_0[8|16]/a_460_290# WL8 SL16 VSS sky130_fd_pr__nfet_g5v0d10v5 ad=0.65 pd=3.3 as=0 ps=0 w=1 l=0.5
X6963 BLN16 rr3t3r_0[8|16]/a_860_290# sky130_fd_pr_reram__reram_cell area_ox=0.0676
X6964 rr3t3r_0[8|16]/a_60_290# WL8 SL16 VSS sky130_fd_pr__nfet_g5v0d10v5 ad=0.65 pd=3.3 as=0 ps=0 w=1 l=0.5
X6965 rr3t3r_0[8|16]/a_860_290# WL8 SL16 VSS sky130_fd_pr__nfet_g5v0d10v5 ad=0.65 pd=3.3 as=0 ps=0 w=1 l=0.5
X6966 BLP16 rr3t3r_0[9|16]/a_60_290# sky130_fd_pr_reram__reram_cell area_ox=0.0676
X6967 BLZ16 rr3t3r_0[9|16]/a_460_290# sky130_fd_pr_reram__reram_cell area_ox=0.0676
X6968 rr3t3r_0[9|16]/a_460_290# WL9 SL16 VSS sky130_fd_pr__nfet_g5v0d10v5 ad=0.65 pd=3.3 as=0 ps=0 w=1 l=0.5
X6969 BLN16 rr3t3r_0[9|16]/a_860_290# sky130_fd_pr_reram__reram_cell area_ox=0.0676
X6970 rr3t3r_0[9|16]/a_60_290# WL9 SL16 VSS sky130_fd_pr__nfet_g5v0d10v5 ad=0.65 pd=3.3 as=0 ps=0 w=1 l=0.5
X6971 rr3t3r_0[9|16]/a_860_290# WL9 SL16 VSS sky130_fd_pr__nfet_g5v0d10v5 ad=0.65 pd=3.3 as=0 ps=0 w=1 l=0.5
X6972 BLP16 rr3t3r_0[10|16]/a_60_290# sky130_fd_pr_reram__reram_cell area_ox=0.0676
X6973 BLZ16 rr3t3r_0[10|16]/a_460_290# sky130_fd_pr_reram__reram_cell area_ox=0.0676
X6974 rr3t3r_0[10|16]/a_460_290# WL10 SL16 VSS sky130_fd_pr__nfet_g5v0d10v5 ad=0.65 pd=3.3 as=0 ps=0 w=1 l=0.5
X6975 BLN16 rr3t3r_0[10|16]/a_860_290# sky130_fd_pr_reram__reram_cell area_ox=0.0676
X6976 rr3t3r_0[10|16]/a_60_290# WL10 SL16 VSS sky130_fd_pr__nfet_g5v0d10v5 ad=0.65 pd=3.3 as=0 ps=0 w=1 l=0.5
X6977 rr3t3r_0[10|16]/a_860_290# WL10 SL16 VSS sky130_fd_pr__nfet_g5v0d10v5 ad=0.65 pd=3.3 as=0 ps=0 w=1 l=0.5
X6978 BLP16 rr3t3r_0[11|16]/a_60_290# sky130_fd_pr_reram__reram_cell area_ox=0.0676
X6979 BLZ16 rr3t3r_0[11|16]/a_460_290# sky130_fd_pr_reram__reram_cell area_ox=0.0676
X6980 rr3t3r_0[11|16]/a_460_290# WL11 SL16 VSS sky130_fd_pr__nfet_g5v0d10v5 ad=0.65 pd=3.3 as=0 ps=0 w=1 l=0.5
X6981 BLN16 rr3t3r_0[11|16]/a_860_290# sky130_fd_pr_reram__reram_cell area_ox=0.0676
X6982 rr3t3r_0[11|16]/a_60_290# WL11 SL16 VSS sky130_fd_pr__nfet_g5v0d10v5 ad=0.65 pd=3.3 as=0 ps=0 w=1 l=0.5
X6983 rr3t3r_0[11|16]/a_860_290# WL11 SL16 VSS sky130_fd_pr__nfet_g5v0d10v5 ad=0.65 pd=3.3 as=0 ps=0 w=1 l=0.5
X6984 BLP16 rr3t3r_0[12|16]/a_60_290# sky130_fd_pr_reram__reram_cell area_ox=0.0676
X6985 BLZ16 rr3t3r_0[12|16]/a_460_290# sky130_fd_pr_reram__reram_cell area_ox=0.0676
X6986 rr3t3r_0[12|16]/a_460_290# WL12 SL16 VSS sky130_fd_pr__nfet_g5v0d10v5 ad=0.65 pd=3.3 as=0 ps=0 w=1 l=0.5
X6987 BLN16 rr3t3r_0[12|16]/a_860_290# sky130_fd_pr_reram__reram_cell area_ox=0.0676
X6988 rr3t3r_0[12|16]/a_60_290# WL12 SL16 VSS sky130_fd_pr__nfet_g5v0d10v5 ad=0.65 pd=3.3 as=0 ps=0 w=1 l=0.5
X6989 rr3t3r_0[12|16]/a_860_290# WL12 SL16 VSS sky130_fd_pr__nfet_g5v0d10v5 ad=0.65 pd=3.3 as=0 ps=0 w=1 l=0.5
X6990 BLP16 rr3t3r_0[13|16]/a_60_290# sky130_fd_pr_reram__reram_cell area_ox=0.0676
X6991 BLZ16 rr3t3r_0[13|16]/a_460_290# sky130_fd_pr_reram__reram_cell area_ox=0.0676
X6992 rr3t3r_0[13|16]/a_460_290# WL13 SL16 VSS sky130_fd_pr__nfet_g5v0d10v5 ad=0.65 pd=3.3 as=0 ps=0 w=1 l=0.5
X6993 BLN16 rr3t3r_0[13|16]/a_860_290# sky130_fd_pr_reram__reram_cell area_ox=0.0676
X6994 rr3t3r_0[13|16]/a_60_290# WL13 SL16 VSS sky130_fd_pr__nfet_g5v0d10v5 ad=0.65 pd=3.3 as=0 ps=0 w=1 l=0.5
X6995 rr3t3r_0[13|16]/a_860_290# WL13 SL16 VSS sky130_fd_pr__nfet_g5v0d10v5 ad=0.65 pd=3.3 as=0 ps=0 w=1 l=0.5
X6996 BLP16 rr3t3r_0[14|16]/a_60_290# sky130_fd_pr_reram__reram_cell area_ox=0.0676
X6997 BLZ16 rr3t3r_0[14|16]/a_460_290# sky130_fd_pr_reram__reram_cell area_ox=0.0676
X6998 rr3t3r_0[14|16]/a_460_290# WL14 SL16 VSS sky130_fd_pr__nfet_g5v0d10v5 ad=0.65 pd=3.3 as=0 ps=0 w=1 l=0.5
X6999 BLN16 rr3t3r_0[14|16]/a_860_290# sky130_fd_pr_reram__reram_cell area_ox=0.0676
X7000 rr3t3r_0[14|16]/a_60_290# WL14 SL16 VSS sky130_fd_pr__nfet_g5v0d10v5 ad=0.65 pd=3.3 as=0 ps=0 w=1 l=0.5
X7001 rr3t3r_0[14|16]/a_860_290# WL14 SL16 VSS sky130_fd_pr__nfet_g5v0d10v5 ad=0.65 pd=3.3 as=0 ps=0 w=1 l=0.5
X7002 BLP16 rr3t3r_0[15|16]/a_60_290# sky130_fd_pr_reram__reram_cell area_ox=0.0676
X7003 BLZ16 rr3t3r_0[15|16]/a_460_290# sky130_fd_pr_reram__reram_cell area_ox=0.0676
X7004 rr3t3r_0[15|16]/a_460_290# WL15 SL16 VSS sky130_fd_pr__nfet_g5v0d10v5 ad=0.65 pd=3.3 as=0 ps=0 w=1 l=0.5
X7005 BLN16 rr3t3r_0[15|16]/a_860_290# sky130_fd_pr_reram__reram_cell area_ox=0.0676
X7006 rr3t3r_0[15|16]/a_60_290# WL15 SL16 VSS sky130_fd_pr__nfet_g5v0d10v5 ad=0.65 pd=3.3 as=0 ps=0 w=1 l=0.5
X7007 rr3t3r_0[15|16]/a_860_290# WL15 SL16 VSS sky130_fd_pr__nfet_g5v0d10v5 ad=0.65 pd=3.3 as=0 ps=0 w=1 l=0.5
X7008 BLP16 rr3t3r_0[16|16]/a_60_290# sky130_fd_pr_reram__reram_cell area_ox=0.0676
X7009 BLZ16 rr3t3r_0[16|16]/a_460_290# sky130_fd_pr_reram__reram_cell area_ox=0.0676
X7010 rr3t3r_0[16|16]/a_460_290# WL16 SL16 VSS sky130_fd_pr__nfet_g5v0d10v5 ad=0.65 pd=3.3 as=0 ps=0 w=1 l=0.5
X7011 BLN16 rr3t3r_0[16|16]/a_860_290# sky130_fd_pr_reram__reram_cell area_ox=0.0676
X7012 rr3t3r_0[16|16]/a_60_290# WL16 SL16 VSS sky130_fd_pr__nfet_g5v0d10v5 ad=0.65 pd=3.3 as=0 ps=0 w=1 l=0.5
X7013 rr3t3r_0[16|16]/a_860_290# WL16 SL16 VSS sky130_fd_pr__nfet_g5v0d10v5 ad=0.65 pd=3.3 as=0 ps=0 w=1 l=0.5
X7014 BLP16 rr3t3r_0[17|16]/a_60_290# sky130_fd_pr_reram__reram_cell area_ox=0.0676
X7015 BLZ16 rr3t3r_0[17|16]/a_460_290# sky130_fd_pr_reram__reram_cell area_ox=0.0676
X7016 rr3t3r_0[17|16]/a_460_290# WL17 SL16 VSS sky130_fd_pr__nfet_g5v0d10v5 ad=0.65 pd=3.3 as=0 ps=0 w=1 l=0.5
X7017 BLN16 rr3t3r_0[17|16]/a_860_290# sky130_fd_pr_reram__reram_cell area_ox=0.0676
X7018 rr3t3r_0[17|16]/a_60_290# WL17 SL16 VSS sky130_fd_pr__nfet_g5v0d10v5 ad=0.65 pd=3.3 as=0 ps=0 w=1 l=0.5
X7019 rr3t3r_0[17|16]/a_860_290# WL17 SL16 VSS sky130_fd_pr__nfet_g5v0d10v5 ad=0.65 pd=3.3 as=0 ps=0 w=1 l=0.5
X7020 BLP16 rr3t3r_0[18|16]/a_60_290# sky130_fd_pr_reram__reram_cell area_ox=0.0676
X7021 BLZ16 rr3t3r_0[18|16]/a_460_290# sky130_fd_pr_reram__reram_cell area_ox=0.0676
X7022 rr3t3r_0[18|16]/a_460_290# WL18 SL16 VSS sky130_fd_pr__nfet_g5v0d10v5 ad=0.65 pd=3.3 as=0 ps=0 w=1 l=0.5
X7023 BLN16 rr3t3r_0[18|16]/a_860_290# sky130_fd_pr_reram__reram_cell area_ox=0.0676
X7024 rr3t3r_0[18|16]/a_60_290# WL18 SL16 VSS sky130_fd_pr__nfet_g5v0d10v5 ad=0.65 pd=3.3 as=0 ps=0 w=1 l=0.5
X7025 rr3t3r_0[18|16]/a_860_290# WL18 SL16 VSS sky130_fd_pr__nfet_g5v0d10v5 ad=0.65 pd=3.3 as=0 ps=0 w=1 l=0.5
X7026 BLP16 rr3t3r_0[19|16]/a_60_290# sky130_fd_pr_reram__reram_cell area_ox=0.0676
X7027 BLZ16 rr3t3r_0[19|16]/a_460_290# sky130_fd_pr_reram__reram_cell area_ox=0.0676
X7028 rr3t3r_0[19|16]/a_460_290# WL19 SL16 VSS sky130_fd_pr__nfet_g5v0d10v5 ad=0.65 pd=3.3 as=0 ps=0 w=1 l=0.5
X7029 BLN16 rr3t3r_0[19|16]/a_860_290# sky130_fd_pr_reram__reram_cell area_ox=0.0676
X7030 rr3t3r_0[19|16]/a_60_290# WL19 SL16 VSS sky130_fd_pr__nfet_g5v0d10v5 ad=0.65 pd=3.3 as=0 ps=0 w=1 l=0.5
X7031 rr3t3r_0[19|16]/a_860_290# WL19 SL16 VSS sky130_fd_pr__nfet_g5v0d10v5 ad=0.65 pd=3.3 as=0 ps=0 w=1 l=0.5
X7032 BLP16 rr3t3r_0[20|16]/a_60_290# sky130_fd_pr_reram__reram_cell area_ox=0.0676
X7033 BLZ16 rr3t3r_0[20|16]/a_460_290# sky130_fd_pr_reram__reram_cell area_ox=0.0676
X7034 rr3t3r_0[20|16]/a_460_290# WL20 SL16 VSS sky130_fd_pr__nfet_g5v0d10v5 ad=0.65 pd=3.3 as=0 ps=0 w=1 l=0.5
X7035 BLN16 rr3t3r_0[20|16]/a_860_290# sky130_fd_pr_reram__reram_cell area_ox=0.0676
X7036 rr3t3r_0[20|16]/a_60_290# WL20 SL16 VSS sky130_fd_pr__nfet_g5v0d10v5 ad=0.65 pd=3.3 as=0 ps=0 w=1 l=0.5
X7037 rr3t3r_0[20|16]/a_860_290# WL20 SL16 VSS sky130_fd_pr__nfet_g5v0d10v5 ad=0.65 pd=3.3 as=0 ps=0 w=1 l=0.5
X7038 BLP16 rr3t3r_0[21|16]/a_60_290# sky130_fd_pr_reram__reram_cell area_ox=0.0676
X7039 BLZ16 rr3t3r_0[21|16]/a_460_290# sky130_fd_pr_reram__reram_cell area_ox=0.0676
X7040 rr3t3r_0[21|16]/a_460_290# WL21 SL16 VSS sky130_fd_pr__nfet_g5v0d10v5 ad=0.65 pd=3.3 as=0 ps=0 w=1 l=0.5
X7041 BLN16 rr3t3r_0[21|16]/a_860_290# sky130_fd_pr_reram__reram_cell area_ox=0.0676
X7042 rr3t3r_0[21|16]/a_60_290# WL21 SL16 VSS sky130_fd_pr__nfet_g5v0d10v5 ad=0.65 pd=3.3 as=0 ps=0 w=1 l=0.5
X7043 rr3t3r_0[21|16]/a_860_290# WL21 SL16 VSS sky130_fd_pr__nfet_g5v0d10v5 ad=0.65 pd=3.3 as=0 ps=0 w=1 l=0.5
X7044 BLP16 rr3t3r_0[22|16]/a_60_290# sky130_fd_pr_reram__reram_cell area_ox=0.0676
X7045 BLZ16 rr3t3r_0[22|16]/a_460_290# sky130_fd_pr_reram__reram_cell area_ox=0.0676
X7046 rr3t3r_0[22|16]/a_460_290# WL22 SL16 VSS sky130_fd_pr__nfet_g5v0d10v5 ad=0.65 pd=3.3 as=0 ps=0 w=1 l=0.5
X7047 BLN16 rr3t3r_0[22|16]/a_860_290# sky130_fd_pr_reram__reram_cell area_ox=0.0676
X7048 rr3t3r_0[22|16]/a_60_290# WL22 SL16 VSS sky130_fd_pr__nfet_g5v0d10v5 ad=0.65 pd=3.3 as=0 ps=0 w=1 l=0.5
X7049 rr3t3r_0[22|16]/a_860_290# WL22 SL16 VSS sky130_fd_pr__nfet_g5v0d10v5 ad=0.65 pd=3.3 as=0 ps=0 w=1 l=0.5
X7050 BLP16 rr3t3r_0[23|16]/a_60_290# sky130_fd_pr_reram__reram_cell area_ox=0.0676
X7051 BLZ16 rr3t3r_0[23|16]/a_460_290# sky130_fd_pr_reram__reram_cell area_ox=0.0676
X7052 rr3t3r_0[23|16]/a_460_290# WL23 SL16 VSS sky130_fd_pr__nfet_g5v0d10v5 ad=0.65 pd=3.3 as=0 ps=0 w=1 l=0.5
X7053 BLN16 rr3t3r_0[23|16]/a_860_290# sky130_fd_pr_reram__reram_cell area_ox=0.0676
X7054 rr3t3r_0[23|16]/a_60_290# WL23 SL16 VSS sky130_fd_pr__nfet_g5v0d10v5 ad=0.65 pd=3.3 as=0 ps=0 w=1 l=0.5
X7055 rr3t3r_0[23|16]/a_860_290# WL23 SL16 VSS sky130_fd_pr__nfet_g5v0d10v5 ad=0.65 pd=3.3 as=0 ps=0 w=1 l=0.5
X7056 BLP16 rr3t3r_0[24|16]/a_60_290# sky130_fd_pr_reram__reram_cell area_ox=0.0676
X7057 BLZ16 rr3t3r_0[24|16]/a_460_290# sky130_fd_pr_reram__reram_cell area_ox=0.0676
X7058 rr3t3r_0[24|16]/a_460_290# WL24 SL16 VSS sky130_fd_pr__nfet_g5v0d10v5 ad=0.65 pd=3.3 as=0 ps=0 w=1 l=0.5
X7059 BLN16 rr3t3r_0[24|16]/a_860_290# sky130_fd_pr_reram__reram_cell area_ox=0.0676
X7060 rr3t3r_0[24|16]/a_60_290# WL24 SL16 VSS sky130_fd_pr__nfet_g5v0d10v5 ad=0.65 pd=3.3 as=0 ps=0 w=1 l=0.5
X7061 rr3t3r_0[24|16]/a_860_290# WL24 SL16 VSS sky130_fd_pr__nfet_g5v0d10v5 ad=0.65 pd=3.3 as=0 ps=0 w=1 l=0.5
X7062 BLP16 rr3t3r_0[25|16]/a_60_290# sky130_fd_pr_reram__reram_cell area_ox=0.0676
X7063 BLZ16 rr3t3r_0[25|16]/a_460_290# sky130_fd_pr_reram__reram_cell area_ox=0.0676
X7064 rr3t3r_0[25|16]/a_460_290# WL25 SL16 VSS sky130_fd_pr__nfet_g5v0d10v5 ad=0.65 pd=3.3 as=0 ps=0 w=1 l=0.5
X7065 BLN16 rr3t3r_0[25|16]/a_860_290# sky130_fd_pr_reram__reram_cell area_ox=0.0676
X7066 rr3t3r_0[25|16]/a_60_290# WL25 SL16 VSS sky130_fd_pr__nfet_g5v0d10v5 ad=0.65 pd=3.3 as=0 ps=0 w=1 l=0.5
X7067 rr3t3r_0[25|16]/a_860_290# WL25 SL16 VSS sky130_fd_pr__nfet_g5v0d10v5 ad=0.65 pd=3.3 as=0 ps=0 w=1 l=0.5
X7068 BLP16 rr3t3r_0[26|16]/a_60_290# sky130_fd_pr_reram__reram_cell area_ox=0.0676
X7069 BLZ16 rr3t3r_0[26|16]/a_460_290# sky130_fd_pr_reram__reram_cell area_ox=0.0676
X7070 rr3t3r_0[26|16]/a_460_290# WL26 SL16 VSS sky130_fd_pr__nfet_g5v0d10v5 ad=0.65 pd=3.3 as=0 ps=0 w=1 l=0.5
X7071 BLN16 rr3t3r_0[26|16]/a_860_290# sky130_fd_pr_reram__reram_cell area_ox=0.0676
X7072 rr3t3r_0[26|16]/a_60_290# WL26 SL16 VSS sky130_fd_pr__nfet_g5v0d10v5 ad=0.65 pd=3.3 as=0 ps=0 w=1 l=0.5
X7073 rr3t3r_0[26|16]/a_860_290# WL26 SL16 VSS sky130_fd_pr__nfet_g5v0d10v5 ad=0.65 pd=3.3 as=0 ps=0 w=1 l=0.5
X7074 BLP16 rr3t3r_0[27|16]/a_60_290# sky130_fd_pr_reram__reram_cell area_ox=0.0676
X7075 BLZ16 rr3t3r_0[27|16]/a_460_290# sky130_fd_pr_reram__reram_cell area_ox=0.0676
X7076 rr3t3r_0[27|16]/a_460_290# WL27 SL16 VSS sky130_fd_pr__nfet_g5v0d10v5 ad=0.65 pd=3.3 as=0 ps=0 w=1 l=0.5
X7077 BLN16 rr3t3r_0[27|16]/a_860_290# sky130_fd_pr_reram__reram_cell area_ox=0.0676
X7078 rr3t3r_0[27|16]/a_60_290# WL27 SL16 VSS sky130_fd_pr__nfet_g5v0d10v5 ad=0.65 pd=3.3 as=0 ps=0 w=1 l=0.5
X7079 rr3t3r_0[27|16]/a_860_290# WL27 SL16 VSS sky130_fd_pr__nfet_g5v0d10v5 ad=0.65 pd=3.3 as=0 ps=0 w=1 l=0.5
X7080 BLP16 rr3t3r_0[28|16]/a_60_290# sky130_fd_pr_reram__reram_cell area_ox=0.0676
X7081 BLZ16 rr3t3r_0[28|16]/a_460_290# sky130_fd_pr_reram__reram_cell area_ox=0.0676
X7082 rr3t3r_0[28|16]/a_460_290# WL28 SL16 VSS sky130_fd_pr__nfet_g5v0d10v5 ad=0.65 pd=3.3 as=0 ps=0 w=1 l=0.5
X7083 BLN16 rr3t3r_0[28|16]/a_860_290# sky130_fd_pr_reram__reram_cell area_ox=0.0676
X7084 rr3t3r_0[28|16]/a_60_290# WL28 SL16 VSS sky130_fd_pr__nfet_g5v0d10v5 ad=0.65 pd=3.3 as=0 ps=0 w=1 l=0.5
X7085 rr3t3r_0[28|16]/a_860_290# WL28 SL16 VSS sky130_fd_pr__nfet_g5v0d10v5 ad=0.65 pd=3.3 as=0 ps=0 w=1 l=0.5
X7086 BLP16 rr3t3r_0[29|16]/a_60_290# sky130_fd_pr_reram__reram_cell area_ox=0.0676
X7087 BLZ16 rr3t3r_0[29|16]/a_460_290# sky130_fd_pr_reram__reram_cell area_ox=0.0676
X7088 rr3t3r_0[29|16]/a_460_290# WL29 SL16 VSS sky130_fd_pr__nfet_g5v0d10v5 ad=0.65 pd=3.3 as=0 ps=0 w=1 l=0.5
X7089 BLN16 rr3t3r_0[29|16]/a_860_290# sky130_fd_pr_reram__reram_cell area_ox=0.0676
X7090 rr3t3r_0[29|16]/a_60_290# WL29 SL16 VSS sky130_fd_pr__nfet_g5v0d10v5 ad=0.65 pd=3.3 as=0 ps=0 w=1 l=0.5
X7091 rr3t3r_0[29|16]/a_860_290# WL29 SL16 VSS sky130_fd_pr__nfet_g5v0d10v5 ad=0.65 pd=3.3 as=0 ps=0 w=1 l=0.5
X7092 BLP16 rr3t3r_0[30|16]/a_60_290# sky130_fd_pr_reram__reram_cell area_ox=0.0676
X7093 BLZ16 rr3t3r_0[30|16]/a_460_290# sky130_fd_pr_reram__reram_cell area_ox=0.0676
X7094 rr3t3r_0[30|16]/a_460_290# WL30 SL16 VSS sky130_fd_pr__nfet_g5v0d10v5 ad=0.65 pd=3.3 as=0 ps=0 w=1 l=0.5
X7095 BLN16 rr3t3r_0[30|16]/a_860_290# sky130_fd_pr_reram__reram_cell area_ox=0.0676
X7096 rr3t3r_0[30|16]/a_60_290# WL30 SL16 VSS sky130_fd_pr__nfet_g5v0d10v5 ad=0.65 pd=3.3 as=0 ps=0 w=1 l=0.5
X7097 rr3t3r_0[30|16]/a_860_290# WL30 SL16 VSS sky130_fd_pr__nfet_g5v0d10v5 ad=0.65 pd=3.3 as=0 ps=0 w=1 l=0.5
X7098 BLP16 rr3t3r_0[31|16]/a_60_290# sky130_fd_pr_reram__reram_cell area_ox=0.0676
X7099 BLZ16 rr3t3r_0[31|16]/a_460_290# sky130_fd_pr_reram__reram_cell area_ox=0.0676
X7100 rr3t3r_0[31|16]/a_460_290# WL31 SL16 VSS sky130_fd_pr__nfet_g5v0d10v5 ad=0.65 pd=3.3 as=0 ps=0 w=1 l=0.5
X7101 BLN16 rr3t3r_0[31|16]/a_860_290# sky130_fd_pr_reram__reram_cell area_ox=0.0676
X7102 rr3t3r_0[31|16]/a_60_290# WL31 SL16 VSS sky130_fd_pr__nfet_g5v0d10v5 ad=0.65 pd=3.3 as=0 ps=0 w=1 l=0.5
X7103 rr3t3r_0[31|16]/a_860_290# WL31 SL16 VSS sky130_fd_pr__nfet_g5v0d10v5 ad=0.65 pd=3.3 as=0 ps=0 w=1 l=0.5
X7104 BLP16 rr3t3r_0[32|16]/a_60_290# sky130_fd_pr_reram__reram_cell area_ox=0.0676
X7105 BLZ16 rr3t3r_0[32|16]/a_460_290# sky130_fd_pr_reram__reram_cell area_ox=0.0676
X7106 rr3t3r_0[32|16]/a_460_290# WL32 SL16 VSS sky130_fd_pr__nfet_g5v0d10v5 ad=0.65 pd=3.3 as=0 ps=0 w=1 l=0.5
X7107 BLN16 rr3t3r_0[32|16]/a_860_290# sky130_fd_pr_reram__reram_cell area_ox=0.0676
X7108 rr3t3r_0[32|16]/a_60_290# WL32 SL16 VSS sky130_fd_pr__nfet_g5v0d10v5 ad=0.65 pd=3.3 as=0 ps=0 w=1 l=0.5
X7109 rr3t3r_0[32|16]/a_860_290# WL32 SL16 VSS sky130_fd_pr__nfet_g5v0d10v5 ad=0.65 pd=3.3 as=0 ps=0 w=1 l=0.5
X7110 BLP16 rr3t3r_0[33|16]/a_60_290# sky130_fd_pr_reram__reram_cell area_ox=0.0676
X7111 BLZ16 rr3t3r_0[33|16]/a_460_290# sky130_fd_pr_reram__reram_cell area_ox=0.0676
X7112 rr3t3r_0[33|16]/a_460_290# WL33 SL16 VSS sky130_fd_pr__nfet_g5v0d10v5 ad=0.65 pd=3.3 as=0 ps=0 w=1 l=0.5
X7113 BLN16 rr3t3r_0[33|16]/a_860_290# sky130_fd_pr_reram__reram_cell area_ox=0.0676
X7114 rr3t3r_0[33|16]/a_60_290# WL33 SL16 VSS sky130_fd_pr__nfet_g5v0d10v5 ad=0.65 pd=3.3 as=0 ps=0 w=1 l=0.5
X7115 rr3t3r_0[33|16]/a_860_290# WL33 SL16 VSS sky130_fd_pr__nfet_g5v0d10v5 ad=0.65 pd=3.3 as=0 ps=0 w=1 l=0.5
X7116 BLP16 rr3t3r_0[34|16]/a_60_290# sky130_fd_pr_reram__reram_cell area_ox=0.0676
X7117 BLZ16 rr3t3r_0[34|16]/a_460_290# sky130_fd_pr_reram__reram_cell area_ox=0.0676
X7118 rr3t3r_0[34|16]/a_460_290# WL34 SL16 VSS sky130_fd_pr__nfet_g5v0d10v5 ad=0.65 pd=3.3 as=0 ps=0 w=1 l=0.5
X7119 BLN16 rr3t3r_0[34|16]/a_860_290# sky130_fd_pr_reram__reram_cell area_ox=0.0676
X7120 rr3t3r_0[34|16]/a_60_290# WL34 SL16 VSS sky130_fd_pr__nfet_g5v0d10v5 ad=0.65 pd=3.3 as=0 ps=0 w=1 l=0.5
X7121 rr3t3r_0[34|16]/a_860_290# WL34 SL16 VSS sky130_fd_pr__nfet_g5v0d10v5 ad=0.65 pd=3.3 as=0 ps=0 w=1 l=0.5
X7122 BLP16 rr3t3r_0[35|16]/a_60_290# sky130_fd_pr_reram__reram_cell area_ox=0.0676
X7123 BLZ16 rr3t3r_0[35|16]/a_460_290# sky130_fd_pr_reram__reram_cell area_ox=0.0676
X7124 rr3t3r_0[35|16]/a_460_290# WL35 SL16 VSS sky130_fd_pr__nfet_g5v0d10v5 ad=0.65 pd=3.3 as=0 ps=0 w=1 l=0.5
X7125 BLN16 rr3t3r_0[35|16]/a_860_290# sky130_fd_pr_reram__reram_cell area_ox=0.0676
X7126 rr3t3r_0[35|16]/a_60_290# WL35 SL16 VSS sky130_fd_pr__nfet_g5v0d10v5 ad=0.65 pd=3.3 as=0 ps=0 w=1 l=0.5
X7127 rr3t3r_0[35|16]/a_860_290# WL35 SL16 VSS sky130_fd_pr__nfet_g5v0d10v5 ad=0.65 pd=3.3 as=0 ps=0 w=1 l=0.5
X7128 BLP16 rr3t3r_0[36|16]/a_60_290# sky130_fd_pr_reram__reram_cell area_ox=0.0676
X7129 BLZ16 rr3t3r_0[36|16]/a_460_290# sky130_fd_pr_reram__reram_cell area_ox=0.0676
X7130 rr3t3r_0[36|16]/a_460_290# WL36 SL16 VSS sky130_fd_pr__nfet_g5v0d10v5 ad=0.65 pd=3.3 as=0 ps=0 w=1 l=0.5
X7131 BLN16 rr3t3r_0[36|16]/a_860_290# sky130_fd_pr_reram__reram_cell area_ox=0.0676
X7132 rr3t3r_0[36|16]/a_60_290# WL36 SL16 VSS sky130_fd_pr__nfet_g5v0d10v5 ad=0.65 pd=3.3 as=0 ps=0 w=1 l=0.5
X7133 rr3t3r_0[36|16]/a_860_290# WL36 SL16 VSS sky130_fd_pr__nfet_g5v0d10v5 ad=0.65 pd=3.3 as=0 ps=0 w=1 l=0.5
X7134 BLP16 rr3t3r_0[37|16]/a_60_290# sky130_fd_pr_reram__reram_cell area_ox=0.0676
X7135 BLZ16 rr3t3r_0[37|16]/a_460_290# sky130_fd_pr_reram__reram_cell area_ox=0.0676
X7136 rr3t3r_0[37|16]/a_460_290# WL37 SL16 VSS sky130_fd_pr__nfet_g5v0d10v5 ad=0.65 pd=3.3 as=0 ps=0 w=1 l=0.5
X7137 BLN16 rr3t3r_0[37|16]/a_860_290# sky130_fd_pr_reram__reram_cell area_ox=0.0676
X7138 rr3t3r_0[37|16]/a_60_290# WL37 SL16 VSS sky130_fd_pr__nfet_g5v0d10v5 ad=0.65 pd=3.3 as=0 ps=0 w=1 l=0.5
X7139 rr3t3r_0[37|16]/a_860_290# WL37 SL16 VSS sky130_fd_pr__nfet_g5v0d10v5 ad=0.65 pd=3.3 as=0 ps=0 w=1 l=0.5
X7140 BLP16 rr3t3r_0[38|16]/a_60_290# sky130_fd_pr_reram__reram_cell area_ox=0.0676
X7141 BLZ16 rr3t3r_0[38|16]/a_460_290# sky130_fd_pr_reram__reram_cell area_ox=0.0676
X7142 rr3t3r_0[38|16]/a_460_290# WL38 SL16 VSS sky130_fd_pr__nfet_g5v0d10v5 ad=0.65 pd=3.3 as=0 ps=0 w=1 l=0.5
X7143 BLN16 rr3t3r_0[38|16]/a_860_290# sky130_fd_pr_reram__reram_cell area_ox=0.0676
X7144 rr3t3r_0[38|16]/a_60_290# WL38 SL16 VSS sky130_fd_pr__nfet_g5v0d10v5 ad=0.65 pd=3.3 as=0 ps=0 w=1 l=0.5
X7145 rr3t3r_0[38|16]/a_860_290# WL38 SL16 VSS sky130_fd_pr__nfet_g5v0d10v5 ad=0.65 pd=3.3 as=0 ps=0 w=1 l=0.5
X7146 BLP16 rr3t3r_0[39|16]/a_60_290# sky130_fd_pr_reram__reram_cell area_ox=0.0676
X7147 BLZ16 rr3t3r_0[39|16]/a_460_290# sky130_fd_pr_reram__reram_cell area_ox=0.0676
X7148 rr3t3r_0[39|16]/a_460_290# WL39 SL16 VSS sky130_fd_pr__nfet_g5v0d10v5 ad=0.65 pd=3.3 as=0 ps=0 w=1 l=0.5
X7149 BLN16 rr3t3r_0[39|16]/a_860_290# sky130_fd_pr_reram__reram_cell area_ox=0.0676
X7150 rr3t3r_0[39|16]/a_60_290# WL39 SL16 VSS sky130_fd_pr__nfet_g5v0d10v5 ad=0.65 pd=3.3 as=0 ps=0 w=1 l=0.5
X7151 rr3t3r_0[39|16]/a_860_290# WL39 SL16 VSS sky130_fd_pr__nfet_g5v0d10v5 ad=0.65 pd=3.3 as=0 ps=0 w=1 l=0.5
X7152 BLP16 rr3t3r_0[40|16]/a_60_290# sky130_fd_pr_reram__reram_cell area_ox=0.0676
X7153 BLZ16 rr3t3r_0[40|16]/a_460_290# sky130_fd_pr_reram__reram_cell area_ox=0.0676
X7154 rr3t3r_0[40|16]/a_460_290# WL40 SL16 VSS sky130_fd_pr__nfet_g5v0d10v5 ad=0.65 pd=3.3 as=0 ps=0 w=1 l=0.5
X7155 BLN16 rr3t3r_0[40|16]/a_860_290# sky130_fd_pr_reram__reram_cell area_ox=0.0676
X7156 rr3t3r_0[40|16]/a_60_290# WL40 SL16 VSS sky130_fd_pr__nfet_g5v0d10v5 ad=0.65 pd=3.3 as=0 ps=0 w=1 l=0.5
X7157 rr3t3r_0[40|16]/a_860_290# WL40 SL16 VSS sky130_fd_pr__nfet_g5v0d10v5 ad=0.65 pd=3.3 as=0 ps=0 w=1 l=0.5
X7158 BLP16 rr3t3r_0[41|16]/a_60_290# sky130_fd_pr_reram__reram_cell area_ox=0.0676
X7159 BLZ16 rr3t3r_0[41|16]/a_460_290# sky130_fd_pr_reram__reram_cell area_ox=0.0676
X7160 rr3t3r_0[41|16]/a_460_290# WL41 SL16 VSS sky130_fd_pr__nfet_g5v0d10v5 ad=0.65 pd=3.3 as=0 ps=0 w=1 l=0.5
X7161 BLN16 rr3t3r_0[41|16]/a_860_290# sky130_fd_pr_reram__reram_cell area_ox=0.0676
X7162 rr3t3r_0[41|16]/a_60_290# WL41 SL16 VSS sky130_fd_pr__nfet_g5v0d10v5 ad=0.65 pd=3.3 as=0 ps=0 w=1 l=0.5
X7163 rr3t3r_0[41|16]/a_860_290# WL41 SL16 VSS sky130_fd_pr__nfet_g5v0d10v5 ad=0.65 pd=3.3 as=0 ps=0 w=1 l=0.5
X7164 BLP16 rr3t3r_0[42|16]/a_60_290# sky130_fd_pr_reram__reram_cell area_ox=0.0676
X7165 BLZ16 rr3t3r_0[42|16]/a_460_290# sky130_fd_pr_reram__reram_cell area_ox=0.0676
X7166 rr3t3r_0[42|16]/a_460_290# WL42 SL16 VSS sky130_fd_pr__nfet_g5v0d10v5 ad=0.65 pd=3.3 as=0 ps=0 w=1 l=0.5
X7167 BLN16 rr3t3r_0[42|16]/a_860_290# sky130_fd_pr_reram__reram_cell area_ox=0.0676
X7168 rr3t3r_0[42|16]/a_60_290# WL42 SL16 VSS sky130_fd_pr__nfet_g5v0d10v5 ad=0.65 pd=3.3 as=0 ps=0 w=1 l=0.5
X7169 rr3t3r_0[42|16]/a_860_290# WL42 SL16 VSS sky130_fd_pr__nfet_g5v0d10v5 ad=0.65 pd=3.3 as=0 ps=0 w=1 l=0.5
X7170 BLP16 rr3t3r_0[43|16]/a_60_290# sky130_fd_pr_reram__reram_cell area_ox=0.0676
X7171 BLZ16 rr3t3r_0[43|16]/a_460_290# sky130_fd_pr_reram__reram_cell area_ox=0.0676
X7172 rr3t3r_0[43|16]/a_460_290# WL43 SL16 VSS sky130_fd_pr__nfet_g5v0d10v5 ad=0.65 pd=3.3 as=0 ps=0 w=1 l=0.5
X7173 BLN16 rr3t3r_0[43|16]/a_860_290# sky130_fd_pr_reram__reram_cell area_ox=0.0676
X7174 rr3t3r_0[43|16]/a_60_290# WL43 SL16 VSS sky130_fd_pr__nfet_g5v0d10v5 ad=0.65 pd=3.3 as=0 ps=0 w=1 l=0.5
X7175 rr3t3r_0[43|16]/a_860_290# WL43 SL16 VSS sky130_fd_pr__nfet_g5v0d10v5 ad=0.65 pd=3.3 as=0 ps=0 w=1 l=0.5
X7176 BLP16 rr3t3r_0[44|16]/a_60_290# sky130_fd_pr_reram__reram_cell area_ox=0.0676
X7177 BLZ16 rr3t3r_0[44|16]/a_460_290# sky130_fd_pr_reram__reram_cell area_ox=0.0676
X7178 rr3t3r_0[44|16]/a_460_290# WL44 SL16 VSS sky130_fd_pr__nfet_g5v0d10v5 ad=0.65 pd=3.3 as=0 ps=0 w=1 l=0.5
X7179 BLN16 rr3t3r_0[44|16]/a_860_290# sky130_fd_pr_reram__reram_cell area_ox=0.0676
X7180 rr3t3r_0[44|16]/a_60_290# WL44 SL16 VSS sky130_fd_pr__nfet_g5v0d10v5 ad=0.65 pd=3.3 as=0 ps=0 w=1 l=0.5
X7181 rr3t3r_0[44|16]/a_860_290# WL44 SL16 VSS sky130_fd_pr__nfet_g5v0d10v5 ad=0.65 pd=3.3 as=0 ps=0 w=1 l=0.5
X7182 BLP16 rr3t3r_0[45|16]/a_60_290# sky130_fd_pr_reram__reram_cell area_ox=0.0676
X7183 BLZ16 rr3t3r_0[45|16]/a_460_290# sky130_fd_pr_reram__reram_cell area_ox=0.0676
X7184 rr3t3r_0[45|16]/a_460_290# WL45 SL16 VSS sky130_fd_pr__nfet_g5v0d10v5 ad=0.65 pd=3.3 as=0 ps=0 w=1 l=0.5
X7185 BLN16 rr3t3r_0[45|16]/a_860_290# sky130_fd_pr_reram__reram_cell area_ox=0.0676
X7186 rr3t3r_0[45|16]/a_60_290# WL45 SL16 VSS sky130_fd_pr__nfet_g5v0d10v5 ad=0.65 pd=3.3 as=0 ps=0 w=1 l=0.5
X7187 rr3t3r_0[45|16]/a_860_290# WL45 SL16 VSS sky130_fd_pr__nfet_g5v0d10v5 ad=0.65 pd=3.3 as=0 ps=0 w=1 l=0.5
X7188 BLP16 rr3t3r_0[46|16]/a_60_290# sky130_fd_pr_reram__reram_cell area_ox=0.0676
X7189 BLZ16 rr3t3r_0[46|16]/a_460_290# sky130_fd_pr_reram__reram_cell area_ox=0.0676
X7190 rr3t3r_0[46|16]/a_460_290# WL46 SL16 VSS sky130_fd_pr__nfet_g5v0d10v5 ad=0.65 pd=3.3 as=0 ps=0 w=1 l=0.5
X7191 BLN16 rr3t3r_0[46|16]/a_860_290# sky130_fd_pr_reram__reram_cell area_ox=0.0676
X7192 rr3t3r_0[46|16]/a_60_290# WL46 SL16 VSS sky130_fd_pr__nfet_g5v0d10v5 ad=0.65 pd=3.3 as=0 ps=0 w=1 l=0.5
X7193 rr3t3r_0[46|16]/a_860_290# WL46 SL16 VSS sky130_fd_pr__nfet_g5v0d10v5 ad=0.65 pd=3.3 as=0 ps=0 w=1 l=0.5
X7194 BLP16 rr3t3r_0[47|16]/a_60_290# sky130_fd_pr_reram__reram_cell area_ox=0.0676
X7195 BLZ16 rr3t3r_0[47|16]/a_460_290# sky130_fd_pr_reram__reram_cell area_ox=0.0676
X7196 rr3t3r_0[47|16]/a_460_290# WL47 SL16 VSS sky130_fd_pr__nfet_g5v0d10v5 ad=0.65 pd=3.3 as=0 ps=0 w=1 l=0.5
X7197 BLN16 rr3t3r_0[47|16]/a_860_290# sky130_fd_pr_reram__reram_cell area_ox=0.0676
X7198 rr3t3r_0[47|16]/a_60_290# WL47 SL16 VSS sky130_fd_pr__nfet_g5v0d10v5 ad=0.65 pd=3.3 as=0 ps=0 w=1 l=0.5
X7199 rr3t3r_0[47|16]/a_860_290# WL47 SL16 VSS sky130_fd_pr__nfet_g5v0d10v5 ad=0.65 pd=3.3 as=0 ps=0 w=1 l=0.5
X7200 BLP16 rr3t3r_0[48|16]/a_60_290# sky130_fd_pr_reram__reram_cell area_ox=0.0676
X7201 BLZ16 rr3t3r_0[48|16]/a_460_290# sky130_fd_pr_reram__reram_cell area_ox=0.0676
X7202 rr3t3r_0[48|16]/a_460_290# WL48 SL16 VSS sky130_fd_pr__nfet_g5v0d10v5 ad=0.65 pd=3.3 as=0 ps=0 w=1 l=0.5
X7203 BLN16 rr3t3r_0[48|16]/a_860_290# sky130_fd_pr_reram__reram_cell area_ox=0.0676
X7204 rr3t3r_0[48|16]/a_60_290# WL48 SL16 VSS sky130_fd_pr__nfet_g5v0d10v5 ad=0.65 pd=3.3 as=0 ps=0 w=1 l=0.5
X7205 rr3t3r_0[48|16]/a_860_290# WL48 SL16 VSS sky130_fd_pr__nfet_g5v0d10v5 ad=0.65 pd=3.3 as=0 ps=0 w=1 l=0.5
X7206 BLP16 rr3t3r_0[49|16]/a_60_290# sky130_fd_pr_reram__reram_cell area_ox=0.0676
X7207 BLZ16 rr3t3r_0[49|16]/a_460_290# sky130_fd_pr_reram__reram_cell area_ox=0.0676
X7208 rr3t3r_0[49|16]/a_460_290# WL49 SL16 VSS sky130_fd_pr__nfet_g5v0d10v5 ad=0.65 pd=3.3 as=0 ps=0 w=1 l=0.5
X7209 BLN16 rr3t3r_0[49|16]/a_860_290# sky130_fd_pr_reram__reram_cell area_ox=0.0676
X7210 rr3t3r_0[49|16]/a_60_290# WL49 SL16 VSS sky130_fd_pr__nfet_g5v0d10v5 ad=0.65 pd=3.3 as=0 ps=0 w=1 l=0.5
X7211 rr3t3r_0[49|16]/a_860_290# WL49 SL16 VSS sky130_fd_pr__nfet_g5v0d10v5 ad=0.65 pd=3.3 as=0 ps=0 w=1 l=0.5
X7212 BLP16 rr3t3r_0[50|16]/a_60_290# sky130_fd_pr_reram__reram_cell area_ox=0.0676
X7213 BLZ16 rr3t3r_0[50|16]/a_460_290# sky130_fd_pr_reram__reram_cell area_ox=0.0676
X7214 rr3t3r_0[50|16]/a_460_290# WL50 SL16 VSS sky130_fd_pr__nfet_g5v0d10v5 ad=0.65 pd=3.3 as=0 ps=0 w=1 l=0.5
X7215 BLN16 rr3t3r_0[50|16]/a_860_290# sky130_fd_pr_reram__reram_cell area_ox=0.0676
X7216 rr3t3r_0[50|16]/a_60_290# WL50 SL16 VSS sky130_fd_pr__nfet_g5v0d10v5 ad=0.65 pd=3.3 as=0 ps=0 w=1 l=0.5
X7217 rr3t3r_0[50|16]/a_860_290# WL50 SL16 VSS sky130_fd_pr__nfet_g5v0d10v5 ad=0.65 pd=3.3 as=0 ps=0 w=1 l=0.5
X7218 BLP16 rr3t3r_0[51|16]/a_60_290# sky130_fd_pr_reram__reram_cell area_ox=0.0676
X7219 BLZ16 rr3t3r_0[51|16]/a_460_290# sky130_fd_pr_reram__reram_cell area_ox=0.0676
X7220 rr3t3r_0[51|16]/a_460_290# WL51 SL16 VSS sky130_fd_pr__nfet_g5v0d10v5 ad=0.65 pd=3.3 as=0 ps=0 w=1 l=0.5
X7221 BLN16 rr3t3r_0[51|16]/a_860_290# sky130_fd_pr_reram__reram_cell area_ox=0.0676
X7222 rr3t3r_0[51|16]/a_60_290# WL51 SL16 VSS sky130_fd_pr__nfet_g5v0d10v5 ad=0.65 pd=3.3 as=0 ps=0 w=1 l=0.5
X7223 rr3t3r_0[51|16]/a_860_290# WL51 SL16 VSS sky130_fd_pr__nfet_g5v0d10v5 ad=0.65 pd=3.3 as=0 ps=0 w=1 l=0.5
X7224 BLP16 rr3t3r_0[52|16]/a_60_290# sky130_fd_pr_reram__reram_cell area_ox=0.0676
X7225 BLZ16 rr3t3r_0[52|16]/a_460_290# sky130_fd_pr_reram__reram_cell area_ox=0.0676
X7226 rr3t3r_0[52|16]/a_460_290# WL52 SL16 VSS sky130_fd_pr__nfet_g5v0d10v5 ad=0.65 pd=3.3 as=0 ps=0 w=1 l=0.5
X7227 BLN16 rr3t3r_0[52|16]/a_860_290# sky130_fd_pr_reram__reram_cell area_ox=0.0676
X7228 rr3t3r_0[52|16]/a_60_290# WL52 SL16 VSS sky130_fd_pr__nfet_g5v0d10v5 ad=0.65 pd=3.3 as=0 ps=0 w=1 l=0.5
X7229 rr3t3r_0[52|16]/a_860_290# WL52 SL16 VSS sky130_fd_pr__nfet_g5v0d10v5 ad=0.65 pd=3.3 as=0 ps=0 w=1 l=0.5
X7230 BLP16 rr3t3r_0[53|16]/a_60_290# sky130_fd_pr_reram__reram_cell area_ox=0.0676
X7231 BLZ16 rr3t3r_0[53|16]/a_460_290# sky130_fd_pr_reram__reram_cell area_ox=0.0676
X7232 rr3t3r_0[53|16]/a_460_290# WL53 SL16 VSS sky130_fd_pr__nfet_g5v0d10v5 ad=0.65 pd=3.3 as=0 ps=0 w=1 l=0.5
X7233 BLN16 rr3t3r_0[53|16]/a_860_290# sky130_fd_pr_reram__reram_cell area_ox=0.0676
X7234 rr3t3r_0[53|16]/a_60_290# WL53 SL16 VSS sky130_fd_pr__nfet_g5v0d10v5 ad=0.65 pd=3.3 as=0 ps=0 w=1 l=0.5
X7235 rr3t3r_0[53|16]/a_860_290# WL53 SL16 VSS sky130_fd_pr__nfet_g5v0d10v5 ad=0.65 pd=3.3 as=0 ps=0 w=1 l=0.5
X7236 BLP16 rr3t3r_0[54|16]/a_60_290# sky130_fd_pr_reram__reram_cell area_ox=0.0676
X7237 BLZ16 rr3t3r_0[54|16]/a_460_290# sky130_fd_pr_reram__reram_cell area_ox=0.0676
X7238 rr3t3r_0[54|16]/a_460_290# WL54 SL16 VSS sky130_fd_pr__nfet_g5v0d10v5 ad=0.65 pd=3.3 as=0 ps=0 w=1 l=0.5
X7239 BLN16 rr3t3r_0[54|16]/a_860_290# sky130_fd_pr_reram__reram_cell area_ox=0.0676
X7240 rr3t3r_0[54|16]/a_60_290# WL54 SL16 VSS sky130_fd_pr__nfet_g5v0d10v5 ad=0.65 pd=3.3 as=0 ps=0 w=1 l=0.5
X7241 rr3t3r_0[54|16]/a_860_290# WL54 SL16 VSS sky130_fd_pr__nfet_g5v0d10v5 ad=0.65 pd=3.3 as=0 ps=0 w=1 l=0.5
X7242 BLP16 rr3t3r_0[55|16]/a_60_290# sky130_fd_pr_reram__reram_cell area_ox=0.0676
X7243 BLZ16 rr3t3r_0[55|16]/a_460_290# sky130_fd_pr_reram__reram_cell area_ox=0.0676
X7244 rr3t3r_0[55|16]/a_460_290# WL55 SL16 VSS sky130_fd_pr__nfet_g5v0d10v5 ad=0.65 pd=3.3 as=0 ps=0 w=1 l=0.5
X7245 BLN16 rr3t3r_0[55|16]/a_860_290# sky130_fd_pr_reram__reram_cell area_ox=0.0676
X7246 rr3t3r_0[55|16]/a_60_290# WL55 SL16 VSS sky130_fd_pr__nfet_g5v0d10v5 ad=0.65 pd=3.3 as=0 ps=0 w=1 l=0.5
X7247 rr3t3r_0[55|16]/a_860_290# WL55 SL16 VSS sky130_fd_pr__nfet_g5v0d10v5 ad=0.65 pd=3.3 as=0 ps=0 w=1 l=0.5
X7248 BLP16 rr3t3r_0[56|16]/a_60_290# sky130_fd_pr_reram__reram_cell area_ox=0.0676
X7249 BLZ16 rr3t3r_0[56|16]/a_460_290# sky130_fd_pr_reram__reram_cell area_ox=0.0676
X7250 rr3t3r_0[56|16]/a_460_290# WL56 SL16 VSS sky130_fd_pr__nfet_g5v0d10v5 ad=0.65 pd=3.3 as=0 ps=0 w=1 l=0.5
X7251 BLN16 rr3t3r_0[56|16]/a_860_290# sky130_fd_pr_reram__reram_cell area_ox=0.0676
X7252 rr3t3r_0[56|16]/a_60_290# WL56 SL16 VSS sky130_fd_pr__nfet_g5v0d10v5 ad=0.65 pd=3.3 as=0 ps=0 w=1 l=0.5
X7253 rr3t3r_0[56|16]/a_860_290# WL56 SL16 VSS sky130_fd_pr__nfet_g5v0d10v5 ad=0.65 pd=3.3 as=0 ps=0 w=1 l=0.5
X7254 BLP16 rr3t3r_0[57|16]/a_60_290# sky130_fd_pr_reram__reram_cell area_ox=0.0676
X7255 BLZ16 rr3t3r_0[57|16]/a_460_290# sky130_fd_pr_reram__reram_cell area_ox=0.0676
X7256 rr3t3r_0[57|16]/a_460_290# WL57 SL16 VSS sky130_fd_pr__nfet_g5v0d10v5 ad=0.65 pd=3.3 as=0 ps=0 w=1 l=0.5
X7257 BLN16 rr3t3r_0[57|16]/a_860_290# sky130_fd_pr_reram__reram_cell area_ox=0.0676
X7258 rr3t3r_0[57|16]/a_60_290# WL57 SL16 VSS sky130_fd_pr__nfet_g5v0d10v5 ad=0.65 pd=3.3 as=0 ps=0 w=1 l=0.5
X7259 rr3t3r_0[57|16]/a_860_290# WL57 SL16 VSS sky130_fd_pr__nfet_g5v0d10v5 ad=0.65 pd=3.3 as=0 ps=0 w=1 l=0.5
X7260 BLP16 rr3t3r_0[58|16]/a_60_290# sky130_fd_pr_reram__reram_cell area_ox=0.0676
X7261 BLZ16 rr3t3r_0[58|16]/a_460_290# sky130_fd_pr_reram__reram_cell area_ox=0.0676
X7262 rr3t3r_0[58|16]/a_460_290# WL58 SL16 VSS sky130_fd_pr__nfet_g5v0d10v5 ad=0.65 pd=3.3 as=0 ps=0 w=1 l=0.5
X7263 BLN16 rr3t3r_0[58|16]/a_860_290# sky130_fd_pr_reram__reram_cell area_ox=0.0676
X7264 rr3t3r_0[58|16]/a_60_290# WL58 SL16 VSS sky130_fd_pr__nfet_g5v0d10v5 ad=0.65 pd=3.3 as=0 ps=0 w=1 l=0.5
X7265 rr3t3r_0[58|16]/a_860_290# WL58 SL16 VSS sky130_fd_pr__nfet_g5v0d10v5 ad=0.65 pd=3.3 as=0 ps=0 w=1 l=0.5
X7266 BLP16 rr3t3r_0[59|16]/a_60_290# sky130_fd_pr_reram__reram_cell area_ox=0.0676
X7267 BLZ16 rr3t3r_0[59|16]/a_460_290# sky130_fd_pr_reram__reram_cell area_ox=0.0676
X7268 rr3t3r_0[59|16]/a_460_290# WL59 SL16 VSS sky130_fd_pr__nfet_g5v0d10v5 ad=0.65 pd=3.3 as=0 ps=0 w=1 l=0.5
X7269 BLN16 rr3t3r_0[59|16]/a_860_290# sky130_fd_pr_reram__reram_cell area_ox=0.0676
X7270 rr3t3r_0[59|16]/a_60_290# WL59 SL16 VSS sky130_fd_pr__nfet_g5v0d10v5 ad=0.65 pd=3.3 as=0 ps=0 w=1 l=0.5
X7271 rr3t3r_0[59|16]/a_860_290# WL59 SL16 VSS sky130_fd_pr__nfet_g5v0d10v5 ad=0.65 pd=3.3 as=0 ps=0 w=1 l=0.5
X7272 BLP16 rr3t3r_0[60|16]/a_60_290# sky130_fd_pr_reram__reram_cell area_ox=0.0676
X7273 BLZ16 rr3t3r_0[60|16]/a_460_290# sky130_fd_pr_reram__reram_cell area_ox=0.0676
X7274 rr3t3r_0[60|16]/a_460_290# WL60 SL16 VSS sky130_fd_pr__nfet_g5v0d10v5 ad=0.65 pd=3.3 as=0 ps=0 w=1 l=0.5
X7275 BLN16 rr3t3r_0[60|16]/a_860_290# sky130_fd_pr_reram__reram_cell area_ox=0.0676
X7276 rr3t3r_0[60|16]/a_60_290# WL60 SL16 VSS sky130_fd_pr__nfet_g5v0d10v5 ad=0.65 pd=3.3 as=0 ps=0 w=1 l=0.5
X7277 rr3t3r_0[60|16]/a_860_290# WL60 SL16 VSS sky130_fd_pr__nfet_g5v0d10v5 ad=0.65 pd=3.3 as=0 ps=0 w=1 l=0.5
X7278 BLP16 rr3t3r_0[61|16]/a_60_290# sky130_fd_pr_reram__reram_cell area_ox=0.0676
X7279 BLZ16 rr3t3r_0[61|16]/a_460_290# sky130_fd_pr_reram__reram_cell area_ox=0.0676
X7280 rr3t3r_0[61|16]/a_460_290# WL61 SL16 VSS sky130_fd_pr__nfet_g5v0d10v5 ad=0.65 pd=3.3 as=0 ps=0 w=1 l=0.5
X7281 BLN16 rr3t3r_0[61|16]/a_860_290# sky130_fd_pr_reram__reram_cell area_ox=0.0676
X7282 rr3t3r_0[61|16]/a_60_290# WL61 SL16 VSS sky130_fd_pr__nfet_g5v0d10v5 ad=0.65 pd=3.3 as=0 ps=0 w=1 l=0.5
X7283 rr3t3r_0[61|16]/a_860_290# WL61 SL16 VSS sky130_fd_pr__nfet_g5v0d10v5 ad=0.65 pd=3.3 as=0 ps=0 w=1 l=0.5
X7284 BLP16 rr3t3r_0[62|16]/a_60_290# sky130_fd_pr_reram__reram_cell area_ox=0.0676
X7285 BLZ16 rr3t3r_0[62|16]/a_460_290# sky130_fd_pr_reram__reram_cell area_ox=0.0676
X7286 rr3t3r_0[62|16]/a_460_290# WL62 SL16 VSS sky130_fd_pr__nfet_g5v0d10v5 ad=0.65 pd=3.3 as=0 ps=0 w=1 l=0.5
X7287 BLN16 rr3t3r_0[62|16]/a_860_290# sky130_fd_pr_reram__reram_cell area_ox=0.0676
X7288 rr3t3r_0[62|16]/a_60_290# WL62 SL16 VSS sky130_fd_pr__nfet_g5v0d10v5 ad=0.65 pd=3.3 as=0 ps=0 w=1 l=0.5
X7289 rr3t3r_0[62|16]/a_860_290# WL62 SL16 VSS sky130_fd_pr__nfet_g5v0d10v5 ad=0.65 pd=3.3 as=0 ps=0 w=1 l=0.5
X7290 BLP16 rr3t3r_0[63|16]/a_60_290# sky130_fd_pr_reram__reram_cell area_ox=0.0676
X7291 BLZ16 rr3t3r_0[63|16]/a_460_290# sky130_fd_pr_reram__reram_cell area_ox=0.0676
X7292 rr3t3r_0[63|16]/a_460_290# WL63 SL16 VSS sky130_fd_pr__nfet_g5v0d10v5 ad=0.65 pd=3.3 as=0 ps=0 w=1 l=0.5
X7293 BLN16 rr3t3r_0[63|16]/a_860_290# sky130_fd_pr_reram__reram_cell area_ox=0.0676
X7294 rr3t3r_0[63|16]/a_60_290# WL63 SL16 VSS sky130_fd_pr__nfet_g5v0d10v5 ad=0.65 pd=3.3 as=0 ps=0 w=1 l=0.5
X7295 rr3t3r_0[63|16]/a_860_290# WL63 SL16 VSS sky130_fd_pr__nfet_g5v0d10v5 ad=0.65 pd=3.3 as=0 ps=0 w=1 l=0.5
X7296 BLP16 rr3t3r_0[64|16]/a_60_290# sky130_fd_pr_reram__reram_cell area_ox=0.0676
X7297 BLZ16 rr3t3r_0[64|16]/a_460_290# sky130_fd_pr_reram__reram_cell area_ox=0.0676
X7298 rr3t3r_0[64|16]/a_460_290# WL64 SL16 VSS sky130_fd_pr__nfet_g5v0d10v5 ad=0.65 pd=3.3 as=0 ps=0 w=1 l=0.5
X7299 BLN16 rr3t3r_0[64|16]/a_860_290# sky130_fd_pr_reram__reram_cell area_ox=0.0676
X7300 rr3t3r_0[64|16]/a_60_290# WL64 SL16 VSS sky130_fd_pr__nfet_g5v0d10v5 ad=0.65 pd=3.3 as=0 ps=0 w=1 l=0.5
X7301 rr3t3r_0[64|16]/a_860_290# WL64 SL16 VSS sky130_fd_pr__nfet_g5v0d10v5 ad=0.65 pd=3.3 as=0 ps=0 w=1 l=0.5
X7302 BLP16 rr3t3r_0[65|16]/a_60_290# sky130_fd_pr_reram__reram_cell area_ox=0.0676
X7303 BLZ16 rr3t3r_0[65|16]/a_460_290# sky130_fd_pr_reram__reram_cell area_ox=0.0676
X7304 rr3t3r_0[65|16]/a_460_290# WL65 SL16 VSS sky130_fd_pr__nfet_g5v0d10v5 ad=0.65 pd=3.3 as=0 ps=0 w=1 l=0.5
X7305 BLN16 rr3t3r_0[65|16]/a_860_290# sky130_fd_pr_reram__reram_cell area_ox=0.0676
X7306 rr3t3r_0[65|16]/a_60_290# WL65 SL16 VSS sky130_fd_pr__nfet_g5v0d10v5 ad=0.65 pd=3.3 as=0 ps=0 w=1 l=0.5
X7307 rr3t3r_0[65|16]/a_860_290# WL65 SL16 VSS sky130_fd_pr__nfet_g5v0d10v5 ad=0.65 pd=3.3 as=0 ps=0 w=1 l=0.5
X7308 BLP16 rr3t3r_0[66|16]/a_60_290# sky130_fd_pr_reram__reram_cell area_ox=0.0676
X7309 BLZ16 rr3t3r_0[66|16]/a_460_290# sky130_fd_pr_reram__reram_cell area_ox=0.0676
X7310 rr3t3r_0[66|16]/a_460_290# WL66 SL16 VSS sky130_fd_pr__nfet_g5v0d10v5 ad=0.65 pd=3.3 as=0 ps=0 w=1 l=0.5
X7311 BLN16 rr3t3r_0[66|16]/a_860_290# sky130_fd_pr_reram__reram_cell area_ox=0.0676
X7312 rr3t3r_0[66|16]/a_60_290# WL66 SL16 VSS sky130_fd_pr__nfet_g5v0d10v5 ad=0.65 pd=3.3 as=0 ps=0 w=1 l=0.5
X7313 rr3t3r_0[66|16]/a_860_290# WL66 SL16 VSS sky130_fd_pr__nfet_g5v0d10v5 ad=0.65 pd=3.3 as=0 ps=0 w=1 l=0.5
X7314 BLP16 rr3t3r_0[67|16]/a_60_290# sky130_fd_pr_reram__reram_cell area_ox=0.0676
X7315 BLZ16 rr3t3r_0[67|16]/a_460_290# sky130_fd_pr_reram__reram_cell area_ox=0.0676
X7316 rr3t3r_0[67|16]/a_460_290# WL67 SL16 VSS sky130_fd_pr__nfet_g5v0d10v5 ad=0.65 pd=3.3 as=0 ps=0 w=1 l=0.5
X7317 BLN16 rr3t3r_0[67|16]/a_860_290# sky130_fd_pr_reram__reram_cell area_ox=0.0676
X7318 rr3t3r_0[67|16]/a_60_290# WL67 SL16 VSS sky130_fd_pr__nfet_g5v0d10v5 ad=0.65 pd=3.3 as=0 ps=0 w=1 l=0.5
X7319 rr3t3r_0[67|16]/a_860_290# WL67 SL16 VSS sky130_fd_pr__nfet_g5v0d10v5 ad=0.65 pd=3.3 as=0 ps=0 w=1 l=0.5
X7320 BLP16 rr3t3r_0[68|16]/a_60_290# sky130_fd_pr_reram__reram_cell area_ox=0.0676
X7321 BLZ16 rr3t3r_0[68|16]/a_460_290# sky130_fd_pr_reram__reram_cell area_ox=0.0676
X7322 rr3t3r_0[68|16]/a_460_290# WL68 SL16 VSS sky130_fd_pr__nfet_g5v0d10v5 ad=0.65 pd=3.3 as=0 ps=0 w=1 l=0.5
X7323 BLN16 rr3t3r_0[68|16]/a_860_290# sky130_fd_pr_reram__reram_cell area_ox=0.0676
X7324 rr3t3r_0[68|16]/a_60_290# WL68 SL16 VSS sky130_fd_pr__nfet_g5v0d10v5 ad=0.65 pd=3.3 as=0 ps=0 w=1 l=0.5
X7325 rr3t3r_0[68|16]/a_860_290# WL68 SL16 VSS sky130_fd_pr__nfet_g5v0d10v5 ad=0.65 pd=3.3 as=0 ps=0 w=1 l=0.5
X7326 BLP16 rr3t3r_0[69|16]/a_60_290# sky130_fd_pr_reram__reram_cell area_ox=0.0676
X7327 BLZ16 rr3t3r_0[69|16]/a_460_290# sky130_fd_pr_reram__reram_cell area_ox=0.0676
X7328 rr3t3r_0[69|16]/a_460_290# WL69 SL16 VSS sky130_fd_pr__nfet_g5v0d10v5 ad=0.65 pd=3.3 as=0 ps=0 w=1 l=0.5
X7329 BLN16 rr3t3r_0[69|16]/a_860_290# sky130_fd_pr_reram__reram_cell area_ox=0.0676
X7330 rr3t3r_0[69|16]/a_60_290# WL69 SL16 VSS sky130_fd_pr__nfet_g5v0d10v5 ad=0.65 pd=3.3 as=0 ps=0 w=1 l=0.5
X7331 rr3t3r_0[69|16]/a_860_290# WL69 SL16 VSS sky130_fd_pr__nfet_g5v0d10v5 ad=0.65 pd=3.3 as=0 ps=0 w=1 l=0.5
X7332 BLP16 rr3t3r_0[70|16]/a_60_290# sky130_fd_pr_reram__reram_cell area_ox=0.0676
X7333 BLZ16 rr3t3r_0[70|16]/a_460_290# sky130_fd_pr_reram__reram_cell area_ox=0.0676
X7334 rr3t3r_0[70|16]/a_460_290# WL70 SL16 VSS sky130_fd_pr__nfet_g5v0d10v5 ad=0.65 pd=3.3 as=0 ps=0 w=1 l=0.5
X7335 BLN16 rr3t3r_0[70|16]/a_860_290# sky130_fd_pr_reram__reram_cell area_ox=0.0676
X7336 rr3t3r_0[70|16]/a_60_290# WL70 SL16 VSS sky130_fd_pr__nfet_g5v0d10v5 ad=0.65 pd=3.3 as=0 ps=0 w=1 l=0.5
X7337 rr3t3r_0[70|16]/a_860_290# WL70 SL16 VSS sky130_fd_pr__nfet_g5v0d10v5 ad=0.65 pd=3.3 as=0 ps=0 w=1 l=0.5
X7338 BLP16 rr3t3r_0[71|16]/a_60_290# sky130_fd_pr_reram__reram_cell area_ox=0.0676
X7339 BLZ16 rr3t3r_0[71|16]/a_460_290# sky130_fd_pr_reram__reram_cell area_ox=0.0676
X7340 rr3t3r_0[71|16]/a_460_290# WL71 SL16 VSS sky130_fd_pr__nfet_g5v0d10v5 ad=0.65 pd=3.3 as=0 ps=0 w=1 l=0.5
X7341 BLN16 rr3t3r_0[71|16]/a_860_290# sky130_fd_pr_reram__reram_cell area_ox=0.0676
X7342 rr3t3r_0[71|16]/a_60_290# WL71 SL16 VSS sky130_fd_pr__nfet_g5v0d10v5 ad=0.65 pd=3.3 as=0 ps=0 w=1 l=0.5
X7343 rr3t3r_0[71|16]/a_860_290# WL71 SL16 VSS sky130_fd_pr__nfet_g5v0d10v5 ad=0.65 pd=3.3 as=0 ps=0 w=1 l=0.5
X7344 BLP17 rr3t3r_0[0|17]/a_60_290# sky130_fd_pr_reram__reram_cell area_ox=0.0676
X7345 BLZ17 rr3t3r_0[0|17]/a_460_290# sky130_fd_pr_reram__reram_cell area_ox=0.0676
X7346 rr3t3r_0[0|17]/a_460_290# WL0 SL17 VSS sky130_fd_pr__nfet_g5v0d10v5 ad=0.65 pd=3.3 as=162 ps=756 w=1 l=0.5
X7347 BLN17 rr3t3r_0[0|17]/a_860_290# sky130_fd_pr_reram__reram_cell area_ox=0.0676
X7348 rr3t3r_0[0|17]/a_60_290# WL0 SL17 VSS sky130_fd_pr__nfet_g5v0d10v5 ad=0.65 pd=3.3 as=0 ps=0 w=1 l=0.5
X7349 rr3t3r_0[0|17]/a_860_290# WL0 SL17 VSS sky130_fd_pr__nfet_g5v0d10v5 ad=0.65 pd=3.3 as=0 ps=0 w=1 l=0.5
X7350 BLP17 rr3t3r_0[1|17]/a_60_290# sky130_fd_pr_reram__reram_cell area_ox=0.0676
X7351 BLZ17 rr3t3r_0[1|17]/a_460_290# sky130_fd_pr_reram__reram_cell area_ox=0.0676
X7352 rr3t3r_0[1|17]/a_460_290# WL1 SL17 VSS sky130_fd_pr__nfet_g5v0d10v5 ad=0.65 pd=3.3 as=0 ps=0 w=1 l=0.5
X7353 BLN17 rr3t3r_0[1|17]/a_860_290# sky130_fd_pr_reram__reram_cell area_ox=0.0676
X7354 rr3t3r_0[1|17]/a_60_290# WL1 SL17 VSS sky130_fd_pr__nfet_g5v0d10v5 ad=0.65 pd=3.3 as=0 ps=0 w=1 l=0.5
X7355 rr3t3r_0[1|17]/a_860_290# WL1 SL17 VSS sky130_fd_pr__nfet_g5v0d10v5 ad=0.65 pd=3.3 as=0 ps=0 w=1 l=0.5
X7356 BLP17 rr3t3r_0[2|17]/a_60_290# sky130_fd_pr_reram__reram_cell area_ox=0.0676
X7357 BLZ17 rr3t3r_0[2|17]/a_460_290# sky130_fd_pr_reram__reram_cell area_ox=0.0676
X7358 rr3t3r_0[2|17]/a_460_290# WL2 SL17 VSS sky130_fd_pr__nfet_g5v0d10v5 ad=0.65 pd=3.3 as=0 ps=0 w=1 l=0.5
X7359 BLN17 rr3t3r_0[2|17]/a_860_290# sky130_fd_pr_reram__reram_cell area_ox=0.0676
X7360 rr3t3r_0[2|17]/a_60_290# WL2 SL17 VSS sky130_fd_pr__nfet_g5v0d10v5 ad=0.65 pd=3.3 as=0 ps=0 w=1 l=0.5
X7361 rr3t3r_0[2|17]/a_860_290# WL2 SL17 VSS sky130_fd_pr__nfet_g5v0d10v5 ad=0.65 pd=3.3 as=0 ps=0 w=1 l=0.5
X7362 BLP17 rr3t3r_0[3|17]/a_60_290# sky130_fd_pr_reram__reram_cell area_ox=0.0676
X7363 BLZ17 rr3t3r_0[3|17]/a_460_290# sky130_fd_pr_reram__reram_cell area_ox=0.0676
X7364 rr3t3r_0[3|17]/a_460_290# WL3 SL17 VSS sky130_fd_pr__nfet_g5v0d10v5 ad=0.65 pd=3.3 as=0 ps=0 w=1 l=0.5
X7365 BLN17 rr3t3r_0[3|17]/a_860_290# sky130_fd_pr_reram__reram_cell area_ox=0.0676
X7366 rr3t3r_0[3|17]/a_60_290# WL3 SL17 VSS sky130_fd_pr__nfet_g5v0d10v5 ad=0.65 pd=3.3 as=0 ps=0 w=1 l=0.5
X7367 rr3t3r_0[3|17]/a_860_290# WL3 SL17 VSS sky130_fd_pr__nfet_g5v0d10v5 ad=0.65 pd=3.3 as=0 ps=0 w=1 l=0.5
X7368 BLP17 rr3t3r_0[4|17]/a_60_290# sky130_fd_pr_reram__reram_cell area_ox=0.0676
X7369 BLZ17 rr3t3r_0[4|17]/a_460_290# sky130_fd_pr_reram__reram_cell area_ox=0.0676
X7370 rr3t3r_0[4|17]/a_460_290# WL4 SL17 VSS sky130_fd_pr__nfet_g5v0d10v5 ad=0.65 pd=3.3 as=0 ps=0 w=1 l=0.5
X7371 BLN17 rr3t3r_0[4|17]/a_860_290# sky130_fd_pr_reram__reram_cell area_ox=0.0676
X7372 rr3t3r_0[4|17]/a_60_290# WL4 SL17 VSS sky130_fd_pr__nfet_g5v0d10v5 ad=0.65 pd=3.3 as=0 ps=0 w=1 l=0.5
X7373 rr3t3r_0[4|17]/a_860_290# WL4 SL17 VSS sky130_fd_pr__nfet_g5v0d10v5 ad=0.65 pd=3.3 as=0 ps=0 w=1 l=0.5
X7374 BLP17 rr3t3r_0[5|17]/a_60_290# sky130_fd_pr_reram__reram_cell area_ox=0.0676
X7375 BLZ17 rr3t3r_0[5|17]/a_460_290# sky130_fd_pr_reram__reram_cell area_ox=0.0676
X7376 rr3t3r_0[5|17]/a_460_290# WL5 SL17 VSS sky130_fd_pr__nfet_g5v0d10v5 ad=0.65 pd=3.3 as=0 ps=0 w=1 l=0.5
X7377 BLN17 rr3t3r_0[5|17]/a_860_290# sky130_fd_pr_reram__reram_cell area_ox=0.0676
X7378 rr3t3r_0[5|17]/a_60_290# WL5 SL17 VSS sky130_fd_pr__nfet_g5v0d10v5 ad=0.65 pd=3.3 as=0 ps=0 w=1 l=0.5
X7379 rr3t3r_0[5|17]/a_860_290# WL5 SL17 VSS sky130_fd_pr__nfet_g5v0d10v5 ad=0.65 pd=3.3 as=0 ps=0 w=1 l=0.5
X7380 BLP17 rr3t3r_0[6|17]/a_60_290# sky130_fd_pr_reram__reram_cell area_ox=0.0676
X7381 BLZ17 rr3t3r_0[6|17]/a_460_290# sky130_fd_pr_reram__reram_cell area_ox=0.0676
X7382 rr3t3r_0[6|17]/a_460_290# WL6 SL17 VSS sky130_fd_pr__nfet_g5v0d10v5 ad=0.65 pd=3.3 as=0 ps=0 w=1 l=0.5
X7383 BLN17 rr3t3r_0[6|17]/a_860_290# sky130_fd_pr_reram__reram_cell area_ox=0.0676
X7384 rr3t3r_0[6|17]/a_60_290# WL6 SL17 VSS sky130_fd_pr__nfet_g5v0d10v5 ad=0.65 pd=3.3 as=0 ps=0 w=1 l=0.5
X7385 rr3t3r_0[6|17]/a_860_290# WL6 SL17 VSS sky130_fd_pr__nfet_g5v0d10v5 ad=0.65 pd=3.3 as=0 ps=0 w=1 l=0.5
X7386 BLP17 rr3t3r_0[7|17]/a_60_290# sky130_fd_pr_reram__reram_cell area_ox=0.0676
X7387 BLZ17 rr3t3r_0[7|17]/a_460_290# sky130_fd_pr_reram__reram_cell area_ox=0.0676
X7388 rr3t3r_0[7|17]/a_460_290# WL7 SL17 VSS sky130_fd_pr__nfet_g5v0d10v5 ad=0.65 pd=3.3 as=0 ps=0 w=1 l=0.5
X7389 BLN17 rr3t3r_0[7|17]/a_860_290# sky130_fd_pr_reram__reram_cell area_ox=0.0676
X7390 rr3t3r_0[7|17]/a_60_290# WL7 SL17 VSS sky130_fd_pr__nfet_g5v0d10v5 ad=0.65 pd=3.3 as=0 ps=0 w=1 l=0.5
X7391 rr3t3r_0[7|17]/a_860_290# WL7 SL17 VSS sky130_fd_pr__nfet_g5v0d10v5 ad=0.65 pd=3.3 as=0 ps=0 w=1 l=0.5
X7392 BLP17 rr3t3r_0[8|17]/a_60_290# sky130_fd_pr_reram__reram_cell area_ox=0.0676
X7393 BLZ17 rr3t3r_0[8|17]/a_460_290# sky130_fd_pr_reram__reram_cell area_ox=0.0676
X7394 rr3t3r_0[8|17]/a_460_290# WL8 SL17 VSS sky130_fd_pr__nfet_g5v0d10v5 ad=0.65 pd=3.3 as=0 ps=0 w=1 l=0.5
X7395 BLN17 rr3t3r_0[8|17]/a_860_290# sky130_fd_pr_reram__reram_cell area_ox=0.0676
X7396 rr3t3r_0[8|17]/a_60_290# WL8 SL17 VSS sky130_fd_pr__nfet_g5v0d10v5 ad=0.65 pd=3.3 as=0 ps=0 w=1 l=0.5
X7397 rr3t3r_0[8|17]/a_860_290# WL8 SL17 VSS sky130_fd_pr__nfet_g5v0d10v5 ad=0.65 pd=3.3 as=0 ps=0 w=1 l=0.5
X7398 BLP17 rr3t3r_0[9|17]/a_60_290# sky130_fd_pr_reram__reram_cell area_ox=0.0676
X7399 BLZ17 rr3t3r_0[9|17]/a_460_290# sky130_fd_pr_reram__reram_cell area_ox=0.0676
X7400 rr3t3r_0[9|17]/a_460_290# WL9 SL17 VSS sky130_fd_pr__nfet_g5v0d10v5 ad=0.65 pd=3.3 as=0 ps=0 w=1 l=0.5
X7401 BLN17 rr3t3r_0[9|17]/a_860_290# sky130_fd_pr_reram__reram_cell area_ox=0.0676
X7402 rr3t3r_0[9|17]/a_60_290# WL9 SL17 VSS sky130_fd_pr__nfet_g5v0d10v5 ad=0.65 pd=3.3 as=0 ps=0 w=1 l=0.5
X7403 rr3t3r_0[9|17]/a_860_290# WL9 SL17 VSS sky130_fd_pr__nfet_g5v0d10v5 ad=0.65 pd=3.3 as=0 ps=0 w=1 l=0.5
X7404 BLP17 rr3t3r_0[10|17]/a_60_290# sky130_fd_pr_reram__reram_cell area_ox=0.0676
X7405 BLZ17 rr3t3r_0[10|17]/a_460_290# sky130_fd_pr_reram__reram_cell area_ox=0.0676
X7406 rr3t3r_0[10|17]/a_460_290# WL10 SL17 VSS sky130_fd_pr__nfet_g5v0d10v5 ad=0.65 pd=3.3 as=0 ps=0 w=1 l=0.5
X7407 BLN17 rr3t3r_0[10|17]/a_860_290# sky130_fd_pr_reram__reram_cell area_ox=0.0676
X7408 rr3t3r_0[10|17]/a_60_290# WL10 SL17 VSS sky130_fd_pr__nfet_g5v0d10v5 ad=0.65 pd=3.3 as=0 ps=0 w=1 l=0.5
X7409 rr3t3r_0[10|17]/a_860_290# WL10 SL17 VSS sky130_fd_pr__nfet_g5v0d10v5 ad=0.65 pd=3.3 as=0 ps=0 w=1 l=0.5
X7410 BLP17 rr3t3r_0[11|17]/a_60_290# sky130_fd_pr_reram__reram_cell area_ox=0.0676
X7411 BLZ17 rr3t3r_0[11|17]/a_460_290# sky130_fd_pr_reram__reram_cell area_ox=0.0676
X7412 rr3t3r_0[11|17]/a_460_290# WL11 SL17 VSS sky130_fd_pr__nfet_g5v0d10v5 ad=0.65 pd=3.3 as=0 ps=0 w=1 l=0.5
X7413 BLN17 rr3t3r_0[11|17]/a_860_290# sky130_fd_pr_reram__reram_cell area_ox=0.0676
X7414 rr3t3r_0[11|17]/a_60_290# WL11 SL17 VSS sky130_fd_pr__nfet_g5v0d10v5 ad=0.65 pd=3.3 as=0 ps=0 w=1 l=0.5
X7415 rr3t3r_0[11|17]/a_860_290# WL11 SL17 VSS sky130_fd_pr__nfet_g5v0d10v5 ad=0.65 pd=3.3 as=0 ps=0 w=1 l=0.5
X7416 BLP17 rr3t3r_0[12|17]/a_60_290# sky130_fd_pr_reram__reram_cell area_ox=0.0676
X7417 BLZ17 rr3t3r_0[12|17]/a_460_290# sky130_fd_pr_reram__reram_cell area_ox=0.0676
X7418 rr3t3r_0[12|17]/a_460_290# WL12 SL17 VSS sky130_fd_pr__nfet_g5v0d10v5 ad=0.65 pd=3.3 as=0 ps=0 w=1 l=0.5
X7419 BLN17 rr3t3r_0[12|17]/a_860_290# sky130_fd_pr_reram__reram_cell area_ox=0.0676
X7420 rr3t3r_0[12|17]/a_60_290# WL12 SL17 VSS sky130_fd_pr__nfet_g5v0d10v5 ad=0.65 pd=3.3 as=0 ps=0 w=1 l=0.5
X7421 rr3t3r_0[12|17]/a_860_290# WL12 SL17 VSS sky130_fd_pr__nfet_g5v0d10v5 ad=0.65 pd=3.3 as=0 ps=0 w=1 l=0.5
X7422 BLP17 rr3t3r_0[13|17]/a_60_290# sky130_fd_pr_reram__reram_cell area_ox=0.0676
X7423 BLZ17 rr3t3r_0[13|17]/a_460_290# sky130_fd_pr_reram__reram_cell area_ox=0.0676
X7424 rr3t3r_0[13|17]/a_460_290# WL13 SL17 VSS sky130_fd_pr__nfet_g5v0d10v5 ad=0.65 pd=3.3 as=0 ps=0 w=1 l=0.5
X7425 BLN17 rr3t3r_0[13|17]/a_860_290# sky130_fd_pr_reram__reram_cell area_ox=0.0676
X7426 rr3t3r_0[13|17]/a_60_290# WL13 SL17 VSS sky130_fd_pr__nfet_g5v0d10v5 ad=0.65 pd=3.3 as=0 ps=0 w=1 l=0.5
X7427 rr3t3r_0[13|17]/a_860_290# WL13 SL17 VSS sky130_fd_pr__nfet_g5v0d10v5 ad=0.65 pd=3.3 as=0 ps=0 w=1 l=0.5
X7428 BLP17 rr3t3r_0[14|17]/a_60_290# sky130_fd_pr_reram__reram_cell area_ox=0.0676
X7429 BLZ17 rr3t3r_0[14|17]/a_460_290# sky130_fd_pr_reram__reram_cell area_ox=0.0676
X7430 rr3t3r_0[14|17]/a_460_290# WL14 SL17 VSS sky130_fd_pr__nfet_g5v0d10v5 ad=0.65 pd=3.3 as=0 ps=0 w=1 l=0.5
X7431 BLN17 rr3t3r_0[14|17]/a_860_290# sky130_fd_pr_reram__reram_cell area_ox=0.0676
X7432 rr3t3r_0[14|17]/a_60_290# WL14 SL17 VSS sky130_fd_pr__nfet_g5v0d10v5 ad=0.65 pd=3.3 as=0 ps=0 w=1 l=0.5
X7433 rr3t3r_0[14|17]/a_860_290# WL14 SL17 VSS sky130_fd_pr__nfet_g5v0d10v5 ad=0.65 pd=3.3 as=0 ps=0 w=1 l=0.5
X7434 BLP17 rr3t3r_0[15|17]/a_60_290# sky130_fd_pr_reram__reram_cell area_ox=0.0676
X7435 BLZ17 rr3t3r_0[15|17]/a_460_290# sky130_fd_pr_reram__reram_cell area_ox=0.0676
X7436 rr3t3r_0[15|17]/a_460_290# WL15 SL17 VSS sky130_fd_pr__nfet_g5v0d10v5 ad=0.65 pd=3.3 as=0 ps=0 w=1 l=0.5
X7437 BLN17 rr3t3r_0[15|17]/a_860_290# sky130_fd_pr_reram__reram_cell area_ox=0.0676
X7438 rr3t3r_0[15|17]/a_60_290# WL15 SL17 VSS sky130_fd_pr__nfet_g5v0d10v5 ad=0.65 pd=3.3 as=0 ps=0 w=1 l=0.5
X7439 rr3t3r_0[15|17]/a_860_290# WL15 SL17 VSS sky130_fd_pr__nfet_g5v0d10v5 ad=0.65 pd=3.3 as=0 ps=0 w=1 l=0.5
X7440 BLP17 rr3t3r_0[16|17]/a_60_290# sky130_fd_pr_reram__reram_cell area_ox=0.0676
X7441 BLZ17 rr3t3r_0[16|17]/a_460_290# sky130_fd_pr_reram__reram_cell area_ox=0.0676
X7442 rr3t3r_0[16|17]/a_460_290# WL16 SL17 VSS sky130_fd_pr__nfet_g5v0d10v5 ad=0.65 pd=3.3 as=0 ps=0 w=1 l=0.5
X7443 BLN17 rr3t3r_0[16|17]/a_860_290# sky130_fd_pr_reram__reram_cell area_ox=0.0676
X7444 rr3t3r_0[16|17]/a_60_290# WL16 SL17 VSS sky130_fd_pr__nfet_g5v0d10v5 ad=0.65 pd=3.3 as=0 ps=0 w=1 l=0.5
X7445 rr3t3r_0[16|17]/a_860_290# WL16 SL17 VSS sky130_fd_pr__nfet_g5v0d10v5 ad=0.65 pd=3.3 as=0 ps=0 w=1 l=0.5
X7446 BLP17 rr3t3r_0[17|17]/a_60_290# sky130_fd_pr_reram__reram_cell area_ox=0.0676
X7447 BLZ17 rr3t3r_0[17|17]/a_460_290# sky130_fd_pr_reram__reram_cell area_ox=0.0676
X7448 rr3t3r_0[17|17]/a_460_290# WL17 SL17 VSS sky130_fd_pr__nfet_g5v0d10v5 ad=0.65 pd=3.3 as=0 ps=0 w=1 l=0.5
X7449 BLN17 rr3t3r_0[17|17]/a_860_290# sky130_fd_pr_reram__reram_cell area_ox=0.0676
X7450 rr3t3r_0[17|17]/a_60_290# WL17 SL17 VSS sky130_fd_pr__nfet_g5v0d10v5 ad=0.65 pd=3.3 as=0 ps=0 w=1 l=0.5
X7451 rr3t3r_0[17|17]/a_860_290# WL17 SL17 VSS sky130_fd_pr__nfet_g5v0d10v5 ad=0.65 pd=3.3 as=0 ps=0 w=1 l=0.5
X7452 BLP17 rr3t3r_0[18|17]/a_60_290# sky130_fd_pr_reram__reram_cell area_ox=0.0676
X7453 BLZ17 rr3t3r_0[18|17]/a_460_290# sky130_fd_pr_reram__reram_cell area_ox=0.0676
X7454 rr3t3r_0[18|17]/a_460_290# WL18 SL17 VSS sky130_fd_pr__nfet_g5v0d10v5 ad=0.65 pd=3.3 as=0 ps=0 w=1 l=0.5
X7455 BLN17 rr3t3r_0[18|17]/a_860_290# sky130_fd_pr_reram__reram_cell area_ox=0.0676
X7456 rr3t3r_0[18|17]/a_60_290# WL18 SL17 VSS sky130_fd_pr__nfet_g5v0d10v5 ad=0.65 pd=3.3 as=0 ps=0 w=1 l=0.5
X7457 rr3t3r_0[18|17]/a_860_290# WL18 SL17 VSS sky130_fd_pr__nfet_g5v0d10v5 ad=0.65 pd=3.3 as=0 ps=0 w=1 l=0.5
X7458 BLP17 rr3t3r_0[19|17]/a_60_290# sky130_fd_pr_reram__reram_cell area_ox=0.0676
X7459 BLZ17 rr3t3r_0[19|17]/a_460_290# sky130_fd_pr_reram__reram_cell area_ox=0.0676
X7460 rr3t3r_0[19|17]/a_460_290# WL19 SL17 VSS sky130_fd_pr__nfet_g5v0d10v5 ad=0.65 pd=3.3 as=0 ps=0 w=1 l=0.5
X7461 BLN17 rr3t3r_0[19|17]/a_860_290# sky130_fd_pr_reram__reram_cell area_ox=0.0676
X7462 rr3t3r_0[19|17]/a_60_290# WL19 SL17 VSS sky130_fd_pr__nfet_g5v0d10v5 ad=0.65 pd=3.3 as=0 ps=0 w=1 l=0.5
X7463 rr3t3r_0[19|17]/a_860_290# WL19 SL17 VSS sky130_fd_pr__nfet_g5v0d10v5 ad=0.65 pd=3.3 as=0 ps=0 w=1 l=0.5
X7464 BLP17 rr3t3r_0[20|17]/a_60_290# sky130_fd_pr_reram__reram_cell area_ox=0.0676
X7465 BLZ17 rr3t3r_0[20|17]/a_460_290# sky130_fd_pr_reram__reram_cell area_ox=0.0676
X7466 rr3t3r_0[20|17]/a_460_290# WL20 SL17 VSS sky130_fd_pr__nfet_g5v0d10v5 ad=0.65 pd=3.3 as=0 ps=0 w=1 l=0.5
X7467 BLN17 rr3t3r_0[20|17]/a_860_290# sky130_fd_pr_reram__reram_cell area_ox=0.0676
X7468 rr3t3r_0[20|17]/a_60_290# WL20 SL17 VSS sky130_fd_pr__nfet_g5v0d10v5 ad=0.65 pd=3.3 as=0 ps=0 w=1 l=0.5
X7469 rr3t3r_0[20|17]/a_860_290# WL20 SL17 VSS sky130_fd_pr__nfet_g5v0d10v5 ad=0.65 pd=3.3 as=0 ps=0 w=1 l=0.5
X7470 BLP17 rr3t3r_0[21|17]/a_60_290# sky130_fd_pr_reram__reram_cell area_ox=0.0676
X7471 BLZ17 rr3t3r_0[21|17]/a_460_290# sky130_fd_pr_reram__reram_cell area_ox=0.0676
X7472 rr3t3r_0[21|17]/a_460_290# WL21 SL17 VSS sky130_fd_pr__nfet_g5v0d10v5 ad=0.65 pd=3.3 as=0 ps=0 w=1 l=0.5
X7473 BLN17 rr3t3r_0[21|17]/a_860_290# sky130_fd_pr_reram__reram_cell area_ox=0.0676
X7474 rr3t3r_0[21|17]/a_60_290# WL21 SL17 VSS sky130_fd_pr__nfet_g5v0d10v5 ad=0.65 pd=3.3 as=0 ps=0 w=1 l=0.5
X7475 rr3t3r_0[21|17]/a_860_290# WL21 SL17 VSS sky130_fd_pr__nfet_g5v0d10v5 ad=0.65 pd=3.3 as=0 ps=0 w=1 l=0.5
X7476 BLP17 rr3t3r_0[22|17]/a_60_290# sky130_fd_pr_reram__reram_cell area_ox=0.0676
X7477 BLZ17 rr3t3r_0[22|17]/a_460_290# sky130_fd_pr_reram__reram_cell area_ox=0.0676
X7478 rr3t3r_0[22|17]/a_460_290# WL22 SL17 VSS sky130_fd_pr__nfet_g5v0d10v5 ad=0.65 pd=3.3 as=0 ps=0 w=1 l=0.5
X7479 BLN17 rr3t3r_0[22|17]/a_860_290# sky130_fd_pr_reram__reram_cell area_ox=0.0676
X7480 rr3t3r_0[22|17]/a_60_290# WL22 SL17 VSS sky130_fd_pr__nfet_g5v0d10v5 ad=0.65 pd=3.3 as=0 ps=0 w=1 l=0.5
X7481 rr3t3r_0[22|17]/a_860_290# WL22 SL17 VSS sky130_fd_pr__nfet_g5v0d10v5 ad=0.65 pd=3.3 as=0 ps=0 w=1 l=0.5
X7482 BLP17 rr3t3r_0[23|17]/a_60_290# sky130_fd_pr_reram__reram_cell area_ox=0.0676
X7483 BLZ17 rr3t3r_0[23|17]/a_460_290# sky130_fd_pr_reram__reram_cell area_ox=0.0676
X7484 rr3t3r_0[23|17]/a_460_290# WL23 SL17 VSS sky130_fd_pr__nfet_g5v0d10v5 ad=0.65 pd=3.3 as=0 ps=0 w=1 l=0.5
X7485 BLN17 rr3t3r_0[23|17]/a_860_290# sky130_fd_pr_reram__reram_cell area_ox=0.0676
X7486 rr3t3r_0[23|17]/a_60_290# WL23 SL17 VSS sky130_fd_pr__nfet_g5v0d10v5 ad=0.65 pd=3.3 as=0 ps=0 w=1 l=0.5
X7487 rr3t3r_0[23|17]/a_860_290# WL23 SL17 VSS sky130_fd_pr__nfet_g5v0d10v5 ad=0.65 pd=3.3 as=0 ps=0 w=1 l=0.5
X7488 BLP17 rr3t3r_0[24|17]/a_60_290# sky130_fd_pr_reram__reram_cell area_ox=0.0676
X7489 BLZ17 rr3t3r_0[24|17]/a_460_290# sky130_fd_pr_reram__reram_cell area_ox=0.0676
X7490 rr3t3r_0[24|17]/a_460_290# WL24 SL17 VSS sky130_fd_pr__nfet_g5v0d10v5 ad=0.65 pd=3.3 as=0 ps=0 w=1 l=0.5
X7491 BLN17 rr3t3r_0[24|17]/a_860_290# sky130_fd_pr_reram__reram_cell area_ox=0.0676
X7492 rr3t3r_0[24|17]/a_60_290# WL24 SL17 VSS sky130_fd_pr__nfet_g5v0d10v5 ad=0.65 pd=3.3 as=0 ps=0 w=1 l=0.5
X7493 rr3t3r_0[24|17]/a_860_290# WL24 SL17 VSS sky130_fd_pr__nfet_g5v0d10v5 ad=0.65 pd=3.3 as=0 ps=0 w=1 l=0.5
X7494 BLP17 rr3t3r_0[25|17]/a_60_290# sky130_fd_pr_reram__reram_cell area_ox=0.0676
X7495 BLZ17 rr3t3r_0[25|17]/a_460_290# sky130_fd_pr_reram__reram_cell area_ox=0.0676
X7496 rr3t3r_0[25|17]/a_460_290# WL25 SL17 VSS sky130_fd_pr__nfet_g5v0d10v5 ad=0.65 pd=3.3 as=0 ps=0 w=1 l=0.5
X7497 BLN17 rr3t3r_0[25|17]/a_860_290# sky130_fd_pr_reram__reram_cell area_ox=0.0676
X7498 rr3t3r_0[25|17]/a_60_290# WL25 SL17 VSS sky130_fd_pr__nfet_g5v0d10v5 ad=0.65 pd=3.3 as=0 ps=0 w=1 l=0.5
X7499 rr3t3r_0[25|17]/a_860_290# WL25 SL17 VSS sky130_fd_pr__nfet_g5v0d10v5 ad=0.65 pd=3.3 as=0 ps=0 w=1 l=0.5
X7500 BLP17 rr3t3r_0[26|17]/a_60_290# sky130_fd_pr_reram__reram_cell area_ox=0.0676
X7501 BLZ17 rr3t3r_0[26|17]/a_460_290# sky130_fd_pr_reram__reram_cell area_ox=0.0676
X7502 rr3t3r_0[26|17]/a_460_290# WL26 SL17 VSS sky130_fd_pr__nfet_g5v0d10v5 ad=0.65 pd=3.3 as=0 ps=0 w=1 l=0.5
X7503 BLN17 rr3t3r_0[26|17]/a_860_290# sky130_fd_pr_reram__reram_cell area_ox=0.0676
X7504 rr3t3r_0[26|17]/a_60_290# WL26 SL17 VSS sky130_fd_pr__nfet_g5v0d10v5 ad=0.65 pd=3.3 as=0 ps=0 w=1 l=0.5
X7505 rr3t3r_0[26|17]/a_860_290# WL26 SL17 VSS sky130_fd_pr__nfet_g5v0d10v5 ad=0.65 pd=3.3 as=0 ps=0 w=1 l=0.5
X7506 BLP17 rr3t3r_0[27|17]/a_60_290# sky130_fd_pr_reram__reram_cell area_ox=0.0676
X7507 BLZ17 rr3t3r_0[27|17]/a_460_290# sky130_fd_pr_reram__reram_cell area_ox=0.0676
X7508 rr3t3r_0[27|17]/a_460_290# WL27 SL17 VSS sky130_fd_pr__nfet_g5v0d10v5 ad=0.65 pd=3.3 as=0 ps=0 w=1 l=0.5
X7509 BLN17 rr3t3r_0[27|17]/a_860_290# sky130_fd_pr_reram__reram_cell area_ox=0.0676
X7510 rr3t3r_0[27|17]/a_60_290# WL27 SL17 VSS sky130_fd_pr__nfet_g5v0d10v5 ad=0.65 pd=3.3 as=0 ps=0 w=1 l=0.5
X7511 rr3t3r_0[27|17]/a_860_290# WL27 SL17 VSS sky130_fd_pr__nfet_g5v0d10v5 ad=0.65 pd=3.3 as=0 ps=0 w=1 l=0.5
X7512 BLP17 rr3t3r_0[28|17]/a_60_290# sky130_fd_pr_reram__reram_cell area_ox=0.0676
X7513 BLZ17 rr3t3r_0[28|17]/a_460_290# sky130_fd_pr_reram__reram_cell area_ox=0.0676
X7514 rr3t3r_0[28|17]/a_460_290# WL28 SL17 VSS sky130_fd_pr__nfet_g5v0d10v5 ad=0.65 pd=3.3 as=0 ps=0 w=1 l=0.5
X7515 BLN17 rr3t3r_0[28|17]/a_860_290# sky130_fd_pr_reram__reram_cell area_ox=0.0676
X7516 rr3t3r_0[28|17]/a_60_290# WL28 SL17 VSS sky130_fd_pr__nfet_g5v0d10v5 ad=0.65 pd=3.3 as=0 ps=0 w=1 l=0.5
X7517 rr3t3r_0[28|17]/a_860_290# WL28 SL17 VSS sky130_fd_pr__nfet_g5v0d10v5 ad=0.65 pd=3.3 as=0 ps=0 w=1 l=0.5
X7518 BLP17 rr3t3r_0[29|17]/a_60_290# sky130_fd_pr_reram__reram_cell area_ox=0.0676
X7519 BLZ17 rr3t3r_0[29|17]/a_460_290# sky130_fd_pr_reram__reram_cell area_ox=0.0676
X7520 rr3t3r_0[29|17]/a_460_290# WL29 SL17 VSS sky130_fd_pr__nfet_g5v0d10v5 ad=0.65 pd=3.3 as=0 ps=0 w=1 l=0.5
X7521 BLN17 rr3t3r_0[29|17]/a_860_290# sky130_fd_pr_reram__reram_cell area_ox=0.0676
X7522 rr3t3r_0[29|17]/a_60_290# WL29 SL17 VSS sky130_fd_pr__nfet_g5v0d10v5 ad=0.65 pd=3.3 as=0 ps=0 w=1 l=0.5
X7523 rr3t3r_0[29|17]/a_860_290# WL29 SL17 VSS sky130_fd_pr__nfet_g5v0d10v5 ad=0.65 pd=3.3 as=0 ps=0 w=1 l=0.5
X7524 BLP17 rr3t3r_0[30|17]/a_60_290# sky130_fd_pr_reram__reram_cell area_ox=0.0676
X7525 BLZ17 rr3t3r_0[30|17]/a_460_290# sky130_fd_pr_reram__reram_cell area_ox=0.0676
X7526 rr3t3r_0[30|17]/a_460_290# WL30 SL17 VSS sky130_fd_pr__nfet_g5v0d10v5 ad=0.65 pd=3.3 as=0 ps=0 w=1 l=0.5
X7527 BLN17 rr3t3r_0[30|17]/a_860_290# sky130_fd_pr_reram__reram_cell area_ox=0.0676
X7528 rr3t3r_0[30|17]/a_60_290# WL30 SL17 VSS sky130_fd_pr__nfet_g5v0d10v5 ad=0.65 pd=3.3 as=0 ps=0 w=1 l=0.5
X7529 rr3t3r_0[30|17]/a_860_290# WL30 SL17 VSS sky130_fd_pr__nfet_g5v0d10v5 ad=0.65 pd=3.3 as=0 ps=0 w=1 l=0.5
X7530 BLP17 rr3t3r_0[31|17]/a_60_290# sky130_fd_pr_reram__reram_cell area_ox=0.0676
X7531 BLZ17 rr3t3r_0[31|17]/a_460_290# sky130_fd_pr_reram__reram_cell area_ox=0.0676
X7532 rr3t3r_0[31|17]/a_460_290# WL31 SL17 VSS sky130_fd_pr__nfet_g5v0d10v5 ad=0.65 pd=3.3 as=0 ps=0 w=1 l=0.5
X7533 BLN17 rr3t3r_0[31|17]/a_860_290# sky130_fd_pr_reram__reram_cell area_ox=0.0676
X7534 rr3t3r_0[31|17]/a_60_290# WL31 SL17 VSS sky130_fd_pr__nfet_g5v0d10v5 ad=0.65 pd=3.3 as=0 ps=0 w=1 l=0.5
X7535 rr3t3r_0[31|17]/a_860_290# WL31 SL17 VSS sky130_fd_pr__nfet_g5v0d10v5 ad=0.65 pd=3.3 as=0 ps=0 w=1 l=0.5
X7536 BLP17 rr3t3r_0[32|17]/a_60_290# sky130_fd_pr_reram__reram_cell area_ox=0.0676
X7537 BLZ17 rr3t3r_0[32|17]/a_460_290# sky130_fd_pr_reram__reram_cell area_ox=0.0676
X7538 rr3t3r_0[32|17]/a_460_290# WL32 SL17 VSS sky130_fd_pr__nfet_g5v0d10v5 ad=0.65 pd=3.3 as=0 ps=0 w=1 l=0.5
X7539 BLN17 rr3t3r_0[32|17]/a_860_290# sky130_fd_pr_reram__reram_cell area_ox=0.0676
X7540 rr3t3r_0[32|17]/a_60_290# WL32 SL17 VSS sky130_fd_pr__nfet_g5v0d10v5 ad=0.65 pd=3.3 as=0 ps=0 w=1 l=0.5
X7541 rr3t3r_0[32|17]/a_860_290# WL32 SL17 VSS sky130_fd_pr__nfet_g5v0d10v5 ad=0.65 pd=3.3 as=0 ps=0 w=1 l=0.5
X7542 BLP17 rr3t3r_0[33|17]/a_60_290# sky130_fd_pr_reram__reram_cell area_ox=0.0676
X7543 BLZ17 rr3t3r_0[33|17]/a_460_290# sky130_fd_pr_reram__reram_cell area_ox=0.0676
X7544 rr3t3r_0[33|17]/a_460_290# WL33 SL17 VSS sky130_fd_pr__nfet_g5v0d10v5 ad=0.65 pd=3.3 as=0 ps=0 w=1 l=0.5
X7545 BLN17 rr3t3r_0[33|17]/a_860_290# sky130_fd_pr_reram__reram_cell area_ox=0.0676
X7546 rr3t3r_0[33|17]/a_60_290# WL33 SL17 VSS sky130_fd_pr__nfet_g5v0d10v5 ad=0.65 pd=3.3 as=0 ps=0 w=1 l=0.5
X7547 rr3t3r_0[33|17]/a_860_290# WL33 SL17 VSS sky130_fd_pr__nfet_g5v0d10v5 ad=0.65 pd=3.3 as=0 ps=0 w=1 l=0.5
X7548 BLP17 rr3t3r_0[34|17]/a_60_290# sky130_fd_pr_reram__reram_cell area_ox=0.0676
X7549 BLZ17 rr3t3r_0[34|17]/a_460_290# sky130_fd_pr_reram__reram_cell area_ox=0.0676
X7550 rr3t3r_0[34|17]/a_460_290# WL34 SL17 VSS sky130_fd_pr__nfet_g5v0d10v5 ad=0.65 pd=3.3 as=0 ps=0 w=1 l=0.5
X7551 BLN17 rr3t3r_0[34|17]/a_860_290# sky130_fd_pr_reram__reram_cell area_ox=0.0676
X7552 rr3t3r_0[34|17]/a_60_290# WL34 SL17 VSS sky130_fd_pr__nfet_g5v0d10v5 ad=0.65 pd=3.3 as=0 ps=0 w=1 l=0.5
X7553 rr3t3r_0[34|17]/a_860_290# WL34 SL17 VSS sky130_fd_pr__nfet_g5v0d10v5 ad=0.65 pd=3.3 as=0 ps=0 w=1 l=0.5
X7554 BLP17 rr3t3r_0[35|17]/a_60_290# sky130_fd_pr_reram__reram_cell area_ox=0.0676
X7555 BLZ17 rr3t3r_0[35|17]/a_460_290# sky130_fd_pr_reram__reram_cell area_ox=0.0676
X7556 rr3t3r_0[35|17]/a_460_290# WL35 SL17 VSS sky130_fd_pr__nfet_g5v0d10v5 ad=0.65 pd=3.3 as=0 ps=0 w=1 l=0.5
X7557 BLN17 rr3t3r_0[35|17]/a_860_290# sky130_fd_pr_reram__reram_cell area_ox=0.0676
X7558 rr3t3r_0[35|17]/a_60_290# WL35 SL17 VSS sky130_fd_pr__nfet_g5v0d10v5 ad=0.65 pd=3.3 as=0 ps=0 w=1 l=0.5
X7559 rr3t3r_0[35|17]/a_860_290# WL35 SL17 VSS sky130_fd_pr__nfet_g5v0d10v5 ad=0.65 pd=3.3 as=0 ps=0 w=1 l=0.5
X7560 BLP17 rr3t3r_0[36|17]/a_60_290# sky130_fd_pr_reram__reram_cell area_ox=0.0676
X7561 BLZ17 rr3t3r_0[36|17]/a_460_290# sky130_fd_pr_reram__reram_cell area_ox=0.0676
X7562 rr3t3r_0[36|17]/a_460_290# WL36 SL17 VSS sky130_fd_pr__nfet_g5v0d10v5 ad=0.65 pd=3.3 as=0 ps=0 w=1 l=0.5
X7563 BLN17 rr3t3r_0[36|17]/a_860_290# sky130_fd_pr_reram__reram_cell area_ox=0.0676
X7564 rr3t3r_0[36|17]/a_60_290# WL36 SL17 VSS sky130_fd_pr__nfet_g5v0d10v5 ad=0.65 pd=3.3 as=0 ps=0 w=1 l=0.5
X7565 rr3t3r_0[36|17]/a_860_290# WL36 SL17 VSS sky130_fd_pr__nfet_g5v0d10v5 ad=0.65 pd=3.3 as=0 ps=0 w=1 l=0.5
X7566 BLP17 rr3t3r_0[37|17]/a_60_290# sky130_fd_pr_reram__reram_cell area_ox=0.0676
X7567 BLZ17 rr3t3r_0[37|17]/a_460_290# sky130_fd_pr_reram__reram_cell area_ox=0.0676
X7568 rr3t3r_0[37|17]/a_460_290# WL37 SL17 VSS sky130_fd_pr__nfet_g5v0d10v5 ad=0.65 pd=3.3 as=0 ps=0 w=1 l=0.5
X7569 BLN17 rr3t3r_0[37|17]/a_860_290# sky130_fd_pr_reram__reram_cell area_ox=0.0676
X7570 rr3t3r_0[37|17]/a_60_290# WL37 SL17 VSS sky130_fd_pr__nfet_g5v0d10v5 ad=0.65 pd=3.3 as=0 ps=0 w=1 l=0.5
X7571 rr3t3r_0[37|17]/a_860_290# WL37 SL17 VSS sky130_fd_pr__nfet_g5v0d10v5 ad=0.65 pd=3.3 as=0 ps=0 w=1 l=0.5
X7572 BLP17 rr3t3r_0[38|17]/a_60_290# sky130_fd_pr_reram__reram_cell area_ox=0.0676
X7573 BLZ17 rr3t3r_0[38|17]/a_460_290# sky130_fd_pr_reram__reram_cell area_ox=0.0676
X7574 rr3t3r_0[38|17]/a_460_290# WL38 SL17 VSS sky130_fd_pr__nfet_g5v0d10v5 ad=0.65 pd=3.3 as=0 ps=0 w=1 l=0.5
X7575 BLN17 rr3t3r_0[38|17]/a_860_290# sky130_fd_pr_reram__reram_cell area_ox=0.0676
X7576 rr3t3r_0[38|17]/a_60_290# WL38 SL17 VSS sky130_fd_pr__nfet_g5v0d10v5 ad=0.65 pd=3.3 as=0 ps=0 w=1 l=0.5
X7577 rr3t3r_0[38|17]/a_860_290# WL38 SL17 VSS sky130_fd_pr__nfet_g5v0d10v5 ad=0.65 pd=3.3 as=0 ps=0 w=1 l=0.5
X7578 BLP17 rr3t3r_0[39|17]/a_60_290# sky130_fd_pr_reram__reram_cell area_ox=0.0676
X7579 BLZ17 rr3t3r_0[39|17]/a_460_290# sky130_fd_pr_reram__reram_cell area_ox=0.0676
X7580 rr3t3r_0[39|17]/a_460_290# WL39 SL17 VSS sky130_fd_pr__nfet_g5v0d10v5 ad=0.65 pd=3.3 as=0 ps=0 w=1 l=0.5
X7581 BLN17 rr3t3r_0[39|17]/a_860_290# sky130_fd_pr_reram__reram_cell area_ox=0.0676
X7582 rr3t3r_0[39|17]/a_60_290# WL39 SL17 VSS sky130_fd_pr__nfet_g5v0d10v5 ad=0.65 pd=3.3 as=0 ps=0 w=1 l=0.5
X7583 rr3t3r_0[39|17]/a_860_290# WL39 SL17 VSS sky130_fd_pr__nfet_g5v0d10v5 ad=0.65 pd=3.3 as=0 ps=0 w=1 l=0.5
X7584 BLP17 rr3t3r_0[40|17]/a_60_290# sky130_fd_pr_reram__reram_cell area_ox=0.0676
X7585 BLZ17 rr3t3r_0[40|17]/a_460_290# sky130_fd_pr_reram__reram_cell area_ox=0.0676
X7586 rr3t3r_0[40|17]/a_460_290# WL40 SL17 VSS sky130_fd_pr__nfet_g5v0d10v5 ad=0.65 pd=3.3 as=0 ps=0 w=1 l=0.5
X7587 BLN17 rr3t3r_0[40|17]/a_860_290# sky130_fd_pr_reram__reram_cell area_ox=0.0676
X7588 rr3t3r_0[40|17]/a_60_290# WL40 SL17 VSS sky130_fd_pr__nfet_g5v0d10v5 ad=0.65 pd=3.3 as=0 ps=0 w=1 l=0.5
X7589 rr3t3r_0[40|17]/a_860_290# WL40 SL17 VSS sky130_fd_pr__nfet_g5v0d10v5 ad=0.65 pd=3.3 as=0 ps=0 w=1 l=0.5
X7590 BLP17 rr3t3r_0[41|17]/a_60_290# sky130_fd_pr_reram__reram_cell area_ox=0.0676
X7591 BLZ17 rr3t3r_0[41|17]/a_460_290# sky130_fd_pr_reram__reram_cell area_ox=0.0676
X7592 rr3t3r_0[41|17]/a_460_290# WL41 SL17 VSS sky130_fd_pr__nfet_g5v0d10v5 ad=0.65 pd=3.3 as=0 ps=0 w=1 l=0.5
X7593 BLN17 rr3t3r_0[41|17]/a_860_290# sky130_fd_pr_reram__reram_cell area_ox=0.0676
X7594 rr3t3r_0[41|17]/a_60_290# WL41 SL17 VSS sky130_fd_pr__nfet_g5v0d10v5 ad=0.65 pd=3.3 as=0 ps=0 w=1 l=0.5
X7595 rr3t3r_0[41|17]/a_860_290# WL41 SL17 VSS sky130_fd_pr__nfet_g5v0d10v5 ad=0.65 pd=3.3 as=0 ps=0 w=1 l=0.5
X7596 BLP17 rr3t3r_0[42|17]/a_60_290# sky130_fd_pr_reram__reram_cell area_ox=0.0676
X7597 BLZ17 rr3t3r_0[42|17]/a_460_290# sky130_fd_pr_reram__reram_cell area_ox=0.0676
X7598 rr3t3r_0[42|17]/a_460_290# WL42 SL17 VSS sky130_fd_pr__nfet_g5v0d10v5 ad=0.65 pd=3.3 as=0 ps=0 w=1 l=0.5
X7599 BLN17 rr3t3r_0[42|17]/a_860_290# sky130_fd_pr_reram__reram_cell area_ox=0.0676
X7600 rr3t3r_0[42|17]/a_60_290# WL42 SL17 VSS sky130_fd_pr__nfet_g5v0d10v5 ad=0.65 pd=3.3 as=0 ps=0 w=1 l=0.5
X7601 rr3t3r_0[42|17]/a_860_290# WL42 SL17 VSS sky130_fd_pr__nfet_g5v0d10v5 ad=0.65 pd=3.3 as=0 ps=0 w=1 l=0.5
X7602 BLP17 rr3t3r_0[43|17]/a_60_290# sky130_fd_pr_reram__reram_cell area_ox=0.0676
X7603 BLZ17 rr3t3r_0[43|17]/a_460_290# sky130_fd_pr_reram__reram_cell area_ox=0.0676
X7604 rr3t3r_0[43|17]/a_460_290# WL43 SL17 VSS sky130_fd_pr__nfet_g5v0d10v5 ad=0.65 pd=3.3 as=0 ps=0 w=1 l=0.5
X7605 BLN17 rr3t3r_0[43|17]/a_860_290# sky130_fd_pr_reram__reram_cell area_ox=0.0676
X7606 rr3t3r_0[43|17]/a_60_290# WL43 SL17 VSS sky130_fd_pr__nfet_g5v0d10v5 ad=0.65 pd=3.3 as=0 ps=0 w=1 l=0.5
X7607 rr3t3r_0[43|17]/a_860_290# WL43 SL17 VSS sky130_fd_pr__nfet_g5v0d10v5 ad=0.65 pd=3.3 as=0 ps=0 w=1 l=0.5
X7608 BLP17 rr3t3r_0[44|17]/a_60_290# sky130_fd_pr_reram__reram_cell area_ox=0.0676
X7609 BLZ17 rr3t3r_0[44|17]/a_460_290# sky130_fd_pr_reram__reram_cell area_ox=0.0676
X7610 rr3t3r_0[44|17]/a_460_290# WL44 SL17 VSS sky130_fd_pr__nfet_g5v0d10v5 ad=0.65 pd=3.3 as=0 ps=0 w=1 l=0.5
X7611 BLN17 rr3t3r_0[44|17]/a_860_290# sky130_fd_pr_reram__reram_cell area_ox=0.0676
X7612 rr3t3r_0[44|17]/a_60_290# WL44 SL17 VSS sky130_fd_pr__nfet_g5v0d10v5 ad=0.65 pd=3.3 as=0 ps=0 w=1 l=0.5
X7613 rr3t3r_0[44|17]/a_860_290# WL44 SL17 VSS sky130_fd_pr__nfet_g5v0d10v5 ad=0.65 pd=3.3 as=0 ps=0 w=1 l=0.5
X7614 BLP17 rr3t3r_0[45|17]/a_60_290# sky130_fd_pr_reram__reram_cell area_ox=0.0676
X7615 BLZ17 rr3t3r_0[45|17]/a_460_290# sky130_fd_pr_reram__reram_cell area_ox=0.0676
X7616 rr3t3r_0[45|17]/a_460_290# WL45 SL17 VSS sky130_fd_pr__nfet_g5v0d10v5 ad=0.65 pd=3.3 as=0 ps=0 w=1 l=0.5
X7617 BLN17 rr3t3r_0[45|17]/a_860_290# sky130_fd_pr_reram__reram_cell area_ox=0.0676
X7618 rr3t3r_0[45|17]/a_60_290# WL45 SL17 VSS sky130_fd_pr__nfet_g5v0d10v5 ad=0.65 pd=3.3 as=0 ps=0 w=1 l=0.5
X7619 rr3t3r_0[45|17]/a_860_290# WL45 SL17 VSS sky130_fd_pr__nfet_g5v0d10v5 ad=0.65 pd=3.3 as=0 ps=0 w=1 l=0.5
X7620 BLP17 rr3t3r_0[46|17]/a_60_290# sky130_fd_pr_reram__reram_cell area_ox=0.0676
X7621 BLZ17 rr3t3r_0[46|17]/a_460_290# sky130_fd_pr_reram__reram_cell area_ox=0.0676
X7622 rr3t3r_0[46|17]/a_460_290# WL46 SL17 VSS sky130_fd_pr__nfet_g5v0d10v5 ad=0.65 pd=3.3 as=0 ps=0 w=1 l=0.5
X7623 BLN17 rr3t3r_0[46|17]/a_860_290# sky130_fd_pr_reram__reram_cell area_ox=0.0676
X7624 rr3t3r_0[46|17]/a_60_290# WL46 SL17 VSS sky130_fd_pr__nfet_g5v0d10v5 ad=0.65 pd=3.3 as=0 ps=0 w=1 l=0.5
X7625 rr3t3r_0[46|17]/a_860_290# WL46 SL17 VSS sky130_fd_pr__nfet_g5v0d10v5 ad=0.65 pd=3.3 as=0 ps=0 w=1 l=0.5
X7626 BLP17 rr3t3r_0[47|17]/a_60_290# sky130_fd_pr_reram__reram_cell area_ox=0.0676
X7627 BLZ17 rr3t3r_0[47|17]/a_460_290# sky130_fd_pr_reram__reram_cell area_ox=0.0676
X7628 rr3t3r_0[47|17]/a_460_290# WL47 SL17 VSS sky130_fd_pr__nfet_g5v0d10v5 ad=0.65 pd=3.3 as=0 ps=0 w=1 l=0.5
X7629 BLN17 rr3t3r_0[47|17]/a_860_290# sky130_fd_pr_reram__reram_cell area_ox=0.0676
X7630 rr3t3r_0[47|17]/a_60_290# WL47 SL17 VSS sky130_fd_pr__nfet_g5v0d10v5 ad=0.65 pd=3.3 as=0 ps=0 w=1 l=0.5
X7631 rr3t3r_0[47|17]/a_860_290# WL47 SL17 VSS sky130_fd_pr__nfet_g5v0d10v5 ad=0.65 pd=3.3 as=0 ps=0 w=1 l=0.5
X7632 BLP17 rr3t3r_0[48|17]/a_60_290# sky130_fd_pr_reram__reram_cell area_ox=0.0676
X7633 BLZ17 rr3t3r_0[48|17]/a_460_290# sky130_fd_pr_reram__reram_cell area_ox=0.0676
X7634 rr3t3r_0[48|17]/a_460_290# WL48 SL17 VSS sky130_fd_pr__nfet_g5v0d10v5 ad=0.65 pd=3.3 as=0 ps=0 w=1 l=0.5
X7635 BLN17 rr3t3r_0[48|17]/a_860_290# sky130_fd_pr_reram__reram_cell area_ox=0.0676
X7636 rr3t3r_0[48|17]/a_60_290# WL48 SL17 VSS sky130_fd_pr__nfet_g5v0d10v5 ad=0.65 pd=3.3 as=0 ps=0 w=1 l=0.5
X7637 rr3t3r_0[48|17]/a_860_290# WL48 SL17 VSS sky130_fd_pr__nfet_g5v0d10v5 ad=0.65 pd=3.3 as=0 ps=0 w=1 l=0.5
X7638 BLP17 rr3t3r_0[49|17]/a_60_290# sky130_fd_pr_reram__reram_cell area_ox=0.0676
X7639 BLZ17 rr3t3r_0[49|17]/a_460_290# sky130_fd_pr_reram__reram_cell area_ox=0.0676
X7640 rr3t3r_0[49|17]/a_460_290# WL49 SL17 VSS sky130_fd_pr__nfet_g5v0d10v5 ad=0.65 pd=3.3 as=0 ps=0 w=1 l=0.5
X7641 BLN17 rr3t3r_0[49|17]/a_860_290# sky130_fd_pr_reram__reram_cell area_ox=0.0676
X7642 rr3t3r_0[49|17]/a_60_290# WL49 SL17 VSS sky130_fd_pr__nfet_g5v0d10v5 ad=0.65 pd=3.3 as=0 ps=0 w=1 l=0.5
X7643 rr3t3r_0[49|17]/a_860_290# WL49 SL17 VSS sky130_fd_pr__nfet_g5v0d10v5 ad=0.65 pd=3.3 as=0 ps=0 w=1 l=0.5
X7644 BLP17 rr3t3r_0[50|17]/a_60_290# sky130_fd_pr_reram__reram_cell area_ox=0.0676
X7645 BLZ17 rr3t3r_0[50|17]/a_460_290# sky130_fd_pr_reram__reram_cell area_ox=0.0676
X7646 rr3t3r_0[50|17]/a_460_290# WL50 SL17 VSS sky130_fd_pr__nfet_g5v0d10v5 ad=0.65 pd=3.3 as=0 ps=0 w=1 l=0.5
X7647 BLN17 rr3t3r_0[50|17]/a_860_290# sky130_fd_pr_reram__reram_cell area_ox=0.0676
X7648 rr3t3r_0[50|17]/a_60_290# WL50 SL17 VSS sky130_fd_pr__nfet_g5v0d10v5 ad=0.65 pd=3.3 as=0 ps=0 w=1 l=0.5
X7649 rr3t3r_0[50|17]/a_860_290# WL50 SL17 VSS sky130_fd_pr__nfet_g5v0d10v5 ad=0.65 pd=3.3 as=0 ps=0 w=1 l=0.5
X7650 BLP17 rr3t3r_0[51|17]/a_60_290# sky130_fd_pr_reram__reram_cell area_ox=0.0676
X7651 BLZ17 rr3t3r_0[51|17]/a_460_290# sky130_fd_pr_reram__reram_cell area_ox=0.0676
X7652 rr3t3r_0[51|17]/a_460_290# WL51 SL17 VSS sky130_fd_pr__nfet_g5v0d10v5 ad=0.65 pd=3.3 as=0 ps=0 w=1 l=0.5
X7653 BLN17 rr3t3r_0[51|17]/a_860_290# sky130_fd_pr_reram__reram_cell area_ox=0.0676
X7654 rr3t3r_0[51|17]/a_60_290# WL51 SL17 VSS sky130_fd_pr__nfet_g5v0d10v5 ad=0.65 pd=3.3 as=0 ps=0 w=1 l=0.5
X7655 rr3t3r_0[51|17]/a_860_290# WL51 SL17 VSS sky130_fd_pr__nfet_g5v0d10v5 ad=0.65 pd=3.3 as=0 ps=0 w=1 l=0.5
X7656 BLP17 rr3t3r_0[52|17]/a_60_290# sky130_fd_pr_reram__reram_cell area_ox=0.0676
X7657 BLZ17 rr3t3r_0[52|17]/a_460_290# sky130_fd_pr_reram__reram_cell area_ox=0.0676
X7658 rr3t3r_0[52|17]/a_460_290# WL52 SL17 VSS sky130_fd_pr__nfet_g5v0d10v5 ad=0.65 pd=3.3 as=0 ps=0 w=1 l=0.5
X7659 BLN17 rr3t3r_0[52|17]/a_860_290# sky130_fd_pr_reram__reram_cell area_ox=0.0676
X7660 rr3t3r_0[52|17]/a_60_290# WL52 SL17 VSS sky130_fd_pr__nfet_g5v0d10v5 ad=0.65 pd=3.3 as=0 ps=0 w=1 l=0.5
X7661 rr3t3r_0[52|17]/a_860_290# WL52 SL17 VSS sky130_fd_pr__nfet_g5v0d10v5 ad=0.65 pd=3.3 as=0 ps=0 w=1 l=0.5
X7662 BLP17 rr3t3r_0[53|17]/a_60_290# sky130_fd_pr_reram__reram_cell area_ox=0.0676
X7663 BLZ17 rr3t3r_0[53|17]/a_460_290# sky130_fd_pr_reram__reram_cell area_ox=0.0676
X7664 rr3t3r_0[53|17]/a_460_290# WL53 SL17 VSS sky130_fd_pr__nfet_g5v0d10v5 ad=0.65 pd=3.3 as=0 ps=0 w=1 l=0.5
X7665 BLN17 rr3t3r_0[53|17]/a_860_290# sky130_fd_pr_reram__reram_cell area_ox=0.0676
X7666 rr3t3r_0[53|17]/a_60_290# WL53 SL17 VSS sky130_fd_pr__nfet_g5v0d10v5 ad=0.65 pd=3.3 as=0 ps=0 w=1 l=0.5
X7667 rr3t3r_0[53|17]/a_860_290# WL53 SL17 VSS sky130_fd_pr__nfet_g5v0d10v5 ad=0.65 pd=3.3 as=0 ps=0 w=1 l=0.5
X7668 BLP17 rr3t3r_0[54|17]/a_60_290# sky130_fd_pr_reram__reram_cell area_ox=0.0676
X7669 BLZ17 rr3t3r_0[54|17]/a_460_290# sky130_fd_pr_reram__reram_cell area_ox=0.0676
X7670 rr3t3r_0[54|17]/a_460_290# WL54 SL17 VSS sky130_fd_pr__nfet_g5v0d10v5 ad=0.65 pd=3.3 as=0 ps=0 w=1 l=0.5
X7671 BLN17 rr3t3r_0[54|17]/a_860_290# sky130_fd_pr_reram__reram_cell area_ox=0.0676
X7672 rr3t3r_0[54|17]/a_60_290# WL54 SL17 VSS sky130_fd_pr__nfet_g5v0d10v5 ad=0.65 pd=3.3 as=0 ps=0 w=1 l=0.5
X7673 rr3t3r_0[54|17]/a_860_290# WL54 SL17 VSS sky130_fd_pr__nfet_g5v0d10v5 ad=0.65 pd=3.3 as=0 ps=0 w=1 l=0.5
X7674 BLP17 rr3t3r_0[55|17]/a_60_290# sky130_fd_pr_reram__reram_cell area_ox=0.0676
X7675 BLZ17 rr3t3r_0[55|17]/a_460_290# sky130_fd_pr_reram__reram_cell area_ox=0.0676
X7676 rr3t3r_0[55|17]/a_460_290# WL55 SL17 VSS sky130_fd_pr__nfet_g5v0d10v5 ad=0.65 pd=3.3 as=0 ps=0 w=1 l=0.5
X7677 BLN17 rr3t3r_0[55|17]/a_860_290# sky130_fd_pr_reram__reram_cell area_ox=0.0676
X7678 rr3t3r_0[55|17]/a_60_290# WL55 SL17 VSS sky130_fd_pr__nfet_g5v0d10v5 ad=0.65 pd=3.3 as=0 ps=0 w=1 l=0.5
X7679 rr3t3r_0[55|17]/a_860_290# WL55 SL17 VSS sky130_fd_pr__nfet_g5v0d10v5 ad=0.65 pd=3.3 as=0 ps=0 w=1 l=0.5
X7680 BLP17 rr3t3r_0[56|17]/a_60_290# sky130_fd_pr_reram__reram_cell area_ox=0.0676
X7681 BLZ17 rr3t3r_0[56|17]/a_460_290# sky130_fd_pr_reram__reram_cell area_ox=0.0676
X7682 rr3t3r_0[56|17]/a_460_290# WL56 SL17 VSS sky130_fd_pr__nfet_g5v0d10v5 ad=0.65 pd=3.3 as=0 ps=0 w=1 l=0.5
X7683 BLN17 rr3t3r_0[56|17]/a_860_290# sky130_fd_pr_reram__reram_cell area_ox=0.0676
X7684 rr3t3r_0[56|17]/a_60_290# WL56 SL17 VSS sky130_fd_pr__nfet_g5v0d10v5 ad=0.65 pd=3.3 as=0 ps=0 w=1 l=0.5
X7685 rr3t3r_0[56|17]/a_860_290# WL56 SL17 VSS sky130_fd_pr__nfet_g5v0d10v5 ad=0.65 pd=3.3 as=0 ps=0 w=1 l=0.5
X7686 BLP17 rr3t3r_0[57|17]/a_60_290# sky130_fd_pr_reram__reram_cell area_ox=0.0676
X7687 BLZ17 rr3t3r_0[57|17]/a_460_290# sky130_fd_pr_reram__reram_cell area_ox=0.0676
X7688 rr3t3r_0[57|17]/a_460_290# WL57 SL17 VSS sky130_fd_pr__nfet_g5v0d10v5 ad=0.65 pd=3.3 as=0 ps=0 w=1 l=0.5
X7689 BLN17 rr3t3r_0[57|17]/a_860_290# sky130_fd_pr_reram__reram_cell area_ox=0.0676
X7690 rr3t3r_0[57|17]/a_60_290# WL57 SL17 VSS sky130_fd_pr__nfet_g5v0d10v5 ad=0.65 pd=3.3 as=0 ps=0 w=1 l=0.5
X7691 rr3t3r_0[57|17]/a_860_290# WL57 SL17 VSS sky130_fd_pr__nfet_g5v0d10v5 ad=0.65 pd=3.3 as=0 ps=0 w=1 l=0.5
X7692 BLP17 rr3t3r_0[58|17]/a_60_290# sky130_fd_pr_reram__reram_cell area_ox=0.0676
X7693 BLZ17 rr3t3r_0[58|17]/a_460_290# sky130_fd_pr_reram__reram_cell area_ox=0.0676
X7694 rr3t3r_0[58|17]/a_460_290# WL58 SL17 VSS sky130_fd_pr__nfet_g5v0d10v5 ad=0.65 pd=3.3 as=0 ps=0 w=1 l=0.5
X7695 BLN17 rr3t3r_0[58|17]/a_860_290# sky130_fd_pr_reram__reram_cell area_ox=0.0676
X7696 rr3t3r_0[58|17]/a_60_290# WL58 SL17 VSS sky130_fd_pr__nfet_g5v0d10v5 ad=0.65 pd=3.3 as=0 ps=0 w=1 l=0.5
X7697 rr3t3r_0[58|17]/a_860_290# WL58 SL17 VSS sky130_fd_pr__nfet_g5v0d10v5 ad=0.65 pd=3.3 as=0 ps=0 w=1 l=0.5
X7698 BLP17 rr3t3r_0[59|17]/a_60_290# sky130_fd_pr_reram__reram_cell area_ox=0.0676
X7699 BLZ17 rr3t3r_0[59|17]/a_460_290# sky130_fd_pr_reram__reram_cell area_ox=0.0676
X7700 rr3t3r_0[59|17]/a_460_290# WL59 SL17 VSS sky130_fd_pr__nfet_g5v0d10v5 ad=0.65 pd=3.3 as=0 ps=0 w=1 l=0.5
X7701 BLN17 rr3t3r_0[59|17]/a_860_290# sky130_fd_pr_reram__reram_cell area_ox=0.0676
X7702 rr3t3r_0[59|17]/a_60_290# WL59 SL17 VSS sky130_fd_pr__nfet_g5v0d10v5 ad=0.65 pd=3.3 as=0 ps=0 w=1 l=0.5
X7703 rr3t3r_0[59|17]/a_860_290# WL59 SL17 VSS sky130_fd_pr__nfet_g5v0d10v5 ad=0.65 pd=3.3 as=0 ps=0 w=1 l=0.5
X7704 BLP17 rr3t3r_0[60|17]/a_60_290# sky130_fd_pr_reram__reram_cell area_ox=0.0676
X7705 BLZ17 rr3t3r_0[60|17]/a_460_290# sky130_fd_pr_reram__reram_cell area_ox=0.0676
X7706 rr3t3r_0[60|17]/a_460_290# WL60 SL17 VSS sky130_fd_pr__nfet_g5v0d10v5 ad=0.65 pd=3.3 as=0 ps=0 w=1 l=0.5
X7707 BLN17 rr3t3r_0[60|17]/a_860_290# sky130_fd_pr_reram__reram_cell area_ox=0.0676
X7708 rr3t3r_0[60|17]/a_60_290# WL60 SL17 VSS sky130_fd_pr__nfet_g5v0d10v5 ad=0.65 pd=3.3 as=0 ps=0 w=1 l=0.5
X7709 rr3t3r_0[60|17]/a_860_290# WL60 SL17 VSS sky130_fd_pr__nfet_g5v0d10v5 ad=0.65 pd=3.3 as=0 ps=0 w=1 l=0.5
X7710 BLP17 rr3t3r_0[61|17]/a_60_290# sky130_fd_pr_reram__reram_cell area_ox=0.0676
X7711 BLZ17 rr3t3r_0[61|17]/a_460_290# sky130_fd_pr_reram__reram_cell area_ox=0.0676
X7712 rr3t3r_0[61|17]/a_460_290# WL61 SL17 VSS sky130_fd_pr__nfet_g5v0d10v5 ad=0.65 pd=3.3 as=0 ps=0 w=1 l=0.5
X7713 BLN17 rr3t3r_0[61|17]/a_860_290# sky130_fd_pr_reram__reram_cell area_ox=0.0676
X7714 rr3t3r_0[61|17]/a_60_290# WL61 SL17 VSS sky130_fd_pr__nfet_g5v0d10v5 ad=0.65 pd=3.3 as=0 ps=0 w=1 l=0.5
X7715 rr3t3r_0[61|17]/a_860_290# WL61 SL17 VSS sky130_fd_pr__nfet_g5v0d10v5 ad=0.65 pd=3.3 as=0 ps=0 w=1 l=0.5
X7716 BLP17 rr3t3r_0[62|17]/a_60_290# sky130_fd_pr_reram__reram_cell area_ox=0.0676
X7717 BLZ17 rr3t3r_0[62|17]/a_460_290# sky130_fd_pr_reram__reram_cell area_ox=0.0676
X7718 rr3t3r_0[62|17]/a_460_290# WL62 SL17 VSS sky130_fd_pr__nfet_g5v0d10v5 ad=0.65 pd=3.3 as=0 ps=0 w=1 l=0.5
X7719 BLN17 rr3t3r_0[62|17]/a_860_290# sky130_fd_pr_reram__reram_cell area_ox=0.0676
X7720 rr3t3r_0[62|17]/a_60_290# WL62 SL17 VSS sky130_fd_pr__nfet_g5v0d10v5 ad=0.65 pd=3.3 as=0 ps=0 w=1 l=0.5
X7721 rr3t3r_0[62|17]/a_860_290# WL62 SL17 VSS sky130_fd_pr__nfet_g5v0d10v5 ad=0.65 pd=3.3 as=0 ps=0 w=1 l=0.5
X7722 BLP17 rr3t3r_0[63|17]/a_60_290# sky130_fd_pr_reram__reram_cell area_ox=0.0676
X7723 BLZ17 rr3t3r_0[63|17]/a_460_290# sky130_fd_pr_reram__reram_cell area_ox=0.0676
X7724 rr3t3r_0[63|17]/a_460_290# WL63 SL17 VSS sky130_fd_pr__nfet_g5v0d10v5 ad=0.65 pd=3.3 as=0 ps=0 w=1 l=0.5
X7725 BLN17 rr3t3r_0[63|17]/a_860_290# sky130_fd_pr_reram__reram_cell area_ox=0.0676
X7726 rr3t3r_0[63|17]/a_60_290# WL63 SL17 VSS sky130_fd_pr__nfet_g5v0d10v5 ad=0.65 pd=3.3 as=0 ps=0 w=1 l=0.5
X7727 rr3t3r_0[63|17]/a_860_290# WL63 SL17 VSS sky130_fd_pr__nfet_g5v0d10v5 ad=0.65 pd=3.3 as=0 ps=0 w=1 l=0.5
X7728 BLP17 rr3t3r_0[64|17]/a_60_290# sky130_fd_pr_reram__reram_cell area_ox=0.0676
X7729 BLZ17 rr3t3r_0[64|17]/a_460_290# sky130_fd_pr_reram__reram_cell area_ox=0.0676
X7730 rr3t3r_0[64|17]/a_460_290# WL64 SL17 VSS sky130_fd_pr__nfet_g5v0d10v5 ad=0.65 pd=3.3 as=0 ps=0 w=1 l=0.5
X7731 BLN17 rr3t3r_0[64|17]/a_860_290# sky130_fd_pr_reram__reram_cell area_ox=0.0676
X7732 rr3t3r_0[64|17]/a_60_290# WL64 SL17 VSS sky130_fd_pr__nfet_g5v0d10v5 ad=0.65 pd=3.3 as=0 ps=0 w=1 l=0.5
X7733 rr3t3r_0[64|17]/a_860_290# WL64 SL17 VSS sky130_fd_pr__nfet_g5v0d10v5 ad=0.65 pd=3.3 as=0 ps=0 w=1 l=0.5
X7734 BLP17 rr3t3r_0[65|17]/a_60_290# sky130_fd_pr_reram__reram_cell area_ox=0.0676
X7735 BLZ17 rr3t3r_0[65|17]/a_460_290# sky130_fd_pr_reram__reram_cell area_ox=0.0676
X7736 rr3t3r_0[65|17]/a_460_290# WL65 SL17 VSS sky130_fd_pr__nfet_g5v0d10v5 ad=0.65 pd=3.3 as=0 ps=0 w=1 l=0.5
X7737 BLN17 rr3t3r_0[65|17]/a_860_290# sky130_fd_pr_reram__reram_cell area_ox=0.0676
X7738 rr3t3r_0[65|17]/a_60_290# WL65 SL17 VSS sky130_fd_pr__nfet_g5v0d10v5 ad=0.65 pd=3.3 as=0 ps=0 w=1 l=0.5
X7739 rr3t3r_0[65|17]/a_860_290# WL65 SL17 VSS sky130_fd_pr__nfet_g5v0d10v5 ad=0.65 pd=3.3 as=0 ps=0 w=1 l=0.5
X7740 BLP17 rr3t3r_0[66|17]/a_60_290# sky130_fd_pr_reram__reram_cell area_ox=0.0676
X7741 BLZ17 rr3t3r_0[66|17]/a_460_290# sky130_fd_pr_reram__reram_cell area_ox=0.0676
X7742 rr3t3r_0[66|17]/a_460_290# WL66 SL17 VSS sky130_fd_pr__nfet_g5v0d10v5 ad=0.65 pd=3.3 as=0 ps=0 w=1 l=0.5
X7743 BLN17 rr3t3r_0[66|17]/a_860_290# sky130_fd_pr_reram__reram_cell area_ox=0.0676
X7744 rr3t3r_0[66|17]/a_60_290# WL66 SL17 VSS sky130_fd_pr__nfet_g5v0d10v5 ad=0.65 pd=3.3 as=0 ps=0 w=1 l=0.5
X7745 rr3t3r_0[66|17]/a_860_290# WL66 SL17 VSS sky130_fd_pr__nfet_g5v0d10v5 ad=0.65 pd=3.3 as=0 ps=0 w=1 l=0.5
X7746 BLP17 rr3t3r_0[67|17]/a_60_290# sky130_fd_pr_reram__reram_cell area_ox=0.0676
X7747 BLZ17 rr3t3r_0[67|17]/a_460_290# sky130_fd_pr_reram__reram_cell area_ox=0.0676
X7748 rr3t3r_0[67|17]/a_460_290# WL67 SL17 VSS sky130_fd_pr__nfet_g5v0d10v5 ad=0.65 pd=3.3 as=0 ps=0 w=1 l=0.5
X7749 BLN17 rr3t3r_0[67|17]/a_860_290# sky130_fd_pr_reram__reram_cell area_ox=0.0676
X7750 rr3t3r_0[67|17]/a_60_290# WL67 SL17 VSS sky130_fd_pr__nfet_g5v0d10v5 ad=0.65 pd=3.3 as=0 ps=0 w=1 l=0.5
X7751 rr3t3r_0[67|17]/a_860_290# WL67 SL17 VSS sky130_fd_pr__nfet_g5v0d10v5 ad=0.65 pd=3.3 as=0 ps=0 w=1 l=0.5
X7752 BLP17 rr3t3r_0[68|17]/a_60_290# sky130_fd_pr_reram__reram_cell area_ox=0.0676
X7753 BLZ17 rr3t3r_0[68|17]/a_460_290# sky130_fd_pr_reram__reram_cell area_ox=0.0676
X7754 rr3t3r_0[68|17]/a_460_290# WL68 SL17 VSS sky130_fd_pr__nfet_g5v0d10v5 ad=0.65 pd=3.3 as=0 ps=0 w=1 l=0.5
X7755 BLN17 rr3t3r_0[68|17]/a_860_290# sky130_fd_pr_reram__reram_cell area_ox=0.0676
X7756 rr3t3r_0[68|17]/a_60_290# WL68 SL17 VSS sky130_fd_pr__nfet_g5v0d10v5 ad=0.65 pd=3.3 as=0 ps=0 w=1 l=0.5
X7757 rr3t3r_0[68|17]/a_860_290# WL68 SL17 VSS sky130_fd_pr__nfet_g5v0d10v5 ad=0.65 pd=3.3 as=0 ps=0 w=1 l=0.5
X7758 BLP17 rr3t3r_0[69|17]/a_60_290# sky130_fd_pr_reram__reram_cell area_ox=0.0676
X7759 BLZ17 rr3t3r_0[69|17]/a_460_290# sky130_fd_pr_reram__reram_cell area_ox=0.0676
X7760 rr3t3r_0[69|17]/a_460_290# WL69 SL17 VSS sky130_fd_pr__nfet_g5v0d10v5 ad=0.65 pd=3.3 as=0 ps=0 w=1 l=0.5
X7761 BLN17 rr3t3r_0[69|17]/a_860_290# sky130_fd_pr_reram__reram_cell area_ox=0.0676
X7762 rr3t3r_0[69|17]/a_60_290# WL69 SL17 VSS sky130_fd_pr__nfet_g5v0d10v5 ad=0.65 pd=3.3 as=0 ps=0 w=1 l=0.5
X7763 rr3t3r_0[69|17]/a_860_290# WL69 SL17 VSS sky130_fd_pr__nfet_g5v0d10v5 ad=0.65 pd=3.3 as=0 ps=0 w=1 l=0.5
X7764 BLP17 rr3t3r_0[70|17]/a_60_290# sky130_fd_pr_reram__reram_cell area_ox=0.0676
X7765 BLZ17 rr3t3r_0[70|17]/a_460_290# sky130_fd_pr_reram__reram_cell area_ox=0.0676
X7766 rr3t3r_0[70|17]/a_460_290# WL70 SL17 VSS sky130_fd_pr__nfet_g5v0d10v5 ad=0.65 pd=3.3 as=0 ps=0 w=1 l=0.5
X7767 BLN17 rr3t3r_0[70|17]/a_860_290# sky130_fd_pr_reram__reram_cell area_ox=0.0676
X7768 rr3t3r_0[70|17]/a_60_290# WL70 SL17 VSS sky130_fd_pr__nfet_g5v0d10v5 ad=0.65 pd=3.3 as=0 ps=0 w=1 l=0.5
X7769 rr3t3r_0[70|17]/a_860_290# WL70 SL17 VSS sky130_fd_pr__nfet_g5v0d10v5 ad=0.65 pd=3.3 as=0 ps=0 w=1 l=0.5
X7770 BLP17 rr3t3r_0[71|17]/a_60_290# sky130_fd_pr_reram__reram_cell area_ox=0.0676
X7771 BLZ17 rr3t3r_0[71|17]/a_460_290# sky130_fd_pr_reram__reram_cell area_ox=0.0676
X7772 rr3t3r_0[71|17]/a_460_290# WL71 SL17 VSS sky130_fd_pr__nfet_g5v0d10v5 ad=0.65 pd=3.3 as=0 ps=0 w=1 l=0.5
X7773 BLN17 rr3t3r_0[71|17]/a_860_290# sky130_fd_pr_reram__reram_cell area_ox=0.0676
X7774 rr3t3r_0[71|17]/a_60_290# WL71 SL17 VSS sky130_fd_pr__nfet_g5v0d10v5 ad=0.65 pd=3.3 as=0 ps=0 w=1 l=0.5
X7775 rr3t3r_0[71|17]/a_860_290# WL71 SL17 VSS sky130_fd_pr__nfet_g5v0d10v5 ad=0.65 pd=3.3 as=0 ps=0 w=1 l=0.5
X7776 BLP18 rr3t3r_0[0|18]/a_60_290# sky130_fd_pr_reram__reram_cell area_ox=0.0676
X7777 BLZ18 rr3t3r_0[0|18]/a_460_290# sky130_fd_pr_reram__reram_cell area_ox=0.0676
X7778 rr3t3r_0[0|18]/a_460_290# WL0 SL18 VSS sky130_fd_pr__nfet_g5v0d10v5 ad=0.65 pd=3.3 as=162 ps=756 w=1 l=0.5
X7779 BLN18 rr3t3r_0[0|18]/a_860_290# sky130_fd_pr_reram__reram_cell area_ox=0.0676
X7780 rr3t3r_0[0|18]/a_60_290# WL0 SL18 VSS sky130_fd_pr__nfet_g5v0d10v5 ad=0.65 pd=3.3 as=0 ps=0 w=1 l=0.5
X7781 rr3t3r_0[0|18]/a_860_290# WL0 SL18 VSS sky130_fd_pr__nfet_g5v0d10v5 ad=0.65 pd=3.3 as=0 ps=0 w=1 l=0.5
X7782 BLP18 rr3t3r_0[1|18]/a_60_290# sky130_fd_pr_reram__reram_cell area_ox=0.0676
X7783 BLZ18 rr3t3r_0[1|18]/a_460_290# sky130_fd_pr_reram__reram_cell area_ox=0.0676
X7784 rr3t3r_0[1|18]/a_460_290# WL1 SL18 VSS sky130_fd_pr__nfet_g5v0d10v5 ad=0.65 pd=3.3 as=0 ps=0 w=1 l=0.5
X7785 BLN18 rr3t3r_0[1|18]/a_860_290# sky130_fd_pr_reram__reram_cell area_ox=0.0676
X7786 rr3t3r_0[1|18]/a_60_290# WL1 SL18 VSS sky130_fd_pr__nfet_g5v0d10v5 ad=0.65 pd=3.3 as=0 ps=0 w=1 l=0.5
X7787 rr3t3r_0[1|18]/a_860_290# WL1 SL18 VSS sky130_fd_pr__nfet_g5v0d10v5 ad=0.65 pd=3.3 as=0 ps=0 w=1 l=0.5
X7788 BLP18 rr3t3r_0[2|18]/a_60_290# sky130_fd_pr_reram__reram_cell area_ox=0.0676
X7789 BLZ18 rr3t3r_0[2|18]/a_460_290# sky130_fd_pr_reram__reram_cell area_ox=0.0676
X7790 rr3t3r_0[2|18]/a_460_290# WL2 SL18 VSS sky130_fd_pr__nfet_g5v0d10v5 ad=0.65 pd=3.3 as=0 ps=0 w=1 l=0.5
X7791 BLN18 rr3t3r_0[2|18]/a_860_290# sky130_fd_pr_reram__reram_cell area_ox=0.0676
X7792 rr3t3r_0[2|18]/a_60_290# WL2 SL18 VSS sky130_fd_pr__nfet_g5v0d10v5 ad=0.65 pd=3.3 as=0 ps=0 w=1 l=0.5
X7793 rr3t3r_0[2|18]/a_860_290# WL2 SL18 VSS sky130_fd_pr__nfet_g5v0d10v5 ad=0.65 pd=3.3 as=0 ps=0 w=1 l=0.5
X7794 BLP18 rr3t3r_0[3|18]/a_60_290# sky130_fd_pr_reram__reram_cell area_ox=0.0676
X7795 BLZ18 rr3t3r_0[3|18]/a_460_290# sky130_fd_pr_reram__reram_cell area_ox=0.0676
X7796 rr3t3r_0[3|18]/a_460_290# WL3 SL18 VSS sky130_fd_pr__nfet_g5v0d10v5 ad=0.65 pd=3.3 as=0 ps=0 w=1 l=0.5
X7797 BLN18 rr3t3r_0[3|18]/a_860_290# sky130_fd_pr_reram__reram_cell area_ox=0.0676
X7798 rr3t3r_0[3|18]/a_60_290# WL3 SL18 VSS sky130_fd_pr__nfet_g5v0d10v5 ad=0.65 pd=3.3 as=0 ps=0 w=1 l=0.5
X7799 rr3t3r_0[3|18]/a_860_290# WL3 SL18 VSS sky130_fd_pr__nfet_g5v0d10v5 ad=0.65 pd=3.3 as=0 ps=0 w=1 l=0.5
X7800 BLP18 rr3t3r_0[4|18]/a_60_290# sky130_fd_pr_reram__reram_cell area_ox=0.0676
X7801 BLZ18 rr3t3r_0[4|18]/a_460_290# sky130_fd_pr_reram__reram_cell area_ox=0.0676
X7802 rr3t3r_0[4|18]/a_460_290# WL4 SL18 VSS sky130_fd_pr__nfet_g5v0d10v5 ad=0.65 pd=3.3 as=0 ps=0 w=1 l=0.5
X7803 BLN18 rr3t3r_0[4|18]/a_860_290# sky130_fd_pr_reram__reram_cell area_ox=0.0676
X7804 rr3t3r_0[4|18]/a_60_290# WL4 SL18 VSS sky130_fd_pr__nfet_g5v0d10v5 ad=0.65 pd=3.3 as=0 ps=0 w=1 l=0.5
X7805 rr3t3r_0[4|18]/a_860_290# WL4 SL18 VSS sky130_fd_pr__nfet_g5v0d10v5 ad=0.65 pd=3.3 as=0 ps=0 w=1 l=0.5
X7806 BLP18 rr3t3r_0[5|18]/a_60_290# sky130_fd_pr_reram__reram_cell area_ox=0.0676
X7807 BLZ18 rr3t3r_0[5|18]/a_460_290# sky130_fd_pr_reram__reram_cell area_ox=0.0676
X7808 rr3t3r_0[5|18]/a_460_290# WL5 SL18 VSS sky130_fd_pr__nfet_g5v0d10v5 ad=0.65 pd=3.3 as=0 ps=0 w=1 l=0.5
X7809 BLN18 rr3t3r_0[5|18]/a_860_290# sky130_fd_pr_reram__reram_cell area_ox=0.0676
X7810 rr3t3r_0[5|18]/a_60_290# WL5 SL18 VSS sky130_fd_pr__nfet_g5v0d10v5 ad=0.65 pd=3.3 as=0 ps=0 w=1 l=0.5
X7811 rr3t3r_0[5|18]/a_860_290# WL5 SL18 VSS sky130_fd_pr__nfet_g5v0d10v5 ad=0.65 pd=3.3 as=0 ps=0 w=1 l=0.5
X7812 BLP18 rr3t3r_0[6|18]/a_60_290# sky130_fd_pr_reram__reram_cell area_ox=0.0676
X7813 BLZ18 rr3t3r_0[6|18]/a_460_290# sky130_fd_pr_reram__reram_cell area_ox=0.0676
X7814 rr3t3r_0[6|18]/a_460_290# WL6 SL18 VSS sky130_fd_pr__nfet_g5v0d10v5 ad=0.65 pd=3.3 as=0 ps=0 w=1 l=0.5
X7815 BLN18 rr3t3r_0[6|18]/a_860_290# sky130_fd_pr_reram__reram_cell area_ox=0.0676
X7816 rr3t3r_0[6|18]/a_60_290# WL6 SL18 VSS sky130_fd_pr__nfet_g5v0d10v5 ad=0.65 pd=3.3 as=0 ps=0 w=1 l=0.5
X7817 rr3t3r_0[6|18]/a_860_290# WL6 SL18 VSS sky130_fd_pr__nfet_g5v0d10v5 ad=0.65 pd=3.3 as=0 ps=0 w=1 l=0.5
X7818 BLP18 rr3t3r_0[7|18]/a_60_290# sky130_fd_pr_reram__reram_cell area_ox=0.0676
X7819 BLZ18 rr3t3r_0[7|18]/a_460_290# sky130_fd_pr_reram__reram_cell area_ox=0.0676
X7820 rr3t3r_0[7|18]/a_460_290# WL7 SL18 VSS sky130_fd_pr__nfet_g5v0d10v5 ad=0.65 pd=3.3 as=0 ps=0 w=1 l=0.5
X7821 BLN18 rr3t3r_0[7|18]/a_860_290# sky130_fd_pr_reram__reram_cell area_ox=0.0676
X7822 rr3t3r_0[7|18]/a_60_290# WL7 SL18 VSS sky130_fd_pr__nfet_g5v0d10v5 ad=0.65 pd=3.3 as=0 ps=0 w=1 l=0.5
X7823 rr3t3r_0[7|18]/a_860_290# WL7 SL18 VSS sky130_fd_pr__nfet_g5v0d10v5 ad=0.65 pd=3.3 as=0 ps=0 w=1 l=0.5
X7824 BLP18 rr3t3r_0[8|18]/a_60_290# sky130_fd_pr_reram__reram_cell area_ox=0.0676
X7825 BLZ18 rr3t3r_0[8|18]/a_460_290# sky130_fd_pr_reram__reram_cell area_ox=0.0676
X7826 rr3t3r_0[8|18]/a_460_290# WL8 SL18 VSS sky130_fd_pr__nfet_g5v0d10v5 ad=0.65 pd=3.3 as=0 ps=0 w=1 l=0.5
X7827 BLN18 rr3t3r_0[8|18]/a_860_290# sky130_fd_pr_reram__reram_cell area_ox=0.0676
X7828 rr3t3r_0[8|18]/a_60_290# WL8 SL18 VSS sky130_fd_pr__nfet_g5v0d10v5 ad=0.65 pd=3.3 as=0 ps=0 w=1 l=0.5
X7829 rr3t3r_0[8|18]/a_860_290# WL8 SL18 VSS sky130_fd_pr__nfet_g5v0d10v5 ad=0.65 pd=3.3 as=0 ps=0 w=1 l=0.5
X7830 BLP18 rr3t3r_0[9|18]/a_60_290# sky130_fd_pr_reram__reram_cell area_ox=0.0676
X7831 BLZ18 rr3t3r_0[9|18]/a_460_290# sky130_fd_pr_reram__reram_cell area_ox=0.0676
X7832 rr3t3r_0[9|18]/a_460_290# WL9 SL18 VSS sky130_fd_pr__nfet_g5v0d10v5 ad=0.65 pd=3.3 as=0 ps=0 w=1 l=0.5
X7833 BLN18 rr3t3r_0[9|18]/a_860_290# sky130_fd_pr_reram__reram_cell area_ox=0.0676
X7834 rr3t3r_0[9|18]/a_60_290# WL9 SL18 VSS sky130_fd_pr__nfet_g5v0d10v5 ad=0.65 pd=3.3 as=0 ps=0 w=1 l=0.5
X7835 rr3t3r_0[9|18]/a_860_290# WL9 SL18 VSS sky130_fd_pr__nfet_g5v0d10v5 ad=0.65 pd=3.3 as=0 ps=0 w=1 l=0.5
X7836 BLP18 rr3t3r_0[10|18]/a_60_290# sky130_fd_pr_reram__reram_cell area_ox=0.0676
X7837 BLZ18 rr3t3r_0[10|18]/a_460_290# sky130_fd_pr_reram__reram_cell area_ox=0.0676
X7838 rr3t3r_0[10|18]/a_460_290# WL10 SL18 VSS sky130_fd_pr__nfet_g5v0d10v5 ad=0.65 pd=3.3 as=0 ps=0 w=1 l=0.5
X7839 BLN18 rr3t3r_0[10|18]/a_860_290# sky130_fd_pr_reram__reram_cell area_ox=0.0676
X7840 rr3t3r_0[10|18]/a_60_290# WL10 SL18 VSS sky130_fd_pr__nfet_g5v0d10v5 ad=0.65 pd=3.3 as=0 ps=0 w=1 l=0.5
X7841 rr3t3r_0[10|18]/a_860_290# WL10 SL18 VSS sky130_fd_pr__nfet_g5v0d10v5 ad=0.65 pd=3.3 as=0 ps=0 w=1 l=0.5
X7842 BLP18 rr3t3r_0[11|18]/a_60_290# sky130_fd_pr_reram__reram_cell area_ox=0.0676
X7843 BLZ18 rr3t3r_0[11|18]/a_460_290# sky130_fd_pr_reram__reram_cell area_ox=0.0676
X7844 rr3t3r_0[11|18]/a_460_290# WL11 SL18 VSS sky130_fd_pr__nfet_g5v0d10v5 ad=0.65 pd=3.3 as=0 ps=0 w=1 l=0.5
X7845 BLN18 rr3t3r_0[11|18]/a_860_290# sky130_fd_pr_reram__reram_cell area_ox=0.0676
X7846 rr3t3r_0[11|18]/a_60_290# WL11 SL18 VSS sky130_fd_pr__nfet_g5v0d10v5 ad=0.65 pd=3.3 as=0 ps=0 w=1 l=0.5
X7847 rr3t3r_0[11|18]/a_860_290# WL11 SL18 VSS sky130_fd_pr__nfet_g5v0d10v5 ad=0.65 pd=3.3 as=0 ps=0 w=1 l=0.5
X7848 BLP18 rr3t3r_0[12|18]/a_60_290# sky130_fd_pr_reram__reram_cell area_ox=0.0676
X7849 BLZ18 rr3t3r_0[12|18]/a_460_290# sky130_fd_pr_reram__reram_cell area_ox=0.0676
X7850 rr3t3r_0[12|18]/a_460_290# WL12 SL18 VSS sky130_fd_pr__nfet_g5v0d10v5 ad=0.65 pd=3.3 as=0 ps=0 w=1 l=0.5
X7851 BLN18 rr3t3r_0[12|18]/a_860_290# sky130_fd_pr_reram__reram_cell area_ox=0.0676
X7852 rr3t3r_0[12|18]/a_60_290# WL12 SL18 VSS sky130_fd_pr__nfet_g5v0d10v5 ad=0.65 pd=3.3 as=0 ps=0 w=1 l=0.5
X7853 rr3t3r_0[12|18]/a_860_290# WL12 SL18 VSS sky130_fd_pr__nfet_g5v0d10v5 ad=0.65 pd=3.3 as=0 ps=0 w=1 l=0.5
X7854 BLP18 rr3t3r_0[13|18]/a_60_290# sky130_fd_pr_reram__reram_cell area_ox=0.0676
X7855 BLZ18 rr3t3r_0[13|18]/a_460_290# sky130_fd_pr_reram__reram_cell area_ox=0.0676
X7856 rr3t3r_0[13|18]/a_460_290# WL13 SL18 VSS sky130_fd_pr__nfet_g5v0d10v5 ad=0.65 pd=3.3 as=0 ps=0 w=1 l=0.5
X7857 BLN18 rr3t3r_0[13|18]/a_860_290# sky130_fd_pr_reram__reram_cell area_ox=0.0676
X7858 rr3t3r_0[13|18]/a_60_290# WL13 SL18 VSS sky130_fd_pr__nfet_g5v0d10v5 ad=0.65 pd=3.3 as=0 ps=0 w=1 l=0.5
X7859 rr3t3r_0[13|18]/a_860_290# WL13 SL18 VSS sky130_fd_pr__nfet_g5v0d10v5 ad=0.65 pd=3.3 as=0 ps=0 w=1 l=0.5
X7860 BLP18 rr3t3r_0[14|18]/a_60_290# sky130_fd_pr_reram__reram_cell area_ox=0.0676
X7861 BLZ18 rr3t3r_0[14|18]/a_460_290# sky130_fd_pr_reram__reram_cell area_ox=0.0676
X7862 rr3t3r_0[14|18]/a_460_290# WL14 SL18 VSS sky130_fd_pr__nfet_g5v0d10v5 ad=0.65 pd=3.3 as=0 ps=0 w=1 l=0.5
X7863 BLN18 rr3t3r_0[14|18]/a_860_290# sky130_fd_pr_reram__reram_cell area_ox=0.0676
X7864 rr3t3r_0[14|18]/a_60_290# WL14 SL18 VSS sky130_fd_pr__nfet_g5v0d10v5 ad=0.65 pd=3.3 as=0 ps=0 w=1 l=0.5
X7865 rr3t3r_0[14|18]/a_860_290# WL14 SL18 VSS sky130_fd_pr__nfet_g5v0d10v5 ad=0.65 pd=3.3 as=0 ps=0 w=1 l=0.5
X7866 BLP18 rr3t3r_0[15|18]/a_60_290# sky130_fd_pr_reram__reram_cell area_ox=0.0676
X7867 BLZ18 rr3t3r_0[15|18]/a_460_290# sky130_fd_pr_reram__reram_cell area_ox=0.0676
X7868 rr3t3r_0[15|18]/a_460_290# WL15 SL18 VSS sky130_fd_pr__nfet_g5v0d10v5 ad=0.65 pd=3.3 as=0 ps=0 w=1 l=0.5
X7869 BLN18 rr3t3r_0[15|18]/a_860_290# sky130_fd_pr_reram__reram_cell area_ox=0.0676
X7870 rr3t3r_0[15|18]/a_60_290# WL15 SL18 VSS sky130_fd_pr__nfet_g5v0d10v5 ad=0.65 pd=3.3 as=0 ps=0 w=1 l=0.5
X7871 rr3t3r_0[15|18]/a_860_290# WL15 SL18 VSS sky130_fd_pr__nfet_g5v0d10v5 ad=0.65 pd=3.3 as=0 ps=0 w=1 l=0.5
X7872 BLP18 rr3t3r_0[16|18]/a_60_290# sky130_fd_pr_reram__reram_cell area_ox=0.0676
X7873 BLZ18 rr3t3r_0[16|18]/a_460_290# sky130_fd_pr_reram__reram_cell area_ox=0.0676
X7874 rr3t3r_0[16|18]/a_460_290# WL16 SL18 VSS sky130_fd_pr__nfet_g5v0d10v5 ad=0.65 pd=3.3 as=0 ps=0 w=1 l=0.5
X7875 BLN18 rr3t3r_0[16|18]/a_860_290# sky130_fd_pr_reram__reram_cell area_ox=0.0676
X7876 rr3t3r_0[16|18]/a_60_290# WL16 SL18 VSS sky130_fd_pr__nfet_g5v0d10v5 ad=0.65 pd=3.3 as=0 ps=0 w=1 l=0.5
X7877 rr3t3r_0[16|18]/a_860_290# WL16 SL18 VSS sky130_fd_pr__nfet_g5v0d10v5 ad=0.65 pd=3.3 as=0 ps=0 w=1 l=0.5
X7878 BLP18 rr3t3r_0[17|18]/a_60_290# sky130_fd_pr_reram__reram_cell area_ox=0.0676
X7879 BLZ18 rr3t3r_0[17|18]/a_460_290# sky130_fd_pr_reram__reram_cell area_ox=0.0676
X7880 rr3t3r_0[17|18]/a_460_290# WL17 SL18 VSS sky130_fd_pr__nfet_g5v0d10v5 ad=0.65 pd=3.3 as=0 ps=0 w=1 l=0.5
X7881 BLN18 rr3t3r_0[17|18]/a_860_290# sky130_fd_pr_reram__reram_cell area_ox=0.0676
X7882 rr3t3r_0[17|18]/a_60_290# WL17 SL18 VSS sky130_fd_pr__nfet_g5v0d10v5 ad=0.65 pd=3.3 as=0 ps=0 w=1 l=0.5
X7883 rr3t3r_0[17|18]/a_860_290# WL17 SL18 VSS sky130_fd_pr__nfet_g5v0d10v5 ad=0.65 pd=3.3 as=0 ps=0 w=1 l=0.5
X7884 BLP18 rr3t3r_0[18|18]/a_60_290# sky130_fd_pr_reram__reram_cell area_ox=0.0676
X7885 BLZ18 rr3t3r_0[18|18]/a_460_290# sky130_fd_pr_reram__reram_cell area_ox=0.0676
X7886 rr3t3r_0[18|18]/a_460_290# WL18 SL18 VSS sky130_fd_pr__nfet_g5v0d10v5 ad=0.65 pd=3.3 as=0 ps=0 w=1 l=0.5
X7887 BLN18 rr3t3r_0[18|18]/a_860_290# sky130_fd_pr_reram__reram_cell area_ox=0.0676
X7888 rr3t3r_0[18|18]/a_60_290# WL18 SL18 VSS sky130_fd_pr__nfet_g5v0d10v5 ad=0.65 pd=3.3 as=0 ps=0 w=1 l=0.5
X7889 rr3t3r_0[18|18]/a_860_290# WL18 SL18 VSS sky130_fd_pr__nfet_g5v0d10v5 ad=0.65 pd=3.3 as=0 ps=0 w=1 l=0.5
X7890 BLP18 rr3t3r_0[19|18]/a_60_290# sky130_fd_pr_reram__reram_cell area_ox=0.0676
X7891 BLZ18 rr3t3r_0[19|18]/a_460_290# sky130_fd_pr_reram__reram_cell area_ox=0.0676
X7892 rr3t3r_0[19|18]/a_460_290# WL19 SL18 VSS sky130_fd_pr__nfet_g5v0d10v5 ad=0.65 pd=3.3 as=0 ps=0 w=1 l=0.5
X7893 BLN18 rr3t3r_0[19|18]/a_860_290# sky130_fd_pr_reram__reram_cell area_ox=0.0676
X7894 rr3t3r_0[19|18]/a_60_290# WL19 SL18 VSS sky130_fd_pr__nfet_g5v0d10v5 ad=0.65 pd=3.3 as=0 ps=0 w=1 l=0.5
X7895 rr3t3r_0[19|18]/a_860_290# WL19 SL18 VSS sky130_fd_pr__nfet_g5v0d10v5 ad=0.65 pd=3.3 as=0 ps=0 w=1 l=0.5
X7896 BLP18 rr3t3r_0[20|18]/a_60_290# sky130_fd_pr_reram__reram_cell area_ox=0.0676
X7897 BLZ18 rr3t3r_0[20|18]/a_460_290# sky130_fd_pr_reram__reram_cell area_ox=0.0676
X7898 rr3t3r_0[20|18]/a_460_290# WL20 SL18 VSS sky130_fd_pr__nfet_g5v0d10v5 ad=0.65 pd=3.3 as=0 ps=0 w=1 l=0.5
X7899 BLN18 rr3t3r_0[20|18]/a_860_290# sky130_fd_pr_reram__reram_cell area_ox=0.0676
X7900 rr3t3r_0[20|18]/a_60_290# WL20 SL18 VSS sky130_fd_pr__nfet_g5v0d10v5 ad=0.65 pd=3.3 as=0 ps=0 w=1 l=0.5
X7901 rr3t3r_0[20|18]/a_860_290# WL20 SL18 VSS sky130_fd_pr__nfet_g5v0d10v5 ad=0.65 pd=3.3 as=0 ps=0 w=1 l=0.5
X7902 BLP18 rr3t3r_0[21|18]/a_60_290# sky130_fd_pr_reram__reram_cell area_ox=0.0676
X7903 BLZ18 rr3t3r_0[21|18]/a_460_290# sky130_fd_pr_reram__reram_cell area_ox=0.0676
X7904 rr3t3r_0[21|18]/a_460_290# WL21 SL18 VSS sky130_fd_pr__nfet_g5v0d10v5 ad=0.65 pd=3.3 as=0 ps=0 w=1 l=0.5
X7905 BLN18 rr3t3r_0[21|18]/a_860_290# sky130_fd_pr_reram__reram_cell area_ox=0.0676
X7906 rr3t3r_0[21|18]/a_60_290# WL21 SL18 VSS sky130_fd_pr__nfet_g5v0d10v5 ad=0.65 pd=3.3 as=0 ps=0 w=1 l=0.5
X7907 rr3t3r_0[21|18]/a_860_290# WL21 SL18 VSS sky130_fd_pr__nfet_g5v0d10v5 ad=0.65 pd=3.3 as=0 ps=0 w=1 l=0.5
X7908 BLP18 rr3t3r_0[22|18]/a_60_290# sky130_fd_pr_reram__reram_cell area_ox=0.0676
X7909 BLZ18 rr3t3r_0[22|18]/a_460_290# sky130_fd_pr_reram__reram_cell area_ox=0.0676
X7910 rr3t3r_0[22|18]/a_460_290# WL22 SL18 VSS sky130_fd_pr__nfet_g5v0d10v5 ad=0.65 pd=3.3 as=0 ps=0 w=1 l=0.5
X7911 BLN18 rr3t3r_0[22|18]/a_860_290# sky130_fd_pr_reram__reram_cell area_ox=0.0676
X7912 rr3t3r_0[22|18]/a_60_290# WL22 SL18 VSS sky130_fd_pr__nfet_g5v0d10v5 ad=0.65 pd=3.3 as=0 ps=0 w=1 l=0.5
X7913 rr3t3r_0[22|18]/a_860_290# WL22 SL18 VSS sky130_fd_pr__nfet_g5v0d10v5 ad=0.65 pd=3.3 as=0 ps=0 w=1 l=0.5
X7914 BLP18 rr3t3r_0[23|18]/a_60_290# sky130_fd_pr_reram__reram_cell area_ox=0.0676
X7915 BLZ18 rr3t3r_0[23|18]/a_460_290# sky130_fd_pr_reram__reram_cell area_ox=0.0676
X7916 rr3t3r_0[23|18]/a_460_290# WL23 SL18 VSS sky130_fd_pr__nfet_g5v0d10v5 ad=0.65 pd=3.3 as=0 ps=0 w=1 l=0.5
X7917 BLN18 rr3t3r_0[23|18]/a_860_290# sky130_fd_pr_reram__reram_cell area_ox=0.0676
X7918 rr3t3r_0[23|18]/a_60_290# WL23 SL18 VSS sky130_fd_pr__nfet_g5v0d10v5 ad=0.65 pd=3.3 as=0 ps=0 w=1 l=0.5
X7919 rr3t3r_0[23|18]/a_860_290# WL23 SL18 VSS sky130_fd_pr__nfet_g5v0d10v5 ad=0.65 pd=3.3 as=0 ps=0 w=1 l=0.5
X7920 BLP18 rr3t3r_0[24|18]/a_60_290# sky130_fd_pr_reram__reram_cell area_ox=0.0676
X7921 BLZ18 rr3t3r_0[24|18]/a_460_290# sky130_fd_pr_reram__reram_cell area_ox=0.0676
X7922 rr3t3r_0[24|18]/a_460_290# WL24 SL18 VSS sky130_fd_pr__nfet_g5v0d10v5 ad=0.65 pd=3.3 as=0 ps=0 w=1 l=0.5
X7923 BLN18 rr3t3r_0[24|18]/a_860_290# sky130_fd_pr_reram__reram_cell area_ox=0.0676
X7924 rr3t3r_0[24|18]/a_60_290# WL24 SL18 VSS sky130_fd_pr__nfet_g5v0d10v5 ad=0.65 pd=3.3 as=0 ps=0 w=1 l=0.5
X7925 rr3t3r_0[24|18]/a_860_290# WL24 SL18 VSS sky130_fd_pr__nfet_g5v0d10v5 ad=0.65 pd=3.3 as=0 ps=0 w=1 l=0.5
X7926 BLP18 rr3t3r_0[25|18]/a_60_290# sky130_fd_pr_reram__reram_cell area_ox=0.0676
X7927 BLZ18 rr3t3r_0[25|18]/a_460_290# sky130_fd_pr_reram__reram_cell area_ox=0.0676
X7928 rr3t3r_0[25|18]/a_460_290# WL25 SL18 VSS sky130_fd_pr__nfet_g5v0d10v5 ad=0.65 pd=3.3 as=0 ps=0 w=1 l=0.5
X7929 BLN18 rr3t3r_0[25|18]/a_860_290# sky130_fd_pr_reram__reram_cell area_ox=0.0676
X7930 rr3t3r_0[25|18]/a_60_290# WL25 SL18 VSS sky130_fd_pr__nfet_g5v0d10v5 ad=0.65 pd=3.3 as=0 ps=0 w=1 l=0.5
X7931 rr3t3r_0[25|18]/a_860_290# WL25 SL18 VSS sky130_fd_pr__nfet_g5v0d10v5 ad=0.65 pd=3.3 as=0 ps=0 w=1 l=0.5
X7932 BLP18 rr3t3r_0[26|18]/a_60_290# sky130_fd_pr_reram__reram_cell area_ox=0.0676
X7933 BLZ18 rr3t3r_0[26|18]/a_460_290# sky130_fd_pr_reram__reram_cell area_ox=0.0676
X7934 rr3t3r_0[26|18]/a_460_290# WL26 SL18 VSS sky130_fd_pr__nfet_g5v0d10v5 ad=0.65 pd=3.3 as=0 ps=0 w=1 l=0.5
X7935 BLN18 rr3t3r_0[26|18]/a_860_290# sky130_fd_pr_reram__reram_cell area_ox=0.0676
X7936 rr3t3r_0[26|18]/a_60_290# WL26 SL18 VSS sky130_fd_pr__nfet_g5v0d10v5 ad=0.65 pd=3.3 as=0 ps=0 w=1 l=0.5
X7937 rr3t3r_0[26|18]/a_860_290# WL26 SL18 VSS sky130_fd_pr__nfet_g5v0d10v5 ad=0.65 pd=3.3 as=0 ps=0 w=1 l=0.5
X7938 BLP18 rr3t3r_0[27|18]/a_60_290# sky130_fd_pr_reram__reram_cell area_ox=0.0676
X7939 BLZ18 rr3t3r_0[27|18]/a_460_290# sky130_fd_pr_reram__reram_cell area_ox=0.0676
X7940 rr3t3r_0[27|18]/a_460_290# WL27 SL18 VSS sky130_fd_pr__nfet_g5v0d10v5 ad=0.65 pd=3.3 as=0 ps=0 w=1 l=0.5
X7941 BLN18 rr3t3r_0[27|18]/a_860_290# sky130_fd_pr_reram__reram_cell area_ox=0.0676
X7942 rr3t3r_0[27|18]/a_60_290# WL27 SL18 VSS sky130_fd_pr__nfet_g5v0d10v5 ad=0.65 pd=3.3 as=0 ps=0 w=1 l=0.5
X7943 rr3t3r_0[27|18]/a_860_290# WL27 SL18 VSS sky130_fd_pr__nfet_g5v0d10v5 ad=0.65 pd=3.3 as=0 ps=0 w=1 l=0.5
X7944 BLP18 rr3t3r_0[28|18]/a_60_290# sky130_fd_pr_reram__reram_cell area_ox=0.0676
X7945 BLZ18 rr3t3r_0[28|18]/a_460_290# sky130_fd_pr_reram__reram_cell area_ox=0.0676
X7946 rr3t3r_0[28|18]/a_460_290# WL28 SL18 VSS sky130_fd_pr__nfet_g5v0d10v5 ad=0.65 pd=3.3 as=0 ps=0 w=1 l=0.5
X7947 BLN18 rr3t3r_0[28|18]/a_860_290# sky130_fd_pr_reram__reram_cell area_ox=0.0676
X7948 rr3t3r_0[28|18]/a_60_290# WL28 SL18 VSS sky130_fd_pr__nfet_g5v0d10v5 ad=0.65 pd=3.3 as=0 ps=0 w=1 l=0.5
X7949 rr3t3r_0[28|18]/a_860_290# WL28 SL18 VSS sky130_fd_pr__nfet_g5v0d10v5 ad=0.65 pd=3.3 as=0 ps=0 w=1 l=0.5
X7950 BLP18 rr3t3r_0[29|18]/a_60_290# sky130_fd_pr_reram__reram_cell area_ox=0.0676
X7951 BLZ18 rr3t3r_0[29|18]/a_460_290# sky130_fd_pr_reram__reram_cell area_ox=0.0676
X7952 rr3t3r_0[29|18]/a_460_290# WL29 SL18 VSS sky130_fd_pr__nfet_g5v0d10v5 ad=0.65 pd=3.3 as=0 ps=0 w=1 l=0.5
X7953 BLN18 rr3t3r_0[29|18]/a_860_290# sky130_fd_pr_reram__reram_cell area_ox=0.0676
X7954 rr3t3r_0[29|18]/a_60_290# WL29 SL18 VSS sky130_fd_pr__nfet_g5v0d10v5 ad=0.65 pd=3.3 as=0 ps=0 w=1 l=0.5
X7955 rr3t3r_0[29|18]/a_860_290# WL29 SL18 VSS sky130_fd_pr__nfet_g5v0d10v5 ad=0.65 pd=3.3 as=0 ps=0 w=1 l=0.5
X7956 BLP18 rr3t3r_0[30|18]/a_60_290# sky130_fd_pr_reram__reram_cell area_ox=0.0676
X7957 BLZ18 rr3t3r_0[30|18]/a_460_290# sky130_fd_pr_reram__reram_cell area_ox=0.0676
X7958 rr3t3r_0[30|18]/a_460_290# WL30 SL18 VSS sky130_fd_pr__nfet_g5v0d10v5 ad=0.65 pd=3.3 as=0 ps=0 w=1 l=0.5
X7959 BLN18 rr3t3r_0[30|18]/a_860_290# sky130_fd_pr_reram__reram_cell area_ox=0.0676
X7960 rr3t3r_0[30|18]/a_60_290# WL30 SL18 VSS sky130_fd_pr__nfet_g5v0d10v5 ad=0.65 pd=3.3 as=0 ps=0 w=1 l=0.5
X7961 rr3t3r_0[30|18]/a_860_290# WL30 SL18 VSS sky130_fd_pr__nfet_g5v0d10v5 ad=0.65 pd=3.3 as=0 ps=0 w=1 l=0.5
X7962 BLP18 rr3t3r_0[31|18]/a_60_290# sky130_fd_pr_reram__reram_cell area_ox=0.0676
X7963 BLZ18 rr3t3r_0[31|18]/a_460_290# sky130_fd_pr_reram__reram_cell area_ox=0.0676
X7964 rr3t3r_0[31|18]/a_460_290# WL31 SL18 VSS sky130_fd_pr__nfet_g5v0d10v5 ad=0.65 pd=3.3 as=0 ps=0 w=1 l=0.5
X7965 BLN18 rr3t3r_0[31|18]/a_860_290# sky130_fd_pr_reram__reram_cell area_ox=0.0676
X7966 rr3t3r_0[31|18]/a_60_290# WL31 SL18 VSS sky130_fd_pr__nfet_g5v0d10v5 ad=0.65 pd=3.3 as=0 ps=0 w=1 l=0.5
X7967 rr3t3r_0[31|18]/a_860_290# WL31 SL18 VSS sky130_fd_pr__nfet_g5v0d10v5 ad=0.65 pd=3.3 as=0 ps=0 w=1 l=0.5
X7968 BLP18 rr3t3r_0[32|18]/a_60_290# sky130_fd_pr_reram__reram_cell area_ox=0.0676
X7969 BLZ18 rr3t3r_0[32|18]/a_460_290# sky130_fd_pr_reram__reram_cell area_ox=0.0676
X7970 rr3t3r_0[32|18]/a_460_290# WL32 SL18 VSS sky130_fd_pr__nfet_g5v0d10v5 ad=0.65 pd=3.3 as=0 ps=0 w=1 l=0.5
X7971 BLN18 rr3t3r_0[32|18]/a_860_290# sky130_fd_pr_reram__reram_cell area_ox=0.0676
X7972 rr3t3r_0[32|18]/a_60_290# WL32 SL18 VSS sky130_fd_pr__nfet_g5v0d10v5 ad=0.65 pd=3.3 as=0 ps=0 w=1 l=0.5
X7973 rr3t3r_0[32|18]/a_860_290# WL32 SL18 VSS sky130_fd_pr__nfet_g5v0d10v5 ad=0.65 pd=3.3 as=0 ps=0 w=1 l=0.5
X7974 BLP18 rr3t3r_0[33|18]/a_60_290# sky130_fd_pr_reram__reram_cell area_ox=0.0676
X7975 BLZ18 rr3t3r_0[33|18]/a_460_290# sky130_fd_pr_reram__reram_cell area_ox=0.0676
X7976 rr3t3r_0[33|18]/a_460_290# WL33 SL18 VSS sky130_fd_pr__nfet_g5v0d10v5 ad=0.65 pd=3.3 as=0 ps=0 w=1 l=0.5
X7977 BLN18 rr3t3r_0[33|18]/a_860_290# sky130_fd_pr_reram__reram_cell area_ox=0.0676
X7978 rr3t3r_0[33|18]/a_60_290# WL33 SL18 VSS sky130_fd_pr__nfet_g5v0d10v5 ad=0.65 pd=3.3 as=0 ps=0 w=1 l=0.5
X7979 rr3t3r_0[33|18]/a_860_290# WL33 SL18 VSS sky130_fd_pr__nfet_g5v0d10v5 ad=0.65 pd=3.3 as=0 ps=0 w=1 l=0.5
X7980 BLP18 rr3t3r_0[34|18]/a_60_290# sky130_fd_pr_reram__reram_cell area_ox=0.0676
X7981 BLZ18 rr3t3r_0[34|18]/a_460_290# sky130_fd_pr_reram__reram_cell area_ox=0.0676
X7982 rr3t3r_0[34|18]/a_460_290# WL34 SL18 VSS sky130_fd_pr__nfet_g5v0d10v5 ad=0.65 pd=3.3 as=0 ps=0 w=1 l=0.5
X7983 BLN18 rr3t3r_0[34|18]/a_860_290# sky130_fd_pr_reram__reram_cell area_ox=0.0676
X7984 rr3t3r_0[34|18]/a_60_290# WL34 SL18 VSS sky130_fd_pr__nfet_g5v0d10v5 ad=0.65 pd=3.3 as=0 ps=0 w=1 l=0.5
X7985 rr3t3r_0[34|18]/a_860_290# WL34 SL18 VSS sky130_fd_pr__nfet_g5v0d10v5 ad=0.65 pd=3.3 as=0 ps=0 w=1 l=0.5
X7986 BLP18 rr3t3r_0[35|18]/a_60_290# sky130_fd_pr_reram__reram_cell area_ox=0.0676
X7987 BLZ18 rr3t3r_0[35|18]/a_460_290# sky130_fd_pr_reram__reram_cell area_ox=0.0676
X7988 rr3t3r_0[35|18]/a_460_290# WL35 SL18 VSS sky130_fd_pr__nfet_g5v0d10v5 ad=0.65 pd=3.3 as=0 ps=0 w=1 l=0.5
X7989 BLN18 rr3t3r_0[35|18]/a_860_290# sky130_fd_pr_reram__reram_cell area_ox=0.0676
X7990 rr3t3r_0[35|18]/a_60_290# WL35 SL18 VSS sky130_fd_pr__nfet_g5v0d10v5 ad=0.65 pd=3.3 as=0 ps=0 w=1 l=0.5
X7991 rr3t3r_0[35|18]/a_860_290# WL35 SL18 VSS sky130_fd_pr__nfet_g5v0d10v5 ad=0.65 pd=3.3 as=0 ps=0 w=1 l=0.5
X7992 BLP18 rr3t3r_0[36|18]/a_60_290# sky130_fd_pr_reram__reram_cell area_ox=0.0676
X7993 BLZ18 rr3t3r_0[36|18]/a_460_290# sky130_fd_pr_reram__reram_cell area_ox=0.0676
X7994 rr3t3r_0[36|18]/a_460_290# WL36 SL18 VSS sky130_fd_pr__nfet_g5v0d10v5 ad=0.65 pd=3.3 as=0 ps=0 w=1 l=0.5
X7995 BLN18 rr3t3r_0[36|18]/a_860_290# sky130_fd_pr_reram__reram_cell area_ox=0.0676
X7996 rr3t3r_0[36|18]/a_60_290# WL36 SL18 VSS sky130_fd_pr__nfet_g5v0d10v5 ad=0.65 pd=3.3 as=0 ps=0 w=1 l=0.5
X7997 rr3t3r_0[36|18]/a_860_290# WL36 SL18 VSS sky130_fd_pr__nfet_g5v0d10v5 ad=0.65 pd=3.3 as=0 ps=0 w=1 l=0.5
X7998 BLP18 rr3t3r_0[37|18]/a_60_290# sky130_fd_pr_reram__reram_cell area_ox=0.0676
X7999 BLZ18 rr3t3r_0[37|18]/a_460_290# sky130_fd_pr_reram__reram_cell area_ox=0.0676
X8000 rr3t3r_0[37|18]/a_460_290# WL37 SL18 VSS sky130_fd_pr__nfet_g5v0d10v5 ad=0.65 pd=3.3 as=0 ps=0 w=1 l=0.5
X8001 BLN18 rr3t3r_0[37|18]/a_860_290# sky130_fd_pr_reram__reram_cell area_ox=0.0676
X8002 rr3t3r_0[37|18]/a_60_290# WL37 SL18 VSS sky130_fd_pr__nfet_g5v0d10v5 ad=0.65 pd=3.3 as=0 ps=0 w=1 l=0.5
X8003 rr3t3r_0[37|18]/a_860_290# WL37 SL18 VSS sky130_fd_pr__nfet_g5v0d10v5 ad=0.65 pd=3.3 as=0 ps=0 w=1 l=0.5
X8004 BLP18 rr3t3r_0[38|18]/a_60_290# sky130_fd_pr_reram__reram_cell area_ox=0.0676
X8005 BLZ18 rr3t3r_0[38|18]/a_460_290# sky130_fd_pr_reram__reram_cell area_ox=0.0676
X8006 rr3t3r_0[38|18]/a_460_290# WL38 SL18 VSS sky130_fd_pr__nfet_g5v0d10v5 ad=0.65 pd=3.3 as=0 ps=0 w=1 l=0.5
X8007 BLN18 rr3t3r_0[38|18]/a_860_290# sky130_fd_pr_reram__reram_cell area_ox=0.0676
X8008 rr3t3r_0[38|18]/a_60_290# WL38 SL18 VSS sky130_fd_pr__nfet_g5v0d10v5 ad=0.65 pd=3.3 as=0 ps=0 w=1 l=0.5
X8009 rr3t3r_0[38|18]/a_860_290# WL38 SL18 VSS sky130_fd_pr__nfet_g5v0d10v5 ad=0.65 pd=3.3 as=0 ps=0 w=1 l=0.5
X8010 BLP18 rr3t3r_0[39|18]/a_60_290# sky130_fd_pr_reram__reram_cell area_ox=0.0676
X8011 BLZ18 rr3t3r_0[39|18]/a_460_290# sky130_fd_pr_reram__reram_cell area_ox=0.0676
X8012 rr3t3r_0[39|18]/a_460_290# WL39 SL18 VSS sky130_fd_pr__nfet_g5v0d10v5 ad=0.65 pd=3.3 as=0 ps=0 w=1 l=0.5
X8013 BLN18 rr3t3r_0[39|18]/a_860_290# sky130_fd_pr_reram__reram_cell area_ox=0.0676
X8014 rr3t3r_0[39|18]/a_60_290# WL39 SL18 VSS sky130_fd_pr__nfet_g5v0d10v5 ad=0.65 pd=3.3 as=0 ps=0 w=1 l=0.5
X8015 rr3t3r_0[39|18]/a_860_290# WL39 SL18 VSS sky130_fd_pr__nfet_g5v0d10v5 ad=0.65 pd=3.3 as=0 ps=0 w=1 l=0.5
X8016 BLP18 rr3t3r_0[40|18]/a_60_290# sky130_fd_pr_reram__reram_cell area_ox=0.0676
X8017 BLZ18 rr3t3r_0[40|18]/a_460_290# sky130_fd_pr_reram__reram_cell area_ox=0.0676
X8018 rr3t3r_0[40|18]/a_460_290# WL40 SL18 VSS sky130_fd_pr__nfet_g5v0d10v5 ad=0.65 pd=3.3 as=0 ps=0 w=1 l=0.5
X8019 BLN18 rr3t3r_0[40|18]/a_860_290# sky130_fd_pr_reram__reram_cell area_ox=0.0676
X8020 rr3t3r_0[40|18]/a_60_290# WL40 SL18 VSS sky130_fd_pr__nfet_g5v0d10v5 ad=0.65 pd=3.3 as=0 ps=0 w=1 l=0.5
X8021 rr3t3r_0[40|18]/a_860_290# WL40 SL18 VSS sky130_fd_pr__nfet_g5v0d10v5 ad=0.65 pd=3.3 as=0 ps=0 w=1 l=0.5
X8022 BLP18 rr3t3r_0[41|18]/a_60_290# sky130_fd_pr_reram__reram_cell area_ox=0.0676
X8023 BLZ18 rr3t3r_0[41|18]/a_460_290# sky130_fd_pr_reram__reram_cell area_ox=0.0676
X8024 rr3t3r_0[41|18]/a_460_290# WL41 SL18 VSS sky130_fd_pr__nfet_g5v0d10v5 ad=0.65 pd=3.3 as=0 ps=0 w=1 l=0.5
X8025 BLN18 rr3t3r_0[41|18]/a_860_290# sky130_fd_pr_reram__reram_cell area_ox=0.0676
X8026 rr3t3r_0[41|18]/a_60_290# WL41 SL18 VSS sky130_fd_pr__nfet_g5v0d10v5 ad=0.65 pd=3.3 as=0 ps=0 w=1 l=0.5
X8027 rr3t3r_0[41|18]/a_860_290# WL41 SL18 VSS sky130_fd_pr__nfet_g5v0d10v5 ad=0.65 pd=3.3 as=0 ps=0 w=1 l=0.5
X8028 BLP18 rr3t3r_0[42|18]/a_60_290# sky130_fd_pr_reram__reram_cell area_ox=0.0676
X8029 BLZ18 rr3t3r_0[42|18]/a_460_290# sky130_fd_pr_reram__reram_cell area_ox=0.0676
X8030 rr3t3r_0[42|18]/a_460_290# WL42 SL18 VSS sky130_fd_pr__nfet_g5v0d10v5 ad=0.65 pd=3.3 as=0 ps=0 w=1 l=0.5
X8031 BLN18 rr3t3r_0[42|18]/a_860_290# sky130_fd_pr_reram__reram_cell area_ox=0.0676
X8032 rr3t3r_0[42|18]/a_60_290# WL42 SL18 VSS sky130_fd_pr__nfet_g5v0d10v5 ad=0.65 pd=3.3 as=0 ps=0 w=1 l=0.5
X8033 rr3t3r_0[42|18]/a_860_290# WL42 SL18 VSS sky130_fd_pr__nfet_g5v0d10v5 ad=0.65 pd=3.3 as=0 ps=0 w=1 l=0.5
X8034 BLP18 rr3t3r_0[43|18]/a_60_290# sky130_fd_pr_reram__reram_cell area_ox=0.0676
X8035 BLZ18 rr3t3r_0[43|18]/a_460_290# sky130_fd_pr_reram__reram_cell area_ox=0.0676
X8036 rr3t3r_0[43|18]/a_460_290# WL43 SL18 VSS sky130_fd_pr__nfet_g5v0d10v5 ad=0.65 pd=3.3 as=0 ps=0 w=1 l=0.5
X8037 BLN18 rr3t3r_0[43|18]/a_860_290# sky130_fd_pr_reram__reram_cell area_ox=0.0676
X8038 rr3t3r_0[43|18]/a_60_290# WL43 SL18 VSS sky130_fd_pr__nfet_g5v0d10v5 ad=0.65 pd=3.3 as=0 ps=0 w=1 l=0.5
X8039 rr3t3r_0[43|18]/a_860_290# WL43 SL18 VSS sky130_fd_pr__nfet_g5v0d10v5 ad=0.65 pd=3.3 as=0 ps=0 w=1 l=0.5
X8040 BLP18 rr3t3r_0[44|18]/a_60_290# sky130_fd_pr_reram__reram_cell area_ox=0.0676
X8041 BLZ18 rr3t3r_0[44|18]/a_460_290# sky130_fd_pr_reram__reram_cell area_ox=0.0676
X8042 rr3t3r_0[44|18]/a_460_290# WL44 SL18 VSS sky130_fd_pr__nfet_g5v0d10v5 ad=0.65 pd=3.3 as=0 ps=0 w=1 l=0.5
X8043 BLN18 rr3t3r_0[44|18]/a_860_290# sky130_fd_pr_reram__reram_cell area_ox=0.0676
X8044 rr3t3r_0[44|18]/a_60_290# WL44 SL18 VSS sky130_fd_pr__nfet_g5v0d10v5 ad=0.65 pd=3.3 as=0 ps=0 w=1 l=0.5
X8045 rr3t3r_0[44|18]/a_860_290# WL44 SL18 VSS sky130_fd_pr__nfet_g5v0d10v5 ad=0.65 pd=3.3 as=0 ps=0 w=1 l=0.5
X8046 BLP18 rr3t3r_0[45|18]/a_60_290# sky130_fd_pr_reram__reram_cell area_ox=0.0676
X8047 BLZ18 rr3t3r_0[45|18]/a_460_290# sky130_fd_pr_reram__reram_cell area_ox=0.0676
X8048 rr3t3r_0[45|18]/a_460_290# WL45 SL18 VSS sky130_fd_pr__nfet_g5v0d10v5 ad=0.65 pd=3.3 as=0 ps=0 w=1 l=0.5
X8049 BLN18 rr3t3r_0[45|18]/a_860_290# sky130_fd_pr_reram__reram_cell area_ox=0.0676
X8050 rr3t3r_0[45|18]/a_60_290# WL45 SL18 VSS sky130_fd_pr__nfet_g5v0d10v5 ad=0.65 pd=3.3 as=0 ps=0 w=1 l=0.5
X8051 rr3t3r_0[45|18]/a_860_290# WL45 SL18 VSS sky130_fd_pr__nfet_g5v0d10v5 ad=0.65 pd=3.3 as=0 ps=0 w=1 l=0.5
X8052 BLP18 rr3t3r_0[46|18]/a_60_290# sky130_fd_pr_reram__reram_cell area_ox=0.0676
X8053 BLZ18 rr3t3r_0[46|18]/a_460_290# sky130_fd_pr_reram__reram_cell area_ox=0.0676
X8054 rr3t3r_0[46|18]/a_460_290# WL46 SL18 VSS sky130_fd_pr__nfet_g5v0d10v5 ad=0.65 pd=3.3 as=0 ps=0 w=1 l=0.5
X8055 BLN18 rr3t3r_0[46|18]/a_860_290# sky130_fd_pr_reram__reram_cell area_ox=0.0676
X8056 rr3t3r_0[46|18]/a_60_290# WL46 SL18 VSS sky130_fd_pr__nfet_g5v0d10v5 ad=0.65 pd=3.3 as=0 ps=0 w=1 l=0.5
X8057 rr3t3r_0[46|18]/a_860_290# WL46 SL18 VSS sky130_fd_pr__nfet_g5v0d10v5 ad=0.65 pd=3.3 as=0 ps=0 w=1 l=0.5
X8058 BLP18 rr3t3r_0[47|18]/a_60_290# sky130_fd_pr_reram__reram_cell area_ox=0.0676
X8059 BLZ18 rr3t3r_0[47|18]/a_460_290# sky130_fd_pr_reram__reram_cell area_ox=0.0676
X8060 rr3t3r_0[47|18]/a_460_290# WL47 SL18 VSS sky130_fd_pr__nfet_g5v0d10v5 ad=0.65 pd=3.3 as=0 ps=0 w=1 l=0.5
X8061 BLN18 rr3t3r_0[47|18]/a_860_290# sky130_fd_pr_reram__reram_cell area_ox=0.0676
X8062 rr3t3r_0[47|18]/a_60_290# WL47 SL18 VSS sky130_fd_pr__nfet_g5v0d10v5 ad=0.65 pd=3.3 as=0 ps=0 w=1 l=0.5
X8063 rr3t3r_0[47|18]/a_860_290# WL47 SL18 VSS sky130_fd_pr__nfet_g5v0d10v5 ad=0.65 pd=3.3 as=0 ps=0 w=1 l=0.5
X8064 BLP18 rr3t3r_0[48|18]/a_60_290# sky130_fd_pr_reram__reram_cell area_ox=0.0676
X8065 BLZ18 rr3t3r_0[48|18]/a_460_290# sky130_fd_pr_reram__reram_cell area_ox=0.0676
X8066 rr3t3r_0[48|18]/a_460_290# WL48 SL18 VSS sky130_fd_pr__nfet_g5v0d10v5 ad=0.65 pd=3.3 as=0 ps=0 w=1 l=0.5
X8067 BLN18 rr3t3r_0[48|18]/a_860_290# sky130_fd_pr_reram__reram_cell area_ox=0.0676
X8068 rr3t3r_0[48|18]/a_60_290# WL48 SL18 VSS sky130_fd_pr__nfet_g5v0d10v5 ad=0.65 pd=3.3 as=0 ps=0 w=1 l=0.5
X8069 rr3t3r_0[48|18]/a_860_290# WL48 SL18 VSS sky130_fd_pr__nfet_g5v0d10v5 ad=0.65 pd=3.3 as=0 ps=0 w=1 l=0.5
X8070 BLP18 rr3t3r_0[49|18]/a_60_290# sky130_fd_pr_reram__reram_cell area_ox=0.0676
X8071 BLZ18 rr3t3r_0[49|18]/a_460_290# sky130_fd_pr_reram__reram_cell area_ox=0.0676
X8072 rr3t3r_0[49|18]/a_460_290# WL49 SL18 VSS sky130_fd_pr__nfet_g5v0d10v5 ad=0.65 pd=3.3 as=0 ps=0 w=1 l=0.5
X8073 BLN18 rr3t3r_0[49|18]/a_860_290# sky130_fd_pr_reram__reram_cell area_ox=0.0676
X8074 rr3t3r_0[49|18]/a_60_290# WL49 SL18 VSS sky130_fd_pr__nfet_g5v0d10v5 ad=0.65 pd=3.3 as=0 ps=0 w=1 l=0.5
X8075 rr3t3r_0[49|18]/a_860_290# WL49 SL18 VSS sky130_fd_pr__nfet_g5v0d10v5 ad=0.65 pd=3.3 as=0 ps=0 w=1 l=0.5
X8076 BLP18 rr3t3r_0[50|18]/a_60_290# sky130_fd_pr_reram__reram_cell area_ox=0.0676
X8077 BLZ18 rr3t3r_0[50|18]/a_460_290# sky130_fd_pr_reram__reram_cell area_ox=0.0676
X8078 rr3t3r_0[50|18]/a_460_290# WL50 SL18 VSS sky130_fd_pr__nfet_g5v0d10v5 ad=0.65 pd=3.3 as=0 ps=0 w=1 l=0.5
X8079 BLN18 rr3t3r_0[50|18]/a_860_290# sky130_fd_pr_reram__reram_cell area_ox=0.0676
X8080 rr3t3r_0[50|18]/a_60_290# WL50 SL18 VSS sky130_fd_pr__nfet_g5v0d10v5 ad=0.65 pd=3.3 as=0 ps=0 w=1 l=0.5
X8081 rr3t3r_0[50|18]/a_860_290# WL50 SL18 VSS sky130_fd_pr__nfet_g5v0d10v5 ad=0.65 pd=3.3 as=0 ps=0 w=1 l=0.5
X8082 BLP18 rr3t3r_0[51|18]/a_60_290# sky130_fd_pr_reram__reram_cell area_ox=0.0676
X8083 BLZ18 rr3t3r_0[51|18]/a_460_290# sky130_fd_pr_reram__reram_cell area_ox=0.0676
X8084 rr3t3r_0[51|18]/a_460_290# WL51 SL18 VSS sky130_fd_pr__nfet_g5v0d10v5 ad=0.65 pd=3.3 as=0 ps=0 w=1 l=0.5
X8085 BLN18 rr3t3r_0[51|18]/a_860_290# sky130_fd_pr_reram__reram_cell area_ox=0.0676
X8086 rr3t3r_0[51|18]/a_60_290# WL51 SL18 VSS sky130_fd_pr__nfet_g5v0d10v5 ad=0.65 pd=3.3 as=0 ps=0 w=1 l=0.5
X8087 rr3t3r_0[51|18]/a_860_290# WL51 SL18 VSS sky130_fd_pr__nfet_g5v0d10v5 ad=0.65 pd=3.3 as=0 ps=0 w=1 l=0.5
X8088 BLP18 rr3t3r_0[52|18]/a_60_290# sky130_fd_pr_reram__reram_cell area_ox=0.0676
X8089 BLZ18 rr3t3r_0[52|18]/a_460_290# sky130_fd_pr_reram__reram_cell area_ox=0.0676
X8090 rr3t3r_0[52|18]/a_460_290# WL52 SL18 VSS sky130_fd_pr__nfet_g5v0d10v5 ad=0.65 pd=3.3 as=0 ps=0 w=1 l=0.5
X8091 BLN18 rr3t3r_0[52|18]/a_860_290# sky130_fd_pr_reram__reram_cell area_ox=0.0676
X8092 rr3t3r_0[52|18]/a_60_290# WL52 SL18 VSS sky130_fd_pr__nfet_g5v0d10v5 ad=0.65 pd=3.3 as=0 ps=0 w=1 l=0.5
X8093 rr3t3r_0[52|18]/a_860_290# WL52 SL18 VSS sky130_fd_pr__nfet_g5v0d10v5 ad=0.65 pd=3.3 as=0 ps=0 w=1 l=0.5
X8094 BLP18 rr3t3r_0[53|18]/a_60_290# sky130_fd_pr_reram__reram_cell area_ox=0.0676
X8095 BLZ18 rr3t3r_0[53|18]/a_460_290# sky130_fd_pr_reram__reram_cell area_ox=0.0676
X8096 rr3t3r_0[53|18]/a_460_290# WL53 SL18 VSS sky130_fd_pr__nfet_g5v0d10v5 ad=0.65 pd=3.3 as=0 ps=0 w=1 l=0.5
X8097 BLN18 rr3t3r_0[53|18]/a_860_290# sky130_fd_pr_reram__reram_cell area_ox=0.0676
X8098 rr3t3r_0[53|18]/a_60_290# WL53 SL18 VSS sky130_fd_pr__nfet_g5v0d10v5 ad=0.65 pd=3.3 as=0 ps=0 w=1 l=0.5
X8099 rr3t3r_0[53|18]/a_860_290# WL53 SL18 VSS sky130_fd_pr__nfet_g5v0d10v5 ad=0.65 pd=3.3 as=0 ps=0 w=1 l=0.5
X8100 BLP18 rr3t3r_0[54|18]/a_60_290# sky130_fd_pr_reram__reram_cell area_ox=0.0676
X8101 BLZ18 rr3t3r_0[54|18]/a_460_290# sky130_fd_pr_reram__reram_cell area_ox=0.0676
X8102 rr3t3r_0[54|18]/a_460_290# WL54 SL18 VSS sky130_fd_pr__nfet_g5v0d10v5 ad=0.65 pd=3.3 as=0 ps=0 w=1 l=0.5
X8103 BLN18 rr3t3r_0[54|18]/a_860_290# sky130_fd_pr_reram__reram_cell area_ox=0.0676
X8104 rr3t3r_0[54|18]/a_60_290# WL54 SL18 VSS sky130_fd_pr__nfet_g5v0d10v5 ad=0.65 pd=3.3 as=0 ps=0 w=1 l=0.5
X8105 rr3t3r_0[54|18]/a_860_290# WL54 SL18 VSS sky130_fd_pr__nfet_g5v0d10v5 ad=0.65 pd=3.3 as=0 ps=0 w=1 l=0.5
X8106 BLP18 rr3t3r_0[55|18]/a_60_290# sky130_fd_pr_reram__reram_cell area_ox=0.0676
X8107 BLZ18 rr3t3r_0[55|18]/a_460_290# sky130_fd_pr_reram__reram_cell area_ox=0.0676
X8108 rr3t3r_0[55|18]/a_460_290# WL55 SL18 VSS sky130_fd_pr__nfet_g5v0d10v5 ad=0.65 pd=3.3 as=0 ps=0 w=1 l=0.5
X8109 BLN18 rr3t3r_0[55|18]/a_860_290# sky130_fd_pr_reram__reram_cell area_ox=0.0676
X8110 rr3t3r_0[55|18]/a_60_290# WL55 SL18 VSS sky130_fd_pr__nfet_g5v0d10v5 ad=0.65 pd=3.3 as=0 ps=0 w=1 l=0.5
X8111 rr3t3r_0[55|18]/a_860_290# WL55 SL18 VSS sky130_fd_pr__nfet_g5v0d10v5 ad=0.65 pd=3.3 as=0 ps=0 w=1 l=0.5
X8112 BLP18 rr3t3r_0[56|18]/a_60_290# sky130_fd_pr_reram__reram_cell area_ox=0.0676
X8113 BLZ18 rr3t3r_0[56|18]/a_460_290# sky130_fd_pr_reram__reram_cell area_ox=0.0676
X8114 rr3t3r_0[56|18]/a_460_290# WL56 SL18 VSS sky130_fd_pr__nfet_g5v0d10v5 ad=0.65 pd=3.3 as=0 ps=0 w=1 l=0.5
X8115 BLN18 rr3t3r_0[56|18]/a_860_290# sky130_fd_pr_reram__reram_cell area_ox=0.0676
X8116 rr3t3r_0[56|18]/a_60_290# WL56 SL18 VSS sky130_fd_pr__nfet_g5v0d10v5 ad=0.65 pd=3.3 as=0 ps=0 w=1 l=0.5
X8117 rr3t3r_0[56|18]/a_860_290# WL56 SL18 VSS sky130_fd_pr__nfet_g5v0d10v5 ad=0.65 pd=3.3 as=0 ps=0 w=1 l=0.5
X8118 BLP18 rr3t3r_0[57|18]/a_60_290# sky130_fd_pr_reram__reram_cell area_ox=0.0676
X8119 BLZ18 rr3t3r_0[57|18]/a_460_290# sky130_fd_pr_reram__reram_cell area_ox=0.0676
X8120 rr3t3r_0[57|18]/a_460_290# WL57 SL18 VSS sky130_fd_pr__nfet_g5v0d10v5 ad=0.65 pd=3.3 as=0 ps=0 w=1 l=0.5
X8121 BLN18 rr3t3r_0[57|18]/a_860_290# sky130_fd_pr_reram__reram_cell area_ox=0.0676
X8122 rr3t3r_0[57|18]/a_60_290# WL57 SL18 VSS sky130_fd_pr__nfet_g5v0d10v5 ad=0.65 pd=3.3 as=0 ps=0 w=1 l=0.5
X8123 rr3t3r_0[57|18]/a_860_290# WL57 SL18 VSS sky130_fd_pr__nfet_g5v0d10v5 ad=0.65 pd=3.3 as=0 ps=0 w=1 l=0.5
X8124 BLP18 rr3t3r_0[58|18]/a_60_290# sky130_fd_pr_reram__reram_cell area_ox=0.0676
X8125 BLZ18 rr3t3r_0[58|18]/a_460_290# sky130_fd_pr_reram__reram_cell area_ox=0.0676
X8126 rr3t3r_0[58|18]/a_460_290# WL58 SL18 VSS sky130_fd_pr__nfet_g5v0d10v5 ad=0.65 pd=3.3 as=0 ps=0 w=1 l=0.5
X8127 BLN18 rr3t3r_0[58|18]/a_860_290# sky130_fd_pr_reram__reram_cell area_ox=0.0676
X8128 rr3t3r_0[58|18]/a_60_290# WL58 SL18 VSS sky130_fd_pr__nfet_g5v0d10v5 ad=0.65 pd=3.3 as=0 ps=0 w=1 l=0.5
X8129 rr3t3r_0[58|18]/a_860_290# WL58 SL18 VSS sky130_fd_pr__nfet_g5v0d10v5 ad=0.65 pd=3.3 as=0 ps=0 w=1 l=0.5
X8130 BLP18 rr3t3r_0[59|18]/a_60_290# sky130_fd_pr_reram__reram_cell area_ox=0.0676
X8131 BLZ18 rr3t3r_0[59|18]/a_460_290# sky130_fd_pr_reram__reram_cell area_ox=0.0676
X8132 rr3t3r_0[59|18]/a_460_290# WL59 SL18 VSS sky130_fd_pr__nfet_g5v0d10v5 ad=0.65 pd=3.3 as=0 ps=0 w=1 l=0.5
X8133 BLN18 rr3t3r_0[59|18]/a_860_290# sky130_fd_pr_reram__reram_cell area_ox=0.0676
X8134 rr3t3r_0[59|18]/a_60_290# WL59 SL18 VSS sky130_fd_pr__nfet_g5v0d10v5 ad=0.65 pd=3.3 as=0 ps=0 w=1 l=0.5
X8135 rr3t3r_0[59|18]/a_860_290# WL59 SL18 VSS sky130_fd_pr__nfet_g5v0d10v5 ad=0.65 pd=3.3 as=0 ps=0 w=1 l=0.5
X8136 BLP18 rr3t3r_0[60|18]/a_60_290# sky130_fd_pr_reram__reram_cell area_ox=0.0676
X8137 BLZ18 rr3t3r_0[60|18]/a_460_290# sky130_fd_pr_reram__reram_cell area_ox=0.0676
X8138 rr3t3r_0[60|18]/a_460_290# WL60 SL18 VSS sky130_fd_pr__nfet_g5v0d10v5 ad=0.65 pd=3.3 as=0 ps=0 w=1 l=0.5
X8139 BLN18 rr3t3r_0[60|18]/a_860_290# sky130_fd_pr_reram__reram_cell area_ox=0.0676
X8140 rr3t3r_0[60|18]/a_60_290# WL60 SL18 VSS sky130_fd_pr__nfet_g5v0d10v5 ad=0.65 pd=3.3 as=0 ps=0 w=1 l=0.5
X8141 rr3t3r_0[60|18]/a_860_290# WL60 SL18 VSS sky130_fd_pr__nfet_g5v0d10v5 ad=0.65 pd=3.3 as=0 ps=0 w=1 l=0.5
X8142 BLP18 rr3t3r_0[61|18]/a_60_290# sky130_fd_pr_reram__reram_cell area_ox=0.0676
X8143 BLZ18 rr3t3r_0[61|18]/a_460_290# sky130_fd_pr_reram__reram_cell area_ox=0.0676
X8144 rr3t3r_0[61|18]/a_460_290# WL61 SL18 VSS sky130_fd_pr__nfet_g5v0d10v5 ad=0.65 pd=3.3 as=0 ps=0 w=1 l=0.5
X8145 BLN18 rr3t3r_0[61|18]/a_860_290# sky130_fd_pr_reram__reram_cell area_ox=0.0676
X8146 rr3t3r_0[61|18]/a_60_290# WL61 SL18 VSS sky130_fd_pr__nfet_g5v0d10v5 ad=0.65 pd=3.3 as=0 ps=0 w=1 l=0.5
X8147 rr3t3r_0[61|18]/a_860_290# WL61 SL18 VSS sky130_fd_pr__nfet_g5v0d10v5 ad=0.65 pd=3.3 as=0 ps=0 w=1 l=0.5
X8148 BLP18 rr3t3r_0[62|18]/a_60_290# sky130_fd_pr_reram__reram_cell area_ox=0.0676
X8149 BLZ18 rr3t3r_0[62|18]/a_460_290# sky130_fd_pr_reram__reram_cell area_ox=0.0676
X8150 rr3t3r_0[62|18]/a_460_290# WL62 SL18 VSS sky130_fd_pr__nfet_g5v0d10v5 ad=0.65 pd=3.3 as=0 ps=0 w=1 l=0.5
X8151 BLN18 rr3t3r_0[62|18]/a_860_290# sky130_fd_pr_reram__reram_cell area_ox=0.0676
X8152 rr3t3r_0[62|18]/a_60_290# WL62 SL18 VSS sky130_fd_pr__nfet_g5v0d10v5 ad=0.65 pd=3.3 as=0 ps=0 w=1 l=0.5
X8153 rr3t3r_0[62|18]/a_860_290# WL62 SL18 VSS sky130_fd_pr__nfet_g5v0d10v5 ad=0.65 pd=3.3 as=0 ps=0 w=1 l=0.5
X8154 BLP18 rr3t3r_0[63|18]/a_60_290# sky130_fd_pr_reram__reram_cell area_ox=0.0676
X8155 BLZ18 rr3t3r_0[63|18]/a_460_290# sky130_fd_pr_reram__reram_cell area_ox=0.0676
X8156 rr3t3r_0[63|18]/a_460_290# WL63 SL18 VSS sky130_fd_pr__nfet_g5v0d10v5 ad=0.65 pd=3.3 as=0 ps=0 w=1 l=0.5
X8157 BLN18 rr3t3r_0[63|18]/a_860_290# sky130_fd_pr_reram__reram_cell area_ox=0.0676
X8158 rr3t3r_0[63|18]/a_60_290# WL63 SL18 VSS sky130_fd_pr__nfet_g5v0d10v5 ad=0.65 pd=3.3 as=0 ps=0 w=1 l=0.5
X8159 rr3t3r_0[63|18]/a_860_290# WL63 SL18 VSS sky130_fd_pr__nfet_g5v0d10v5 ad=0.65 pd=3.3 as=0 ps=0 w=1 l=0.5
X8160 BLP18 rr3t3r_0[64|18]/a_60_290# sky130_fd_pr_reram__reram_cell area_ox=0.0676
X8161 BLZ18 rr3t3r_0[64|18]/a_460_290# sky130_fd_pr_reram__reram_cell area_ox=0.0676
X8162 rr3t3r_0[64|18]/a_460_290# WL64 SL18 VSS sky130_fd_pr__nfet_g5v0d10v5 ad=0.65 pd=3.3 as=0 ps=0 w=1 l=0.5
X8163 BLN18 rr3t3r_0[64|18]/a_860_290# sky130_fd_pr_reram__reram_cell area_ox=0.0676
X8164 rr3t3r_0[64|18]/a_60_290# WL64 SL18 VSS sky130_fd_pr__nfet_g5v0d10v5 ad=0.65 pd=3.3 as=0 ps=0 w=1 l=0.5
X8165 rr3t3r_0[64|18]/a_860_290# WL64 SL18 VSS sky130_fd_pr__nfet_g5v0d10v5 ad=0.65 pd=3.3 as=0 ps=0 w=1 l=0.5
X8166 BLP18 rr3t3r_0[65|18]/a_60_290# sky130_fd_pr_reram__reram_cell area_ox=0.0676
X8167 BLZ18 rr3t3r_0[65|18]/a_460_290# sky130_fd_pr_reram__reram_cell area_ox=0.0676
X8168 rr3t3r_0[65|18]/a_460_290# WL65 SL18 VSS sky130_fd_pr__nfet_g5v0d10v5 ad=0.65 pd=3.3 as=0 ps=0 w=1 l=0.5
X8169 BLN18 rr3t3r_0[65|18]/a_860_290# sky130_fd_pr_reram__reram_cell area_ox=0.0676
X8170 rr3t3r_0[65|18]/a_60_290# WL65 SL18 VSS sky130_fd_pr__nfet_g5v0d10v5 ad=0.65 pd=3.3 as=0 ps=0 w=1 l=0.5
X8171 rr3t3r_0[65|18]/a_860_290# WL65 SL18 VSS sky130_fd_pr__nfet_g5v0d10v5 ad=0.65 pd=3.3 as=0 ps=0 w=1 l=0.5
X8172 BLP18 rr3t3r_0[66|18]/a_60_290# sky130_fd_pr_reram__reram_cell area_ox=0.0676
X8173 BLZ18 rr3t3r_0[66|18]/a_460_290# sky130_fd_pr_reram__reram_cell area_ox=0.0676
X8174 rr3t3r_0[66|18]/a_460_290# WL66 SL18 VSS sky130_fd_pr__nfet_g5v0d10v5 ad=0.65 pd=3.3 as=0 ps=0 w=1 l=0.5
X8175 BLN18 rr3t3r_0[66|18]/a_860_290# sky130_fd_pr_reram__reram_cell area_ox=0.0676
X8176 rr3t3r_0[66|18]/a_60_290# WL66 SL18 VSS sky130_fd_pr__nfet_g5v0d10v5 ad=0.65 pd=3.3 as=0 ps=0 w=1 l=0.5
X8177 rr3t3r_0[66|18]/a_860_290# WL66 SL18 VSS sky130_fd_pr__nfet_g5v0d10v5 ad=0.65 pd=3.3 as=0 ps=0 w=1 l=0.5
X8178 BLP18 rr3t3r_0[67|18]/a_60_290# sky130_fd_pr_reram__reram_cell area_ox=0.0676
X8179 BLZ18 rr3t3r_0[67|18]/a_460_290# sky130_fd_pr_reram__reram_cell area_ox=0.0676
X8180 rr3t3r_0[67|18]/a_460_290# WL67 SL18 VSS sky130_fd_pr__nfet_g5v0d10v5 ad=0.65 pd=3.3 as=0 ps=0 w=1 l=0.5
X8181 BLN18 rr3t3r_0[67|18]/a_860_290# sky130_fd_pr_reram__reram_cell area_ox=0.0676
X8182 rr3t3r_0[67|18]/a_60_290# WL67 SL18 VSS sky130_fd_pr__nfet_g5v0d10v5 ad=0.65 pd=3.3 as=0 ps=0 w=1 l=0.5
X8183 rr3t3r_0[67|18]/a_860_290# WL67 SL18 VSS sky130_fd_pr__nfet_g5v0d10v5 ad=0.65 pd=3.3 as=0 ps=0 w=1 l=0.5
X8184 BLP18 rr3t3r_0[68|18]/a_60_290# sky130_fd_pr_reram__reram_cell area_ox=0.0676
X8185 BLZ18 rr3t3r_0[68|18]/a_460_290# sky130_fd_pr_reram__reram_cell area_ox=0.0676
X8186 rr3t3r_0[68|18]/a_460_290# WL68 SL18 VSS sky130_fd_pr__nfet_g5v0d10v5 ad=0.65 pd=3.3 as=0 ps=0 w=1 l=0.5
X8187 BLN18 rr3t3r_0[68|18]/a_860_290# sky130_fd_pr_reram__reram_cell area_ox=0.0676
X8188 rr3t3r_0[68|18]/a_60_290# WL68 SL18 VSS sky130_fd_pr__nfet_g5v0d10v5 ad=0.65 pd=3.3 as=0 ps=0 w=1 l=0.5
X8189 rr3t3r_0[68|18]/a_860_290# WL68 SL18 VSS sky130_fd_pr__nfet_g5v0d10v5 ad=0.65 pd=3.3 as=0 ps=0 w=1 l=0.5
X8190 BLP18 rr3t3r_0[69|18]/a_60_290# sky130_fd_pr_reram__reram_cell area_ox=0.0676
X8191 BLZ18 rr3t3r_0[69|18]/a_460_290# sky130_fd_pr_reram__reram_cell area_ox=0.0676
X8192 rr3t3r_0[69|18]/a_460_290# WL69 SL18 VSS sky130_fd_pr__nfet_g5v0d10v5 ad=0.65 pd=3.3 as=0 ps=0 w=1 l=0.5
X8193 BLN18 rr3t3r_0[69|18]/a_860_290# sky130_fd_pr_reram__reram_cell area_ox=0.0676
X8194 rr3t3r_0[69|18]/a_60_290# WL69 SL18 VSS sky130_fd_pr__nfet_g5v0d10v5 ad=0.65 pd=3.3 as=0 ps=0 w=1 l=0.5
X8195 rr3t3r_0[69|18]/a_860_290# WL69 SL18 VSS sky130_fd_pr__nfet_g5v0d10v5 ad=0.65 pd=3.3 as=0 ps=0 w=1 l=0.5
X8196 BLP18 rr3t3r_0[70|18]/a_60_290# sky130_fd_pr_reram__reram_cell area_ox=0.0676
X8197 BLZ18 rr3t3r_0[70|18]/a_460_290# sky130_fd_pr_reram__reram_cell area_ox=0.0676
X8198 rr3t3r_0[70|18]/a_460_290# WL70 SL18 VSS sky130_fd_pr__nfet_g5v0d10v5 ad=0.65 pd=3.3 as=0 ps=0 w=1 l=0.5
X8199 BLN18 rr3t3r_0[70|18]/a_860_290# sky130_fd_pr_reram__reram_cell area_ox=0.0676
X8200 rr3t3r_0[70|18]/a_60_290# WL70 SL18 VSS sky130_fd_pr__nfet_g5v0d10v5 ad=0.65 pd=3.3 as=0 ps=0 w=1 l=0.5
X8201 rr3t3r_0[70|18]/a_860_290# WL70 SL18 VSS sky130_fd_pr__nfet_g5v0d10v5 ad=0.65 pd=3.3 as=0 ps=0 w=1 l=0.5
X8202 BLP18 rr3t3r_0[71|18]/a_60_290# sky130_fd_pr_reram__reram_cell area_ox=0.0676
X8203 BLZ18 rr3t3r_0[71|18]/a_460_290# sky130_fd_pr_reram__reram_cell area_ox=0.0676
X8204 rr3t3r_0[71|18]/a_460_290# WL71 SL18 VSS sky130_fd_pr__nfet_g5v0d10v5 ad=0.65 pd=3.3 as=0 ps=0 w=1 l=0.5
X8205 BLN18 rr3t3r_0[71|18]/a_860_290# sky130_fd_pr_reram__reram_cell area_ox=0.0676
X8206 rr3t3r_0[71|18]/a_60_290# WL71 SL18 VSS sky130_fd_pr__nfet_g5v0d10v5 ad=0.65 pd=3.3 as=0 ps=0 w=1 l=0.5
X8207 rr3t3r_0[71|18]/a_860_290# WL71 SL18 VSS sky130_fd_pr__nfet_g5v0d10v5 ad=0.65 pd=3.3 as=0 ps=0 w=1 l=0.5
X8208 BLP19 rr3t3r_0[0|19]/a_60_290# sky130_fd_pr_reram__reram_cell area_ox=0.0676
X8209 BLZ19 rr3t3r_0[0|19]/a_460_290# sky130_fd_pr_reram__reram_cell area_ox=0.0676
X8210 rr3t3r_0[0|19]/a_460_290# WL0 SL19 VSS sky130_fd_pr__nfet_g5v0d10v5 ad=0.65 pd=3.3 as=162 ps=756 w=1 l=0.5
X8211 BLN19 rr3t3r_0[0|19]/a_860_290# sky130_fd_pr_reram__reram_cell area_ox=0.0676
X8212 rr3t3r_0[0|19]/a_60_290# WL0 SL19 VSS sky130_fd_pr__nfet_g5v0d10v5 ad=0.65 pd=3.3 as=0 ps=0 w=1 l=0.5
X8213 rr3t3r_0[0|19]/a_860_290# WL0 SL19 VSS sky130_fd_pr__nfet_g5v0d10v5 ad=0.65 pd=3.3 as=0 ps=0 w=1 l=0.5
X8214 BLP19 rr3t3r_0[1|19]/a_60_290# sky130_fd_pr_reram__reram_cell area_ox=0.0676
X8215 BLZ19 rr3t3r_0[1|19]/a_460_290# sky130_fd_pr_reram__reram_cell area_ox=0.0676
X8216 rr3t3r_0[1|19]/a_460_290# WL1 SL19 VSS sky130_fd_pr__nfet_g5v0d10v5 ad=0.65 pd=3.3 as=0 ps=0 w=1 l=0.5
X8217 BLN19 rr3t3r_0[1|19]/a_860_290# sky130_fd_pr_reram__reram_cell area_ox=0.0676
X8218 rr3t3r_0[1|19]/a_60_290# WL1 SL19 VSS sky130_fd_pr__nfet_g5v0d10v5 ad=0.65 pd=3.3 as=0 ps=0 w=1 l=0.5
X8219 rr3t3r_0[1|19]/a_860_290# WL1 SL19 VSS sky130_fd_pr__nfet_g5v0d10v5 ad=0.65 pd=3.3 as=0 ps=0 w=1 l=0.5
X8220 BLP19 rr3t3r_0[2|19]/a_60_290# sky130_fd_pr_reram__reram_cell area_ox=0.0676
X8221 BLZ19 rr3t3r_0[2|19]/a_460_290# sky130_fd_pr_reram__reram_cell area_ox=0.0676
X8222 rr3t3r_0[2|19]/a_460_290# WL2 SL19 VSS sky130_fd_pr__nfet_g5v0d10v5 ad=0.65 pd=3.3 as=0 ps=0 w=1 l=0.5
X8223 BLN19 rr3t3r_0[2|19]/a_860_290# sky130_fd_pr_reram__reram_cell area_ox=0.0676
X8224 rr3t3r_0[2|19]/a_60_290# WL2 SL19 VSS sky130_fd_pr__nfet_g5v0d10v5 ad=0.65 pd=3.3 as=0 ps=0 w=1 l=0.5
X8225 rr3t3r_0[2|19]/a_860_290# WL2 SL19 VSS sky130_fd_pr__nfet_g5v0d10v5 ad=0.65 pd=3.3 as=0 ps=0 w=1 l=0.5
X8226 BLP19 rr3t3r_0[3|19]/a_60_290# sky130_fd_pr_reram__reram_cell area_ox=0.0676
X8227 BLZ19 rr3t3r_0[3|19]/a_460_290# sky130_fd_pr_reram__reram_cell area_ox=0.0676
X8228 rr3t3r_0[3|19]/a_460_290# WL3 SL19 VSS sky130_fd_pr__nfet_g5v0d10v5 ad=0.65 pd=3.3 as=0 ps=0 w=1 l=0.5
X8229 BLN19 rr3t3r_0[3|19]/a_860_290# sky130_fd_pr_reram__reram_cell area_ox=0.0676
X8230 rr3t3r_0[3|19]/a_60_290# WL3 SL19 VSS sky130_fd_pr__nfet_g5v0d10v5 ad=0.65 pd=3.3 as=0 ps=0 w=1 l=0.5
X8231 rr3t3r_0[3|19]/a_860_290# WL3 SL19 VSS sky130_fd_pr__nfet_g5v0d10v5 ad=0.65 pd=3.3 as=0 ps=0 w=1 l=0.5
X8232 BLP19 rr3t3r_0[4|19]/a_60_290# sky130_fd_pr_reram__reram_cell area_ox=0.0676
X8233 BLZ19 rr3t3r_0[4|19]/a_460_290# sky130_fd_pr_reram__reram_cell area_ox=0.0676
X8234 rr3t3r_0[4|19]/a_460_290# WL4 SL19 VSS sky130_fd_pr__nfet_g5v0d10v5 ad=0.65 pd=3.3 as=0 ps=0 w=1 l=0.5
X8235 BLN19 rr3t3r_0[4|19]/a_860_290# sky130_fd_pr_reram__reram_cell area_ox=0.0676
X8236 rr3t3r_0[4|19]/a_60_290# WL4 SL19 VSS sky130_fd_pr__nfet_g5v0d10v5 ad=0.65 pd=3.3 as=0 ps=0 w=1 l=0.5
X8237 rr3t3r_0[4|19]/a_860_290# WL4 SL19 VSS sky130_fd_pr__nfet_g5v0d10v5 ad=0.65 pd=3.3 as=0 ps=0 w=1 l=0.5
X8238 BLP19 rr3t3r_0[5|19]/a_60_290# sky130_fd_pr_reram__reram_cell area_ox=0.0676
X8239 BLZ19 rr3t3r_0[5|19]/a_460_290# sky130_fd_pr_reram__reram_cell area_ox=0.0676
X8240 rr3t3r_0[5|19]/a_460_290# WL5 SL19 VSS sky130_fd_pr__nfet_g5v0d10v5 ad=0.65 pd=3.3 as=0 ps=0 w=1 l=0.5
X8241 BLN19 rr3t3r_0[5|19]/a_860_290# sky130_fd_pr_reram__reram_cell area_ox=0.0676
X8242 rr3t3r_0[5|19]/a_60_290# WL5 SL19 VSS sky130_fd_pr__nfet_g5v0d10v5 ad=0.65 pd=3.3 as=0 ps=0 w=1 l=0.5
X8243 rr3t3r_0[5|19]/a_860_290# WL5 SL19 VSS sky130_fd_pr__nfet_g5v0d10v5 ad=0.65 pd=3.3 as=0 ps=0 w=1 l=0.5
X8244 BLP19 rr3t3r_0[6|19]/a_60_290# sky130_fd_pr_reram__reram_cell area_ox=0.0676
X8245 BLZ19 rr3t3r_0[6|19]/a_460_290# sky130_fd_pr_reram__reram_cell area_ox=0.0676
X8246 rr3t3r_0[6|19]/a_460_290# WL6 SL19 VSS sky130_fd_pr__nfet_g5v0d10v5 ad=0.65 pd=3.3 as=0 ps=0 w=1 l=0.5
X8247 BLN19 rr3t3r_0[6|19]/a_860_290# sky130_fd_pr_reram__reram_cell area_ox=0.0676
X8248 rr3t3r_0[6|19]/a_60_290# WL6 SL19 VSS sky130_fd_pr__nfet_g5v0d10v5 ad=0.65 pd=3.3 as=0 ps=0 w=1 l=0.5
X8249 rr3t3r_0[6|19]/a_860_290# WL6 SL19 VSS sky130_fd_pr__nfet_g5v0d10v5 ad=0.65 pd=3.3 as=0 ps=0 w=1 l=0.5
X8250 BLP19 rr3t3r_0[7|19]/a_60_290# sky130_fd_pr_reram__reram_cell area_ox=0.0676
X8251 BLZ19 rr3t3r_0[7|19]/a_460_290# sky130_fd_pr_reram__reram_cell area_ox=0.0676
X8252 rr3t3r_0[7|19]/a_460_290# WL7 SL19 VSS sky130_fd_pr__nfet_g5v0d10v5 ad=0.65 pd=3.3 as=0 ps=0 w=1 l=0.5
X8253 BLN19 rr3t3r_0[7|19]/a_860_290# sky130_fd_pr_reram__reram_cell area_ox=0.0676
X8254 rr3t3r_0[7|19]/a_60_290# WL7 SL19 VSS sky130_fd_pr__nfet_g5v0d10v5 ad=0.65 pd=3.3 as=0 ps=0 w=1 l=0.5
X8255 rr3t3r_0[7|19]/a_860_290# WL7 SL19 VSS sky130_fd_pr__nfet_g5v0d10v5 ad=0.65 pd=3.3 as=0 ps=0 w=1 l=0.5
X8256 BLP19 rr3t3r_0[8|19]/a_60_290# sky130_fd_pr_reram__reram_cell area_ox=0.0676
X8257 BLZ19 rr3t3r_0[8|19]/a_460_290# sky130_fd_pr_reram__reram_cell area_ox=0.0676
X8258 rr3t3r_0[8|19]/a_460_290# WL8 SL19 VSS sky130_fd_pr__nfet_g5v0d10v5 ad=0.65 pd=3.3 as=0 ps=0 w=1 l=0.5
X8259 BLN19 rr3t3r_0[8|19]/a_860_290# sky130_fd_pr_reram__reram_cell area_ox=0.0676
X8260 rr3t3r_0[8|19]/a_60_290# WL8 SL19 VSS sky130_fd_pr__nfet_g5v0d10v5 ad=0.65 pd=3.3 as=0 ps=0 w=1 l=0.5
X8261 rr3t3r_0[8|19]/a_860_290# WL8 SL19 VSS sky130_fd_pr__nfet_g5v0d10v5 ad=0.65 pd=3.3 as=0 ps=0 w=1 l=0.5
X8262 BLP19 rr3t3r_0[9|19]/a_60_290# sky130_fd_pr_reram__reram_cell area_ox=0.0676
X8263 BLZ19 rr3t3r_0[9|19]/a_460_290# sky130_fd_pr_reram__reram_cell area_ox=0.0676
X8264 rr3t3r_0[9|19]/a_460_290# WL9 SL19 VSS sky130_fd_pr__nfet_g5v0d10v5 ad=0.65 pd=3.3 as=0 ps=0 w=1 l=0.5
X8265 BLN19 rr3t3r_0[9|19]/a_860_290# sky130_fd_pr_reram__reram_cell area_ox=0.0676
X8266 rr3t3r_0[9|19]/a_60_290# WL9 SL19 VSS sky130_fd_pr__nfet_g5v0d10v5 ad=0.65 pd=3.3 as=0 ps=0 w=1 l=0.5
X8267 rr3t3r_0[9|19]/a_860_290# WL9 SL19 VSS sky130_fd_pr__nfet_g5v0d10v5 ad=0.65 pd=3.3 as=0 ps=0 w=1 l=0.5
X8268 BLP19 rr3t3r_0[10|19]/a_60_290# sky130_fd_pr_reram__reram_cell area_ox=0.0676
X8269 BLZ19 rr3t3r_0[10|19]/a_460_290# sky130_fd_pr_reram__reram_cell area_ox=0.0676
X8270 rr3t3r_0[10|19]/a_460_290# WL10 SL19 VSS sky130_fd_pr__nfet_g5v0d10v5 ad=0.65 pd=3.3 as=0 ps=0 w=1 l=0.5
X8271 BLN19 rr3t3r_0[10|19]/a_860_290# sky130_fd_pr_reram__reram_cell area_ox=0.0676
X8272 rr3t3r_0[10|19]/a_60_290# WL10 SL19 VSS sky130_fd_pr__nfet_g5v0d10v5 ad=0.65 pd=3.3 as=0 ps=0 w=1 l=0.5
X8273 rr3t3r_0[10|19]/a_860_290# WL10 SL19 VSS sky130_fd_pr__nfet_g5v0d10v5 ad=0.65 pd=3.3 as=0 ps=0 w=1 l=0.5
X8274 BLP19 rr3t3r_0[11|19]/a_60_290# sky130_fd_pr_reram__reram_cell area_ox=0.0676
X8275 BLZ19 rr3t3r_0[11|19]/a_460_290# sky130_fd_pr_reram__reram_cell area_ox=0.0676
X8276 rr3t3r_0[11|19]/a_460_290# WL11 SL19 VSS sky130_fd_pr__nfet_g5v0d10v5 ad=0.65 pd=3.3 as=0 ps=0 w=1 l=0.5
X8277 BLN19 rr3t3r_0[11|19]/a_860_290# sky130_fd_pr_reram__reram_cell area_ox=0.0676
X8278 rr3t3r_0[11|19]/a_60_290# WL11 SL19 VSS sky130_fd_pr__nfet_g5v0d10v5 ad=0.65 pd=3.3 as=0 ps=0 w=1 l=0.5
X8279 rr3t3r_0[11|19]/a_860_290# WL11 SL19 VSS sky130_fd_pr__nfet_g5v0d10v5 ad=0.65 pd=3.3 as=0 ps=0 w=1 l=0.5
X8280 BLP19 rr3t3r_0[12|19]/a_60_290# sky130_fd_pr_reram__reram_cell area_ox=0.0676
X8281 BLZ19 rr3t3r_0[12|19]/a_460_290# sky130_fd_pr_reram__reram_cell area_ox=0.0676
X8282 rr3t3r_0[12|19]/a_460_290# WL12 SL19 VSS sky130_fd_pr__nfet_g5v0d10v5 ad=0.65 pd=3.3 as=0 ps=0 w=1 l=0.5
X8283 BLN19 rr3t3r_0[12|19]/a_860_290# sky130_fd_pr_reram__reram_cell area_ox=0.0676
X8284 rr3t3r_0[12|19]/a_60_290# WL12 SL19 VSS sky130_fd_pr__nfet_g5v0d10v5 ad=0.65 pd=3.3 as=0 ps=0 w=1 l=0.5
X8285 rr3t3r_0[12|19]/a_860_290# WL12 SL19 VSS sky130_fd_pr__nfet_g5v0d10v5 ad=0.65 pd=3.3 as=0 ps=0 w=1 l=0.5
X8286 BLP19 rr3t3r_0[13|19]/a_60_290# sky130_fd_pr_reram__reram_cell area_ox=0.0676
X8287 BLZ19 rr3t3r_0[13|19]/a_460_290# sky130_fd_pr_reram__reram_cell area_ox=0.0676
X8288 rr3t3r_0[13|19]/a_460_290# WL13 SL19 VSS sky130_fd_pr__nfet_g5v0d10v5 ad=0.65 pd=3.3 as=0 ps=0 w=1 l=0.5
X8289 BLN19 rr3t3r_0[13|19]/a_860_290# sky130_fd_pr_reram__reram_cell area_ox=0.0676
X8290 rr3t3r_0[13|19]/a_60_290# WL13 SL19 VSS sky130_fd_pr__nfet_g5v0d10v5 ad=0.65 pd=3.3 as=0 ps=0 w=1 l=0.5
X8291 rr3t3r_0[13|19]/a_860_290# WL13 SL19 VSS sky130_fd_pr__nfet_g5v0d10v5 ad=0.65 pd=3.3 as=0 ps=0 w=1 l=0.5
X8292 BLP19 rr3t3r_0[14|19]/a_60_290# sky130_fd_pr_reram__reram_cell area_ox=0.0676
X8293 BLZ19 rr3t3r_0[14|19]/a_460_290# sky130_fd_pr_reram__reram_cell area_ox=0.0676
X8294 rr3t3r_0[14|19]/a_460_290# WL14 SL19 VSS sky130_fd_pr__nfet_g5v0d10v5 ad=0.65 pd=3.3 as=0 ps=0 w=1 l=0.5
X8295 BLN19 rr3t3r_0[14|19]/a_860_290# sky130_fd_pr_reram__reram_cell area_ox=0.0676
X8296 rr3t3r_0[14|19]/a_60_290# WL14 SL19 VSS sky130_fd_pr__nfet_g5v0d10v5 ad=0.65 pd=3.3 as=0 ps=0 w=1 l=0.5
X8297 rr3t3r_0[14|19]/a_860_290# WL14 SL19 VSS sky130_fd_pr__nfet_g5v0d10v5 ad=0.65 pd=3.3 as=0 ps=0 w=1 l=0.5
X8298 BLP19 rr3t3r_0[15|19]/a_60_290# sky130_fd_pr_reram__reram_cell area_ox=0.0676
X8299 BLZ19 rr3t3r_0[15|19]/a_460_290# sky130_fd_pr_reram__reram_cell area_ox=0.0676
X8300 rr3t3r_0[15|19]/a_460_290# WL15 SL19 VSS sky130_fd_pr__nfet_g5v0d10v5 ad=0.65 pd=3.3 as=0 ps=0 w=1 l=0.5
X8301 BLN19 rr3t3r_0[15|19]/a_860_290# sky130_fd_pr_reram__reram_cell area_ox=0.0676
X8302 rr3t3r_0[15|19]/a_60_290# WL15 SL19 VSS sky130_fd_pr__nfet_g5v0d10v5 ad=0.65 pd=3.3 as=0 ps=0 w=1 l=0.5
X8303 rr3t3r_0[15|19]/a_860_290# WL15 SL19 VSS sky130_fd_pr__nfet_g5v0d10v5 ad=0.65 pd=3.3 as=0 ps=0 w=1 l=0.5
X8304 BLP19 rr3t3r_0[16|19]/a_60_290# sky130_fd_pr_reram__reram_cell area_ox=0.0676
X8305 BLZ19 rr3t3r_0[16|19]/a_460_290# sky130_fd_pr_reram__reram_cell area_ox=0.0676
X8306 rr3t3r_0[16|19]/a_460_290# WL16 SL19 VSS sky130_fd_pr__nfet_g5v0d10v5 ad=0.65 pd=3.3 as=0 ps=0 w=1 l=0.5
X8307 BLN19 rr3t3r_0[16|19]/a_860_290# sky130_fd_pr_reram__reram_cell area_ox=0.0676
X8308 rr3t3r_0[16|19]/a_60_290# WL16 SL19 VSS sky130_fd_pr__nfet_g5v0d10v5 ad=0.65 pd=3.3 as=0 ps=0 w=1 l=0.5
X8309 rr3t3r_0[16|19]/a_860_290# WL16 SL19 VSS sky130_fd_pr__nfet_g5v0d10v5 ad=0.65 pd=3.3 as=0 ps=0 w=1 l=0.5
X8310 BLP19 rr3t3r_0[17|19]/a_60_290# sky130_fd_pr_reram__reram_cell area_ox=0.0676
X8311 BLZ19 rr3t3r_0[17|19]/a_460_290# sky130_fd_pr_reram__reram_cell area_ox=0.0676
X8312 rr3t3r_0[17|19]/a_460_290# WL17 SL19 VSS sky130_fd_pr__nfet_g5v0d10v5 ad=0.65 pd=3.3 as=0 ps=0 w=1 l=0.5
X8313 BLN19 rr3t3r_0[17|19]/a_860_290# sky130_fd_pr_reram__reram_cell area_ox=0.0676
X8314 rr3t3r_0[17|19]/a_60_290# WL17 SL19 VSS sky130_fd_pr__nfet_g5v0d10v5 ad=0.65 pd=3.3 as=0 ps=0 w=1 l=0.5
X8315 rr3t3r_0[17|19]/a_860_290# WL17 SL19 VSS sky130_fd_pr__nfet_g5v0d10v5 ad=0.65 pd=3.3 as=0 ps=0 w=1 l=0.5
X8316 BLP19 rr3t3r_0[18|19]/a_60_290# sky130_fd_pr_reram__reram_cell area_ox=0.0676
X8317 BLZ19 rr3t3r_0[18|19]/a_460_290# sky130_fd_pr_reram__reram_cell area_ox=0.0676
X8318 rr3t3r_0[18|19]/a_460_290# WL18 SL19 VSS sky130_fd_pr__nfet_g5v0d10v5 ad=0.65 pd=3.3 as=0 ps=0 w=1 l=0.5
X8319 BLN19 rr3t3r_0[18|19]/a_860_290# sky130_fd_pr_reram__reram_cell area_ox=0.0676
X8320 rr3t3r_0[18|19]/a_60_290# WL18 SL19 VSS sky130_fd_pr__nfet_g5v0d10v5 ad=0.65 pd=3.3 as=0 ps=0 w=1 l=0.5
X8321 rr3t3r_0[18|19]/a_860_290# WL18 SL19 VSS sky130_fd_pr__nfet_g5v0d10v5 ad=0.65 pd=3.3 as=0 ps=0 w=1 l=0.5
X8322 BLP19 rr3t3r_0[19|19]/a_60_290# sky130_fd_pr_reram__reram_cell area_ox=0.0676
X8323 BLZ19 rr3t3r_0[19|19]/a_460_290# sky130_fd_pr_reram__reram_cell area_ox=0.0676
X8324 rr3t3r_0[19|19]/a_460_290# WL19 SL19 VSS sky130_fd_pr__nfet_g5v0d10v5 ad=0.65 pd=3.3 as=0 ps=0 w=1 l=0.5
X8325 BLN19 rr3t3r_0[19|19]/a_860_290# sky130_fd_pr_reram__reram_cell area_ox=0.0676
X8326 rr3t3r_0[19|19]/a_60_290# WL19 SL19 VSS sky130_fd_pr__nfet_g5v0d10v5 ad=0.65 pd=3.3 as=0 ps=0 w=1 l=0.5
X8327 rr3t3r_0[19|19]/a_860_290# WL19 SL19 VSS sky130_fd_pr__nfet_g5v0d10v5 ad=0.65 pd=3.3 as=0 ps=0 w=1 l=0.5
X8328 BLP19 rr3t3r_0[20|19]/a_60_290# sky130_fd_pr_reram__reram_cell area_ox=0.0676
X8329 BLZ19 rr3t3r_0[20|19]/a_460_290# sky130_fd_pr_reram__reram_cell area_ox=0.0676
X8330 rr3t3r_0[20|19]/a_460_290# WL20 SL19 VSS sky130_fd_pr__nfet_g5v0d10v5 ad=0.65 pd=3.3 as=0 ps=0 w=1 l=0.5
X8331 BLN19 rr3t3r_0[20|19]/a_860_290# sky130_fd_pr_reram__reram_cell area_ox=0.0676
X8332 rr3t3r_0[20|19]/a_60_290# WL20 SL19 VSS sky130_fd_pr__nfet_g5v0d10v5 ad=0.65 pd=3.3 as=0 ps=0 w=1 l=0.5
X8333 rr3t3r_0[20|19]/a_860_290# WL20 SL19 VSS sky130_fd_pr__nfet_g5v0d10v5 ad=0.65 pd=3.3 as=0 ps=0 w=1 l=0.5
X8334 BLP19 rr3t3r_0[21|19]/a_60_290# sky130_fd_pr_reram__reram_cell area_ox=0.0676
X8335 BLZ19 rr3t3r_0[21|19]/a_460_290# sky130_fd_pr_reram__reram_cell area_ox=0.0676
X8336 rr3t3r_0[21|19]/a_460_290# WL21 SL19 VSS sky130_fd_pr__nfet_g5v0d10v5 ad=0.65 pd=3.3 as=0 ps=0 w=1 l=0.5
X8337 BLN19 rr3t3r_0[21|19]/a_860_290# sky130_fd_pr_reram__reram_cell area_ox=0.0676
X8338 rr3t3r_0[21|19]/a_60_290# WL21 SL19 VSS sky130_fd_pr__nfet_g5v0d10v5 ad=0.65 pd=3.3 as=0 ps=0 w=1 l=0.5
X8339 rr3t3r_0[21|19]/a_860_290# WL21 SL19 VSS sky130_fd_pr__nfet_g5v0d10v5 ad=0.65 pd=3.3 as=0 ps=0 w=1 l=0.5
X8340 BLP19 rr3t3r_0[22|19]/a_60_290# sky130_fd_pr_reram__reram_cell area_ox=0.0676
X8341 BLZ19 rr3t3r_0[22|19]/a_460_290# sky130_fd_pr_reram__reram_cell area_ox=0.0676
X8342 rr3t3r_0[22|19]/a_460_290# WL22 SL19 VSS sky130_fd_pr__nfet_g5v0d10v5 ad=0.65 pd=3.3 as=0 ps=0 w=1 l=0.5
X8343 BLN19 rr3t3r_0[22|19]/a_860_290# sky130_fd_pr_reram__reram_cell area_ox=0.0676
X8344 rr3t3r_0[22|19]/a_60_290# WL22 SL19 VSS sky130_fd_pr__nfet_g5v0d10v5 ad=0.65 pd=3.3 as=0 ps=0 w=1 l=0.5
X8345 rr3t3r_0[22|19]/a_860_290# WL22 SL19 VSS sky130_fd_pr__nfet_g5v0d10v5 ad=0.65 pd=3.3 as=0 ps=0 w=1 l=0.5
X8346 BLP19 rr3t3r_0[23|19]/a_60_290# sky130_fd_pr_reram__reram_cell area_ox=0.0676
X8347 BLZ19 rr3t3r_0[23|19]/a_460_290# sky130_fd_pr_reram__reram_cell area_ox=0.0676
X8348 rr3t3r_0[23|19]/a_460_290# WL23 SL19 VSS sky130_fd_pr__nfet_g5v0d10v5 ad=0.65 pd=3.3 as=0 ps=0 w=1 l=0.5
X8349 BLN19 rr3t3r_0[23|19]/a_860_290# sky130_fd_pr_reram__reram_cell area_ox=0.0676
X8350 rr3t3r_0[23|19]/a_60_290# WL23 SL19 VSS sky130_fd_pr__nfet_g5v0d10v5 ad=0.65 pd=3.3 as=0 ps=0 w=1 l=0.5
X8351 rr3t3r_0[23|19]/a_860_290# WL23 SL19 VSS sky130_fd_pr__nfet_g5v0d10v5 ad=0.65 pd=3.3 as=0 ps=0 w=1 l=0.5
X8352 BLP19 rr3t3r_0[24|19]/a_60_290# sky130_fd_pr_reram__reram_cell area_ox=0.0676
X8353 BLZ19 rr3t3r_0[24|19]/a_460_290# sky130_fd_pr_reram__reram_cell area_ox=0.0676
X8354 rr3t3r_0[24|19]/a_460_290# WL24 SL19 VSS sky130_fd_pr__nfet_g5v0d10v5 ad=0.65 pd=3.3 as=0 ps=0 w=1 l=0.5
X8355 BLN19 rr3t3r_0[24|19]/a_860_290# sky130_fd_pr_reram__reram_cell area_ox=0.0676
X8356 rr3t3r_0[24|19]/a_60_290# WL24 SL19 VSS sky130_fd_pr__nfet_g5v0d10v5 ad=0.65 pd=3.3 as=0 ps=0 w=1 l=0.5
X8357 rr3t3r_0[24|19]/a_860_290# WL24 SL19 VSS sky130_fd_pr__nfet_g5v0d10v5 ad=0.65 pd=3.3 as=0 ps=0 w=1 l=0.5
X8358 BLP19 rr3t3r_0[25|19]/a_60_290# sky130_fd_pr_reram__reram_cell area_ox=0.0676
X8359 BLZ19 rr3t3r_0[25|19]/a_460_290# sky130_fd_pr_reram__reram_cell area_ox=0.0676
X8360 rr3t3r_0[25|19]/a_460_290# WL25 SL19 VSS sky130_fd_pr__nfet_g5v0d10v5 ad=0.65 pd=3.3 as=0 ps=0 w=1 l=0.5
X8361 BLN19 rr3t3r_0[25|19]/a_860_290# sky130_fd_pr_reram__reram_cell area_ox=0.0676
X8362 rr3t3r_0[25|19]/a_60_290# WL25 SL19 VSS sky130_fd_pr__nfet_g5v0d10v5 ad=0.65 pd=3.3 as=0 ps=0 w=1 l=0.5
X8363 rr3t3r_0[25|19]/a_860_290# WL25 SL19 VSS sky130_fd_pr__nfet_g5v0d10v5 ad=0.65 pd=3.3 as=0 ps=0 w=1 l=0.5
X8364 BLP19 rr3t3r_0[26|19]/a_60_290# sky130_fd_pr_reram__reram_cell area_ox=0.0676
X8365 BLZ19 rr3t3r_0[26|19]/a_460_290# sky130_fd_pr_reram__reram_cell area_ox=0.0676
X8366 rr3t3r_0[26|19]/a_460_290# WL26 SL19 VSS sky130_fd_pr__nfet_g5v0d10v5 ad=0.65 pd=3.3 as=0 ps=0 w=1 l=0.5
X8367 BLN19 rr3t3r_0[26|19]/a_860_290# sky130_fd_pr_reram__reram_cell area_ox=0.0676
X8368 rr3t3r_0[26|19]/a_60_290# WL26 SL19 VSS sky130_fd_pr__nfet_g5v0d10v5 ad=0.65 pd=3.3 as=0 ps=0 w=1 l=0.5
X8369 rr3t3r_0[26|19]/a_860_290# WL26 SL19 VSS sky130_fd_pr__nfet_g5v0d10v5 ad=0.65 pd=3.3 as=0 ps=0 w=1 l=0.5
X8370 BLP19 rr3t3r_0[27|19]/a_60_290# sky130_fd_pr_reram__reram_cell area_ox=0.0676
X8371 BLZ19 rr3t3r_0[27|19]/a_460_290# sky130_fd_pr_reram__reram_cell area_ox=0.0676
X8372 rr3t3r_0[27|19]/a_460_290# WL27 SL19 VSS sky130_fd_pr__nfet_g5v0d10v5 ad=0.65 pd=3.3 as=0 ps=0 w=1 l=0.5
X8373 BLN19 rr3t3r_0[27|19]/a_860_290# sky130_fd_pr_reram__reram_cell area_ox=0.0676
X8374 rr3t3r_0[27|19]/a_60_290# WL27 SL19 VSS sky130_fd_pr__nfet_g5v0d10v5 ad=0.65 pd=3.3 as=0 ps=0 w=1 l=0.5
X8375 rr3t3r_0[27|19]/a_860_290# WL27 SL19 VSS sky130_fd_pr__nfet_g5v0d10v5 ad=0.65 pd=3.3 as=0 ps=0 w=1 l=0.5
X8376 BLP19 rr3t3r_0[28|19]/a_60_290# sky130_fd_pr_reram__reram_cell area_ox=0.0676
X8377 BLZ19 rr3t3r_0[28|19]/a_460_290# sky130_fd_pr_reram__reram_cell area_ox=0.0676
X8378 rr3t3r_0[28|19]/a_460_290# WL28 SL19 VSS sky130_fd_pr__nfet_g5v0d10v5 ad=0.65 pd=3.3 as=0 ps=0 w=1 l=0.5
X8379 BLN19 rr3t3r_0[28|19]/a_860_290# sky130_fd_pr_reram__reram_cell area_ox=0.0676
X8380 rr3t3r_0[28|19]/a_60_290# WL28 SL19 VSS sky130_fd_pr__nfet_g5v0d10v5 ad=0.65 pd=3.3 as=0 ps=0 w=1 l=0.5
X8381 rr3t3r_0[28|19]/a_860_290# WL28 SL19 VSS sky130_fd_pr__nfet_g5v0d10v5 ad=0.65 pd=3.3 as=0 ps=0 w=1 l=0.5
X8382 BLP19 rr3t3r_0[29|19]/a_60_290# sky130_fd_pr_reram__reram_cell area_ox=0.0676
X8383 BLZ19 rr3t3r_0[29|19]/a_460_290# sky130_fd_pr_reram__reram_cell area_ox=0.0676
X8384 rr3t3r_0[29|19]/a_460_290# WL29 SL19 VSS sky130_fd_pr__nfet_g5v0d10v5 ad=0.65 pd=3.3 as=0 ps=0 w=1 l=0.5
X8385 BLN19 rr3t3r_0[29|19]/a_860_290# sky130_fd_pr_reram__reram_cell area_ox=0.0676
X8386 rr3t3r_0[29|19]/a_60_290# WL29 SL19 VSS sky130_fd_pr__nfet_g5v0d10v5 ad=0.65 pd=3.3 as=0 ps=0 w=1 l=0.5
X8387 rr3t3r_0[29|19]/a_860_290# WL29 SL19 VSS sky130_fd_pr__nfet_g5v0d10v5 ad=0.65 pd=3.3 as=0 ps=0 w=1 l=0.5
X8388 BLP19 rr3t3r_0[30|19]/a_60_290# sky130_fd_pr_reram__reram_cell area_ox=0.0676
X8389 BLZ19 rr3t3r_0[30|19]/a_460_290# sky130_fd_pr_reram__reram_cell area_ox=0.0676
X8390 rr3t3r_0[30|19]/a_460_290# WL30 SL19 VSS sky130_fd_pr__nfet_g5v0d10v5 ad=0.65 pd=3.3 as=0 ps=0 w=1 l=0.5
X8391 BLN19 rr3t3r_0[30|19]/a_860_290# sky130_fd_pr_reram__reram_cell area_ox=0.0676
X8392 rr3t3r_0[30|19]/a_60_290# WL30 SL19 VSS sky130_fd_pr__nfet_g5v0d10v5 ad=0.65 pd=3.3 as=0 ps=0 w=1 l=0.5
X8393 rr3t3r_0[30|19]/a_860_290# WL30 SL19 VSS sky130_fd_pr__nfet_g5v0d10v5 ad=0.65 pd=3.3 as=0 ps=0 w=1 l=0.5
X8394 BLP19 rr3t3r_0[31|19]/a_60_290# sky130_fd_pr_reram__reram_cell area_ox=0.0676
X8395 BLZ19 rr3t3r_0[31|19]/a_460_290# sky130_fd_pr_reram__reram_cell area_ox=0.0676
X8396 rr3t3r_0[31|19]/a_460_290# WL31 SL19 VSS sky130_fd_pr__nfet_g5v0d10v5 ad=0.65 pd=3.3 as=0 ps=0 w=1 l=0.5
X8397 BLN19 rr3t3r_0[31|19]/a_860_290# sky130_fd_pr_reram__reram_cell area_ox=0.0676
X8398 rr3t3r_0[31|19]/a_60_290# WL31 SL19 VSS sky130_fd_pr__nfet_g5v0d10v5 ad=0.65 pd=3.3 as=0 ps=0 w=1 l=0.5
X8399 rr3t3r_0[31|19]/a_860_290# WL31 SL19 VSS sky130_fd_pr__nfet_g5v0d10v5 ad=0.65 pd=3.3 as=0 ps=0 w=1 l=0.5
X8400 BLP19 rr3t3r_0[32|19]/a_60_290# sky130_fd_pr_reram__reram_cell area_ox=0.0676
X8401 BLZ19 rr3t3r_0[32|19]/a_460_290# sky130_fd_pr_reram__reram_cell area_ox=0.0676
X8402 rr3t3r_0[32|19]/a_460_290# WL32 SL19 VSS sky130_fd_pr__nfet_g5v0d10v5 ad=0.65 pd=3.3 as=0 ps=0 w=1 l=0.5
X8403 BLN19 rr3t3r_0[32|19]/a_860_290# sky130_fd_pr_reram__reram_cell area_ox=0.0676
X8404 rr3t3r_0[32|19]/a_60_290# WL32 SL19 VSS sky130_fd_pr__nfet_g5v0d10v5 ad=0.65 pd=3.3 as=0 ps=0 w=1 l=0.5
X8405 rr3t3r_0[32|19]/a_860_290# WL32 SL19 VSS sky130_fd_pr__nfet_g5v0d10v5 ad=0.65 pd=3.3 as=0 ps=0 w=1 l=0.5
X8406 BLP19 rr3t3r_0[33|19]/a_60_290# sky130_fd_pr_reram__reram_cell area_ox=0.0676
X8407 BLZ19 rr3t3r_0[33|19]/a_460_290# sky130_fd_pr_reram__reram_cell area_ox=0.0676
X8408 rr3t3r_0[33|19]/a_460_290# WL33 SL19 VSS sky130_fd_pr__nfet_g5v0d10v5 ad=0.65 pd=3.3 as=0 ps=0 w=1 l=0.5
X8409 BLN19 rr3t3r_0[33|19]/a_860_290# sky130_fd_pr_reram__reram_cell area_ox=0.0676
X8410 rr3t3r_0[33|19]/a_60_290# WL33 SL19 VSS sky130_fd_pr__nfet_g5v0d10v5 ad=0.65 pd=3.3 as=0 ps=0 w=1 l=0.5
X8411 rr3t3r_0[33|19]/a_860_290# WL33 SL19 VSS sky130_fd_pr__nfet_g5v0d10v5 ad=0.65 pd=3.3 as=0 ps=0 w=1 l=0.5
X8412 BLP19 rr3t3r_0[34|19]/a_60_290# sky130_fd_pr_reram__reram_cell area_ox=0.0676
X8413 BLZ19 rr3t3r_0[34|19]/a_460_290# sky130_fd_pr_reram__reram_cell area_ox=0.0676
X8414 rr3t3r_0[34|19]/a_460_290# WL34 SL19 VSS sky130_fd_pr__nfet_g5v0d10v5 ad=0.65 pd=3.3 as=0 ps=0 w=1 l=0.5
X8415 BLN19 rr3t3r_0[34|19]/a_860_290# sky130_fd_pr_reram__reram_cell area_ox=0.0676
X8416 rr3t3r_0[34|19]/a_60_290# WL34 SL19 VSS sky130_fd_pr__nfet_g5v0d10v5 ad=0.65 pd=3.3 as=0 ps=0 w=1 l=0.5
X8417 rr3t3r_0[34|19]/a_860_290# WL34 SL19 VSS sky130_fd_pr__nfet_g5v0d10v5 ad=0.65 pd=3.3 as=0 ps=0 w=1 l=0.5
X8418 BLP19 rr3t3r_0[35|19]/a_60_290# sky130_fd_pr_reram__reram_cell area_ox=0.0676
X8419 BLZ19 rr3t3r_0[35|19]/a_460_290# sky130_fd_pr_reram__reram_cell area_ox=0.0676
X8420 rr3t3r_0[35|19]/a_460_290# WL35 SL19 VSS sky130_fd_pr__nfet_g5v0d10v5 ad=0.65 pd=3.3 as=0 ps=0 w=1 l=0.5
X8421 BLN19 rr3t3r_0[35|19]/a_860_290# sky130_fd_pr_reram__reram_cell area_ox=0.0676
X8422 rr3t3r_0[35|19]/a_60_290# WL35 SL19 VSS sky130_fd_pr__nfet_g5v0d10v5 ad=0.65 pd=3.3 as=0 ps=0 w=1 l=0.5
X8423 rr3t3r_0[35|19]/a_860_290# WL35 SL19 VSS sky130_fd_pr__nfet_g5v0d10v5 ad=0.65 pd=3.3 as=0 ps=0 w=1 l=0.5
X8424 BLP19 rr3t3r_0[36|19]/a_60_290# sky130_fd_pr_reram__reram_cell area_ox=0.0676
X8425 BLZ19 rr3t3r_0[36|19]/a_460_290# sky130_fd_pr_reram__reram_cell area_ox=0.0676
X8426 rr3t3r_0[36|19]/a_460_290# WL36 SL19 VSS sky130_fd_pr__nfet_g5v0d10v5 ad=0.65 pd=3.3 as=0 ps=0 w=1 l=0.5
X8427 BLN19 rr3t3r_0[36|19]/a_860_290# sky130_fd_pr_reram__reram_cell area_ox=0.0676
X8428 rr3t3r_0[36|19]/a_60_290# WL36 SL19 VSS sky130_fd_pr__nfet_g5v0d10v5 ad=0.65 pd=3.3 as=0 ps=0 w=1 l=0.5
X8429 rr3t3r_0[36|19]/a_860_290# WL36 SL19 VSS sky130_fd_pr__nfet_g5v0d10v5 ad=0.65 pd=3.3 as=0 ps=0 w=1 l=0.5
X8430 BLP19 rr3t3r_0[37|19]/a_60_290# sky130_fd_pr_reram__reram_cell area_ox=0.0676
X8431 BLZ19 rr3t3r_0[37|19]/a_460_290# sky130_fd_pr_reram__reram_cell area_ox=0.0676
X8432 rr3t3r_0[37|19]/a_460_290# WL37 SL19 VSS sky130_fd_pr__nfet_g5v0d10v5 ad=0.65 pd=3.3 as=0 ps=0 w=1 l=0.5
X8433 BLN19 rr3t3r_0[37|19]/a_860_290# sky130_fd_pr_reram__reram_cell area_ox=0.0676
X8434 rr3t3r_0[37|19]/a_60_290# WL37 SL19 VSS sky130_fd_pr__nfet_g5v0d10v5 ad=0.65 pd=3.3 as=0 ps=0 w=1 l=0.5
X8435 rr3t3r_0[37|19]/a_860_290# WL37 SL19 VSS sky130_fd_pr__nfet_g5v0d10v5 ad=0.65 pd=3.3 as=0 ps=0 w=1 l=0.5
X8436 BLP19 rr3t3r_0[38|19]/a_60_290# sky130_fd_pr_reram__reram_cell area_ox=0.0676
X8437 BLZ19 rr3t3r_0[38|19]/a_460_290# sky130_fd_pr_reram__reram_cell area_ox=0.0676
X8438 rr3t3r_0[38|19]/a_460_290# WL38 SL19 VSS sky130_fd_pr__nfet_g5v0d10v5 ad=0.65 pd=3.3 as=0 ps=0 w=1 l=0.5
X8439 BLN19 rr3t3r_0[38|19]/a_860_290# sky130_fd_pr_reram__reram_cell area_ox=0.0676
X8440 rr3t3r_0[38|19]/a_60_290# WL38 SL19 VSS sky130_fd_pr__nfet_g5v0d10v5 ad=0.65 pd=3.3 as=0 ps=0 w=1 l=0.5
X8441 rr3t3r_0[38|19]/a_860_290# WL38 SL19 VSS sky130_fd_pr__nfet_g5v0d10v5 ad=0.65 pd=3.3 as=0 ps=0 w=1 l=0.5
X8442 BLP19 rr3t3r_0[39|19]/a_60_290# sky130_fd_pr_reram__reram_cell area_ox=0.0676
X8443 BLZ19 rr3t3r_0[39|19]/a_460_290# sky130_fd_pr_reram__reram_cell area_ox=0.0676
X8444 rr3t3r_0[39|19]/a_460_290# WL39 SL19 VSS sky130_fd_pr__nfet_g5v0d10v5 ad=0.65 pd=3.3 as=0 ps=0 w=1 l=0.5
X8445 BLN19 rr3t3r_0[39|19]/a_860_290# sky130_fd_pr_reram__reram_cell area_ox=0.0676
X8446 rr3t3r_0[39|19]/a_60_290# WL39 SL19 VSS sky130_fd_pr__nfet_g5v0d10v5 ad=0.65 pd=3.3 as=0 ps=0 w=1 l=0.5
X8447 rr3t3r_0[39|19]/a_860_290# WL39 SL19 VSS sky130_fd_pr__nfet_g5v0d10v5 ad=0.65 pd=3.3 as=0 ps=0 w=1 l=0.5
X8448 BLP19 rr3t3r_0[40|19]/a_60_290# sky130_fd_pr_reram__reram_cell area_ox=0.0676
X8449 BLZ19 rr3t3r_0[40|19]/a_460_290# sky130_fd_pr_reram__reram_cell area_ox=0.0676
X8450 rr3t3r_0[40|19]/a_460_290# WL40 SL19 VSS sky130_fd_pr__nfet_g5v0d10v5 ad=0.65 pd=3.3 as=0 ps=0 w=1 l=0.5
X8451 BLN19 rr3t3r_0[40|19]/a_860_290# sky130_fd_pr_reram__reram_cell area_ox=0.0676
X8452 rr3t3r_0[40|19]/a_60_290# WL40 SL19 VSS sky130_fd_pr__nfet_g5v0d10v5 ad=0.65 pd=3.3 as=0 ps=0 w=1 l=0.5
X8453 rr3t3r_0[40|19]/a_860_290# WL40 SL19 VSS sky130_fd_pr__nfet_g5v0d10v5 ad=0.65 pd=3.3 as=0 ps=0 w=1 l=0.5
X8454 BLP19 rr3t3r_0[41|19]/a_60_290# sky130_fd_pr_reram__reram_cell area_ox=0.0676
X8455 BLZ19 rr3t3r_0[41|19]/a_460_290# sky130_fd_pr_reram__reram_cell area_ox=0.0676
X8456 rr3t3r_0[41|19]/a_460_290# WL41 SL19 VSS sky130_fd_pr__nfet_g5v0d10v5 ad=0.65 pd=3.3 as=0 ps=0 w=1 l=0.5
X8457 BLN19 rr3t3r_0[41|19]/a_860_290# sky130_fd_pr_reram__reram_cell area_ox=0.0676
X8458 rr3t3r_0[41|19]/a_60_290# WL41 SL19 VSS sky130_fd_pr__nfet_g5v0d10v5 ad=0.65 pd=3.3 as=0 ps=0 w=1 l=0.5
X8459 rr3t3r_0[41|19]/a_860_290# WL41 SL19 VSS sky130_fd_pr__nfet_g5v0d10v5 ad=0.65 pd=3.3 as=0 ps=0 w=1 l=0.5
X8460 BLP19 rr3t3r_0[42|19]/a_60_290# sky130_fd_pr_reram__reram_cell area_ox=0.0676
X8461 BLZ19 rr3t3r_0[42|19]/a_460_290# sky130_fd_pr_reram__reram_cell area_ox=0.0676
X8462 rr3t3r_0[42|19]/a_460_290# WL42 SL19 VSS sky130_fd_pr__nfet_g5v0d10v5 ad=0.65 pd=3.3 as=0 ps=0 w=1 l=0.5
X8463 BLN19 rr3t3r_0[42|19]/a_860_290# sky130_fd_pr_reram__reram_cell area_ox=0.0676
X8464 rr3t3r_0[42|19]/a_60_290# WL42 SL19 VSS sky130_fd_pr__nfet_g5v0d10v5 ad=0.65 pd=3.3 as=0 ps=0 w=1 l=0.5
X8465 rr3t3r_0[42|19]/a_860_290# WL42 SL19 VSS sky130_fd_pr__nfet_g5v0d10v5 ad=0.65 pd=3.3 as=0 ps=0 w=1 l=0.5
X8466 BLP19 rr3t3r_0[43|19]/a_60_290# sky130_fd_pr_reram__reram_cell area_ox=0.0676
X8467 BLZ19 rr3t3r_0[43|19]/a_460_290# sky130_fd_pr_reram__reram_cell area_ox=0.0676
X8468 rr3t3r_0[43|19]/a_460_290# WL43 SL19 VSS sky130_fd_pr__nfet_g5v0d10v5 ad=0.65 pd=3.3 as=0 ps=0 w=1 l=0.5
X8469 BLN19 rr3t3r_0[43|19]/a_860_290# sky130_fd_pr_reram__reram_cell area_ox=0.0676
X8470 rr3t3r_0[43|19]/a_60_290# WL43 SL19 VSS sky130_fd_pr__nfet_g5v0d10v5 ad=0.65 pd=3.3 as=0 ps=0 w=1 l=0.5
X8471 rr3t3r_0[43|19]/a_860_290# WL43 SL19 VSS sky130_fd_pr__nfet_g5v0d10v5 ad=0.65 pd=3.3 as=0 ps=0 w=1 l=0.5
X8472 BLP19 rr3t3r_0[44|19]/a_60_290# sky130_fd_pr_reram__reram_cell area_ox=0.0676
X8473 BLZ19 rr3t3r_0[44|19]/a_460_290# sky130_fd_pr_reram__reram_cell area_ox=0.0676
X8474 rr3t3r_0[44|19]/a_460_290# WL44 SL19 VSS sky130_fd_pr__nfet_g5v0d10v5 ad=0.65 pd=3.3 as=0 ps=0 w=1 l=0.5
X8475 BLN19 rr3t3r_0[44|19]/a_860_290# sky130_fd_pr_reram__reram_cell area_ox=0.0676
X8476 rr3t3r_0[44|19]/a_60_290# WL44 SL19 VSS sky130_fd_pr__nfet_g5v0d10v5 ad=0.65 pd=3.3 as=0 ps=0 w=1 l=0.5
X8477 rr3t3r_0[44|19]/a_860_290# WL44 SL19 VSS sky130_fd_pr__nfet_g5v0d10v5 ad=0.65 pd=3.3 as=0 ps=0 w=1 l=0.5
X8478 BLP19 rr3t3r_0[45|19]/a_60_290# sky130_fd_pr_reram__reram_cell area_ox=0.0676
X8479 BLZ19 rr3t3r_0[45|19]/a_460_290# sky130_fd_pr_reram__reram_cell area_ox=0.0676
X8480 rr3t3r_0[45|19]/a_460_290# WL45 SL19 VSS sky130_fd_pr__nfet_g5v0d10v5 ad=0.65 pd=3.3 as=0 ps=0 w=1 l=0.5
X8481 BLN19 rr3t3r_0[45|19]/a_860_290# sky130_fd_pr_reram__reram_cell area_ox=0.0676
X8482 rr3t3r_0[45|19]/a_60_290# WL45 SL19 VSS sky130_fd_pr__nfet_g5v0d10v5 ad=0.65 pd=3.3 as=0 ps=0 w=1 l=0.5
X8483 rr3t3r_0[45|19]/a_860_290# WL45 SL19 VSS sky130_fd_pr__nfet_g5v0d10v5 ad=0.65 pd=3.3 as=0 ps=0 w=1 l=0.5
X8484 BLP19 rr3t3r_0[46|19]/a_60_290# sky130_fd_pr_reram__reram_cell area_ox=0.0676
X8485 BLZ19 rr3t3r_0[46|19]/a_460_290# sky130_fd_pr_reram__reram_cell area_ox=0.0676
X8486 rr3t3r_0[46|19]/a_460_290# WL46 SL19 VSS sky130_fd_pr__nfet_g5v0d10v5 ad=0.65 pd=3.3 as=0 ps=0 w=1 l=0.5
X8487 BLN19 rr3t3r_0[46|19]/a_860_290# sky130_fd_pr_reram__reram_cell area_ox=0.0676
X8488 rr3t3r_0[46|19]/a_60_290# WL46 SL19 VSS sky130_fd_pr__nfet_g5v0d10v5 ad=0.65 pd=3.3 as=0 ps=0 w=1 l=0.5
X8489 rr3t3r_0[46|19]/a_860_290# WL46 SL19 VSS sky130_fd_pr__nfet_g5v0d10v5 ad=0.65 pd=3.3 as=0 ps=0 w=1 l=0.5
X8490 BLP19 rr3t3r_0[47|19]/a_60_290# sky130_fd_pr_reram__reram_cell area_ox=0.0676
X8491 BLZ19 rr3t3r_0[47|19]/a_460_290# sky130_fd_pr_reram__reram_cell area_ox=0.0676
X8492 rr3t3r_0[47|19]/a_460_290# WL47 SL19 VSS sky130_fd_pr__nfet_g5v0d10v5 ad=0.65 pd=3.3 as=0 ps=0 w=1 l=0.5
X8493 BLN19 rr3t3r_0[47|19]/a_860_290# sky130_fd_pr_reram__reram_cell area_ox=0.0676
X8494 rr3t3r_0[47|19]/a_60_290# WL47 SL19 VSS sky130_fd_pr__nfet_g5v0d10v5 ad=0.65 pd=3.3 as=0 ps=0 w=1 l=0.5
X8495 rr3t3r_0[47|19]/a_860_290# WL47 SL19 VSS sky130_fd_pr__nfet_g5v0d10v5 ad=0.65 pd=3.3 as=0 ps=0 w=1 l=0.5
X8496 BLP19 rr3t3r_0[48|19]/a_60_290# sky130_fd_pr_reram__reram_cell area_ox=0.0676
X8497 BLZ19 rr3t3r_0[48|19]/a_460_290# sky130_fd_pr_reram__reram_cell area_ox=0.0676
X8498 rr3t3r_0[48|19]/a_460_290# WL48 SL19 VSS sky130_fd_pr__nfet_g5v0d10v5 ad=0.65 pd=3.3 as=0 ps=0 w=1 l=0.5
X8499 BLN19 rr3t3r_0[48|19]/a_860_290# sky130_fd_pr_reram__reram_cell area_ox=0.0676
X8500 rr3t3r_0[48|19]/a_60_290# WL48 SL19 VSS sky130_fd_pr__nfet_g5v0d10v5 ad=0.65 pd=3.3 as=0 ps=0 w=1 l=0.5
X8501 rr3t3r_0[48|19]/a_860_290# WL48 SL19 VSS sky130_fd_pr__nfet_g5v0d10v5 ad=0.65 pd=3.3 as=0 ps=0 w=1 l=0.5
X8502 BLP19 rr3t3r_0[49|19]/a_60_290# sky130_fd_pr_reram__reram_cell area_ox=0.0676
X8503 BLZ19 rr3t3r_0[49|19]/a_460_290# sky130_fd_pr_reram__reram_cell area_ox=0.0676
X8504 rr3t3r_0[49|19]/a_460_290# WL49 SL19 VSS sky130_fd_pr__nfet_g5v0d10v5 ad=0.65 pd=3.3 as=0 ps=0 w=1 l=0.5
X8505 BLN19 rr3t3r_0[49|19]/a_860_290# sky130_fd_pr_reram__reram_cell area_ox=0.0676
X8506 rr3t3r_0[49|19]/a_60_290# WL49 SL19 VSS sky130_fd_pr__nfet_g5v0d10v5 ad=0.65 pd=3.3 as=0 ps=0 w=1 l=0.5
X8507 rr3t3r_0[49|19]/a_860_290# WL49 SL19 VSS sky130_fd_pr__nfet_g5v0d10v5 ad=0.65 pd=3.3 as=0 ps=0 w=1 l=0.5
X8508 BLP19 rr3t3r_0[50|19]/a_60_290# sky130_fd_pr_reram__reram_cell area_ox=0.0676
X8509 BLZ19 rr3t3r_0[50|19]/a_460_290# sky130_fd_pr_reram__reram_cell area_ox=0.0676
X8510 rr3t3r_0[50|19]/a_460_290# WL50 SL19 VSS sky130_fd_pr__nfet_g5v0d10v5 ad=0.65 pd=3.3 as=0 ps=0 w=1 l=0.5
X8511 BLN19 rr3t3r_0[50|19]/a_860_290# sky130_fd_pr_reram__reram_cell area_ox=0.0676
X8512 rr3t3r_0[50|19]/a_60_290# WL50 SL19 VSS sky130_fd_pr__nfet_g5v0d10v5 ad=0.65 pd=3.3 as=0 ps=0 w=1 l=0.5
X8513 rr3t3r_0[50|19]/a_860_290# WL50 SL19 VSS sky130_fd_pr__nfet_g5v0d10v5 ad=0.65 pd=3.3 as=0 ps=0 w=1 l=0.5
X8514 BLP19 rr3t3r_0[51|19]/a_60_290# sky130_fd_pr_reram__reram_cell area_ox=0.0676
X8515 BLZ19 rr3t3r_0[51|19]/a_460_290# sky130_fd_pr_reram__reram_cell area_ox=0.0676
X8516 rr3t3r_0[51|19]/a_460_290# WL51 SL19 VSS sky130_fd_pr__nfet_g5v0d10v5 ad=0.65 pd=3.3 as=0 ps=0 w=1 l=0.5
X8517 BLN19 rr3t3r_0[51|19]/a_860_290# sky130_fd_pr_reram__reram_cell area_ox=0.0676
X8518 rr3t3r_0[51|19]/a_60_290# WL51 SL19 VSS sky130_fd_pr__nfet_g5v0d10v5 ad=0.65 pd=3.3 as=0 ps=0 w=1 l=0.5
X8519 rr3t3r_0[51|19]/a_860_290# WL51 SL19 VSS sky130_fd_pr__nfet_g5v0d10v5 ad=0.65 pd=3.3 as=0 ps=0 w=1 l=0.5
X8520 BLP19 rr3t3r_0[52|19]/a_60_290# sky130_fd_pr_reram__reram_cell area_ox=0.0676
X8521 BLZ19 rr3t3r_0[52|19]/a_460_290# sky130_fd_pr_reram__reram_cell area_ox=0.0676
X8522 rr3t3r_0[52|19]/a_460_290# WL52 SL19 VSS sky130_fd_pr__nfet_g5v0d10v5 ad=0.65 pd=3.3 as=0 ps=0 w=1 l=0.5
X8523 BLN19 rr3t3r_0[52|19]/a_860_290# sky130_fd_pr_reram__reram_cell area_ox=0.0676
X8524 rr3t3r_0[52|19]/a_60_290# WL52 SL19 VSS sky130_fd_pr__nfet_g5v0d10v5 ad=0.65 pd=3.3 as=0 ps=0 w=1 l=0.5
X8525 rr3t3r_0[52|19]/a_860_290# WL52 SL19 VSS sky130_fd_pr__nfet_g5v0d10v5 ad=0.65 pd=3.3 as=0 ps=0 w=1 l=0.5
X8526 BLP19 rr3t3r_0[53|19]/a_60_290# sky130_fd_pr_reram__reram_cell area_ox=0.0676
X8527 BLZ19 rr3t3r_0[53|19]/a_460_290# sky130_fd_pr_reram__reram_cell area_ox=0.0676
X8528 rr3t3r_0[53|19]/a_460_290# WL53 SL19 VSS sky130_fd_pr__nfet_g5v0d10v5 ad=0.65 pd=3.3 as=0 ps=0 w=1 l=0.5
X8529 BLN19 rr3t3r_0[53|19]/a_860_290# sky130_fd_pr_reram__reram_cell area_ox=0.0676
X8530 rr3t3r_0[53|19]/a_60_290# WL53 SL19 VSS sky130_fd_pr__nfet_g5v0d10v5 ad=0.65 pd=3.3 as=0 ps=0 w=1 l=0.5
X8531 rr3t3r_0[53|19]/a_860_290# WL53 SL19 VSS sky130_fd_pr__nfet_g5v0d10v5 ad=0.65 pd=3.3 as=0 ps=0 w=1 l=0.5
X8532 BLP19 rr3t3r_0[54|19]/a_60_290# sky130_fd_pr_reram__reram_cell area_ox=0.0676
X8533 BLZ19 rr3t3r_0[54|19]/a_460_290# sky130_fd_pr_reram__reram_cell area_ox=0.0676
X8534 rr3t3r_0[54|19]/a_460_290# WL54 SL19 VSS sky130_fd_pr__nfet_g5v0d10v5 ad=0.65 pd=3.3 as=0 ps=0 w=1 l=0.5
X8535 BLN19 rr3t3r_0[54|19]/a_860_290# sky130_fd_pr_reram__reram_cell area_ox=0.0676
X8536 rr3t3r_0[54|19]/a_60_290# WL54 SL19 VSS sky130_fd_pr__nfet_g5v0d10v5 ad=0.65 pd=3.3 as=0 ps=0 w=1 l=0.5
X8537 rr3t3r_0[54|19]/a_860_290# WL54 SL19 VSS sky130_fd_pr__nfet_g5v0d10v5 ad=0.65 pd=3.3 as=0 ps=0 w=1 l=0.5
X8538 BLP19 rr3t3r_0[55|19]/a_60_290# sky130_fd_pr_reram__reram_cell area_ox=0.0676
X8539 BLZ19 rr3t3r_0[55|19]/a_460_290# sky130_fd_pr_reram__reram_cell area_ox=0.0676
X8540 rr3t3r_0[55|19]/a_460_290# WL55 SL19 VSS sky130_fd_pr__nfet_g5v0d10v5 ad=0.65 pd=3.3 as=0 ps=0 w=1 l=0.5
X8541 BLN19 rr3t3r_0[55|19]/a_860_290# sky130_fd_pr_reram__reram_cell area_ox=0.0676
X8542 rr3t3r_0[55|19]/a_60_290# WL55 SL19 VSS sky130_fd_pr__nfet_g5v0d10v5 ad=0.65 pd=3.3 as=0 ps=0 w=1 l=0.5
X8543 rr3t3r_0[55|19]/a_860_290# WL55 SL19 VSS sky130_fd_pr__nfet_g5v0d10v5 ad=0.65 pd=3.3 as=0 ps=0 w=1 l=0.5
X8544 BLP19 rr3t3r_0[56|19]/a_60_290# sky130_fd_pr_reram__reram_cell area_ox=0.0676
X8545 BLZ19 rr3t3r_0[56|19]/a_460_290# sky130_fd_pr_reram__reram_cell area_ox=0.0676
X8546 rr3t3r_0[56|19]/a_460_290# WL56 SL19 VSS sky130_fd_pr__nfet_g5v0d10v5 ad=0.65 pd=3.3 as=0 ps=0 w=1 l=0.5
X8547 BLN19 rr3t3r_0[56|19]/a_860_290# sky130_fd_pr_reram__reram_cell area_ox=0.0676
X8548 rr3t3r_0[56|19]/a_60_290# WL56 SL19 VSS sky130_fd_pr__nfet_g5v0d10v5 ad=0.65 pd=3.3 as=0 ps=0 w=1 l=0.5
X8549 rr3t3r_0[56|19]/a_860_290# WL56 SL19 VSS sky130_fd_pr__nfet_g5v0d10v5 ad=0.65 pd=3.3 as=0 ps=0 w=1 l=0.5
X8550 BLP19 rr3t3r_0[57|19]/a_60_290# sky130_fd_pr_reram__reram_cell area_ox=0.0676
X8551 BLZ19 rr3t3r_0[57|19]/a_460_290# sky130_fd_pr_reram__reram_cell area_ox=0.0676
X8552 rr3t3r_0[57|19]/a_460_290# WL57 SL19 VSS sky130_fd_pr__nfet_g5v0d10v5 ad=0.65 pd=3.3 as=0 ps=0 w=1 l=0.5
X8553 BLN19 rr3t3r_0[57|19]/a_860_290# sky130_fd_pr_reram__reram_cell area_ox=0.0676
X8554 rr3t3r_0[57|19]/a_60_290# WL57 SL19 VSS sky130_fd_pr__nfet_g5v0d10v5 ad=0.65 pd=3.3 as=0 ps=0 w=1 l=0.5
X8555 rr3t3r_0[57|19]/a_860_290# WL57 SL19 VSS sky130_fd_pr__nfet_g5v0d10v5 ad=0.65 pd=3.3 as=0 ps=0 w=1 l=0.5
X8556 BLP19 rr3t3r_0[58|19]/a_60_290# sky130_fd_pr_reram__reram_cell area_ox=0.0676
X8557 BLZ19 rr3t3r_0[58|19]/a_460_290# sky130_fd_pr_reram__reram_cell area_ox=0.0676
X8558 rr3t3r_0[58|19]/a_460_290# WL58 SL19 VSS sky130_fd_pr__nfet_g5v0d10v5 ad=0.65 pd=3.3 as=0 ps=0 w=1 l=0.5
X8559 BLN19 rr3t3r_0[58|19]/a_860_290# sky130_fd_pr_reram__reram_cell area_ox=0.0676
X8560 rr3t3r_0[58|19]/a_60_290# WL58 SL19 VSS sky130_fd_pr__nfet_g5v0d10v5 ad=0.65 pd=3.3 as=0 ps=0 w=1 l=0.5
X8561 rr3t3r_0[58|19]/a_860_290# WL58 SL19 VSS sky130_fd_pr__nfet_g5v0d10v5 ad=0.65 pd=3.3 as=0 ps=0 w=1 l=0.5
X8562 BLP19 rr3t3r_0[59|19]/a_60_290# sky130_fd_pr_reram__reram_cell area_ox=0.0676
X8563 BLZ19 rr3t3r_0[59|19]/a_460_290# sky130_fd_pr_reram__reram_cell area_ox=0.0676
X8564 rr3t3r_0[59|19]/a_460_290# WL59 SL19 VSS sky130_fd_pr__nfet_g5v0d10v5 ad=0.65 pd=3.3 as=0 ps=0 w=1 l=0.5
X8565 BLN19 rr3t3r_0[59|19]/a_860_290# sky130_fd_pr_reram__reram_cell area_ox=0.0676
X8566 rr3t3r_0[59|19]/a_60_290# WL59 SL19 VSS sky130_fd_pr__nfet_g5v0d10v5 ad=0.65 pd=3.3 as=0 ps=0 w=1 l=0.5
X8567 rr3t3r_0[59|19]/a_860_290# WL59 SL19 VSS sky130_fd_pr__nfet_g5v0d10v5 ad=0.65 pd=3.3 as=0 ps=0 w=1 l=0.5
X8568 BLP19 rr3t3r_0[60|19]/a_60_290# sky130_fd_pr_reram__reram_cell area_ox=0.0676
X8569 BLZ19 rr3t3r_0[60|19]/a_460_290# sky130_fd_pr_reram__reram_cell area_ox=0.0676
X8570 rr3t3r_0[60|19]/a_460_290# WL60 SL19 VSS sky130_fd_pr__nfet_g5v0d10v5 ad=0.65 pd=3.3 as=0 ps=0 w=1 l=0.5
X8571 BLN19 rr3t3r_0[60|19]/a_860_290# sky130_fd_pr_reram__reram_cell area_ox=0.0676
X8572 rr3t3r_0[60|19]/a_60_290# WL60 SL19 VSS sky130_fd_pr__nfet_g5v0d10v5 ad=0.65 pd=3.3 as=0 ps=0 w=1 l=0.5
X8573 rr3t3r_0[60|19]/a_860_290# WL60 SL19 VSS sky130_fd_pr__nfet_g5v0d10v5 ad=0.65 pd=3.3 as=0 ps=0 w=1 l=0.5
X8574 BLP19 rr3t3r_0[61|19]/a_60_290# sky130_fd_pr_reram__reram_cell area_ox=0.0676
X8575 BLZ19 rr3t3r_0[61|19]/a_460_290# sky130_fd_pr_reram__reram_cell area_ox=0.0676
X8576 rr3t3r_0[61|19]/a_460_290# WL61 SL19 VSS sky130_fd_pr__nfet_g5v0d10v5 ad=0.65 pd=3.3 as=0 ps=0 w=1 l=0.5
X8577 BLN19 rr3t3r_0[61|19]/a_860_290# sky130_fd_pr_reram__reram_cell area_ox=0.0676
X8578 rr3t3r_0[61|19]/a_60_290# WL61 SL19 VSS sky130_fd_pr__nfet_g5v0d10v5 ad=0.65 pd=3.3 as=0 ps=0 w=1 l=0.5
X8579 rr3t3r_0[61|19]/a_860_290# WL61 SL19 VSS sky130_fd_pr__nfet_g5v0d10v5 ad=0.65 pd=3.3 as=0 ps=0 w=1 l=0.5
X8580 BLP19 rr3t3r_0[62|19]/a_60_290# sky130_fd_pr_reram__reram_cell area_ox=0.0676
X8581 BLZ19 rr3t3r_0[62|19]/a_460_290# sky130_fd_pr_reram__reram_cell area_ox=0.0676
X8582 rr3t3r_0[62|19]/a_460_290# WL62 SL19 VSS sky130_fd_pr__nfet_g5v0d10v5 ad=0.65 pd=3.3 as=0 ps=0 w=1 l=0.5
X8583 BLN19 rr3t3r_0[62|19]/a_860_290# sky130_fd_pr_reram__reram_cell area_ox=0.0676
X8584 rr3t3r_0[62|19]/a_60_290# WL62 SL19 VSS sky130_fd_pr__nfet_g5v0d10v5 ad=0.65 pd=3.3 as=0 ps=0 w=1 l=0.5
X8585 rr3t3r_0[62|19]/a_860_290# WL62 SL19 VSS sky130_fd_pr__nfet_g5v0d10v5 ad=0.65 pd=3.3 as=0 ps=0 w=1 l=0.5
X8586 BLP19 rr3t3r_0[63|19]/a_60_290# sky130_fd_pr_reram__reram_cell area_ox=0.0676
X8587 BLZ19 rr3t3r_0[63|19]/a_460_290# sky130_fd_pr_reram__reram_cell area_ox=0.0676
X8588 rr3t3r_0[63|19]/a_460_290# WL63 SL19 VSS sky130_fd_pr__nfet_g5v0d10v5 ad=0.65 pd=3.3 as=0 ps=0 w=1 l=0.5
X8589 BLN19 rr3t3r_0[63|19]/a_860_290# sky130_fd_pr_reram__reram_cell area_ox=0.0676
X8590 rr3t3r_0[63|19]/a_60_290# WL63 SL19 VSS sky130_fd_pr__nfet_g5v0d10v5 ad=0.65 pd=3.3 as=0 ps=0 w=1 l=0.5
X8591 rr3t3r_0[63|19]/a_860_290# WL63 SL19 VSS sky130_fd_pr__nfet_g5v0d10v5 ad=0.65 pd=3.3 as=0 ps=0 w=1 l=0.5
X8592 BLP19 rr3t3r_0[64|19]/a_60_290# sky130_fd_pr_reram__reram_cell area_ox=0.0676
X8593 BLZ19 rr3t3r_0[64|19]/a_460_290# sky130_fd_pr_reram__reram_cell area_ox=0.0676
X8594 rr3t3r_0[64|19]/a_460_290# WL64 SL19 VSS sky130_fd_pr__nfet_g5v0d10v5 ad=0.65 pd=3.3 as=0 ps=0 w=1 l=0.5
X8595 BLN19 rr3t3r_0[64|19]/a_860_290# sky130_fd_pr_reram__reram_cell area_ox=0.0676
X8596 rr3t3r_0[64|19]/a_60_290# WL64 SL19 VSS sky130_fd_pr__nfet_g5v0d10v5 ad=0.65 pd=3.3 as=0 ps=0 w=1 l=0.5
X8597 rr3t3r_0[64|19]/a_860_290# WL64 SL19 VSS sky130_fd_pr__nfet_g5v0d10v5 ad=0.65 pd=3.3 as=0 ps=0 w=1 l=0.5
X8598 BLP19 rr3t3r_0[65|19]/a_60_290# sky130_fd_pr_reram__reram_cell area_ox=0.0676
X8599 BLZ19 rr3t3r_0[65|19]/a_460_290# sky130_fd_pr_reram__reram_cell area_ox=0.0676
X8600 rr3t3r_0[65|19]/a_460_290# WL65 SL19 VSS sky130_fd_pr__nfet_g5v0d10v5 ad=0.65 pd=3.3 as=0 ps=0 w=1 l=0.5
X8601 BLN19 rr3t3r_0[65|19]/a_860_290# sky130_fd_pr_reram__reram_cell area_ox=0.0676
X8602 rr3t3r_0[65|19]/a_60_290# WL65 SL19 VSS sky130_fd_pr__nfet_g5v0d10v5 ad=0.65 pd=3.3 as=0 ps=0 w=1 l=0.5
X8603 rr3t3r_0[65|19]/a_860_290# WL65 SL19 VSS sky130_fd_pr__nfet_g5v0d10v5 ad=0.65 pd=3.3 as=0 ps=0 w=1 l=0.5
X8604 BLP19 rr3t3r_0[66|19]/a_60_290# sky130_fd_pr_reram__reram_cell area_ox=0.0676
X8605 BLZ19 rr3t3r_0[66|19]/a_460_290# sky130_fd_pr_reram__reram_cell area_ox=0.0676
X8606 rr3t3r_0[66|19]/a_460_290# WL66 SL19 VSS sky130_fd_pr__nfet_g5v0d10v5 ad=0.65 pd=3.3 as=0 ps=0 w=1 l=0.5
X8607 BLN19 rr3t3r_0[66|19]/a_860_290# sky130_fd_pr_reram__reram_cell area_ox=0.0676
X8608 rr3t3r_0[66|19]/a_60_290# WL66 SL19 VSS sky130_fd_pr__nfet_g5v0d10v5 ad=0.65 pd=3.3 as=0 ps=0 w=1 l=0.5
X8609 rr3t3r_0[66|19]/a_860_290# WL66 SL19 VSS sky130_fd_pr__nfet_g5v0d10v5 ad=0.65 pd=3.3 as=0 ps=0 w=1 l=0.5
X8610 BLP19 rr3t3r_0[67|19]/a_60_290# sky130_fd_pr_reram__reram_cell area_ox=0.0676
X8611 BLZ19 rr3t3r_0[67|19]/a_460_290# sky130_fd_pr_reram__reram_cell area_ox=0.0676
X8612 rr3t3r_0[67|19]/a_460_290# WL67 SL19 VSS sky130_fd_pr__nfet_g5v0d10v5 ad=0.65 pd=3.3 as=0 ps=0 w=1 l=0.5
X8613 BLN19 rr3t3r_0[67|19]/a_860_290# sky130_fd_pr_reram__reram_cell area_ox=0.0676
X8614 rr3t3r_0[67|19]/a_60_290# WL67 SL19 VSS sky130_fd_pr__nfet_g5v0d10v5 ad=0.65 pd=3.3 as=0 ps=0 w=1 l=0.5
X8615 rr3t3r_0[67|19]/a_860_290# WL67 SL19 VSS sky130_fd_pr__nfet_g5v0d10v5 ad=0.65 pd=3.3 as=0 ps=0 w=1 l=0.5
X8616 BLP19 rr3t3r_0[68|19]/a_60_290# sky130_fd_pr_reram__reram_cell area_ox=0.0676
X8617 BLZ19 rr3t3r_0[68|19]/a_460_290# sky130_fd_pr_reram__reram_cell area_ox=0.0676
X8618 rr3t3r_0[68|19]/a_460_290# WL68 SL19 VSS sky130_fd_pr__nfet_g5v0d10v5 ad=0.65 pd=3.3 as=0 ps=0 w=1 l=0.5
X8619 BLN19 rr3t3r_0[68|19]/a_860_290# sky130_fd_pr_reram__reram_cell area_ox=0.0676
X8620 rr3t3r_0[68|19]/a_60_290# WL68 SL19 VSS sky130_fd_pr__nfet_g5v0d10v5 ad=0.65 pd=3.3 as=0 ps=0 w=1 l=0.5
X8621 rr3t3r_0[68|19]/a_860_290# WL68 SL19 VSS sky130_fd_pr__nfet_g5v0d10v5 ad=0.65 pd=3.3 as=0 ps=0 w=1 l=0.5
X8622 BLP19 rr3t3r_0[69|19]/a_60_290# sky130_fd_pr_reram__reram_cell area_ox=0.0676
X8623 BLZ19 rr3t3r_0[69|19]/a_460_290# sky130_fd_pr_reram__reram_cell area_ox=0.0676
X8624 rr3t3r_0[69|19]/a_460_290# WL69 SL19 VSS sky130_fd_pr__nfet_g5v0d10v5 ad=0.65 pd=3.3 as=0 ps=0 w=1 l=0.5
X8625 BLN19 rr3t3r_0[69|19]/a_860_290# sky130_fd_pr_reram__reram_cell area_ox=0.0676
X8626 rr3t3r_0[69|19]/a_60_290# WL69 SL19 VSS sky130_fd_pr__nfet_g5v0d10v5 ad=0.65 pd=3.3 as=0 ps=0 w=1 l=0.5
X8627 rr3t3r_0[69|19]/a_860_290# WL69 SL19 VSS sky130_fd_pr__nfet_g5v0d10v5 ad=0.65 pd=3.3 as=0 ps=0 w=1 l=0.5
X8628 BLP19 rr3t3r_0[70|19]/a_60_290# sky130_fd_pr_reram__reram_cell area_ox=0.0676
X8629 BLZ19 rr3t3r_0[70|19]/a_460_290# sky130_fd_pr_reram__reram_cell area_ox=0.0676
X8630 rr3t3r_0[70|19]/a_460_290# WL70 SL19 VSS sky130_fd_pr__nfet_g5v0d10v5 ad=0.65 pd=3.3 as=0 ps=0 w=1 l=0.5
X8631 BLN19 rr3t3r_0[70|19]/a_860_290# sky130_fd_pr_reram__reram_cell area_ox=0.0676
X8632 rr3t3r_0[70|19]/a_60_290# WL70 SL19 VSS sky130_fd_pr__nfet_g5v0d10v5 ad=0.65 pd=3.3 as=0 ps=0 w=1 l=0.5
X8633 rr3t3r_0[70|19]/a_860_290# WL70 SL19 VSS sky130_fd_pr__nfet_g5v0d10v5 ad=0.65 pd=3.3 as=0 ps=0 w=1 l=0.5
X8634 BLP19 rr3t3r_0[71|19]/a_60_290# sky130_fd_pr_reram__reram_cell area_ox=0.0676
X8635 BLZ19 rr3t3r_0[71|19]/a_460_290# sky130_fd_pr_reram__reram_cell area_ox=0.0676
X8636 rr3t3r_0[71|19]/a_460_290# WL71 SL19 VSS sky130_fd_pr__nfet_g5v0d10v5 ad=0.65 pd=3.3 as=0 ps=0 w=1 l=0.5
X8637 BLN19 rr3t3r_0[71|19]/a_860_290# sky130_fd_pr_reram__reram_cell area_ox=0.0676
X8638 rr3t3r_0[71|19]/a_60_290# WL71 SL19 VSS sky130_fd_pr__nfet_g5v0d10v5 ad=0.65 pd=3.3 as=0 ps=0 w=1 l=0.5
X8639 rr3t3r_0[71|19]/a_860_290# WL71 SL19 VSS sky130_fd_pr__nfet_g5v0d10v5 ad=0.65 pd=3.3 as=0 ps=0 w=1 l=0.5
X8640 BLP20 rr3t3r_0[0|20]/a_60_290# sky130_fd_pr_reram__reram_cell area_ox=0.0676
X8641 BLZ20 rr3t3r_0[0|20]/a_460_290# sky130_fd_pr_reram__reram_cell area_ox=0.0676
X8642 rr3t3r_0[0|20]/a_460_290# WL0 SL20 VSS sky130_fd_pr__nfet_g5v0d10v5 ad=0.65 pd=3.3 as=162 ps=756 w=1 l=0.5
X8643 BLN20 rr3t3r_0[0|20]/a_860_290# sky130_fd_pr_reram__reram_cell area_ox=0.0676
X8644 rr3t3r_0[0|20]/a_60_290# WL0 SL20 VSS sky130_fd_pr__nfet_g5v0d10v5 ad=0.65 pd=3.3 as=0 ps=0 w=1 l=0.5
X8645 rr3t3r_0[0|20]/a_860_290# WL0 SL20 VSS sky130_fd_pr__nfet_g5v0d10v5 ad=0.65 pd=3.3 as=0 ps=0 w=1 l=0.5
X8646 BLP20 rr3t3r_0[1|20]/a_60_290# sky130_fd_pr_reram__reram_cell area_ox=0.0676
X8647 BLZ20 rr3t3r_0[1|20]/a_460_290# sky130_fd_pr_reram__reram_cell area_ox=0.0676
X8648 rr3t3r_0[1|20]/a_460_290# WL1 SL20 VSS sky130_fd_pr__nfet_g5v0d10v5 ad=0.65 pd=3.3 as=0 ps=0 w=1 l=0.5
X8649 BLN20 rr3t3r_0[1|20]/a_860_290# sky130_fd_pr_reram__reram_cell area_ox=0.0676
X8650 rr3t3r_0[1|20]/a_60_290# WL1 SL20 VSS sky130_fd_pr__nfet_g5v0d10v5 ad=0.65 pd=3.3 as=0 ps=0 w=1 l=0.5
X8651 rr3t3r_0[1|20]/a_860_290# WL1 SL20 VSS sky130_fd_pr__nfet_g5v0d10v5 ad=0.65 pd=3.3 as=0 ps=0 w=1 l=0.5
X8652 BLP20 rr3t3r_0[2|20]/a_60_290# sky130_fd_pr_reram__reram_cell area_ox=0.0676
X8653 BLZ20 rr3t3r_0[2|20]/a_460_290# sky130_fd_pr_reram__reram_cell area_ox=0.0676
X8654 rr3t3r_0[2|20]/a_460_290# WL2 SL20 VSS sky130_fd_pr__nfet_g5v0d10v5 ad=0.65 pd=3.3 as=0 ps=0 w=1 l=0.5
X8655 BLN20 rr3t3r_0[2|20]/a_860_290# sky130_fd_pr_reram__reram_cell area_ox=0.0676
X8656 rr3t3r_0[2|20]/a_60_290# WL2 SL20 VSS sky130_fd_pr__nfet_g5v0d10v5 ad=0.65 pd=3.3 as=0 ps=0 w=1 l=0.5
X8657 rr3t3r_0[2|20]/a_860_290# WL2 SL20 VSS sky130_fd_pr__nfet_g5v0d10v5 ad=0.65 pd=3.3 as=0 ps=0 w=1 l=0.5
X8658 BLP20 rr3t3r_0[3|20]/a_60_290# sky130_fd_pr_reram__reram_cell area_ox=0.0676
X8659 BLZ20 rr3t3r_0[3|20]/a_460_290# sky130_fd_pr_reram__reram_cell area_ox=0.0676
X8660 rr3t3r_0[3|20]/a_460_290# WL3 SL20 VSS sky130_fd_pr__nfet_g5v0d10v5 ad=0.65 pd=3.3 as=0 ps=0 w=1 l=0.5
X8661 BLN20 rr3t3r_0[3|20]/a_860_290# sky130_fd_pr_reram__reram_cell area_ox=0.0676
X8662 rr3t3r_0[3|20]/a_60_290# WL3 SL20 VSS sky130_fd_pr__nfet_g5v0d10v5 ad=0.65 pd=3.3 as=0 ps=0 w=1 l=0.5
X8663 rr3t3r_0[3|20]/a_860_290# WL3 SL20 VSS sky130_fd_pr__nfet_g5v0d10v5 ad=0.65 pd=3.3 as=0 ps=0 w=1 l=0.5
X8664 BLP20 rr3t3r_0[4|20]/a_60_290# sky130_fd_pr_reram__reram_cell area_ox=0.0676
X8665 BLZ20 rr3t3r_0[4|20]/a_460_290# sky130_fd_pr_reram__reram_cell area_ox=0.0676
X8666 rr3t3r_0[4|20]/a_460_290# WL4 SL20 VSS sky130_fd_pr__nfet_g5v0d10v5 ad=0.65 pd=3.3 as=0 ps=0 w=1 l=0.5
X8667 BLN20 rr3t3r_0[4|20]/a_860_290# sky130_fd_pr_reram__reram_cell area_ox=0.0676
X8668 rr3t3r_0[4|20]/a_60_290# WL4 SL20 VSS sky130_fd_pr__nfet_g5v0d10v5 ad=0.65 pd=3.3 as=0 ps=0 w=1 l=0.5
X8669 rr3t3r_0[4|20]/a_860_290# WL4 SL20 VSS sky130_fd_pr__nfet_g5v0d10v5 ad=0.65 pd=3.3 as=0 ps=0 w=1 l=0.5
X8670 BLP20 rr3t3r_0[5|20]/a_60_290# sky130_fd_pr_reram__reram_cell area_ox=0.0676
X8671 BLZ20 rr3t3r_0[5|20]/a_460_290# sky130_fd_pr_reram__reram_cell area_ox=0.0676
X8672 rr3t3r_0[5|20]/a_460_290# WL5 SL20 VSS sky130_fd_pr__nfet_g5v0d10v5 ad=0.65 pd=3.3 as=0 ps=0 w=1 l=0.5
X8673 BLN20 rr3t3r_0[5|20]/a_860_290# sky130_fd_pr_reram__reram_cell area_ox=0.0676
X8674 rr3t3r_0[5|20]/a_60_290# WL5 SL20 VSS sky130_fd_pr__nfet_g5v0d10v5 ad=0.65 pd=3.3 as=0 ps=0 w=1 l=0.5
X8675 rr3t3r_0[5|20]/a_860_290# WL5 SL20 VSS sky130_fd_pr__nfet_g5v0d10v5 ad=0.65 pd=3.3 as=0 ps=0 w=1 l=0.5
X8676 BLP20 rr3t3r_0[6|20]/a_60_290# sky130_fd_pr_reram__reram_cell area_ox=0.0676
X8677 BLZ20 rr3t3r_0[6|20]/a_460_290# sky130_fd_pr_reram__reram_cell area_ox=0.0676
X8678 rr3t3r_0[6|20]/a_460_290# WL6 SL20 VSS sky130_fd_pr__nfet_g5v0d10v5 ad=0.65 pd=3.3 as=0 ps=0 w=1 l=0.5
X8679 BLN20 rr3t3r_0[6|20]/a_860_290# sky130_fd_pr_reram__reram_cell area_ox=0.0676
X8680 rr3t3r_0[6|20]/a_60_290# WL6 SL20 VSS sky130_fd_pr__nfet_g5v0d10v5 ad=0.65 pd=3.3 as=0 ps=0 w=1 l=0.5
X8681 rr3t3r_0[6|20]/a_860_290# WL6 SL20 VSS sky130_fd_pr__nfet_g5v0d10v5 ad=0.65 pd=3.3 as=0 ps=0 w=1 l=0.5
X8682 BLP20 rr3t3r_0[7|20]/a_60_290# sky130_fd_pr_reram__reram_cell area_ox=0.0676
X8683 BLZ20 rr3t3r_0[7|20]/a_460_290# sky130_fd_pr_reram__reram_cell area_ox=0.0676
X8684 rr3t3r_0[7|20]/a_460_290# WL7 SL20 VSS sky130_fd_pr__nfet_g5v0d10v5 ad=0.65 pd=3.3 as=0 ps=0 w=1 l=0.5
X8685 BLN20 rr3t3r_0[7|20]/a_860_290# sky130_fd_pr_reram__reram_cell area_ox=0.0676
X8686 rr3t3r_0[7|20]/a_60_290# WL7 SL20 VSS sky130_fd_pr__nfet_g5v0d10v5 ad=0.65 pd=3.3 as=0 ps=0 w=1 l=0.5
X8687 rr3t3r_0[7|20]/a_860_290# WL7 SL20 VSS sky130_fd_pr__nfet_g5v0d10v5 ad=0.65 pd=3.3 as=0 ps=0 w=1 l=0.5
X8688 BLP20 rr3t3r_0[8|20]/a_60_290# sky130_fd_pr_reram__reram_cell area_ox=0.0676
X8689 BLZ20 rr3t3r_0[8|20]/a_460_290# sky130_fd_pr_reram__reram_cell area_ox=0.0676
X8690 rr3t3r_0[8|20]/a_460_290# WL8 SL20 VSS sky130_fd_pr__nfet_g5v0d10v5 ad=0.65 pd=3.3 as=0 ps=0 w=1 l=0.5
X8691 BLN20 rr3t3r_0[8|20]/a_860_290# sky130_fd_pr_reram__reram_cell area_ox=0.0676
X8692 rr3t3r_0[8|20]/a_60_290# WL8 SL20 VSS sky130_fd_pr__nfet_g5v0d10v5 ad=0.65 pd=3.3 as=0 ps=0 w=1 l=0.5
X8693 rr3t3r_0[8|20]/a_860_290# WL8 SL20 VSS sky130_fd_pr__nfet_g5v0d10v5 ad=0.65 pd=3.3 as=0 ps=0 w=1 l=0.5
X8694 BLP20 rr3t3r_0[9|20]/a_60_290# sky130_fd_pr_reram__reram_cell area_ox=0.0676
X8695 BLZ20 rr3t3r_0[9|20]/a_460_290# sky130_fd_pr_reram__reram_cell area_ox=0.0676
X8696 rr3t3r_0[9|20]/a_460_290# WL9 SL20 VSS sky130_fd_pr__nfet_g5v0d10v5 ad=0.65 pd=3.3 as=0 ps=0 w=1 l=0.5
X8697 BLN20 rr3t3r_0[9|20]/a_860_290# sky130_fd_pr_reram__reram_cell area_ox=0.0676
X8698 rr3t3r_0[9|20]/a_60_290# WL9 SL20 VSS sky130_fd_pr__nfet_g5v0d10v5 ad=0.65 pd=3.3 as=0 ps=0 w=1 l=0.5
X8699 rr3t3r_0[9|20]/a_860_290# WL9 SL20 VSS sky130_fd_pr__nfet_g5v0d10v5 ad=0.65 pd=3.3 as=0 ps=0 w=1 l=0.5
X8700 BLP20 rr3t3r_0[10|20]/a_60_290# sky130_fd_pr_reram__reram_cell area_ox=0.0676
X8701 BLZ20 rr3t3r_0[10|20]/a_460_290# sky130_fd_pr_reram__reram_cell area_ox=0.0676
X8702 rr3t3r_0[10|20]/a_460_290# WL10 SL20 VSS sky130_fd_pr__nfet_g5v0d10v5 ad=0.65 pd=3.3 as=0 ps=0 w=1 l=0.5
X8703 BLN20 rr3t3r_0[10|20]/a_860_290# sky130_fd_pr_reram__reram_cell area_ox=0.0676
X8704 rr3t3r_0[10|20]/a_60_290# WL10 SL20 VSS sky130_fd_pr__nfet_g5v0d10v5 ad=0.65 pd=3.3 as=0 ps=0 w=1 l=0.5
X8705 rr3t3r_0[10|20]/a_860_290# WL10 SL20 VSS sky130_fd_pr__nfet_g5v0d10v5 ad=0.65 pd=3.3 as=0 ps=0 w=1 l=0.5
X8706 BLP20 rr3t3r_0[11|20]/a_60_290# sky130_fd_pr_reram__reram_cell area_ox=0.0676
X8707 BLZ20 rr3t3r_0[11|20]/a_460_290# sky130_fd_pr_reram__reram_cell area_ox=0.0676
X8708 rr3t3r_0[11|20]/a_460_290# WL11 SL20 VSS sky130_fd_pr__nfet_g5v0d10v5 ad=0.65 pd=3.3 as=0 ps=0 w=1 l=0.5
X8709 BLN20 rr3t3r_0[11|20]/a_860_290# sky130_fd_pr_reram__reram_cell area_ox=0.0676
X8710 rr3t3r_0[11|20]/a_60_290# WL11 SL20 VSS sky130_fd_pr__nfet_g5v0d10v5 ad=0.65 pd=3.3 as=0 ps=0 w=1 l=0.5
X8711 rr3t3r_0[11|20]/a_860_290# WL11 SL20 VSS sky130_fd_pr__nfet_g5v0d10v5 ad=0.65 pd=3.3 as=0 ps=0 w=1 l=0.5
X8712 BLP20 rr3t3r_0[12|20]/a_60_290# sky130_fd_pr_reram__reram_cell area_ox=0.0676
X8713 BLZ20 rr3t3r_0[12|20]/a_460_290# sky130_fd_pr_reram__reram_cell area_ox=0.0676
X8714 rr3t3r_0[12|20]/a_460_290# WL12 SL20 VSS sky130_fd_pr__nfet_g5v0d10v5 ad=0.65 pd=3.3 as=0 ps=0 w=1 l=0.5
X8715 BLN20 rr3t3r_0[12|20]/a_860_290# sky130_fd_pr_reram__reram_cell area_ox=0.0676
X8716 rr3t3r_0[12|20]/a_60_290# WL12 SL20 VSS sky130_fd_pr__nfet_g5v0d10v5 ad=0.65 pd=3.3 as=0 ps=0 w=1 l=0.5
X8717 rr3t3r_0[12|20]/a_860_290# WL12 SL20 VSS sky130_fd_pr__nfet_g5v0d10v5 ad=0.65 pd=3.3 as=0 ps=0 w=1 l=0.5
X8718 BLP20 rr3t3r_0[13|20]/a_60_290# sky130_fd_pr_reram__reram_cell area_ox=0.0676
X8719 BLZ20 rr3t3r_0[13|20]/a_460_290# sky130_fd_pr_reram__reram_cell area_ox=0.0676
X8720 rr3t3r_0[13|20]/a_460_290# WL13 SL20 VSS sky130_fd_pr__nfet_g5v0d10v5 ad=0.65 pd=3.3 as=0 ps=0 w=1 l=0.5
X8721 BLN20 rr3t3r_0[13|20]/a_860_290# sky130_fd_pr_reram__reram_cell area_ox=0.0676
X8722 rr3t3r_0[13|20]/a_60_290# WL13 SL20 VSS sky130_fd_pr__nfet_g5v0d10v5 ad=0.65 pd=3.3 as=0 ps=0 w=1 l=0.5
X8723 rr3t3r_0[13|20]/a_860_290# WL13 SL20 VSS sky130_fd_pr__nfet_g5v0d10v5 ad=0.65 pd=3.3 as=0 ps=0 w=1 l=0.5
X8724 BLP20 rr3t3r_0[14|20]/a_60_290# sky130_fd_pr_reram__reram_cell area_ox=0.0676
X8725 BLZ20 rr3t3r_0[14|20]/a_460_290# sky130_fd_pr_reram__reram_cell area_ox=0.0676
X8726 rr3t3r_0[14|20]/a_460_290# WL14 SL20 VSS sky130_fd_pr__nfet_g5v0d10v5 ad=0.65 pd=3.3 as=0 ps=0 w=1 l=0.5
X8727 BLN20 rr3t3r_0[14|20]/a_860_290# sky130_fd_pr_reram__reram_cell area_ox=0.0676
X8728 rr3t3r_0[14|20]/a_60_290# WL14 SL20 VSS sky130_fd_pr__nfet_g5v0d10v5 ad=0.65 pd=3.3 as=0 ps=0 w=1 l=0.5
X8729 rr3t3r_0[14|20]/a_860_290# WL14 SL20 VSS sky130_fd_pr__nfet_g5v0d10v5 ad=0.65 pd=3.3 as=0 ps=0 w=1 l=0.5
X8730 BLP20 rr3t3r_0[15|20]/a_60_290# sky130_fd_pr_reram__reram_cell area_ox=0.0676
X8731 BLZ20 rr3t3r_0[15|20]/a_460_290# sky130_fd_pr_reram__reram_cell area_ox=0.0676
X8732 rr3t3r_0[15|20]/a_460_290# WL15 SL20 VSS sky130_fd_pr__nfet_g5v0d10v5 ad=0.65 pd=3.3 as=0 ps=0 w=1 l=0.5
X8733 BLN20 rr3t3r_0[15|20]/a_860_290# sky130_fd_pr_reram__reram_cell area_ox=0.0676
X8734 rr3t3r_0[15|20]/a_60_290# WL15 SL20 VSS sky130_fd_pr__nfet_g5v0d10v5 ad=0.65 pd=3.3 as=0 ps=0 w=1 l=0.5
X8735 rr3t3r_0[15|20]/a_860_290# WL15 SL20 VSS sky130_fd_pr__nfet_g5v0d10v5 ad=0.65 pd=3.3 as=0 ps=0 w=1 l=0.5
X8736 BLP20 rr3t3r_0[16|20]/a_60_290# sky130_fd_pr_reram__reram_cell area_ox=0.0676
X8737 BLZ20 rr3t3r_0[16|20]/a_460_290# sky130_fd_pr_reram__reram_cell area_ox=0.0676
X8738 rr3t3r_0[16|20]/a_460_290# WL16 SL20 VSS sky130_fd_pr__nfet_g5v0d10v5 ad=0.65 pd=3.3 as=0 ps=0 w=1 l=0.5
X8739 BLN20 rr3t3r_0[16|20]/a_860_290# sky130_fd_pr_reram__reram_cell area_ox=0.0676
X8740 rr3t3r_0[16|20]/a_60_290# WL16 SL20 VSS sky130_fd_pr__nfet_g5v0d10v5 ad=0.65 pd=3.3 as=0 ps=0 w=1 l=0.5
X8741 rr3t3r_0[16|20]/a_860_290# WL16 SL20 VSS sky130_fd_pr__nfet_g5v0d10v5 ad=0.65 pd=3.3 as=0 ps=0 w=1 l=0.5
X8742 BLP20 rr3t3r_0[17|20]/a_60_290# sky130_fd_pr_reram__reram_cell area_ox=0.0676
X8743 BLZ20 rr3t3r_0[17|20]/a_460_290# sky130_fd_pr_reram__reram_cell area_ox=0.0676
X8744 rr3t3r_0[17|20]/a_460_290# WL17 SL20 VSS sky130_fd_pr__nfet_g5v0d10v5 ad=0.65 pd=3.3 as=0 ps=0 w=1 l=0.5
X8745 BLN20 rr3t3r_0[17|20]/a_860_290# sky130_fd_pr_reram__reram_cell area_ox=0.0676
X8746 rr3t3r_0[17|20]/a_60_290# WL17 SL20 VSS sky130_fd_pr__nfet_g5v0d10v5 ad=0.65 pd=3.3 as=0 ps=0 w=1 l=0.5
X8747 rr3t3r_0[17|20]/a_860_290# WL17 SL20 VSS sky130_fd_pr__nfet_g5v0d10v5 ad=0.65 pd=3.3 as=0 ps=0 w=1 l=0.5
X8748 BLP20 rr3t3r_0[18|20]/a_60_290# sky130_fd_pr_reram__reram_cell area_ox=0.0676
X8749 BLZ20 rr3t3r_0[18|20]/a_460_290# sky130_fd_pr_reram__reram_cell area_ox=0.0676
X8750 rr3t3r_0[18|20]/a_460_290# WL18 SL20 VSS sky130_fd_pr__nfet_g5v0d10v5 ad=0.65 pd=3.3 as=0 ps=0 w=1 l=0.5
X8751 BLN20 rr3t3r_0[18|20]/a_860_290# sky130_fd_pr_reram__reram_cell area_ox=0.0676
X8752 rr3t3r_0[18|20]/a_60_290# WL18 SL20 VSS sky130_fd_pr__nfet_g5v0d10v5 ad=0.65 pd=3.3 as=0 ps=0 w=1 l=0.5
X8753 rr3t3r_0[18|20]/a_860_290# WL18 SL20 VSS sky130_fd_pr__nfet_g5v0d10v5 ad=0.65 pd=3.3 as=0 ps=0 w=1 l=0.5
X8754 BLP20 rr3t3r_0[19|20]/a_60_290# sky130_fd_pr_reram__reram_cell area_ox=0.0676
X8755 BLZ20 rr3t3r_0[19|20]/a_460_290# sky130_fd_pr_reram__reram_cell area_ox=0.0676
X8756 rr3t3r_0[19|20]/a_460_290# WL19 SL20 VSS sky130_fd_pr__nfet_g5v0d10v5 ad=0.65 pd=3.3 as=0 ps=0 w=1 l=0.5
X8757 BLN20 rr3t3r_0[19|20]/a_860_290# sky130_fd_pr_reram__reram_cell area_ox=0.0676
X8758 rr3t3r_0[19|20]/a_60_290# WL19 SL20 VSS sky130_fd_pr__nfet_g5v0d10v5 ad=0.65 pd=3.3 as=0 ps=0 w=1 l=0.5
X8759 rr3t3r_0[19|20]/a_860_290# WL19 SL20 VSS sky130_fd_pr__nfet_g5v0d10v5 ad=0.65 pd=3.3 as=0 ps=0 w=1 l=0.5
X8760 BLP20 rr3t3r_0[20|20]/a_60_290# sky130_fd_pr_reram__reram_cell area_ox=0.0676
X8761 BLZ20 rr3t3r_0[20|20]/a_460_290# sky130_fd_pr_reram__reram_cell area_ox=0.0676
X8762 rr3t3r_0[20|20]/a_460_290# WL20 SL20 VSS sky130_fd_pr__nfet_g5v0d10v5 ad=0.65 pd=3.3 as=0 ps=0 w=1 l=0.5
X8763 BLN20 rr3t3r_0[20|20]/a_860_290# sky130_fd_pr_reram__reram_cell area_ox=0.0676
X8764 rr3t3r_0[20|20]/a_60_290# WL20 SL20 VSS sky130_fd_pr__nfet_g5v0d10v5 ad=0.65 pd=3.3 as=0 ps=0 w=1 l=0.5
X8765 rr3t3r_0[20|20]/a_860_290# WL20 SL20 VSS sky130_fd_pr__nfet_g5v0d10v5 ad=0.65 pd=3.3 as=0 ps=0 w=1 l=0.5
X8766 BLP20 rr3t3r_0[21|20]/a_60_290# sky130_fd_pr_reram__reram_cell area_ox=0.0676
X8767 BLZ20 rr3t3r_0[21|20]/a_460_290# sky130_fd_pr_reram__reram_cell area_ox=0.0676
X8768 rr3t3r_0[21|20]/a_460_290# WL21 SL20 VSS sky130_fd_pr__nfet_g5v0d10v5 ad=0.65 pd=3.3 as=0 ps=0 w=1 l=0.5
X8769 BLN20 rr3t3r_0[21|20]/a_860_290# sky130_fd_pr_reram__reram_cell area_ox=0.0676
X8770 rr3t3r_0[21|20]/a_60_290# WL21 SL20 VSS sky130_fd_pr__nfet_g5v0d10v5 ad=0.65 pd=3.3 as=0 ps=0 w=1 l=0.5
X8771 rr3t3r_0[21|20]/a_860_290# WL21 SL20 VSS sky130_fd_pr__nfet_g5v0d10v5 ad=0.65 pd=3.3 as=0 ps=0 w=1 l=0.5
X8772 BLP20 rr3t3r_0[22|20]/a_60_290# sky130_fd_pr_reram__reram_cell area_ox=0.0676
X8773 BLZ20 rr3t3r_0[22|20]/a_460_290# sky130_fd_pr_reram__reram_cell area_ox=0.0676
X8774 rr3t3r_0[22|20]/a_460_290# WL22 SL20 VSS sky130_fd_pr__nfet_g5v0d10v5 ad=0.65 pd=3.3 as=0 ps=0 w=1 l=0.5
X8775 BLN20 rr3t3r_0[22|20]/a_860_290# sky130_fd_pr_reram__reram_cell area_ox=0.0676
X8776 rr3t3r_0[22|20]/a_60_290# WL22 SL20 VSS sky130_fd_pr__nfet_g5v0d10v5 ad=0.65 pd=3.3 as=0 ps=0 w=1 l=0.5
X8777 rr3t3r_0[22|20]/a_860_290# WL22 SL20 VSS sky130_fd_pr__nfet_g5v0d10v5 ad=0.65 pd=3.3 as=0 ps=0 w=1 l=0.5
X8778 BLP20 rr3t3r_0[23|20]/a_60_290# sky130_fd_pr_reram__reram_cell area_ox=0.0676
X8779 BLZ20 rr3t3r_0[23|20]/a_460_290# sky130_fd_pr_reram__reram_cell area_ox=0.0676
X8780 rr3t3r_0[23|20]/a_460_290# WL23 SL20 VSS sky130_fd_pr__nfet_g5v0d10v5 ad=0.65 pd=3.3 as=0 ps=0 w=1 l=0.5
X8781 BLN20 rr3t3r_0[23|20]/a_860_290# sky130_fd_pr_reram__reram_cell area_ox=0.0676
X8782 rr3t3r_0[23|20]/a_60_290# WL23 SL20 VSS sky130_fd_pr__nfet_g5v0d10v5 ad=0.65 pd=3.3 as=0 ps=0 w=1 l=0.5
X8783 rr3t3r_0[23|20]/a_860_290# WL23 SL20 VSS sky130_fd_pr__nfet_g5v0d10v5 ad=0.65 pd=3.3 as=0 ps=0 w=1 l=0.5
X8784 BLP20 rr3t3r_0[24|20]/a_60_290# sky130_fd_pr_reram__reram_cell area_ox=0.0676
X8785 BLZ20 rr3t3r_0[24|20]/a_460_290# sky130_fd_pr_reram__reram_cell area_ox=0.0676
X8786 rr3t3r_0[24|20]/a_460_290# WL24 SL20 VSS sky130_fd_pr__nfet_g5v0d10v5 ad=0.65 pd=3.3 as=0 ps=0 w=1 l=0.5
X8787 BLN20 rr3t3r_0[24|20]/a_860_290# sky130_fd_pr_reram__reram_cell area_ox=0.0676
X8788 rr3t3r_0[24|20]/a_60_290# WL24 SL20 VSS sky130_fd_pr__nfet_g5v0d10v5 ad=0.65 pd=3.3 as=0 ps=0 w=1 l=0.5
X8789 rr3t3r_0[24|20]/a_860_290# WL24 SL20 VSS sky130_fd_pr__nfet_g5v0d10v5 ad=0.65 pd=3.3 as=0 ps=0 w=1 l=0.5
X8790 BLP20 rr3t3r_0[25|20]/a_60_290# sky130_fd_pr_reram__reram_cell area_ox=0.0676
X8791 BLZ20 rr3t3r_0[25|20]/a_460_290# sky130_fd_pr_reram__reram_cell area_ox=0.0676
X8792 rr3t3r_0[25|20]/a_460_290# WL25 SL20 VSS sky130_fd_pr__nfet_g5v0d10v5 ad=0.65 pd=3.3 as=0 ps=0 w=1 l=0.5
X8793 BLN20 rr3t3r_0[25|20]/a_860_290# sky130_fd_pr_reram__reram_cell area_ox=0.0676
X8794 rr3t3r_0[25|20]/a_60_290# WL25 SL20 VSS sky130_fd_pr__nfet_g5v0d10v5 ad=0.65 pd=3.3 as=0 ps=0 w=1 l=0.5
X8795 rr3t3r_0[25|20]/a_860_290# WL25 SL20 VSS sky130_fd_pr__nfet_g5v0d10v5 ad=0.65 pd=3.3 as=0 ps=0 w=1 l=0.5
X8796 BLP20 rr3t3r_0[26|20]/a_60_290# sky130_fd_pr_reram__reram_cell area_ox=0.0676
X8797 BLZ20 rr3t3r_0[26|20]/a_460_290# sky130_fd_pr_reram__reram_cell area_ox=0.0676
X8798 rr3t3r_0[26|20]/a_460_290# WL26 SL20 VSS sky130_fd_pr__nfet_g5v0d10v5 ad=0.65 pd=3.3 as=0 ps=0 w=1 l=0.5
X8799 BLN20 rr3t3r_0[26|20]/a_860_290# sky130_fd_pr_reram__reram_cell area_ox=0.0676
X8800 rr3t3r_0[26|20]/a_60_290# WL26 SL20 VSS sky130_fd_pr__nfet_g5v0d10v5 ad=0.65 pd=3.3 as=0 ps=0 w=1 l=0.5
X8801 rr3t3r_0[26|20]/a_860_290# WL26 SL20 VSS sky130_fd_pr__nfet_g5v0d10v5 ad=0.65 pd=3.3 as=0 ps=0 w=1 l=0.5
X8802 BLP20 rr3t3r_0[27|20]/a_60_290# sky130_fd_pr_reram__reram_cell area_ox=0.0676
X8803 BLZ20 rr3t3r_0[27|20]/a_460_290# sky130_fd_pr_reram__reram_cell area_ox=0.0676
X8804 rr3t3r_0[27|20]/a_460_290# WL27 SL20 VSS sky130_fd_pr__nfet_g5v0d10v5 ad=0.65 pd=3.3 as=0 ps=0 w=1 l=0.5
X8805 BLN20 rr3t3r_0[27|20]/a_860_290# sky130_fd_pr_reram__reram_cell area_ox=0.0676
X8806 rr3t3r_0[27|20]/a_60_290# WL27 SL20 VSS sky130_fd_pr__nfet_g5v0d10v5 ad=0.65 pd=3.3 as=0 ps=0 w=1 l=0.5
X8807 rr3t3r_0[27|20]/a_860_290# WL27 SL20 VSS sky130_fd_pr__nfet_g5v0d10v5 ad=0.65 pd=3.3 as=0 ps=0 w=1 l=0.5
X8808 BLP20 rr3t3r_0[28|20]/a_60_290# sky130_fd_pr_reram__reram_cell area_ox=0.0676
X8809 BLZ20 rr3t3r_0[28|20]/a_460_290# sky130_fd_pr_reram__reram_cell area_ox=0.0676
X8810 rr3t3r_0[28|20]/a_460_290# WL28 SL20 VSS sky130_fd_pr__nfet_g5v0d10v5 ad=0.65 pd=3.3 as=0 ps=0 w=1 l=0.5
X8811 BLN20 rr3t3r_0[28|20]/a_860_290# sky130_fd_pr_reram__reram_cell area_ox=0.0676
X8812 rr3t3r_0[28|20]/a_60_290# WL28 SL20 VSS sky130_fd_pr__nfet_g5v0d10v5 ad=0.65 pd=3.3 as=0 ps=0 w=1 l=0.5
X8813 rr3t3r_0[28|20]/a_860_290# WL28 SL20 VSS sky130_fd_pr__nfet_g5v0d10v5 ad=0.65 pd=3.3 as=0 ps=0 w=1 l=0.5
X8814 BLP20 rr3t3r_0[29|20]/a_60_290# sky130_fd_pr_reram__reram_cell area_ox=0.0676
X8815 BLZ20 rr3t3r_0[29|20]/a_460_290# sky130_fd_pr_reram__reram_cell area_ox=0.0676
X8816 rr3t3r_0[29|20]/a_460_290# WL29 SL20 VSS sky130_fd_pr__nfet_g5v0d10v5 ad=0.65 pd=3.3 as=0 ps=0 w=1 l=0.5
X8817 BLN20 rr3t3r_0[29|20]/a_860_290# sky130_fd_pr_reram__reram_cell area_ox=0.0676
X8818 rr3t3r_0[29|20]/a_60_290# WL29 SL20 VSS sky130_fd_pr__nfet_g5v0d10v5 ad=0.65 pd=3.3 as=0 ps=0 w=1 l=0.5
X8819 rr3t3r_0[29|20]/a_860_290# WL29 SL20 VSS sky130_fd_pr__nfet_g5v0d10v5 ad=0.65 pd=3.3 as=0 ps=0 w=1 l=0.5
X8820 BLP20 rr3t3r_0[30|20]/a_60_290# sky130_fd_pr_reram__reram_cell area_ox=0.0676
X8821 BLZ20 rr3t3r_0[30|20]/a_460_290# sky130_fd_pr_reram__reram_cell area_ox=0.0676
X8822 rr3t3r_0[30|20]/a_460_290# WL30 SL20 VSS sky130_fd_pr__nfet_g5v0d10v5 ad=0.65 pd=3.3 as=0 ps=0 w=1 l=0.5
X8823 BLN20 rr3t3r_0[30|20]/a_860_290# sky130_fd_pr_reram__reram_cell area_ox=0.0676
X8824 rr3t3r_0[30|20]/a_60_290# WL30 SL20 VSS sky130_fd_pr__nfet_g5v0d10v5 ad=0.65 pd=3.3 as=0 ps=0 w=1 l=0.5
X8825 rr3t3r_0[30|20]/a_860_290# WL30 SL20 VSS sky130_fd_pr__nfet_g5v0d10v5 ad=0.65 pd=3.3 as=0 ps=0 w=1 l=0.5
X8826 BLP20 rr3t3r_0[31|20]/a_60_290# sky130_fd_pr_reram__reram_cell area_ox=0.0676
X8827 BLZ20 rr3t3r_0[31|20]/a_460_290# sky130_fd_pr_reram__reram_cell area_ox=0.0676
X8828 rr3t3r_0[31|20]/a_460_290# WL31 SL20 VSS sky130_fd_pr__nfet_g5v0d10v5 ad=0.65 pd=3.3 as=0 ps=0 w=1 l=0.5
X8829 BLN20 rr3t3r_0[31|20]/a_860_290# sky130_fd_pr_reram__reram_cell area_ox=0.0676
X8830 rr3t3r_0[31|20]/a_60_290# WL31 SL20 VSS sky130_fd_pr__nfet_g5v0d10v5 ad=0.65 pd=3.3 as=0 ps=0 w=1 l=0.5
X8831 rr3t3r_0[31|20]/a_860_290# WL31 SL20 VSS sky130_fd_pr__nfet_g5v0d10v5 ad=0.65 pd=3.3 as=0 ps=0 w=1 l=0.5
X8832 BLP20 rr3t3r_0[32|20]/a_60_290# sky130_fd_pr_reram__reram_cell area_ox=0.0676
X8833 BLZ20 rr3t3r_0[32|20]/a_460_290# sky130_fd_pr_reram__reram_cell area_ox=0.0676
X8834 rr3t3r_0[32|20]/a_460_290# WL32 SL20 VSS sky130_fd_pr__nfet_g5v0d10v5 ad=0.65 pd=3.3 as=0 ps=0 w=1 l=0.5
X8835 BLN20 rr3t3r_0[32|20]/a_860_290# sky130_fd_pr_reram__reram_cell area_ox=0.0676
X8836 rr3t3r_0[32|20]/a_60_290# WL32 SL20 VSS sky130_fd_pr__nfet_g5v0d10v5 ad=0.65 pd=3.3 as=0 ps=0 w=1 l=0.5
X8837 rr3t3r_0[32|20]/a_860_290# WL32 SL20 VSS sky130_fd_pr__nfet_g5v0d10v5 ad=0.65 pd=3.3 as=0 ps=0 w=1 l=0.5
X8838 BLP20 rr3t3r_0[33|20]/a_60_290# sky130_fd_pr_reram__reram_cell area_ox=0.0676
X8839 BLZ20 rr3t3r_0[33|20]/a_460_290# sky130_fd_pr_reram__reram_cell area_ox=0.0676
X8840 rr3t3r_0[33|20]/a_460_290# WL33 SL20 VSS sky130_fd_pr__nfet_g5v0d10v5 ad=0.65 pd=3.3 as=0 ps=0 w=1 l=0.5
X8841 BLN20 rr3t3r_0[33|20]/a_860_290# sky130_fd_pr_reram__reram_cell area_ox=0.0676
X8842 rr3t3r_0[33|20]/a_60_290# WL33 SL20 VSS sky130_fd_pr__nfet_g5v0d10v5 ad=0.65 pd=3.3 as=0 ps=0 w=1 l=0.5
X8843 rr3t3r_0[33|20]/a_860_290# WL33 SL20 VSS sky130_fd_pr__nfet_g5v0d10v5 ad=0.65 pd=3.3 as=0 ps=0 w=1 l=0.5
X8844 BLP20 rr3t3r_0[34|20]/a_60_290# sky130_fd_pr_reram__reram_cell area_ox=0.0676
X8845 BLZ20 rr3t3r_0[34|20]/a_460_290# sky130_fd_pr_reram__reram_cell area_ox=0.0676
X8846 rr3t3r_0[34|20]/a_460_290# WL34 SL20 VSS sky130_fd_pr__nfet_g5v0d10v5 ad=0.65 pd=3.3 as=0 ps=0 w=1 l=0.5
X8847 BLN20 rr3t3r_0[34|20]/a_860_290# sky130_fd_pr_reram__reram_cell area_ox=0.0676
X8848 rr3t3r_0[34|20]/a_60_290# WL34 SL20 VSS sky130_fd_pr__nfet_g5v0d10v5 ad=0.65 pd=3.3 as=0 ps=0 w=1 l=0.5
X8849 rr3t3r_0[34|20]/a_860_290# WL34 SL20 VSS sky130_fd_pr__nfet_g5v0d10v5 ad=0.65 pd=3.3 as=0 ps=0 w=1 l=0.5
X8850 BLP20 rr3t3r_0[35|20]/a_60_290# sky130_fd_pr_reram__reram_cell area_ox=0.0676
X8851 BLZ20 rr3t3r_0[35|20]/a_460_290# sky130_fd_pr_reram__reram_cell area_ox=0.0676
X8852 rr3t3r_0[35|20]/a_460_290# WL35 SL20 VSS sky130_fd_pr__nfet_g5v0d10v5 ad=0.65 pd=3.3 as=0 ps=0 w=1 l=0.5
X8853 BLN20 rr3t3r_0[35|20]/a_860_290# sky130_fd_pr_reram__reram_cell area_ox=0.0676
X8854 rr3t3r_0[35|20]/a_60_290# WL35 SL20 VSS sky130_fd_pr__nfet_g5v0d10v5 ad=0.65 pd=3.3 as=0 ps=0 w=1 l=0.5
X8855 rr3t3r_0[35|20]/a_860_290# WL35 SL20 VSS sky130_fd_pr__nfet_g5v0d10v5 ad=0.65 pd=3.3 as=0 ps=0 w=1 l=0.5
X8856 BLP20 rr3t3r_0[36|20]/a_60_290# sky130_fd_pr_reram__reram_cell area_ox=0.0676
X8857 BLZ20 rr3t3r_0[36|20]/a_460_290# sky130_fd_pr_reram__reram_cell area_ox=0.0676
X8858 rr3t3r_0[36|20]/a_460_290# WL36 SL20 VSS sky130_fd_pr__nfet_g5v0d10v5 ad=0.65 pd=3.3 as=0 ps=0 w=1 l=0.5
X8859 BLN20 rr3t3r_0[36|20]/a_860_290# sky130_fd_pr_reram__reram_cell area_ox=0.0676
X8860 rr3t3r_0[36|20]/a_60_290# WL36 SL20 VSS sky130_fd_pr__nfet_g5v0d10v5 ad=0.65 pd=3.3 as=0 ps=0 w=1 l=0.5
X8861 rr3t3r_0[36|20]/a_860_290# WL36 SL20 VSS sky130_fd_pr__nfet_g5v0d10v5 ad=0.65 pd=3.3 as=0 ps=0 w=1 l=0.5
X8862 BLP20 rr3t3r_0[37|20]/a_60_290# sky130_fd_pr_reram__reram_cell area_ox=0.0676
X8863 BLZ20 rr3t3r_0[37|20]/a_460_290# sky130_fd_pr_reram__reram_cell area_ox=0.0676
X8864 rr3t3r_0[37|20]/a_460_290# WL37 SL20 VSS sky130_fd_pr__nfet_g5v0d10v5 ad=0.65 pd=3.3 as=0 ps=0 w=1 l=0.5
X8865 BLN20 rr3t3r_0[37|20]/a_860_290# sky130_fd_pr_reram__reram_cell area_ox=0.0676
X8866 rr3t3r_0[37|20]/a_60_290# WL37 SL20 VSS sky130_fd_pr__nfet_g5v0d10v5 ad=0.65 pd=3.3 as=0 ps=0 w=1 l=0.5
X8867 rr3t3r_0[37|20]/a_860_290# WL37 SL20 VSS sky130_fd_pr__nfet_g5v0d10v5 ad=0.65 pd=3.3 as=0 ps=0 w=1 l=0.5
X8868 BLP20 rr3t3r_0[38|20]/a_60_290# sky130_fd_pr_reram__reram_cell area_ox=0.0676
X8869 BLZ20 rr3t3r_0[38|20]/a_460_290# sky130_fd_pr_reram__reram_cell area_ox=0.0676
X8870 rr3t3r_0[38|20]/a_460_290# WL38 SL20 VSS sky130_fd_pr__nfet_g5v0d10v5 ad=0.65 pd=3.3 as=0 ps=0 w=1 l=0.5
X8871 BLN20 rr3t3r_0[38|20]/a_860_290# sky130_fd_pr_reram__reram_cell area_ox=0.0676
X8872 rr3t3r_0[38|20]/a_60_290# WL38 SL20 VSS sky130_fd_pr__nfet_g5v0d10v5 ad=0.65 pd=3.3 as=0 ps=0 w=1 l=0.5
X8873 rr3t3r_0[38|20]/a_860_290# WL38 SL20 VSS sky130_fd_pr__nfet_g5v0d10v5 ad=0.65 pd=3.3 as=0 ps=0 w=1 l=0.5
X8874 BLP20 rr3t3r_0[39|20]/a_60_290# sky130_fd_pr_reram__reram_cell area_ox=0.0676
X8875 BLZ20 rr3t3r_0[39|20]/a_460_290# sky130_fd_pr_reram__reram_cell area_ox=0.0676
X8876 rr3t3r_0[39|20]/a_460_290# WL39 SL20 VSS sky130_fd_pr__nfet_g5v0d10v5 ad=0.65 pd=3.3 as=0 ps=0 w=1 l=0.5
X8877 BLN20 rr3t3r_0[39|20]/a_860_290# sky130_fd_pr_reram__reram_cell area_ox=0.0676
X8878 rr3t3r_0[39|20]/a_60_290# WL39 SL20 VSS sky130_fd_pr__nfet_g5v0d10v5 ad=0.65 pd=3.3 as=0 ps=0 w=1 l=0.5
X8879 rr3t3r_0[39|20]/a_860_290# WL39 SL20 VSS sky130_fd_pr__nfet_g5v0d10v5 ad=0.65 pd=3.3 as=0 ps=0 w=1 l=0.5
X8880 BLP20 rr3t3r_0[40|20]/a_60_290# sky130_fd_pr_reram__reram_cell area_ox=0.0676
X8881 BLZ20 rr3t3r_0[40|20]/a_460_290# sky130_fd_pr_reram__reram_cell area_ox=0.0676
X8882 rr3t3r_0[40|20]/a_460_290# WL40 SL20 VSS sky130_fd_pr__nfet_g5v0d10v5 ad=0.65 pd=3.3 as=0 ps=0 w=1 l=0.5
X8883 BLN20 rr3t3r_0[40|20]/a_860_290# sky130_fd_pr_reram__reram_cell area_ox=0.0676
X8884 rr3t3r_0[40|20]/a_60_290# WL40 SL20 VSS sky130_fd_pr__nfet_g5v0d10v5 ad=0.65 pd=3.3 as=0 ps=0 w=1 l=0.5
X8885 rr3t3r_0[40|20]/a_860_290# WL40 SL20 VSS sky130_fd_pr__nfet_g5v0d10v5 ad=0.65 pd=3.3 as=0 ps=0 w=1 l=0.5
X8886 BLP20 rr3t3r_0[41|20]/a_60_290# sky130_fd_pr_reram__reram_cell area_ox=0.0676
X8887 BLZ20 rr3t3r_0[41|20]/a_460_290# sky130_fd_pr_reram__reram_cell area_ox=0.0676
X8888 rr3t3r_0[41|20]/a_460_290# WL41 SL20 VSS sky130_fd_pr__nfet_g5v0d10v5 ad=0.65 pd=3.3 as=0 ps=0 w=1 l=0.5
X8889 BLN20 rr3t3r_0[41|20]/a_860_290# sky130_fd_pr_reram__reram_cell area_ox=0.0676
X8890 rr3t3r_0[41|20]/a_60_290# WL41 SL20 VSS sky130_fd_pr__nfet_g5v0d10v5 ad=0.65 pd=3.3 as=0 ps=0 w=1 l=0.5
X8891 rr3t3r_0[41|20]/a_860_290# WL41 SL20 VSS sky130_fd_pr__nfet_g5v0d10v5 ad=0.65 pd=3.3 as=0 ps=0 w=1 l=0.5
X8892 BLP20 rr3t3r_0[42|20]/a_60_290# sky130_fd_pr_reram__reram_cell area_ox=0.0676
X8893 BLZ20 rr3t3r_0[42|20]/a_460_290# sky130_fd_pr_reram__reram_cell area_ox=0.0676
X8894 rr3t3r_0[42|20]/a_460_290# WL42 SL20 VSS sky130_fd_pr__nfet_g5v0d10v5 ad=0.65 pd=3.3 as=0 ps=0 w=1 l=0.5
X8895 BLN20 rr3t3r_0[42|20]/a_860_290# sky130_fd_pr_reram__reram_cell area_ox=0.0676
X8896 rr3t3r_0[42|20]/a_60_290# WL42 SL20 VSS sky130_fd_pr__nfet_g5v0d10v5 ad=0.65 pd=3.3 as=0 ps=0 w=1 l=0.5
X8897 rr3t3r_0[42|20]/a_860_290# WL42 SL20 VSS sky130_fd_pr__nfet_g5v0d10v5 ad=0.65 pd=3.3 as=0 ps=0 w=1 l=0.5
X8898 BLP20 rr3t3r_0[43|20]/a_60_290# sky130_fd_pr_reram__reram_cell area_ox=0.0676
X8899 BLZ20 rr3t3r_0[43|20]/a_460_290# sky130_fd_pr_reram__reram_cell area_ox=0.0676
X8900 rr3t3r_0[43|20]/a_460_290# WL43 SL20 VSS sky130_fd_pr__nfet_g5v0d10v5 ad=0.65 pd=3.3 as=0 ps=0 w=1 l=0.5
X8901 BLN20 rr3t3r_0[43|20]/a_860_290# sky130_fd_pr_reram__reram_cell area_ox=0.0676
X8902 rr3t3r_0[43|20]/a_60_290# WL43 SL20 VSS sky130_fd_pr__nfet_g5v0d10v5 ad=0.65 pd=3.3 as=0 ps=0 w=1 l=0.5
X8903 rr3t3r_0[43|20]/a_860_290# WL43 SL20 VSS sky130_fd_pr__nfet_g5v0d10v5 ad=0.65 pd=3.3 as=0 ps=0 w=1 l=0.5
X8904 BLP20 rr3t3r_0[44|20]/a_60_290# sky130_fd_pr_reram__reram_cell area_ox=0.0676
X8905 BLZ20 rr3t3r_0[44|20]/a_460_290# sky130_fd_pr_reram__reram_cell area_ox=0.0676
X8906 rr3t3r_0[44|20]/a_460_290# WL44 SL20 VSS sky130_fd_pr__nfet_g5v0d10v5 ad=0.65 pd=3.3 as=0 ps=0 w=1 l=0.5
X8907 BLN20 rr3t3r_0[44|20]/a_860_290# sky130_fd_pr_reram__reram_cell area_ox=0.0676
X8908 rr3t3r_0[44|20]/a_60_290# WL44 SL20 VSS sky130_fd_pr__nfet_g5v0d10v5 ad=0.65 pd=3.3 as=0 ps=0 w=1 l=0.5
X8909 rr3t3r_0[44|20]/a_860_290# WL44 SL20 VSS sky130_fd_pr__nfet_g5v0d10v5 ad=0.65 pd=3.3 as=0 ps=0 w=1 l=0.5
X8910 BLP20 rr3t3r_0[45|20]/a_60_290# sky130_fd_pr_reram__reram_cell area_ox=0.0676
X8911 BLZ20 rr3t3r_0[45|20]/a_460_290# sky130_fd_pr_reram__reram_cell area_ox=0.0676
X8912 rr3t3r_0[45|20]/a_460_290# WL45 SL20 VSS sky130_fd_pr__nfet_g5v0d10v5 ad=0.65 pd=3.3 as=0 ps=0 w=1 l=0.5
X8913 BLN20 rr3t3r_0[45|20]/a_860_290# sky130_fd_pr_reram__reram_cell area_ox=0.0676
X8914 rr3t3r_0[45|20]/a_60_290# WL45 SL20 VSS sky130_fd_pr__nfet_g5v0d10v5 ad=0.65 pd=3.3 as=0 ps=0 w=1 l=0.5
X8915 rr3t3r_0[45|20]/a_860_290# WL45 SL20 VSS sky130_fd_pr__nfet_g5v0d10v5 ad=0.65 pd=3.3 as=0 ps=0 w=1 l=0.5
X8916 BLP20 rr3t3r_0[46|20]/a_60_290# sky130_fd_pr_reram__reram_cell area_ox=0.0676
X8917 BLZ20 rr3t3r_0[46|20]/a_460_290# sky130_fd_pr_reram__reram_cell area_ox=0.0676
X8918 rr3t3r_0[46|20]/a_460_290# WL46 SL20 VSS sky130_fd_pr__nfet_g5v0d10v5 ad=0.65 pd=3.3 as=0 ps=0 w=1 l=0.5
X8919 BLN20 rr3t3r_0[46|20]/a_860_290# sky130_fd_pr_reram__reram_cell area_ox=0.0676
X8920 rr3t3r_0[46|20]/a_60_290# WL46 SL20 VSS sky130_fd_pr__nfet_g5v0d10v5 ad=0.65 pd=3.3 as=0 ps=0 w=1 l=0.5
X8921 rr3t3r_0[46|20]/a_860_290# WL46 SL20 VSS sky130_fd_pr__nfet_g5v0d10v5 ad=0.65 pd=3.3 as=0 ps=0 w=1 l=0.5
X8922 BLP20 rr3t3r_0[47|20]/a_60_290# sky130_fd_pr_reram__reram_cell area_ox=0.0676
X8923 BLZ20 rr3t3r_0[47|20]/a_460_290# sky130_fd_pr_reram__reram_cell area_ox=0.0676
X8924 rr3t3r_0[47|20]/a_460_290# WL47 SL20 VSS sky130_fd_pr__nfet_g5v0d10v5 ad=0.65 pd=3.3 as=0 ps=0 w=1 l=0.5
X8925 BLN20 rr3t3r_0[47|20]/a_860_290# sky130_fd_pr_reram__reram_cell area_ox=0.0676
X8926 rr3t3r_0[47|20]/a_60_290# WL47 SL20 VSS sky130_fd_pr__nfet_g5v0d10v5 ad=0.65 pd=3.3 as=0 ps=0 w=1 l=0.5
X8927 rr3t3r_0[47|20]/a_860_290# WL47 SL20 VSS sky130_fd_pr__nfet_g5v0d10v5 ad=0.65 pd=3.3 as=0 ps=0 w=1 l=0.5
X8928 BLP20 rr3t3r_0[48|20]/a_60_290# sky130_fd_pr_reram__reram_cell area_ox=0.0676
X8929 BLZ20 rr3t3r_0[48|20]/a_460_290# sky130_fd_pr_reram__reram_cell area_ox=0.0676
X8930 rr3t3r_0[48|20]/a_460_290# WL48 SL20 VSS sky130_fd_pr__nfet_g5v0d10v5 ad=0.65 pd=3.3 as=0 ps=0 w=1 l=0.5
X8931 BLN20 rr3t3r_0[48|20]/a_860_290# sky130_fd_pr_reram__reram_cell area_ox=0.0676
X8932 rr3t3r_0[48|20]/a_60_290# WL48 SL20 VSS sky130_fd_pr__nfet_g5v0d10v5 ad=0.65 pd=3.3 as=0 ps=0 w=1 l=0.5
X8933 rr3t3r_0[48|20]/a_860_290# WL48 SL20 VSS sky130_fd_pr__nfet_g5v0d10v5 ad=0.65 pd=3.3 as=0 ps=0 w=1 l=0.5
X8934 BLP20 rr3t3r_0[49|20]/a_60_290# sky130_fd_pr_reram__reram_cell area_ox=0.0676
X8935 BLZ20 rr3t3r_0[49|20]/a_460_290# sky130_fd_pr_reram__reram_cell area_ox=0.0676
X8936 rr3t3r_0[49|20]/a_460_290# WL49 SL20 VSS sky130_fd_pr__nfet_g5v0d10v5 ad=0.65 pd=3.3 as=0 ps=0 w=1 l=0.5
X8937 BLN20 rr3t3r_0[49|20]/a_860_290# sky130_fd_pr_reram__reram_cell area_ox=0.0676
X8938 rr3t3r_0[49|20]/a_60_290# WL49 SL20 VSS sky130_fd_pr__nfet_g5v0d10v5 ad=0.65 pd=3.3 as=0 ps=0 w=1 l=0.5
X8939 rr3t3r_0[49|20]/a_860_290# WL49 SL20 VSS sky130_fd_pr__nfet_g5v0d10v5 ad=0.65 pd=3.3 as=0 ps=0 w=1 l=0.5
X8940 BLP20 rr3t3r_0[50|20]/a_60_290# sky130_fd_pr_reram__reram_cell area_ox=0.0676
X8941 BLZ20 rr3t3r_0[50|20]/a_460_290# sky130_fd_pr_reram__reram_cell area_ox=0.0676
X8942 rr3t3r_0[50|20]/a_460_290# WL50 SL20 VSS sky130_fd_pr__nfet_g5v0d10v5 ad=0.65 pd=3.3 as=0 ps=0 w=1 l=0.5
X8943 BLN20 rr3t3r_0[50|20]/a_860_290# sky130_fd_pr_reram__reram_cell area_ox=0.0676
X8944 rr3t3r_0[50|20]/a_60_290# WL50 SL20 VSS sky130_fd_pr__nfet_g5v0d10v5 ad=0.65 pd=3.3 as=0 ps=0 w=1 l=0.5
X8945 rr3t3r_0[50|20]/a_860_290# WL50 SL20 VSS sky130_fd_pr__nfet_g5v0d10v5 ad=0.65 pd=3.3 as=0 ps=0 w=1 l=0.5
X8946 BLP20 rr3t3r_0[51|20]/a_60_290# sky130_fd_pr_reram__reram_cell area_ox=0.0676
X8947 BLZ20 rr3t3r_0[51|20]/a_460_290# sky130_fd_pr_reram__reram_cell area_ox=0.0676
X8948 rr3t3r_0[51|20]/a_460_290# WL51 SL20 VSS sky130_fd_pr__nfet_g5v0d10v5 ad=0.65 pd=3.3 as=0 ps=0 w=1 l=0.5
X8949 BLN20 rr3t3r_0[51|20]/a_860_290# sky130_fd_pr_reram__reram_cell area_ox=0.0676
X8950 rr3t3r_0[51|20]/a_60_290# WL51 SL20 VSS sky130_fd_pr__nfet_g5v0d10v5 ad=0.65 pd=3.3 as=0 ps=0 w=1 l=0.5
X8951 rr3t3r_0[51|20]/a_860_290# WL51 SL20 VSS sky130_fd_pr__nfet_g5v0d10v5 ad=0.65 pd=3.3 as=0 ps=0 w=1 l=0.5
X8952 BLP20 rr3t3r_0[52|20]/a_60_290# sky130_fd_pr_reram__reram_cell area_ox=0.0676
X8953 BLZ20 rr3t3r_0[52|20]/a_460_290# sky130_fd_pr_reram__reram_cell area_ox=0.0676
X8954 rr3t3r_0[52|20]/a_460_290# WL52 SL20 VSS sky130_fd_pr__nfet_g5v0d10v5 ad=0.65 pd=3.3 as=0 ps=0 w=1 l=0.5
X8955 BLN20 rr3t3r_0[52|20]/a_860_290# sky130_fd_pr_reram__reram_cell area_ox=0.0676
X8956 rr3t3r_0[52|20]/a_60_290# WL52 SL20 VSS sky130_fd_pr__nfet_g5v0d10v5 ad=0.65 pd=3.3 as=0 ps=0 w=1 l=0.5
X8957 rr3t3r_0[52|20]/a_860_290# WL52 SL20 VSS sky130_fd_pr__nfet_g5v0d10v5 ad=0.65 pd=3.3 as=0 ps=0 w=1 l=0.5
X8958 BLP20 rr3t3r_0[53|20]/a_60_290# sky130_fd_pr_reram__reram_cell area_ox=0.0676
X8959 BLZ20 rr3t3r_0[53|20]/a_460_290# sky130_fd_pr_reram__reram_cell area_ox=0.0676
X8960 rr3t3r_0[53|20]/a_460_290# WL53 SL20 VSS sky130_fd_pr__nfet_g5v0d10v5 ad=0.65 pd=3.3 as=0 ps=0 w=1 l=0.5
X8961 BLN20 rr3t3r_0[53|20]/a_860_290# sky130_fd_pr_reram__reram_cell area_ox=0.0676
X8962 rr3t3r_0[53|20]/a_60_290# WL53 SL20 VSS sky130_fd_pr__nfet_g5v0d10v5 ad=0.65 pd=3.3 as=0 ps=0 w=1 l=0.5
X8963 rr3t3r_0[53|20]/a_860_290# WL53 SL20 VSS sky130_fd_pr__nfet_g5v0d10v5 ad=0.65 pd=3.3 as=0 ps=0 w=1 l=0.5
X8964 BLP20 rr3t3r_0[54|20]/a_60_290# sky130_fd_pr_reram__reram_cell area_ox=0.0676
X8965 BLZ20 rr3t3r_0[54|20]/a_460_290# sky130_fd_pr_reram__reram_cell area_ox=0.0676
X8966 rr3t3r_0[54|20]/a_460_290# WL54 SL20 VSS sky130_fd_pr__nfet_g5v0d10v5 ad=0.65 pd=3.3 as=0 ps=0 w=1 l=0.5
X8967 BLN20 rr3t3r_0[54|20]/a_860_290# sky130_fd_pr_reram__reram_cell area_ox=0.0676
X8968 rr3t3r_0[54|20]/a_60_290# WL54 SL20 VSS sky130_fd_pr__nfet_g5v0d10v5 ad=0.65 pd=3.3 as=0 ps=0 w=1 l=0.5
X8969 rr3t3r_0[54|20]/a_860_290# WL54 SL20 VSS sky130_fd_pr__nfet_g5v0d10v5 ad=0.65 pd=3.3 as=0 ps=0 w=1 l=0.5
X8970 BLP20 rr3t3r_0[55|20]/a_60_290# sky130_fd_pr_reram__reram_cell area_ox=0.0676
X8971 BLZ20 rr3t3r_0[55|20]/a_460_290# sky130_fd_pr_reram__reram_cell area_ox=0.0676
X8972 rr3t3r_0[55|20]/a_460_290# WL55 SL20 VSS sky130_fd_pr__nfet_g5v0d10v5 ad=0.65 pd=3.3 as=0 ps=0 w=1 l=0.5
X8973 BLN20 rr3t3r_0[55|20]/a_860_290# sky130_fd_pr_reram__reram_cell area_ox=0.0676
X8974 rr3t3r_0[55|20]/a_60_290# WL55 SL20 VSS sky130_fd_pr__nfet_g5v0d10v5 ad=0.65 pd=3.3 as=0 ps=0 w=1 l=0.5
X8975 rr3t3r_0[55|20]/a_860_290# WL55 SL20 VSS sky130_fd_pr__nfet_g5v0d10v5 ad=0.65 pd=3.3 as=0 ps=0 w=1 l=0.5
X8976 BLP20 rr3t3r_0[56|20]/a_60_290# sky130_fd_pr_reram__reram_cell area_ox=0.0676
X8977 BLZ20 rr3t3r_0[56|20]/a_460_290# sky130_fd_pr_reram__reram_cell area_ox=0.0676
X8978 rr3t3r_0[56|20]/a_460_290# WL56 SL20 VSS sky130_fd_pr__nfet_g5v0d10v5 ad=0.65 pd=3.3 as=0 ps=0 w=1 l=0.5
X8979 BLN20 rr3t3r_0[56|20]/a_860_290# sky130_fd_pr_reram__reram_cell area_ox=0.0676
X8980 rr3t3r_0[56|20]/a_60_290# WL56 SL20 VSS sky130_fd_pr__nfet_g5v0d10v5 ad=0.65 pd=3.3 as=0 ps=0 w=1 l=0.5
X8981 rr3t3r_0[56|20]/a_860_290# WL56 SL20 VSS sky130_fd_pr__nfet_g5v0d10v5 ad=0.65 pd=3.3 as=0 ps=0 w=1 l=0.5
X8982 BLP20 rr3t3r_0[57|20]/a_60_290# sky130_fd_pr_reram__reram_cell area_ox=0.0676
X8983 BLZ20 rr3t3r_0[57|20]/a_460_290# sky130_fd_pr_reram__reram_cell area_ox=0.0676
X8984 rr3t3r_0[57|20]/a_460_290# WL57 SL20 VSS sky130_fd_pr__nfet_g5v0d10v5 ad=0.65 pd=3.3 as=0 ps=0 w=1 l=0.5
X8985 BLN20 rr3t3r_0[57|20]/a_860_290# sky130_fd_pr_reram__reram_cell area_ox=0.0676
X8986 rr3t3r_0[57|20]/a_60_290# WL57 SL20 VSS sky130_fd_pr__nfet_g5v0d10v5 ad=0.65 pd=3.3 as=0 ps=0 w=1 l=0.5
X8987 rr3t3r_0[57|20]/a_860_290# WL57 SL20 VSS sky130_fd_pr__nfet_g5v0d10v5 ad=0.65 pd=3.3 as=0 ps=0 w=1 l=0.5
X8988 BLP20 rr3t3r_0[58|20]/a_60_290# sky130_fd_pr_reram__reram_cell area_ox=0.0676
X8989 BLZ20 rr3t3r_0[58|20]/a_460_290# sky130_fd_pr_reram__reram_cell area_ox=0.0676
X8990 rr3t3r_0[58|20]/a_460_290# WL58 SL20 VSS sky130_fd_pr__nfet_g5v0d10v5 ad=0.65 pd=3.3 as=0 ps=0 w=1 l=0.5
X8991 BLN20 rr3t3r_0[58|20]/a_860_290# sky130_fd_pr_reram__reram_cell area_ox=0.0676
X8992 rr3t3r_0[58|20]/a_60_290# WL58 SL20 VSS sky130_fd_pr__nfet_g5v0d10v5 ad=0.65 pd=3.3 as=0 ps=0 w=1 l=0.5
X8993 rr3t3r_0[58|20]/a_860_290# WL58 SL20 VSS sky130_fd_pr__nfet_g5v0d10v5 ad=0.65 pd=3.3 as=0 ps=0 w=1 l=0.5
X8994 BLP20 rr3t3r_0[59|20]/a_60_290# sky130_fd_pr_reram__reram_cell area_ox=0.0676
X8995 BLZ20 rr3t3r_0[59|20]/a_460_290# sky130_fd_pr_reram__reram_cell area_ox=0.0676
X8996 rr3t3r_0[59|20]/a_460_290# WL59 SL20 VSS sky130_fd_pr__nfet_g5v0d10v5 ad=0.65 pd=3.3 as=0 ps=0 w=1 l=0.5
X8997 BLN20 rr3t3r_0[59|20]/a_860_290# sky130_fd_pr_reram__reram_cell area_ox=0.0676
X8998 rr3t3r_0[59|20]/a_60_290# WL59 SL20 VSS sky130_fd_pr__nfet_g5v0d10v5 ad=0.65 pd=3.3 as=0 ps=0 w=1 l=0.5
X8999 rr3t3r_0[59|20]/a_860_290# WL59 SL20 VSS sky130_fd_pr__nfet_g5v0d10v5 ad=0.65 pd=3.3 as=0 ps=0 w=1 l=0.5
X9000 BLP20 rr3t3r_0[60|20]/a_60_290# sky130_fd_pr_reram__reram_cell area_ox=0.0676
X9001 BLZ20 rr3t3r_0[60|20]/a_460_290# sky130_fd_pr_reram__reram_cell area_ox=0.0676
X9002 rr3t3r_0[60|20]/a_460_290# WL60 SL20 VSS sky130_fd_pr__nfet_g5v0d10v5 ad=0.65 pd=3.3 as=0 ps=0 w=1 l=0.5
X9003 BLN20 rr3t3r_0[60|20]/a_860_290# sky130_fd_pr_reram__reram_cell area_ox=0.0676
X9004 rr3t3r_0[60|20]/a_60_290# WL60 SL20 VSS sky130_fd_pr__nfet_g5v0d10v5 ad=0.65 pd=3.3 as=0 ps=0 w=1 l=0.5
X9005 rr3t3r_0[60|20]/a_860_290# WL60 SL20 VSS sky130_fd_pr__nfet_g5v0d10v5 ad=0.65 pd=3.3 as=0 ps=0 w=1 l=0.5
X9006 BLP20 rr3t3r_0[61|20]/a_60_290# sky130_fd_pr_reram__reram_cell area_ox=0.0676
X9007 BLZ20 rr3t3r_0[61|20]/a_460_290# sky130_fd_pr_reram__reram_cell area_ox=0.0676
X9008 rr3t3r_0[61|20]/a_460_290# WL61 SL20 VSS sky130_fd_pr__nfet_g5v0d10v5 ad=0.65 pd=3.3 as=0 ps=0 w=1 l=0.5
X9009 BLN20 rr3t3r_0[61|20]/a_860_290# sky130_fd_pr_reram__reram_cell area_ox=0.0676
X9010 rr3t3r_0[61|20]/a_60_290# WL61 SL20 VSS sky130_fd_pr__nfet_g5v0d10v5 ad=0.65 pd=3.3 as=0 ps=0 w=1 l=0.5
X9011 rr3t3r_0[61|20]/a_860_290# WL61 SL20 VSS sky130_fd_pr__nfet_g5v0d10v5 ad=0.65 pd=3.3 as=0 ps=0 w=1 l=0.5
X9012 BLP20 rr3t3r_0[62|20]/a_60_290# sky130_fd_pr_reram__reram_cell area_ox=0.0676
X9013 BLZ20 rr3t3r_0[62|20]/a_460_290# sky130_fd_pr_reram__reram_cell area_ox=0.0676
X9014 rr3t3r_0[62|20]/a_460_290# WL62 SL20 VSS sky130_fd_pr__nfet_g5v0d10v5 ad=0.65 pd=3.3 as=0 ps=0 w=1 l=0.5
X9015 BLN20 rr3t3r_0[62|20]/a_860_290# sky130_fd_pr_reram__reram_cell area_ox=0.0676
X9016 rr3t3r_0[62|20]/a_60_290# WL62 SL20 VSS sky130_fd_pr__nfet_g5v0d10v5 ad=0.65 pd=3.3 as=0 ps=0 w=1 l=0.5
X9017 rr3t3r_0[62|20]/a_860_290# WL62 SL20 VSS sky130_fd_pr__nfet_g5v0d10v5 ad=0.65 pd=3.3 as=0 ps=0 w=1 l=0.5
X9018 BLP20 rr3t3r_0[63|20]/a_60_290# sky130_fd_pr_reram__reram_cell area_ox=0.0676
X9019 BLZ20 rr3t3r_0[63|20]/a_460_290# sky130_fd_pr_reram__reram_cell area_ox=0.0676
X9020 rr3t3r_0[63|20]/a_460_290# WL63 SL20 VSS sky130_fd_pr__nfet_g5v0d10v5 ad=0.65 pd=3.3 as=0 ps=0 w=1 l=0.5
X9021 BLN20 rr3t3r_0[63|20]/a_860_290# sky130_fd_pr_reram__reram_cell area_ox=0.0676
X9022 rr3t3r_0[63|20]/a_60_290# WL63 SL20 VSS sky130_fd_pr__nfet_g5v0d10v5 ad=0.65 pd=3.3 as=0 ps=0 w=1 l=0.5
X9023 rr3t3r_0[63|20]/a_860_290# WL63 SL20 VSS sky130_fd_pr__nfet_g5v0d10v5 ad=0.65 pd=3.3 as=0 ps=0 w=1 l=0.5
X9024 BLP20 rr3t3r_0[64|20]/a_60_290# sky130_fd_pr_reram__reram_cell area_ox=0.0676
X9025 BLZ20 rr3t3r_0[64|20]/a_460_290# sky130_fd_pr_reram__reram_cell area_ox=0.0676
X9026 rr3t3r_0[64|20]/a_460_290# WL64 SL20 VSS sky130_fd_pr__nfet_g5v0d10v5 ad=0.65 pd=3.3 as=0 ps=0 w=1 l=0.5
X9027 BLN20 rr3t3r_0[64|20]/a_860_290# sky130_fd_pr_reram__reram_cell area_ox=0.0676
X9028 rr3t3r_0[64|20]/a_60_290# WL64 SL20 VSS sky130_fd_pr__nfet_g5v0d10v5 ad=0.65 pd=3.3 as=0 ps=0 w=1 l=0.5
X9029 rr3t3r_0[64|20]/a_860_290# WL64 SL20 VSS sky130_fd_pr__nfet_g5v0d10v5 ad=0.65 pd=3.3 as=0 ps=0 w=1 l=0.5
X9030 BLP20 rr3t3r_0[65|20]/a_60_290# sky130_fd_pr_reram__reram_cell area_ox=0.0676
X9031 BLZ20 rr3t3r_0[65|20]/a_460_290# sky130_fd_pr_reram__reram_cell area_ox=0.0676
X9032 rr3t3r_0[65|20]/a_460_290# WL65 SL20 VSS sky130_fd_pr__nfet_g5v0d10v5 ad=0.65 pd=3.3 as=0 ps=0 w=1 l=0.5
X9033 BLN20 rr3t3r_0[65|20]/a_860_290# sky130_fd_pr_reram__reram_cell area_ox=0.0676
X9034 rr3t3r_0[65|20]/a_60_290# WL65 SL20 VSS sky130_fd_pr__nfet_g5v0d10v5 ad=0.65 pd=3.3 as=0 ps=0 w=1 l=0.5
X9035 rr3t3r_0[65|20]/a_860_290# WL65 SL20 VSS sky130_fd_pr__nfet_g5v0d10v5 ad=0.65 pd=3.3 as=0 ps=0 w=1 l=0.5
X9036 BLP20 rr3t3r_0[66|20]/a_60_290# sky130_fd_pr_reram__reram_cell area_ox=0.0676
X9037 BLZ20 rr3t3r_0[66|20]/a_460_290# sky130_fd_pr_reram__reram_cell area_ox=0.0676
X9038 rr3t3r_0[66|20]/a_460_290# WL66 SL20 VSS sky130_fd_pr__nfet_g5v0d10v5 ad=0.65 pd=3.3 as=0 ps=0 w=1 l=0.5
X9039 BLN20 rr3t3r_0[66|20]/a_860_290# sky130_fd_pr_reram__reram_cell area_ox=0.0676
X9040 rr3t3r_0[66|20]/a_60_290# WL66 SL20 VSS sky130_fd_pr__nfet_g5v0d10v5 ad=0.65 pd=3.3 as=0 ps=0 w=1 l=0.5
X9041 rr3t3r_0[66|20]/a_860_290# WL66 SL20 VSS sky130_fd_pr__nfet_g5v0d10v5 ad=0.65 pd=3.3 as=0 ps=0 w=1 l=0.5
X9042 BLP20 rr3t3r_0[67|20]/a_60_290# sky130_fd_pr_reram__reram_cell area_ox=0.0676
X9043 BLZ20 rr3t3r_0[67|20]/a_460_290# sky130_fd_pr_reram__reram_cell area_ox=0.0676
X9044 rr3t3r_0[67|20]/a_460_290# WL67 SL20 VSS sky130_fd_pr__nfet_g5v0d10v5 ad=0.65 pd=3.3 as=0 ps=0 w=1 l=0.5
X9045 BLN20 rr3t3r_0[67|20]/a_860_290# sky130_fd_pr_reram__reram_cell area_ox=0.0676
X9046 rr3t3r_0[67|20]/a_60_290# WL67 SL20 VSS sky130_fd_pr__nfet_g5v0d10v5 ad=0.65 pd=3.3 as=0 ps=0 w=1 l=0.5
X9047 rr3t3r_0[67|20]/a_860_290# WL67 SL20 VSS sky130_fd_pr__nfet_g5v0d10v5 ad=0.65 pd=3.3 as=0 ps=0 w=1 l=0.5
X9048 BLP20 rr3t3r_0[68|20]/a_60_290# sky130_fd_pr_reram__reram_cell area_ox=0.0676
X9049 BLZ20 rr3t3r_0[68|20]/a_460_290# sky130_fd_pr_reram__reram_cell area_ox=0.0676
X9050 rr3t3r_0[68|20]/a_460_290# WL68 SL20 VSS sky130_fd_pr__nfet_g5v0d10v5 ad=0.65 pd=3.3 as=0 ps=0 w=1 l=0.5
X9051 BLN20 rr3t3r_0[68|20]/a_860_290# sky130_fd_pr_reram__reram_cell area_ox=0.0676
X9052 rr3t3r_0[68|20]/a_60_290# WL68 SL20 VSS sky130_fd_pr__nfet_g5v0d10v5 ad=0.65 pd=3.3 as=0 ps=0 w=1 l=0.5
X9053 rr3t3r_0[68|20]/a_860_290# WL68 SL20 VSS sky130_fd_pr__nfet_g5v0d10v5 ad=0.65 pd=3.3 as=0 ps=0 w=1 l=0.5
X9054 BLP20 rr3t3r_0[69|20]/a_60_290# sky130_fd_pr_reram__reram_cell area_ox=0.0676
X9055 BLZ20 rr3t3r_0[69|20]/a_460_290# sky130_fd_pr_reram__reram_cell area_ox=0.0676
X9056 rr3t3r_0[69|20]/a_460_290# WL69 SL20 VSS sky130_fd_pr__nfet_g5v0d10v5 ad=0.65 pd=3.3 as=0 ps=0 w=1 l=0.5
X9057 BLN20 rr3t3r_0[69|20]/a_860_290# sky130_fd_pr_reram__reram_cell area_ox=0.0676
X9058 rr3t3r_0[69|20]/a_60_290# WL69 SL20 VSS sky130_fd_pr__nfet_g5v0d10v5 ad=0.65 pd=3.3 as=0 ps=0 w=1 l=0.5
X9059 rr3t3r_0[69|20]/a_860_290# WL69 SL20 VSS sky130_fd_pr__nfet_g5v0d10v5 ad=0.65 pd=3.3 as=0 ps=0 w=1 l=0.5
X9060 BLP20 rr3t3r_0[70|20]/a_60_290# sky130_fd_pr_reram__reram_cell area_ox=0.0676
X9061 BLZ20 rr3t3r_0[70|20]/a_460_290# sky130_fd_pr_reram__reram_cell area_ox=0.0676
X9062 rr3t3r_0[70|20]/a_460_290# WL70 SL20 VSS sky130_fd_pr__nfet_g5v0d10v5 ad=0.65 pd=3.3 as=0 ps=0 w=1 l=0.5
X9063 BLN20 rr3t3r_0[70|20]/a_860_290# sky130_fd_pr_reram__reram_cell area_ox=0.0676
X9064 rr3t3r_0[70|20]/a_60_290# WL70 SL20 VSS sky130_fd_pr__nfet_g5v0d10v5 ad=0.65 pd=3.3 as=0 ps=0 w=1 l=0.5
X9065 rr3t3r_0[70|20]/a_860_290# WL70 SL20 VSS sky130_fd_pr__nfet_g5v0d10v5 ad=0.65 pd=3.3 as=0 ps=0 w=1 l=0.5
X9066 BLP20 rr3t3r_0[71|20]/a_60_290# sky130_fd_pr_reram__reram_cell area_ox=0.0676
X9067 BLZ20 rr3t3r_0[71|20]/a_460_290# sky130_fd_pr_reram__reram_cell area_ox=0.0676
X9068 rr3t3r_0[71|20]/a_460_290# WL71 SL20 VSS sky130_fd_pr__nfet_g5v0d10v5 ad=0.65 pd=3.3 as=0 ps=0 w=1 l=0.5
X9069 BLN20 rr3t3r_0[71|20]/a_860_290# sky130_fd_pr_reram__reram_cell area_ox=0.0676
X9070 rr3t3r_0[71|20]/a_60_290# WL71 SL20 VSS sky130_fd_pr__nfet_g5v0d10v5 ad=0.65 pd=3.3 as=0 ps=0 w=1 l=0.5
X9071 rr3t3r_0[71|20]/a_860_290# WL71 SL20 VSS sky130_fd_pr__nfet_g5v0d10v5 ad=0.65 pd=3.3 as=0 ps=0 w=1 l=0.5
X9072 BLP21 rr3t3r_0[0|21]/a_60_290# sky130_fd_pr_reram__reram_cell area_ox=0.0676
X9073 BLZ21 rr3t3r_0[0|21]/a_460_290# sky130_fd_pr_reram__reram_cell area_ox=0.0676
X9074 rr3t3r_0[0|21]/a_460_290# WL0 SL21 VSS sky130_fd_pr__nfet_g5v0d10v5 ad=0.65 pd=3.3 as=162 ps=756 w=1 l=0.5
X9075 BLN21 rr3t3r_0[0|21]/a_860_290# sky130_fd_pr_reram__reram_cell area_ox=0.0676
X9076 rr3t3r_0[0|21]/a_60_290# WL0 SL21 VSS sky130_fd_pr__nfet_g5v0d10v5 ad=0.65 pd=3.3 as=0 ps=0 w=1 l=0.5
X9077 rr3t3r_0[0|21]/a_860_290# WL0 SL21 VSS sky130_fd_pr__nfet_g5v0d10v5 ad=0.65 pd=3.3 as=0 ps=0 w=1 l=0.5
X9078 BLP21 rr3t3r_0[1|21]/a_60_290# sky130_fd_pr_reram__reram_cell area_ox=0.0676
X9079 BLZ21 rr3t3r_0[1|21]/a_460_290# sky130_fd_pr_reram__reram_cell area_ox=0.0676
X9080 rr3t3r_0[1|21]/a_460_290# WL1 SL21 VSS sky130_fd_pr__nfet_g5v0d10v5 ad=0.65 pd=3.3 as=0 ps=0 w=1 l=0.5
X9081 BLN21 rr3t3r_0[1|21]/a_860_290# sky130_fd_pr_reram__reram_cell area_ox=0.0676
X9082 rr3t3r_0[1|21]/a_60_290# WL1 SL21 VSS sky130_fd_pr__nfet_g5v0d10v5 ad=0.65 pd=3.3 as=0 ps=0 w=1 l=0.5
X9083 rr3t3r_0[1|21]/a_860_290# WL1 SL21 VSS sky130_fd_pr__nfet_g5v0d10v5 ad=0.65 pd=3.3 as=0 ps=0 w=1 l=0.5
X9084 BLP21 rr3t3r_0[2|21]/a_60_290# sky130_fd_pr_reram__reram_cell area_ox=0.0676
X9085 BLZ21 rr3t3r_0[2|21]/a_460_290# sky130_fd_pr_reram__reram_cell area_ox=0.0676
X9086 rr3t3r_0[2|21]/a_460_290# WL2 SL21 VSS sky130_fd_pr__nfet_g5v0d10v5 ad=0.65 pd=3.3 as=0 ps=0 w=1 l=0.5
X9087 BLN21 rr3t3r_0[2|21]/a_860_290# sky130_fd_pr_reram__reram_cell area_ox=0.0676
X9088 rr3t3r_0[2|21]/a_60_290# WL2 SL21 VSS sky130_fd_pr__nfet_g5v0d10v5 ad=0.65 pd=3.3 as=0 ps=0 w=1 l=0.5
X9089 rr3t3r_0[2|21]/a_860_290# WL2 SL21 VSS sky130_fd_pr__nfet_g5v0d10v5 ad=0.65 pd=3.3 as=0 ps=0 w=1 l=0.5
X9090 BLP21 rr3t3r_0[3|21]/a_60_290# sky130_fd_pr_reram__reram_cell area_ox=0.0676
X9091 BLZ21 rr3t3r_0[3|21]/a_460_290# sky130_fd_pr_reram__reram_cell area_ox=0.0676
X9092 rr3t3r_0[3|21]/a_460_290# WL3 SL21 VSS sky130_fd_pr__nfet_g5v0d10v5 ad=0.65 pd=3.3 as=0 ps=0 w=1 l=0.5
X9093 BLN21 rr3t3r_0[3|21]/a_860_290# sky130_fd_pr_reram__reram_cell area_ox=0.0676
X9094 rr3t3r_0[3|21]/a_60_290# WL3 SL21 VSS sky130_fd_pr__nfet_g5v0d10v5 ad=0.65 pd=3.3 as=0 ps=0 w=1 l=0.5
X9095 rr3t3r_0[3|21]/a_860_290# WL3 SL21 VSS sky130_fd_pr__nfet_g5v0d10v5 ad=0.65 pd=3.3 as=0 ps=0 w=1 l=0.5
X9096 BLP21 rr3t3r_0[4|21]/a_60_290# sky130_fd_pr_reram__reram_cell area_ox=0.0676
X9097 BLZ21 rr3t3r_0[4|21]/a_460_290# sky130_fd_pr_reram__reram_cell area_ox=0.0676
X9098 rr3t3r_0[4|21]/a_460_290# WL4 SL21 VSS sky130_fd_pr__nfet_g5v0d10v5 ad=0.65 pd=3.3 as=0 ps=0 w=1 l=0.5
X9099 BLN21 rr3t3r_0[4|21]/a_860_290# sky130_fd_pr_reram__reram_cell area_ox=0.0676
X9100 rr3t3r_0[4|21]/a_60_290# WL4 SL21 VSS sky130_fd_pr__nfet_g5v0d10v5 ad=0.65 pd=3.3 as=0 ps=0 w=1 l=0.5
X9101 rr3t3r_0[4|21]/a_860_290# WL4 SL21 VSS sky130_fd_pr__nfet_g5v0d10v5 ad=0.65 pd=3.3 as=0 ps=0 w=1 l=0.5
X9102 BLP21 rr3t3r_0[5|21]/a_60_290# sky130_fd_pr_reram__reram_cell area_ox=0.0676
X9103 BLZ21 rr3t3r_0[5|21]/a_460_290# sky130_fd_pr_reram__reram_cell area_ox=0.0676
X9104 rr3t3r_0[5|21]/a_460_290# WL5 SL21 VSS sky130_fd_pr__nfet_g5v0d10v5 ad=0.65 pd=3.3 as=0 ps=0 w=1 l=0.5
X9105 BLN21 rr3t3r_0[5|21]/a_860_290# sky130_fd_pr_reram__reram_cell area_ox=0.0676
X9106 rr3t3r_0[5|21]/a_60_290# WL5 SL21 VSS sky130_fd_pr__nfet_g5v0d10v5 ad=0.65 pd=3.3 as=0 ps=0 w=1 l=0.5
X9107 rr3t3r_0[5|21]/a_860_290# WL5 SL21 VSS sky130_fd_pr__nfet_g5v0d10v5 ad=0.65 pd=3.3 as=0 ps=0 w=1 l=0.5
X9108 BLP21 rr3t3r_0[6|21]/a_60_290# sky130_fd_pr_reram__reram_cell area_ox=0.0676
X9109 BLZ21 rr3t3r_0[6|21]/a_460_290# sky130_fd_pr_reram__reram_cell area_ox=0.0676
X9110 rr3t3r_0[6|21]/a_460_290# WL6 SL21 VSS sky130_fd_pr__nfet_g5v0d10v5 ad=0.65 pd=3.3 as=0 ps=0 w=1 l=0.5
X9111 BLN21 rr3t3r_0[6|21]/a_860_290# sky130_fd_pr_reram__reram_cell area_ox=0.0676
X9112 rr3t3r_0[6|21]/a_60_290# WL6 SL21 VSS sky130_fd_pr__nfet_g5v0d10v5 ad=0.65 pd=3.3 as=0 ps=0 w=1 l=0.5
X9113 rr3t3r_0[6|21]/a_860_290# WL6 SL21 VSS sky130_fd_pr__nfet_g5v0d10v5 ad=0.65 pd=3.3 as=0 ps=0 w=1 l=0.5
X9114 BLP21 rr3t3r_0[7|21]/a_60_290# sky130_fd_pr_reram__reram_cell area_ox=0.0676
X9115 BLZ21 rr3t3r_0[7|21]/a_460_290# sky130_fd_pr_reram__reram_cell area_ox=0.0676
X9116 rr3t3r_0[7|21]/a_460_290# WL7 SL21 VSS sky130_fd_pr__nfet_g5v0d10v5 ad=0.65 pd=3.3 as=0 ps=0 w=1 l=0.5
X9117 BLN21 rr3t3r_0[7|21]/a_860_290# sky130_fd_pr_reram__reram_cell area_ox=0.0676
X9118 rr3t3r_0[7|21]/a_60_290# WL7 SL21 VSS sky130_fd_pr__nfet_g5v0d10v5 ad=0.65 pd=3.3 as=0 ps=0 w=1 l=0.5
X9119 rr3t3r_0[7|21]/a_860_290# WL7 SL21 VSS sky130_fd_pr__nfet_g5v0d10v5 ad=0.65 pd=3.3 as=0 ps=0 w=1 l=0.5
X9120 BLP21 rr3t3r_0[8|21]/a_60_290# sky130_fd_pr_reram__reram_cell area_ox=0.0676
X9121 BLZ21 rr3t3r_0[8|21]/a_460_290# sky130_fd_pr_reram__reram_cell area_ox=0.0676
X9122 rr3t3r_0[8|21]/a_460_290# WL8 SL21 VSS sky130_fd_pr__nfet_g5v0d10v5 ad=0.65 pd=3.3 as=0 ps=0 w=1 l=0.5
X9123 BLN21 rr3t3r_0[8|21]/a_860_290# sky130_fd_pr_reram__reram_cell area_ox=0.0676
X9124 rr3t3r_0[8|21]/a_60_290# WL8 SL21 VSS sky130_fd_pr__nfet_g5v0d10v5 ad=0.65 pd=3.3 as=0 ps=0 w=1 l=0.5
X9125 rr3t3r_0[8|21]/a_860_290# WL8 SL21 VSS sky130_fd_pr__nfet_g5v0d10v5 ad=0.65 pd=3.3 as=0 ps=0 w=1 l=0.5
X9126 BLP21 rr3t3r_0[9|21]/a_60_290# sky130_fd_pr_reram__reram_cell area_ox=0.0676
X9127 BLZ21 rr3t3r_0[9|21]/a_460_290# sky130_fd_pr_reram__reram_cell area_ox=0.0676
X9128 rr3t3r_0[9|21]/a_460_290# WL9 SL21 VSS sky130_fd_pr__nfet_g5v0d10v5 ad=0.65 pd=3.3 as=0 ps=0 w=1 l=0.5
X9129 BLN21 rr3t3r_0[9|21]/a_860_290# sky130_fd_pr_reram__reram_cell area_ox=0.0676
X9130 rr3t3r_0[9|21]/a_60_290# WL9 SL21 VSS sky130_fd_pr__nfet_g5v0d10v5 ad=0.65 pd=3.3 as=0 ps=0 w=1 l=0.5
X9131 rr3t3r_0[9|21]/a_860_290# WL9 SL21 VSS sky130_fd_pr__nfet_g5v0d10v5 ad=0.65 pd=3.3 as=0 ps=0 w=1 l=0.5
X9132 BLP21 rr3t3r_0[10|21]/a_60_290# sky130_fd_pr_reram__reram_cell area_ox=0.0676
X9133 BLZ21 rr3t3r_0[10|21]/a_460_290# sky130_fd_pr_reram__reram_cell area_ox=0.0676
X9134 rr3t3r_0[10|21]/a_460_290# WL10 SL21 VSS sky130_fd_pr__nfet_g5v0d10v5 ad=0.65 pd=3.3 as=0 ps=0 w=1 l=0.5
X9135 BLN21 rr3t3r_0[10|21]/a_860_290# sky130_fd_pr_reram__reram_cell area_ox=0.0676
X9136 rr3t3r_0[10|21]/a_60_290# WL10 SL21 VSS sky130_fd_pr__nfet_g5v0d10v5 ad=0.65 pd=3.3 as=0 ps=0 w=1 l=0.5
X9137 rr3t3r_0[10|21]/a_860_290# WL10 SL21 VSS sky130_fd_pr__nfet_g5v0d10v5 ad=0.65 pd=3.3 as=0 ps=0 w=1 l=0.5
X9138 BLP21 rr3t3r_0[11|21]/a_60_290# sky130_fd_pr_reram__reram_cell area_ox=0.0676
X9139 BLZ21 rr3t3r_0[11|21]/a_460_290# sky130_fd_pr_reram__reram_cell area_ox=0.0676
X9140 rr3t3r_0[11|21]/a_460_290# WL11 SL21 VSS sky130_fd_pr__nfet_g5v0d10v5 ad=0.65 pd=3.3 as=0 ps=0 w=1 l=0.5
X9141 BLN21 rr3t3r_0[11|21]/a_860_290# sky130_fd_pr_reram__reram_cell area_ox=0.0676
X9142 rr3t3r_0[11|21]/a_60_290# WL11 SL21 VSS sky130_fd_pr__nfet_g5v0d10v5 ad=0.65 pd=3.3 as=0 ps=0 w=1 l=0.5
X9143 rr3t3r_0[11|21]/a_860_290# WL11 SL21 VSS sky130_fd_pr__nfet_g5v0d10v5 ad=0.65 pd=3.3 as=0 ps=0 w=1 l=0.5
X9144 BLP21 rr3t3r_0[12|21]/a_60_290# sky130_fd_pr_reram__reram_cell area_ox=0.0676
X9145 BLZ21 rr3t3r_0[12|21]/a_460_290# sky130_fd_pr_reram__reram_cell area_ox=0.0676
X9146 rr3t3r_0[12|21]/a_460_290# WL12 SL21 VSS sky130_fd_pr__nfet_g5v0d10v5 ad=0.65 pd=3.3 as=0 ps=0 w=1 l=0.5
X9147 BLN21 rr3t3r_0[12|21]/a_860_290# sky130_fd_pr_reram__reram_cell area_ox=0.0676
X9148 rr3t3r_0[12|21]/a_60_290# WL12 SL21 VSS sky130_fd_pr__nfet_g5v0d10v5 ad=0.65 pd=3.3 as=0 ps=0 w=1 l=0.5
X9149 rr3t3r_0[12|21]/a_860_290# WL12 SL21 VSS sky130_fd_pr__nfet_g5v0d10v5 ad=0.65 pd=3.3 as=0 ps=0 w=1 l=0.5
X9150 BLP21 rr3t3r_0[13|21]/a_60_290# sky130_fd_pr_reram__reram_cell area_ox=0.0676
X9151 BLZ21 rr3t3r_0[13|21]/a_460_290# sky130_fd_pr_reram__reram_cell area_ox=0.0676
X9152 rr3t3r_0[13|21]/a_460_290# WL13 SL21 VSS sky130_fd_pr__nfet_g5v0d10v5 ad=0.65 pd=3.3 as=0 ps=0 w=1 l=0.5
X9153 BLN21 rr3t3r_0[13|21]/a_860_290# sky130_fd_pr_reram__reram_cell area_ox=0.0676
X9154 rr3t3r_0[13|21]/a_60_290# WL13 SL21 VSS sky130_fd_pr__nfet_g5v0d10v5 ad=0.65 pd=3.3 as=0 ps=0 w=1 l=0.5
X9155 rr3t3r_0[13|21]/a_860_290# WL13 SL21 VSS sky130_fd_pr__nfet_g5v0d10v5 ad=0.65 pd=3.3 as=0 ps=0 w=1 l=0.5
X9156 BLP21 rr3t3r_0[14|21]/a_60_290# sky130_fd_pr_reram__reram_cell area_ox=0.0676
X9157 BLZ21 rr3t3r_0[14|21]/a_460_290# sky130_fd_pr_reram__reram_cell area_ox=0.0676
X9158 rr3t3r_0[14|21]/a_460_290# WL14 SL21 VSS sky130_fd_pr__nfet_g5v0d10v5 ad=0.65 pd=3.3 as=0 ps=0 w=1 l=0.5
X9159 BLN21 rr3t3r_0[14|21]/a_860_290# sky130_fd_pr_reram__reram_cell area_ox=0.0676
X9160 rr3t3r_0[14|21]/a_60_290# WL14 SL21 VSS sky130_fd_pr__nfet_g5v0d10v5 ad=0.65 pd=3.3 as=0 ps=0 w=1 l=0.5
X9161 rr3t3r_0[14|21]/a_860_290# WL14 SL21 VSS sky130_fd_pr__nfet_g5v0d10v5 ad=0.65 pd=3.3 as=0 ps=0 w=1 l=0.5
X9162 BLP21 rr3t3r_0[15|21]/a_60_290# sky130_fd_pr_reram__reram_cell area_ox=0.0676
X9163 BLZ21 rr3t3r_0[15|21]/a_460_290# sky130_fd_pr_reram__reram_cell area_ox=0.0676
X9164 rr3t3r_0[15|21]/a_460_290# WL15 SL21 VSS sky130_fd_pr__nfet_g5v0d10v5 ad=0.65 pd=3.3 as=0 ps=0 w=1 l=0.5
X9165 BLN21 rr3t3r_0[15|21]/a_860_290# sky130_fd_pr_reram__reram_cell area_ox=0.0676
X9166 rr3t3r_0[15|21]/a_60_290# WL15 SL21 VSS sky130_fd_pr__nfet_g5v0d10v5 ad=0.65 pd=3.3 as=0 ps=0 w=1 l=0.5
X9167 rr3t3r_0[15|21]/a_860_290# WL15 SL21 VSS sky130_fd_pr__nfet_g5v0d10v5 ad=0.65 pd=3.3 as=0 ps=0 w=1 l=0.5
X9168 BLP21 rr3t3r_0[16|21]/a_60_290# sky130_fd_pr_reram__reram_cell area_ox=0.0676
X9169 BLZ21 rr3t3r_0[16|21]/a_460_290# sky130_fd_pr_reram__reram_cell area_ox=0.0676
X9170 rr3t3r_0[16|21]/a_460_290# WL16 SL21 VSS sky130_fd_pr__nfet_g5v0d10v5 ad=0.65 pd=3.3 as=0 ps=0 w=1 l=0.5
X9171 BLN21 rr3t3r_0[16|21]/a_860_290# sky130_fd_pr_reram__reram_cell area_ox=0.0676
X9172 rr3t3r_0[16|21]/a_60_290# WL16 SL21 VSS sky130_fd_pr__nfet_g5v0d10v5 ad=0.65 pd=3.3 as=0 ps=0 w=1 l=0.5
X9173 rr3t3r_0[16|21]/a_860_290# WL16 SL21 VSS sky130_fd_pr__nfet_g5v0d10v5 ad=0.65 pd=3.3 as=0 ps=0 w=1 l=0.5
X9174 BLP21 rr3t3r_0[17|21]/a_60_290# sky130_fd_pr_reram__reram_cell area_ox=0.0676
X9175 BLZ21 rr3t3r_0[17|21]/a_460_290# sky130_fd_pr_reram__reram_cell area_ox=0.0676
X9176 rr3t3r_0[17|21]/a_460_290# WL17 SL21 VSS sky130_fd_pr__nfet_g5v0d10v5 ad=0.65 pd=3.3 as=0 ps=0 w=1 l=0.5
X9177 BLN21 rr3t3r_0[17|21]/a_860_290# sky130_fd_pr_reram__reram_cell area_ox=0.0676
X9178 rr3t3r_0[17|21]/a_60_290# WL17 SL21 VSS sky130_fd_pr__nfet_g5v0d10v5 ad=0.65 pd=3.3 as=0 ps=0 w=1 l=0.5
X9179 rr3t3r_0[17|21]/a_860_290# WL17 SL21 VSS sky130_fd_pr__nfet_g5v0d10v5 ad=0.65 pd=3.3 as=0 ps=0 w=1 l=0.5
X9180 BLP21 rr3t3r_0[18|21]/a_60_290# sky130_fd_pr_reram__reram_cell area_ox=0.0676
X9181 BLZ21 rr3t3r_0[18|21]/a_460_290# sky130_fd_pr_reram__reram_cell area_ox=0.0676
X9182 rr3t3r_0[18|21]/a_460_290# WL18 SL21 VSS sky130_fd_pr__nfet_g5v0d10v5 ad=0.65 pd=3.3 as=0 ps=0 w=1 l=0.5
X9183 BLN21 rr3t3r_0[18|21]/a_860_290# sky130_fd_pr_reram__reram_cell area_ox=0.0676
X9184 rr3t3r_0[18|21]/a_60_290# WL18 SL21 VSS sky130_fd_pr__nfet_g5v0d10v5 ad=0.65 pd=3.3 as=0 ps=0 w=1 l=0.5
X9185 rr3t3r_0[18|21]/a_860_290# WL18 SL21 VSS sky130_fd_pr__nfet_g5v0d10v5 ad=0.65 pd=3.3 as=0 ps=0 w=1 l=0.5
X9186 BLP21 rr3t3r_0[19|21]/a_60_290# sky130_fd_pr_reram__reram_cell area_ox=0.0676
X9187 BLZ21 rr3t3r_0[19|21]/a_460_290# sky130_fd_pr_reram__reram_cell area_ox=0.0676
X9188 rr3t3r_0[19|21]/a_460_290# WL19 SL21 VSS sky130_fd_pr__nfet_g5v0d10v5 ad=0.65 pd=3.3 as=0 ps=0 w=1 l=0.5
X9189 BLN21 rr3t3r_0[19|21]/a_860_290# sky130_fd_pr_reram__reram_cell area_ox=0.0676
X9190 rr3t3r_0[19|21]/a_60_290# WL19 SL21 VSS sky130_fd_pr__nfet_g5v0d10v5 ad=0.65 pd=3.3 as=0 ps=0 w=1 l=0.5
X9191 rr3t3r_0[19|21]/a_860_290# WL19 SL21 VSS sky130_fd_pr__nfet_g5v0d10v5 ad=0.65 pd=3.3 as=0 ps=0 w=1 l=0.5
X9192 BLP21 rr3t3r_0[20|21]/a_60_290# sky130_fd_pr_reram__reram_cell area_ox=0.0676
X9193 BLZ21 rr3t3r_0[20|21]/a_460_290# sky130_fd_pr_reram__reram_cell area_ox=0.0676
X9194 rr3t3r_0[20|21]/a_460_290# WL20 SL21 VSS sky130_fd_pr__nfet_g5v0d10v5 ad=0.65 pd=3.3 as=0 ps=0 w=1 l=0.5
X9195 BLN21 rr3t3r_0[20|21]/a_860_290# sky130_fd_pr_reram__reram_cell area_ox=0.0676
X9196 rr3t3r_0[20|21]/a_60_290# WL20 SL21 VSS sky130_fd_pr__nfet_g5v0d10v5 ad=0.65 pd=3.3 as=0 ps=0 w=1 l=0.5
X9197 rr3t3r_0[20|21]/a_860_290# WL20 SL21 VSS sky130_fd_pr__nfet_g5v0d10v5 ad=0.65 pd=3.3 as=0 ps=0 w=1 l=0.5
X9198 BLP21 rr3t3r_0[21|21]/a_60_290# sky130_fd_pr_reram__reram_cell area_ox=0.0676
X9199 BLZ21 rr3t3r_0[21|21]/a_460_290# sky130_fd_pr_reram__reram_cell area_ox=0.0676
X9200 rr3t3r_0[21|21]/a_460_290# WL21 SL21 VSS sky130_fd_pr__nfet_g5v0d10v5 ad=0.65 pd=3.3 as=0 ps=0 w=1 l=0.5
X9201 BLN21 rr3t3r_0[21|21]/a_860_290# sky130_fd_pr_reram__reram_cell area_ox=0.0676
X9202 rr3t3r_0[21|21]/a_60_290# WL21 SL21 VSS sky130_fd_pr__nfet_g5v0d10v5 ad=0.65 pd=3.3 as=0 ps=0 w=1 l=0.5
X9203 rr3t3r_0[21|21]/a_860_290# WL21 SL21 VSS sky130_fd_pr__nfet_g5v0d10v5 ad=0.65 pd=3.3 as=0 ps=0 w=1 l=0.5
X9204 BLP21 rr3t3r_0[22|21]/a_60_290# sky130_fd_pr_reram__reram_cell area_ox=0.0676
X9205 BLZ21 rr3t3r_0[22|21]/a_460_290# sky130_fd_pr_reram__reram_cell area_ox=0.0676
X9206 rr3t3r_0[22|21]/a_460_290# WL22 SL21 VSS sky130_fd_pr__nfet_g5v0d10v5 ad=0.65 pd=3.3 as=0 ps=0 w=1 l=0.5
X9207 BLN21 rr3t3r_0[22|21]/a_860_290# sky130_fd_pr_reram__reram_cell area_ox=0.0676
X9208 rr3t3r_0[22|21]/a_60_290# WL22 SL21 VSS sky130_fd_pr__nfet_g5v0d10v5 ad=0.65 pd=3.3 as=0 ps=0 w=1 l=0.5
X9209 rr3t3r_0[22|21]/a_860_290# WL22 SL21 VSS sky130_fd_pr__nfet_g5v0d10v5 ad=0.65 pd=3.3 as=0 ps=0 w=1 l=0.5
X9210 BLP21 rr3t3r_0[23|21]/a_60_290# sky130_fd_pr_reram__reram_cell area_ox=0.0676
X9211 BLZ21 rr3t3r_0[23|21]/a_460_290# sky130_fd_pr_reram__reram_cell area_ox=0.0676
X9212 rr3t3r_0[23|21]/a_460_290# WL23 SL21 VSS sky130_fd_pr__nfet_g5v0d10v5 ad=0.65 pd=3.3 as=0 ps=0 w=1 l=0.5
X9213 BLN21 rr3t3r_0[23|21]/a_860_290# sky130_fd_pr_reram__reram_cell area_ox=0.0676
X9214 rr3t3r_0[23|21]/a_60_290# WL23 SL21 VSS sky130_fd_pr__nfet_g5v0d10v5 ad=0.65 pd=3.3 as=0 ps=0 w=1 l=0.5
X9215 rr3t3r_0[23|21]/a_860_290# WL23 SL21 VSS sky130_fd_pr__nfet_g5v0d10v5 ad=0.65 pd=3.3 as=0 ps=0 w=1 l=0.5
X9216 BLP21 rr3t3r_0[24|21]/a_60_290# sky130_fd_pr_reram__reram_cell area_ox=0.0676
X9217 BLZ21 rr3t3r_0[24|21]/a_460_290# sky130_fd_pr_reram__reram_cell area_ox=0.0676
X9218 rr3t3r_0[24|21]/a_460_290# WL24 SL21 VSS sky130_fd_pr__nfet_g5v0d10v5 ad=0.65 pd=3.3 as=0 ps=0 w=1 l=0.5
X9219 BLN21 rr3t3r_0[24|21]/a_860_290# sky130_fd_pr_reram__reram_cell area_ox=0.0676
X9220 rr3t3r_0[24|21]/a_60_290# WL24 SL21 VSS sky130_fd_pr__nfet_g5v0d10v5 ad=0.65 pd=3.3 as=0 ps=0 w=1 l=0.5
X9221 rr3t3r_0[24|21]/a_860_290# WL24 SL21 VSS sky130_fd_pr__nfet_g5v0d10v5 ad=0.65 pd=3.3 as=0 ps=0 w=1 l=0.5
X9222 BLP21 rr3t3r_0[25|21]/a_60_290# sky130_fd_pr_reram__reram_cell area_ox=0.0676
X9223 BLZ21 rr3t3r_0[25|21]/a_460_290# sky130_fd_pr_reram__reram_cell area_ox=0.0676
X9224 rr3t3r_0[25|21]/a_460_290# WL25 SL21 VSS sky130_fd_pr__nfet_g5v0d10v5 ad=0.65 pd=3.3 as=0 ps=0 w=1 l=0.5
X9225 BLN21 rr3t3r_0[25|21]/a_860_290# sky130_fd_pr_reram__reram_cell area_ox=0.0676
X9226 rr3t3r_0[25|21]/a_60_290# WL25 SL21 VSS sky130_fd_pr__nfet_g5v0d10v5 ad=0.65 pd=3.3 as=0 ps=0 w=1 l=0.5
X9227 rr3t3r_0[25|21]/a_860_290# WL25 SL21 VSS sky130_fd_pr__nfet_g5v0d10v5 ad=0.65 pd=3.3 as=0 ps=0 w=1 l=0.5
X9228 BLP21 rr3t3r_0[26|21]/a_60_290# sky130_fd_pr_reram__reram_cell area_ox=0.0676
X9229 BLZ21 rr3t3r_0[26|21]/a_460_290# sky130_fd_pr_reram__reram_cell area_ox=0.0676
X9230 rr3t3r_0[26|21]/a_460_290# WL26 SL21 VSS sky130_fd_pr__nfet_g5v0d10v5 ad=0.65 pd=3.3 as=0 ps=0 w=1 l=0.5
X9231 BLN21 rr3t3r_0[26|21]/a_860_290# sky130_fd_pr_reram__reram_cell area_ox=0.0676
X9232 rr3t3r_0[26|21]/a_60_290# WL26 SL21 VSS sky130_fd_pr__nfet_g5v0d10v5 ad=0.65 pd=3.3 as=0 ps=0 w=1 l=0.5
X9233 rr3t3r_0[26|21]/a_860_290# WL26 SL21 VSS sky130_fd_pr__nfet_g5v0d10v5 ad=0.65 pd=3.3 as=0 ps=0 w=1 l=0.5
X9234 BLP21 rr3t3r_0[27|21]/a_60_290# sky130_fd_pr_reram__reram_cell area_ox=0.0676
X9235 BLZ21 rr3t3r_0[27|21]/a_460_290# sky130_fd_pr_reram__reram_cell area_ox=0.0676
X9236 rr3t3r_0[27|21]/a_460_290# WL27 SL21 VSS sky130_fd_pr__nfet_g5v0d10v5 ad=0.65 pd=3.3 as=0 ps=0 w=1 l=0.5
X9237 BLN21 rr3t3r_0[27|21]/a_860_290# sky130_fd_pr_reram__reram_cell area_ox=0.0676
X9238 rr3t3r_0[27|21]/a_60_290# WL27 SL21 VSS sky130_fd_pr__nfet_g5v0d10v5 ad=0.65 pd=3.3 as=0 ps=0 w=1 l=0.5
X9239 rr3t3r_0[27|21]/a_860_290# WL27 SL21 VSS sky130_fd_pr__nfet_g5v0d10v5 ad=0.65 pd=3.3 as=0 ps=0 w=1 l=0.5
X9240 BLP21 rr3t3r_0[28|21]/a_60_290# sky130_fd_pr_reram__reram_cell area_ox=0.0676
X9241 BLZ21 rr3t3r_0[28|21]/a_460_290# sky130_fd_pr_reram__reram_cell area_ox=0.0676
X9242 rr3t3r_0[28|21]/a_460_290# WL28 SL21 VSS sky130_fd_pr__nfet_g5v0d10v5 ad=0.65 pd=3.3 as=0 ps=0 w=1 l=0.5
X9243 BLN21 rr3t3r_0[28|21]/a_860_290# sky130_fd_pr_reram__reram_cell area_ox=0.0676
X9244 rr3t3r_0[28|21]/a_60_290# WL28 SL21 VSS sky130_fd_pr__nfet_g5v0d10v5 ad=0.65 pd=3.3 as=0 ps=0 w=1 l=0.5
X9245 rr3t3r_0[28|21]/a_860_290# WL28 SL21 VSS sky130_fd_pr__nfet_g5v0d10v5 ad=0.65 pd=3.3 as=0 ps=0 w=1 l=0.5
X9246 BLP21 rr3t3r_0[29|21]/a_60_290# sky130_fd_pr_reram__reram_cell area_ox=0.0676
X9247 BLZ21 rr3t3r_0[29|21]/a_460_290# sky130_fd_pr_reram__reram_cell area_ox=0.0676
X9248 rr3t3r_0[29|21]/a_460_290# WL29 SL21 VSS sky130_fd_pr__nfet_g5v0d10v5 ad=0.65 pd=3.3 as=0 ps=0 w=1 l=0.5
X9249 BLN21 rr3t3r_0[29|21]/a_860_290# sky130_fd_pr_reram__reram_cell area_ox=0.0676
X9250 rr3t3r_0[29|21]/a_60_290# WL29 SL21 VSS sky130_fd_pr__nfet_g5v0d10v5 ad=0.65 pd=3.3 as=0 ps=0 w=1 l=0.5
X9251 rr3t3r_0[29|21]/a_860_290# WL29 SL21 VSS sky130_fd_pr__nfet_g5v0d10v5 ad=0.65 pd=3.3 as=0 ps=0 w=1 l=0.5
X9252 BLP21 rr3t3r_0[30|21]/a_60_290# sky130_fd_pr_reram__reram_cell area_ox=0.0676
X9253 BLZ21 rr3t3r_0[30|21]/a_460_290# sky130_fd_pr_reram__reram_cell area_ox=0.0676
X9254 rr3t3r_0[30|21]/a_460_290# WL30 SL21 VSS sky130_fd_pr__nfet_g5v0d10v5 ad=0.65 pd=3.3 as=0 ps=0 w=1 l=0.5
X9255 BLN21 rr3t3r_0[30|21]/a_860_290# sky130_fd_pr_reram__reram_cell area_ox=0.0676
X9256 rr3t3r_0[30|21]/a_60_290# WL30 SL21 VSS sky130_fd_pr__nfet_g5v0d10v5 ad=0.65 pd=3.3 as=0 ps=0 w=1 l=0.5
X9257 rr3t3r_0[30|21]/a_860_290# WL30 SL21 VSS sky130_fd_pr__nfet_g5v0d10v5 ad=0.65 pd=3.3 as=0 ps=0 w=1 l=0.5
X9258 BLP21 rr3t3r_0[31|21]/a_60_290# sky130_fd_pr_reram__reram_cell area_ox=0.0676
X9259 BLZ21 rr3t3r_0[31|21]/a_460_290# sky130_fd_pr_reram__reram_cell area_ox=0.0676
X9260 rr3t3r_0[31|21]/a_460_290# WL31 SL21 VSS sky130_fd_pr__nfet_g5v0d10v5 ad=0.65 pd=3.3 as=0 ps=0 w=1 l=0.5
X9261 BLN21 rr3t3r_0[31|21]/a_860_290# sky130_fd_pr_reram__reram_cell area_ox=0.0676
X9262 rr3t3r_0[31|21]/a_60_290# WL31 SL21 VSS sky130_fd_pr__nfet_g5v0d10v5 ad=0.65 pd=3.3 as=0 ps=0 w=1 l=0.5
X9263 rr3t3r_0[31|21]/a_860_290# WL31 SL21 VSS sky130_fd_pr__nfet_g5v0d10v5 ad=0.65 pd=3.3 as=0 ps=0 w=1 l=0.5
X9264 BLP21 rr3t3r_0[32|21]/a_60_290# sky130_fd_pr_reram__reram_cell area_ox=0.0676
X9265 BLZ21 rr3t3r_0[32|21]/a_460_290# sky130_fd_pr_reram__reram_cell area_ox=0.0676
X9266 rr3t3r_0[32|21]/a_460_290# WL32 SL21 VSS sky130_fd_pr__nfet_g5v0d10v5 ad=0.65 pd=3.3 as=0 ps=0 w=1 l=0.5
X9267 BLN21 rr3t3r_0[32|21]/a_860_290# sky130_fd_pr_reram__reram_cell area_ox=0.0676
X9268 rr3t3r_0[32|21]/a_60_290# WL32 SL21 VSS sky130_fd_pr__nfet_g5v0d10v5 ad=0.65 pd=3.3 as=0 ps=0 w=1 l=0.5
X9269 rr3t3r_0[32|21]/a_860_290# WL32 SL21 VSS sky130_fd_pr__nfet_g5v0d10v5 ad=0.65 pd=3.3 as=0 ps=0 w=1 l=0.5
X9270 BLP21 rr3t3r_0[33|21]/a_60_290# sky130_fd_pr_reram__reram_cell area_ox=0.0676
X9271 BLZ21 rr3t3r_0[33|21]/a_460_290# sky130_fd_pr_reram__reram_cell area_ox=0.0676
X9272 rr3t3r_0[33|21]/a_460_290# WL33 SL21 VSS sky130_fd_pr__nfet_g5v0d10v5 ad=0.65 pd=3.3 as=0 ps=0 w=1 l=0.5
X9273 BLN21 rr3t3r_0[33|21]/a_860_290# sky130_fd_pr_reram__reram_cell area_ox=0.0676
X9274 rr3t3r_0[33|21]/a_60_290# WL33 SL21 VSS sky130_fd_pr__nfet_g5v0d10v5 ad=0.65 pd=3.3 as=0 ps=0 w=1 l=0.5
X9275 rr3t3r_0[33|21]/a_860_290# WL33 SL21 VSS sky130_fd_pr__nfet_g5v0d10v5 ad=0.65 pd=3.3 as=0 ps=0 w=1 l=0.5
X9276 BLP21 rr3t3r_0[34|21]/a_60_290# sky130_fd_pr_reram__reram_cell area_ox=0.0676
X9277 BLZ21 rr3t3r_0[34|21]/a_460_290# sky130_fd_pr_reram__reram_cell area_ox=0.0676
X9278 rr3t3r_0[34|21]/a_460_290# WL34 SL21 VSS sky130_fd_pr__nfet_g5v0d10v5 ad=0.65 pd=3.3 as=0 ps=0 w=1 l=0.5
X9279 BLN21 rr3t3r_0[34|21]/a_860_290# sky130_fd_pr_reram__reram_cell area_ox=0.0676
X9280 rr3t3r_0[34|21]/a_60_290# WL34 SL21 VSS sky130_fd_pr__nfet_g5v0d10v5 ad=0.65 pd=3.3 as=0 ps=0 w=1 l=0.5
X9281 rr3t3r_0[34|21]/a_860_290# WL34 SL21 VSS sky130_fd_pr__nfet_g5v0d10v5 ad=0.65 pd=3.3 as=0 ps=0 w=1 l=0.5
X9282 BLP21 rr3t3r_0[35|21]/a_60_290# sky130_fd_pr_reram__reram_cell area_ox=0.0676
X9283 BLZ21 rr3t3r_0[35|21]/a_460_290# sky130_fd_pr_reram__reram_cell area_ox=0.0676
X9284 rr3t3r_0[35|21]/a_460_290# WL35 SL21 VSS sky130_fd_pr__nfet_g5v0d10v5 ad=0.65 pd=3.3 as=0 ps=0 w=1 l=0.5
X9285 BLN21 rr3t3r_0[35|21]/a_860_290# sky130_fd_pr_reram__reram_cell area_ox=0.0676
X9286 rr3t3r_0[35|21]/a_60_290# WL35 SL21 VSS sky130_fd_pr__nfet_g5v0d10v5 ad=0.65 pd=3.3 as=0 ps=0 w=1 l=0.5
X9287 rr3t3r_0[35|21]/a_860_290# WL35 SL21 VSS sky130_fd_pr__nfet_g5v0d10v5 ad=0.65 pd=3.3 as=0 ps=0 w=1 l=0.5
X9288 BLP21 rr3t3r_0[36|21]/a_60_290# sky130_fd_pr_reram__reram_cell area_ox=0.0676
X9289 BLZ21 rr3t3r_0[36|21]/a_460_290# sky130_fd_pr_reram__reram_cell area_ox=0.0676
X9290 rr3t3r_0[36|21]/a_460_290# WL36 SL21 VSS sky130_fd_pr__nfet_g5v0d10v5 ad=0.65 pd=3.3 as=0 ps=0 w=1 l=0.5
X9291 BLN21 rr3t3r_0[36|21]/a_860_290# sky130_fd_pr_reram__reram_cell area_ox=0.0676
X9292 rr3t3r_0[36|21]/a_60_290# WL36 SL21 VSS sky130_fd_pr__nfet_g5v0d10v5 ad=0.65 pd=3.3 as=0 ps=0 w=1 l=0.5
X9293 rr3t3r_0[36|21]/a_860_290# WL36 SL21 VSS sky130_fd_pr__nfet_g5v0d10v5 ad=0.65 pd=3.3 as=0 ps=0 w=1 l=0.5
X9294 BLP21 rr3t3r_0[37|21]/a_60_290# sky130_fd_pr_reram__reram_cell area_ox=0.0676
X9295 BLZ21 rr3t3r_0[37|21]/a_460_290# sky130_fd_pr_reram__reram_cell area_ox=0.0676
X9296 rr3t3r_0[37|21]/a_460_290# WL37 SL21 VSS sky130_fd_pr__nfet_g5v0d10v5 ad=0.65 pd=3.3 as=0 ps=0 w=1 l=0.5
X9297 BLN21 rr3t3r_0[37|21]/a_860_290# sky130_fd_pr_reram__reram_cell area_ox=0.0676
X9298 rr3t3r_0[37|21]/a_60_290# WL37 SL21 VSS sky130_fd_pr__nfet_g5v0d10v5 ad=0.65 pd=3.3 as=0 ps=0 w=1 l=0.5
X9299 rr3t3r_0[37|21]/a_860_290# WL37 SL21 VSS sky130_fd_pr__nfet_g5v0d10v5 ad=0.65 pd=3.3 as=0 ps=0 w=1 l=0.5
X9300 BLP21 rr3t3r_0[38|21]/a_60_290# sky130_fd_pr_reram__reram_cell area_ox=0.0676
X9301 BLZ21 rr3t3r_0[38|21]/a_460_290# sky130_fd_pr_reram__reram_cell area_ox=0.0676
X9302 rr3t3r_0[38|21]/a_460_290# WL38 SL21 VSS sky130_fd_pr__nfet_g5v0d10v5 ad=0.65 pd=3.3 as=0 ps=0 w=1 l=0.5
X9303 BLN21 rr3t3r_0[38|21]/a_860_290# sky130_fd_pr_reram__reram_cell area_ox=0.0676
X9304 rr3t3r_0[38|21]/a_60_290# WL38 SL21 VSS sky130_fd_pr__nfet_g5v0d10v5 ad=0.65 pd=3.3 as=0 ps=0 w=1 l=0.5
X9305 rr3t3r_0[38|21]/a_860_290# WL38 SL21 VSS sky130_fd_pr__nfet_g5v0d10v5 ad=0.65 pd=3.3 as=0 ps=0 w=1 l=0.5
X9306 BLP21 rr3t3r_0[39|21]/a_60_290# sky130_fd_pr_reram__reram_cell area_ox=0.0676
X9307 BLZ21 rr3t3r_0[39|21]/a_460_290# sky130_fd_pr_reram__reram_cell area_ox=0.0676
X9308 rr3t3r_0[39|21]/a_460_290# WL39 SL21 VSS sky130_fd_pr__nfet_g5v0d10v5 ad=0.65 pd=3.3 as=0 ps=0 w=1 l=0.5
X9309 BLN21 rr3t3r_0[39|21]/a_860_290# sky130_fd_pr_reram__reram_cell area_ox=0.0676
X9310 rr3t3r_0[39|21]/a_60_290# WL39 SL21 VSS sky130_fd_pr__nfet_g5v0d10v5 ad=0.65 pd=3.3 as=0 ps=0 w=1 l=0.5
X9311 rr3t3r_0[39|21]/a_860_290# WL39 SL21 VSS sky130_fd_pr__nfet_g5v0d10v5 ad=0.65 pd=3.3 as=0 ps=0 w=1 l=0.5
X9312 BLP21 rr3t3r_0[40|21]/a_60_290# sky130_fd_pr_reram__reram_cell area_ox=0.0676
X9313 BLZ21 rr3t3r_0[40|21]/a_460_290# sky130_fd_pr_reram__reram_cell area_ox=0.0676
X9314 rr3t3r_0[40|21]/a_460_290# WL40 SL21 VSS sky130_fd_pr__nfet_g5v0d10v5 ad=0.65 pd=3.3 as=0 ps=0 w=1 l=0.5
X9315 BLN21 rr3t3r_0[40|21]/a_860_290# sky130_fd_pr_reram__reram_cell area_ox=0.0676
X9316 rr3t3r_0[40|21]/a_60_290# WL40 SL21 VSS sky130_fd_pr__nfet_g5v0d10v5 ad=0.65 pd=3.3 as=0 ps=0 w=1 l=0.5
X9317 rr3t3r_0[40|21]/a_860_290# WL40 SL21 VSS sky130_fd_pr__nfet_g5v0d10v5 ad=0.65 pd=3.3 as=0 ps=0 w=1 l=0.5
X9318 BLP21 rr3t3r_0[41|21]/a_60_290# sky130_fd_pr_reram__reram_cell area_ox=0.0676
X9319 BLZ21 rr3t3r_0[41|21]/a_460_290# sky130_fd_pr_reram__reram_cell area_ox=0.0676
X9320 rr3t3r_0[41|21]/a_460_290# WL41 SL21 VSS sky130_fd_pr__nfet_g5v0d10v5 ad=0.65 pd=3.3 as=0 ps=0 w=1 l=0.5
X9321 BLN21 rr3t3r_0[41|21]/a_860_290# sky130_fd_pr_reram__reram_cell area_ox=0.0676
X9322 rr3t3r_0[41|21]/a_60_290# WL41 SL21 VSS sky130_fd_pr__nfet_g5v0d10v5 ad=0.65 pd=3.3 as=0 ps=0 w=1 l=0.5
X9323 rr3t3r_0[41|21]/a_860_290# WL41 SL21 VSS sky130_fd_pr__nfet_g5v0d10v5 ad=0.65 pd=3.3 as=0 ps=0 w=1 l=0.5
X9324 BLP21 rr3t3r_0[42|21]/a_60_290# sky130_fd_pr_reram__reram_cell area_ox=0.0676
X9325 BLZ21 rr3t3r_0[42|21]/a_460_290# sky130_fd_pr_reram__reram_cell area_ox=0.0676
X9326 rr3t3r_0[42|21]/a_460_290# WL42 SL21 VSS sky130_fd_pr__nfet_g5v0d10v5 ad=0.65 pd=3.3 as=0 ps=0 w=1 l=0.5
X9327 BLN21 rr3t3r_0[42|21]/a_860_290# sky130_fd_pr_reram__reram_cell area_ox=0.0676
X9328 rr3t3r_0[42|21]/a_60_290# WL42 SL21 VSS sky130_fd_pr__nfet_g5v0d10v5 ad=0.65 pd=3.3 as=0 ps=0 w=1 l=0.5
X9329 rr3t3r_0[42|21]/a_860_290# WL42 SL21 VSS sky130_fd_pr__nfet_g5v0d10v5 ad=0.65 pd=3.3 as=0 ps=0 w=1 l=0.5
X9330 BLP21 rr3t3r_0[43|21]/a_60_290# sky130_fd_pr_reram__reram_cell area_ox=0.0676
X9331 BLZ21 rr3t3r_0[43|21]/a_460_290# sky130_fd_pr_reram__reram_cell area_ox=0.0676
X9332 rr3t3r_0[43|21]/a_460_290# WL43 SL21 VSS sky130_fd_pr__nfet_g5v0d10v5 ad=0.65 pd=3.3 as=0 ps=0 w=1 l=0.5
X9333 BLN21 rr3t3r_0[43|21]/a_860_290# sky130_fd_pr_reram__reram_cell area_ox=0.0676
X9334 rr3t3r_0[43|21]/a_60_290# WL43 SL21 VSS sky130_fd_pr__nfet_g5v0d10v5 ad=0.65 pd=3.3 as=0 ps=0 w=1 l=0.5
X9335 rr3t3r_0[43|21]/a_860_290# WL43 SL21 VSS sky130_fd_pr__nfet_g5v0d10v5 ad=0.65 pd=3.3 as=0 ps=0 w=1 l=0.5
X9336 BLP21 rr3t3r_0[44|21]/a_60_290# sky130_fd_pr_reram__reram_cell area_ox=0.0676
X9337 BLZ21 rr3t3r_0[44|21]/a_460_290# sky130_fd_pr_reram__reram_cell area_ox=0.0676
X9338 rr3t3r_0[44|21]/a_460_290# WL44 SL21 VSS sky130_fd_pr__nfet_g5v0d10v5 ad=0.65 pd=3.3 as=0 ps=0 w=1 l=0.5
X9339 BLN21 rr3t3r_0[44|21]/a_860_290# sky130_fd_pr_reram__reram_cell area_ox=0.0676
X9340 rr3t3r_0[44|21]/a_60_290# WL44 SL21 VSS sky130_fd_pr__nfet_g5v0d10v5 ad=0.65 pd=3.3 as=0 ps=0 w=1 l=0.5
X9341 rr3t3r_0[44|21]/a_860_290# WL44 SL21 VSS sky130_fd_pr__nfet_g5v0d10v5 ad=0.65 pd=3.3 as=0 ps=0 w=1 l=0.5
X9342 BLP21 rr3t3r_0[45|21]/a_60_290# sky130_fd_pr_reram__reram_cell area_ox=0.0676
X9343 BLZ21 rr3t3r_0[45|21]/a_460_290# sky130_fd_pr_reram__reram_cell area_ox=0.0676
X9344 rr3t3r_0[45|21]/a_460_290# WL45 SL21 VSS sky130_fd_pr__nfet_g5v0d10v5 ad=0.65 pd=3.3 as=0 ps=0 w=1 l=0.5
X9345 BLN21 rr3t3r_0[45|21]/a_860_290# sky130_fd_pr_reram__reram_cell area_ox=0.0676
X9346 rr3t3r_0[45|21]/a_60_290# WL45 SL21 VSS sky130_fd_pr__nfet_g5v0d10v5 ad=0.65 pd=3.3 as=0 ps=0 w=1 l=0.5
X9347 rr3t3r_0[45|21]/a_860_290# WL45 SL21 VSS sky130_fd_pr__nfet_g5v0d10v5 ad=0.65 pd=3.3 as=0 ps=0 w=1 l=0.5
X9348 BLP21 rr3t3r_0[46|21]/a_60_290# sky130_fd_pr_reram__reram_cell area_ox=0.0676
X9349 BLZ21 rr3t3r_0[46|21]/a_460_290# sky130_fd_pr_reram__reram_cell area_ox=0.0676
X9350 rr3t3r_0[46|21]/a_460_290# WL46 SL21 VSS sky130_fd_pr__nfet_g5v0d10v5 ad=0.65 pd=3.3 as=0 ps=0 w=1 l=0.5
X9351 BLN21 rr3t3r_0[46|21]/a_860_290# sky130_fd_pr_reram__reram_cell area_ox=0.0676
X9352 rr3t3r_0[46|21]/a_60_290# WL46 SL21 VSS sky130_fd_pr__nfet_g5v0d10v5 ad=0.65 pd=3.3 as=0 ps=0 w=1 l=0.5
X9353 rr3t3r_0[46|21]/a_860_290# WL46 SL21 VSS sky130_fd_pr__nfet_g5v0d10v5 ad=0.65 pd=3.3 as=0 ps=0 w=1 l=0.5
X9354 BLP21 rr3t3r_0[47|21]/a_60_290# sky130_fd_pr_reram__reram_cell area_ox=0.0676
X9355 BLZ21 rr3t3r_0[47|21]/a_460_290# sky130_fd_pr_reram__reram_cell area_ox=0.0676
X9356 rr3t3r_0[47|21]/a_460_290# WL47 SL21 VSS sky130_fd_pr__nfet_g5v0d10v5 ad=0.65 pd=3.3 as=0 ps=0 w=1 l=0.5
X9357 BLN21 rr3t3r_0[47|21]/a_860_290# sky130_fd_pr_reram__reram_cell area_ox=0.0676
X9358 rr3t3r_0[47|21]/a_60_290# WL47 SL21 VSS sky130_fd_pr__nfet_g5v0d10v5 ad=0.65 pd=3.3 as=0 ps=0 w=1 l=0.5
X9359 rr3t3r_0[47|21]/a_860_290# WL47 SL21 VSS sky130_fd_pr__nfet_g5v0d10v5 ad=0.65 pd=3.3 as=0 ps=0 w=1 l=0.5
X9360 BLP21 rr3t3r_0[48|21]/a_60_290# sky130_fd_pr_reram__reram_cell area_ox=0.0676
X9361 BLZ21 rr3t3r_0[48|21]/a_460_290# sky130_fd_pr_reram__reram_cell area_ox=0.0676
X9362 rr3t3r_0[48|21]/a_460_290# WL48 SL21 VSS sky130_fd_pr__nfet_g5v0d10v5 ad=0.65 pd=3.3 as=0 ps=0 w=1 l=0.5
X9363 BLN21 rr3t3r_0[48|21]/a_860_290# sky130_fd_pr_reram__reram_cell area_ox=0.0676
X9364 rr3t3r_0[48|21]/a_60_290# WL48 SL21 VSS sky130_fd_pr__nfet_g5v0d10v5 ad=0.65 pd=3.3 as=0 ps=0 w=1 l=0.5
X9365 rr3t3r_0[48|21]/a_860_290# WL48 SL21 VSS sky130_fd_pr__nfet_g5v0d10v5 ad=0.65 pd=3.3 as=0 ps=0 w=1 l=0.5
X9366 BLP21 rr3t3r_0[49|21]/a_60_290# sky130_fd_pr_reram__reram_cell area_ox=0.0676
X9367 BLZ21 rr3t3r_0[49|21]/a_460_290# sky130_fd_pr_reram__reram_cell area_ox=0.0676
X9368 rr3t3r_0[49|21]/a_460_290# WL49 SL21 VSS sky130_fd_pr__nfet_g5v0d10v5 ad=0.65 pd=3.3 as=0 ps=0 w=1 l=0.5
X9369 BLN21 rr3t3r_0[49|21]/a_860_290# sky130_fd_pr_reram__reram_cell area_ox=0.0676
X9370 rr3t3r_0[49|21]/a_60_290# WL49 SL21 VSS sky130_fd_pr__nfet_g5v0d10v5 ad=0.65 pd=3.3 as=0 ps=0 w=1 l=0.5
X9371 rr3t3r_0[49|21]/a_860_290# WL49 SL21 VSS sky130_fd_pr__nfet_g5v0d10v5 ad=0.65 pd=3.3 as=0 ps=0 w=1 l=0.5
X9372 BLP21 rr3t3r_0[50|21]/a_60_290# sky130_fd_pr_reram__reram_cell area_ox=0.0676
X9373 BLZ21 rr3t3r_0[50|21]/a_460_290# sky130_fd_pr_reram__reram_cell area_ox=0.0676
X9374 rr3t3r_0[50|21]/a_460_290# WL50 SL21 VSS sky130_fd_pr__nfet_g5v0d10v5 ad=0.65 pd=3.3 as=0 ps=0 w=1 l=0.5
X9375 BLN21 rr3t3r_0[50|21]/a_860_290# sky130_fd_pr_reram__reram_cell area_ox=0.0676
X9376 rr3t3r_0[50|21]/a_60_290# WL50 SL21 VSS sky130_fd_pr__nfet_g5v0d10v5 ad=0.65 pd=3.3 as=0 ps=0 w=1 l=0.5
X9377 rr3t3r_0[50|21]/a_860_290# WL50 SL21 VSS sky130_fd_pr__nfet_g5v0d10v5 ad=0.65 pd=3.3 as=0 ps=0 w=1 l=0.5
X9378 BLP21 rr3t3r_0[51|21]/a_60_290# sky130_fd_pr_reram__reram_cell area_ox=0.0676
X9379 BLZ21 rr3t3r_0[51|21]/a_460_290# sky130_fd_pr_reram__reram_cell area_ox=0.0676
X9380 rr3t3r_0[51|21]/a_460_290# WL51 SL21 VSS sky130_fd_pr__nfet_g5v0d10v5 ad=0.65 pd=3.3 as=0 ps=0 w=1 l=0.5
X9381 BLN21 rr3t3r_0[51|21]/a_860_290# sky130_fd_pr_reram__reram_cell area_ox=0.0676
X9382 rr3t3r_0[51|21]/a_60_290# WL51 SL21 VSS sky130_fd_pr__nfet_g5v0d10v5 ad=0.65 pd=3.3 as=0 ps=0 w=1 l=0.5
X9383 rr3t3r_0[51|21]/a_860_290# WL51 SL21 VSS sky130_fd_pr__nfet_g5v0d10v5 ad=0.65 pd=3.3 as=0 ps=0 w=1 l=0.5
X9384 BLP21 rr3t3r_0[52|21]/a_60_290# sky130_fd_pr_reram__reram_cell area_ox=0.0676
X9385 BLZ21 rr3t3r_0[52|21]/a_460_290# sky130_fd_pr_reram__reram_cell area_ox=0.0676
X9386 rr3t3r_0[52|21]/a_460_290# WL52 SL21 VSS sky130_fd_pr__nfet_g5v0d10v5 ad=0.65 pd=3.3 as=0 ps=0 w=1 l=0.5
X9387 BLN21 rr3t3r_0[52|21]/a_860_290# sky130_fd_pr_reram__reram_cell area_ox=0.0676
X9388 rr3t3r_0[52|21]/a_60_290# WL52 SL21 VSS sky130_fd_pr__nfet_g5v0d10v5 ad=0.65 pd=3.3 as=0 ps=0 w=1 l=0.5
X9389 rr3t3r_0[52|21]/a_860_290# WL52 SL21 VSS sky130_fd_pr__nfet_g5v0d10v5 ad=0.65 pd=3.3 as=0 ps=0 w=1 l=0.5
X9390 BLP21 rr3t3r_0[53|21]/a_60_290# sky130_fd_pr_reram__reram_cell area_ox=0.0676
X9391 BLZ21 rr3t3r_0[53|21]/a_460_290# sky130_fd_pr_reram__reram_cell area_ox=0.0676
X9392 rr3t3r_0[53|21]/a_460_290# WL53 SL21 VSS sky130_fd_pr__nfet_g5v0d10v5 ad=0.65 pd=3.3 as=0 ps=0 w=1 l=0.5
X9393 BLN21 rr3t3r_0[53|21]/a_860_290# sky130_fd_pr_reram__reram_cell area_ox=0.0676
X9394 rr3t3r_0[53|21]/a_60_290# WL53 SL21 VSS sky130_fd_pr__nfet_g5v0d10v5 ad=0.65 pd=3.3 as=0 ps=0 w=1 l=0.5
X9395 rr3t3r_0[53|21]/a_860_290# WL53 SL21 VSS sky130_fd_pr__nfet_g5v0d10v5 ad=0.65 pd=3.3 as=0 ps=0 w=1 l=0.5
X9396 BLP21 rr3t3r_0[54|21]/a_60_290# sky130_fd_pr_reram__reram_cell area_ox=0.0676
X9397 BLZ21 rr3t3r_0[54|21]/a_460_290# sky130_fd_pr_reram__reram_cell area_ox=0.0676
X9398 rr3t3r_0[54|21]/a_460_290# WL54 SL21 VSS sky130_fd_pr__nfet_g5v0d10v5 ad=0.65 pd=3.3 as=0 ps=0 w=1 l=0.5
X9399 BLN21 rr3t3r_0[54|21]/a_860_290# sky130_fd_pr_reram__reram_cell area_ox=0.0676
X9400 rr3t3r_0[54|21]/a_60_290# WL54 SL21 VSS sky130_fd_pr__nfet_g5v0d10v5 ad=0.65 pd=3.3 as=0 ps=0 w=1 l=0.5
X9401 rr3t3r_0[54|21]/a_860_290# WL54 SL21 VSS sky130_fd_pr__nfet_g5v0d10v5 ad=0.65 pd=3.3 as=0 ps=0 w=1 l=0.5
X9402 BLP21 rr3t3r_0[55|21]/a_60_290# sky130_fd_pr_reram__reram_cell area_ox=0.0676
X9403 BLZ21 rr3t3r_0[55|21]/a_460_290# sky130_fd_pr_reram__reram_cell area_ox=0.0676
X9404 rr3t3r_0[55|21]/a_460_290# WL55 SL21 VSS sky130_fd_pr__nfet_g5v0d10v5 ad=0.65 pd=3.3 as=0 ps=0 w=1 l=0.5
X9405 BLN21 rr3t3r_0[55|21]/a_860_290# sky130_fd_pr_reram__reram_cell area_ox=0.0676
X9406 rr3t3r_0[55|21]/a_60_290# WL55 SL21 VSS sky130_fd_pr__nfet_g5v0d10v5 ad=0.65 pd=3.3 as=0 ps=0 w=1 l=0.5
X9407 rr3t3r_0[55|21]/a_860_290# WL55 SL21 VSS sky130_fd_pr__nfet_g5v0d10v5 ad=0.65 pd=3.3 as=0 ps=0 w=1 l=0.5
X9408 BLP21 rr3t3r_0[56|21]/a_60_290# sky130_fd_pr_reram__reram_cell area_ox=0.0676
X9409 BLZ21 rr3t3r_0[56|21]/a_460_290# sky130_fd_pr_reram__reram_cell area_ox=0.0676
X9410 rr3t3r_0[56|21]/a_460_290# WL56 SL21 VSS sky130_fd_pr__nfet_g5v0d10v5 ad=0.65 pd=3.3 as=0 ps=0 w=1 l=0.5
X9411 BLN21 rr3t3r_0[56|21]/a_860_290# sky130_fd_pr_reram__reram_cell area_ox=0.0676
X9412 rr3t3r_0[56|21]/a_60_290# WL56 SL21 VSS sky130_fd_pr__nfet_g5v0d10v5 ad=0.65 pd=3.3 as=0 ps=0 w=1 l=0.5
X9413 rr3t3r_0[56|21]/a_860_290# WL56 SL21 VSS sky130_fd_pr__nfet_g5v0d10v5 ad=0.65 pd=3.3 as=0 ps=0 w=1 l=0.5
X9414 BLP21 rr3t3r_0[57|21]/a_60_290# sky130_fd_pr_reram__reram_cell area_ox=0.0676
X9415 BLZ21 rr3t3r_0[57|21]/a_460_290# sky130_fd_pr_reram__reram_cell area_ox=0.0676
X9416 rr3t3r_0[57|21]/a_460_290# WL57 SL21 VSS sky130_fd_pr__nfet_g5v0d10v5 ad=0.65 pd=3.3 as=0 ps=0 w=1 l=0.5
X9417 BLN21 rr3t3r_0[57|21]/a_860_290# sky130_fd_pr_reram__reram_cell area_ox=0.0676
X9418 rr3t3r_0[57|21]/a_60_290# WL57 SL21 VSS sky130_fd_pr__nfet_g5v0d10v5 ad=0.65 pd=3.3 as=0 ps=0 w=1 l=0.5
X9419 rr3t3r_0[57|21]/a_860_290# WL57 SL21 VSS sky130_fd_pr__nfet_g5v0d10v5 ad=0.65 pd=3.3 as=0 ps=0 w=1 l=0.5
X9420 BLP21 rr3t3r_0[58|21]/a_60_290# sky130_fd_pr_reram__reram_cell area_ox=0.0676
X9421 BLZ21 rr3t3r_0[58|21]/a_460_290# sky130_fd_pr_reram__reram_cell area_ox=0.0676
X9422 rr3t3r_0[58|21]/a_460_290# WL58 SL21 VSS sky130_fd_pr__nfet_g5v0d10v5 ad=0.65 pd=3.3 as=0 ps=0 w=1 l=0.5
X9423 BLN21 rr3t3r_0[58|21]/a_860_290# sky130_fd_pr_reram__reram_cell area_ox=0.0676
X9424 rr3t3r_0[58|21]/a_60_290# WL58 SL21 VSS sky130_fd_pr__nfet_g5v0d10v5 ad=0.65 pd=3.3 as=0 ps=0 w=1 l=0.5
X9425 rr3t3r_0[58|21]/a_860_290# WL58 SL21 VSS sky130_fd_pr__nfet_g5v0d10v5 ad=0.65 pd=3.3 as=0 ps=0 w=1 l=0.5
X9426 BLP21 rr3t3r_0[59|21]/a_60_290# sky130_fd_pr_reram__reram_cell area_ox=0.0676
X9427 BLZ21 rr3t3r_0[59|21]/a_460_290# sky130_fd_pr_reram__reram_cell area_ox=0.0676
X9428 rr3t3r_0[59|21]/a_460_290# WL59 SL21 VSS sky130_fd_pr__nfet_g5v0d10v5 ad=0.65 pd=3.3 as=0 ps=0 w=1 l=0.5
X9429 BLN21 rr3t3r_0[59|21]/a_860_290# sky130_fd_pr_reram__reram_cell area_ox=0.0676
X9430 rr3t3r_0[59|21]/a_60_290# WL59 SL21 VSS sky130_fd_pr__nfet_g5v0d10v5 ad=0.65 pd=3.3 as=0 ps=0 w=1 l=0.5
X9431 rr3t3r_0[59|21]/a_860_290# WL59 SL21 VSS sky130_fd_pr__nfet_g5v0d10v5 ad=0.65 pd=3.3 as=0 ps=0 w=1 l=0.5
X9432 BLP21 rr3t3r_0[60|21]/a_60_290# sky130_fd_pr_reram__reram_cell area_ox=0.0676
X9433 BLZ21 rr3t3r_0[60|21]/a_460_290# sky130_fd_pr_reram__reram_cell area_ox=0.0676
X9434 rr3t3r_0[60|21]/a_460_290# WL60 SL21 VSS sky130_fd_pr__nfet_g5v0d10v5 ad=0.65 pd=3.3 as=0 ps=0 w=1 l=0.5
X9435 BLN21 rr3t3r_0[60|21]/a_860_290# sky130_fd_pr_reram__reram_cell area_ox=0.0676
X9436 rr3t3r_0[60|21]/a_60_290# WL60 SL21 VSS sky130_fd_pr__nfet_g5v0d10v5 ad=0.65 pd=3.3 as=0 ps=0 w=1 l=0.5
X9437 rr3t3r_0[60|21]/a_860_290# WL60 SL21 VSS sky130_fd_pr__nfet_g5v0d10v5 ad=0.65 pd=3.3 as=0 ps=0 w=1 l=0.5
X9438 BLP21 rr3t3r_0[61|21]/a_60_290# sky130_fd_pr_reram__reram_cell area_ox=0.0676
X9439 BLZ21 rr3t3r_0[61|21]/a_460_290# sky130_fd_pr_reram__reram_cell area_ox=0.0676
X9440 rr3t3r_0[61|21]/a_460_290# WL61 SL21 VSS sky130_fd_pr__nfet_g5v0d10v5 ad=0.65 pd=3.3 as=0 ps=0 w=1 l=0.5
X9441 BLN21 rr3t3r_0[61|21]/a_860_290# sky130_fd_pr_reram__reram_cell area_ox=0.0676
X9442 rr3t3r_0[61|21]/a_60_290# WL61 SL21 VSS sky130_fd_pr__nfet_g5v0d10v5 ad=0.65 pd=3.3 as=0 ps=0 w=1 l=0.5
X9443 rr3t3r_0[61|21]/a_860_290# WL61 SL21 VSS sky130_fd_pr__nfet_g5v0d10v5 ad=0.65 pd=3.3 as=0 ps=0 w=1 l=0.5
X9444 BLP21 rr3t3r_0[62|21]/a_60_290# sky130_fd_pr_reram__reram_cell area_ox=0.0676
X9445 BLZ21 rr3t3r_0[62|21]/a_460_290# sky130_fd_pr_reram__reram_cell area_ox=0.0676
X9446 rr3t3r_0[62|21]/a_460_290# WL62 SL21 VSS sky130_fd_pr__nfet_g5v0d10v5 ad=0.65 pd=3.3 as=0 ps=0 w=1 l=0.5
X9447 BLN21 rr3t3r_0[62|21]/a_860_290# sky130_fd_pr_reram__reram_cell area_ox=0.0676
X9448 rr3t3r_0[62|21]/a_60_290# WL62 SL21 VSS sky130_fd_pr__nfet_g5v0d10v5 ad=0.65 pd=3.3 as=0 ps=0 w=1 l=0.5
X9449 rr3t3r_0[62|21]/a_860_290# WL62 SL21 VSS sky130_fd_pr__nfet_g5v0d10v5 ad=0.65 pd=3.3 as=0 ps=0 w=1 l=0.5
X9450 BLP21 rr3t3r_0[63|21]/a_60_290# sky130_fd_pr_reram__reram_cell area_ox=0.0676
X9451 BLZ21 rr3t3r_0[63|21]/a_460_290# sky130_fd_pr_reram__reram_cell area_ox=0.0676
X9452 rr3t3r_0[63|21]/a_460_290# WL63 SL21 VSS sky130_fd_pr__nfet_g5v0d10v5 ad=0.65 pd=3.3 as=0 ps=0 w=1 l=0.5
X9453 BLN21 rr3t3r_0[63|21]/a_860_290# sky130_fd_pr_reram__reram_cell area_ox=0.0676
X9454 rr3t3r_0[63|21]/a_60_290# WL63 SL21 VSS sky130_fd_pr__nfet_g5v0d10v5 ad=0.65 pd=3.3 as=0 ps=0 w=1 l=0.5
X9455 rr3t3r_0[63|21]/a_860_290# WL63 SL21 VSS sky130_fd_pr__nfet_g5v0d10v5 ad=0.65 pd=3.3 as=0 ps=0 w=1 l=0.5
X9456 BLP21 rr3t3r_0[64|21]/a_60_290# sky130_fd_pr_reram__reram_cell area_ox=0.0676
X9457 BLZ21 rr3t3r_0[64|21]/a_460_290# sky130_fd_pr_reram__reram_cell area_ox=0.0676
X9458 rr3t3r_0[64|21]/a_460_290# WL64 SL21 VSS sky130_fd_pr__nfet_g5v0d10v5 ad=0.65 pd=3.3 as=0 ps=0 w=1 l=0.5
X9459 BLN21 rr3t3r_0[64|21]/a_860_290# sky130_fd_pr_reram__reram_cell area_ox=0.0676
X9460 rr3t3r_0[64|21]/a_60_290# WL64 SL21 VSS sky130_fd_pr__nfet_g5v0d10v5 ad=0.65 pd=3.3 as=0 ps=0 w=1 l=0.5
X9461 rr3t3r_0[64|21]/a_860_290# WL64 SL21 VSS sky130_fd_pr__nfet_g5v0d10v5 ad=0.65 pd=3.3 as=0 ps=0 w=1 l=0.5
X9462 BLP21 rr3t3r_0[65|21]/a_60_290# sky130_fd_pr_reram__reram_cell area_ox=0.0676
X9463 BLZ21 rr3t3r_0[65|21]/a_460_290# sky130_fd_pr_reram__reram_cell area_ox=0.0676
X9464 rr3t3r_0[65|21]/a_460_290# WL65 SL21 VSS sky130_fd_pr__nfet_g5v0d10v5 ad=0.65 pd=3.3 as=0 ps=0 w=1 l=0.5
X9465 BLN21 rr3t3r_0[65|21]/a_860_290# sky130_fd_pr_reram__reram_cell area_ox=0.0676
X9466 rr3t3r_0[65|21]/a_60_290# WL65 SL21 VSS sky130_fd_pr__nfet_g5v0d10v5 ad=0.65 pd=3.3 as=0 ps=0 w=1 l=0.5
X9467 rr3t3r_0[65|21]/a_860_290# WL65 SL21 VSS sky130_fd_pr__nfet_g5v0d10v5 ad=0.65 pd=3.3 as=0 ps=0 w=1 l=0.5
X9468 BLP21 rr3t3r_0[66|21]/a_60_290# sky130_fd_pr_reram__reram_cell area_ox=0.0676
X9469 BLZ21 rr3t3r_0[66|21]/a_460_290# sky130_fd_pr_reram__reram_cell area_ox=0.0676
X9470 rr3t3r_0[66|21]/a_460_290# WL66 SL21 VSS sky130_fd_pr__nfet_g5v0d10v5 ad=0.65 pd=3.3 as=0 ps=0 w=1 l=0.5
X9471 BLN21 rr3t3r_0[66|21]/a_860_290# sky130_fd_pr_reram__reram_cell area_ox=0.0676
X9472 rr3t3r_0[66|21]/a_60_290# WL66 SL21 VSS sky130_fd_pr__nfet_g5v0d10v5 ad=0.65 pd=3.3 as=0 ps=0 w=1 l=0.5
X9473 rr3t3r_0[66|21]/a_860_290# WL66 SL21 VSS sky130_fd_pr__nfet_g5v0d10v5 ad=0.65 pd=3.3 as=0 ps=0 w=1 l=0.5
X9474 BLP21 rr3t3r_0[67|21]/a_60_290# sky130_fd_pr_reram__reram_cell area_ox=0.0676
X9475 BLZ21 rr3t3r_0[67|21]/a_460_290# sky130_fd_pr_reram__reram_cell area_ox=0.0676
X9476 rr3t3r_0[67|21]/a_460_290# WL67 SL21 VSS sky130_fd_pr__nfet_g5v0d10v5 ad=0.65 pd=3.3 as=0 ps=0 w=1 l=0.5
X9477 BLN21 rr3t3r_0[67|21]/a_860_290# sky130_fd_pr_reram__reram_cell area_ox=0.0676
X9478 rr3t3r_0[67|21]/a_60_290# WL67 SL21 VSS sky130_fd_pr__nfet_g5v0d10v5 ad=0.65 pd=3.3 as=0 ps=0 w=1 l=0.5
X9479 rr3t3r_0[67|21]/a_860_290# WL67 SL21 VSS sky130_fd_pr__nfet_g5v0d10v5 ad=0.65 pd=3.3 as=0 ps=0 w=1 l=0.5
X9480 BLP21 rr3t3r_0[68|21]/a_60_290# sky130_fd_pr_reram__reram_cell area_ox=0.0676
X9481 BLZ21 rr3t3r_0[68|21]/a_460_290# sky130_fd_pr_reram__reram_cell area_ox=0.0676
X9482 rr3t3r_0[68|21]/a_460_290# WL68 SL21 VSS sky130_fd_pr__nfet_g5v0d10v5 ad=0.65 pd=3.3 as=0 ps=0 w=1 l=0.5
X9483 BLN21 rr3t3r_0[68|21]/a_860_290# sky130_fd_pr_reram__reram_cell area_ox=0.0676
X9484 rr3t3r_0[68|21]/a_60_290# WL68 SL21 VSS sky130_fd_pr__nfet_g5v0d10v5 ad=0.65 pd=3.3 as=0 ps=0 w=1 l=0.5
X9485 rr3t3r_0[68|21]/a_860_290# WL68 SL21 VSS sky130_fd_pr__nfet_g5v0d10v5 ad=0.65 pd=3.3 as=0 ps=0 w=1 l=0.5
X9486 BLP21 rr3t3r_0[69|21]/a_60_290# sky130_fd_pr_reram__reram_cell area_ox=0.0676
X9487 BLZ21 rr3t3r_0[69|21]/a_460_290# sky130_fd_pr_reram__reram_cell area_ox=0.0676
X9488 rr3t3r_0[69|21]/a_460_290# WL69 SL21 VSS sky130_fd_pr__nfet_g5v0d10v5 ad=0.65 pd=3.3 as=0 ps=0 w=1 l=0.5
X9489 BLN21 rr3t3r_0[69|21]/a_860_290# sky130_fd_pr_reram__reram_cell area_ox=0.0676
X9490 rr3t3r_0[69|21]/a_60_290# WL69 SL21 VSS sky130_fd_pr__nfet_g5v0d10v5 ad=0.65 pd=3.3 as=0 ps=0 w=1 l=0.5
X9491 rr3t3r_0[69|21]/a_860_290# WL69 SL21 VSS sky130_fd_pr__nfet_g5v0d10v5 ad=0.65 pd=3.3 as=0 ps=0 w=1 l=0.5
X9492 BLP21 rr3t3r_0[70|21]/a_60_290# sky130_fd_pr_reram__reram_cell area_ox=0.0676
X9493 BLZ21 rr3t3r_0[70|21]/a_460_290# sky130_fd_pr_reram__reram_cell area_ox=0.0676
X9494 rr3t3r_0[70|21]/a_460_290# WL70 SL21 VSS sky130_fd_pr__nfet_g5v0d10v5 ad=0.65 pd=3.3 as=0 ps=0 w=1 l=0.5
X9495 BLN21 rr3t3r_0[70|21]/a_860_290# sky130_fd_pr_reram__reram_cell area_ox=0.0676
X9496 rr3t3r_0[70|21]/a_60_290# WL70 SL21 VSS sky130_fd_pr__nfet_g5v0d10v5 ad=0.65 pd=3.3 as=0 ps=0 w=1 l=0.5
X9497 rr3t3r_0[70|21]/a_860_290# WL70 SL21 VSS sky130_fd_pr__nfet_g5v0d10v5 ad=0.65 pd=3.3 as=0 ps=0 w=1 l=0.5
X9498 BLP21 rr3t3r_0[71|21]/a_60_290# sky130_fd_pr_reram__reram_cell area_ox=0.0676
X9499 BLZ21 rr3t3r_0[71|21]/a_460_290# sky130_fd_pr_reram__reram_cell area_ox=0.0676
X9500 rr3t3r_0[71|21]/a_460_290# WL71 SL21 VSS sky130_fd_pr__nfet_g5v0d10v5 ad=0.65 pd=3.3 as=0 ps=0 w=1 l=0.5
X9501 BLN21 rr3t3r_0[71|21]/a_860_290# sky130_fd_pr_reram__reram_cell area_ox=0.0676
X9502 rr3t3r_0[71|21]/a_60_290# WL71 SL21 VSS sky130_fd_pr__nfet_g5v0d10v5 ad=0.65 pd=3.3 as=0 ps=0 w=1 l=0.5
X9503 rr3t3r_0[71|21]/a_860_290# WL71 SL21 VSS sky130_fd_pr__nfet_g5v0d10v5 ad=0.65 pd=3.3 as=0 ps=0 w=1 l=0.5
X9504 BLP22 rr3t3r_0[0|22]/a_60_290# sky130_fd_pr_reram__reram_cell area_ox=0.0676
X9505 BLZ22 rr3t3r_0[0|22]/a_460_290# sky130_fd_pr_reram__reram_cell area_ox=0.0676
X9506 rr3t3r_0[0|22]/a_460_290# WL0 SL22 VSS sky130_fd_pr__nfet_g5v0d10v5 ad=0.65 pd=3.3 as=162 ps=756 w=1 l=0.5
X9507 BLN22 rr3t3r_0[0|22]/a_860_290# sky130_fd_pr_reram__reram_cell area_ox=0.0676
X9508 rr3t3r_0[0|22]/a_60_290# WL0 SL22 VSS sky130_fd_pr__nfet_g5v0d10v5 ad=0.65 pd=3.3 as=0 ps=0 w=1 l=0.5
X9509 rr3t3r_0[0|22]/a_860_290# WL0 SL22 VSS sky130_fd_pr__nfet_g5v0d10v5 ad=0.65 pd=3.3 as=0 ps=0 w=1 l=0.5
X9510 BLP22 rr3t3r_0[1|22]/a_60_290# sky130_fd_pr_reram__reram_cell area_ox=0.0676
X9511 BLZ22 rr3t3r_0[1|22]/a_460_290# sky130_fd_pr_reram__reram_cell area_ox=0.0676
X9512 rr3t3r_0[1|22]/a_460_290# WL1 SL22 VSS sky130_fd_pr__nfet_g5v0d10v5 ad=0.65 pd=3.3 as=0 ps=0 w=1 l=0.5
X9513 BLN22 rr3t3r_0[1|22]/a_860_290# sky130_fd_pr_reram__reram_cell area_ox=0.0676
X9514 rr3t3r_0[1|22]/a_60_290# WL1 SL22 VSS sky130_fd_pr__nfet_g5v0d10v5 ad=0.65 pd=3.3 as=0 ps=0 w=1 l=0.5
X9515 rr3t3r_0[1|22]/a_860_290# WL1 SL22 VSS sky130_fd_pr__nfet_g5v0d10v5 ad=0.65 pd=3.3 as=0 ps=0 w=1 l=0.5
X9516 BLP22 rr3t3r_0[2|22]/a_60_290# sky130_fd_pr_reram__reram_cell area_ox=0.0676
X9517 BLZ22 rr3t3r_0[2|22]/a_460_290# sky130_fd_pr_reram__reram_cell area_ox=0.0676
X9518 rr3t3r_0[2|22]/a_460_290# WL2 SL22 VSS sky130_fd_pr__nfet_g5v0d10v5 ad=0.65 pd=3.3 as=0 ps=0 w=1 l=0.5
X9519 BLN22 rr3t3r_0[2|22]/a_860_290# sky130_fd_pr_reram__reram_cell area_ox=0.0676
X9520 rr3t3r_0[2|22]/a_60_290# WL2 SL22 VSS sky130_fd_pr__nfet_g5v0d10v5 ad=0.65 pd=3.3 as=0 ps=0 w=1 l=0.5
X9521 rr3t3r_0[2|22]/a_860_290# WL2 SL22 VSS sky130_fd_pr__nfet_g5v0d10v5 ad=0.65 pd=3.3 as=0 ps=0 w=1 l=0.5
X9522 BLP22 rr3t3r_0[3|22]/a_60_290# sky130_fd_pr_reram__reram_cell area_ox=0.0676
X9523 BLZ22 rr3t3r_0[3|22]/a_460_290# sky130_fd_pr_reram__reram_cell area_ox=0.0676
X9524 rr3t3r_0[3|22]/a_460_290# WL3 SL22 VSS sky130_fd_pr__nfet_g5v0d10v5 ad=0.65 pd=3.3 as=0 ps=0 w=1 l=0.5
X9525 BLN22 rr3t3r_0[3|22]/a_860_290# sky130_fd_pr_reram__reram_cell area_ox=0.0676
X9526 rr3t3r_0[3|22]/a_60_290# WL3 SL22 VSS sky130_fd_pr__nfet_g5v0d10v5 ad=0.65 pd=3.3 as=0 ps=0 w=1 l=0.5
X9527 rr3t3r_0[3|22]/a_860_290# WL3 SL22 VSS sky130_fd_pr__nfet_g5v0d10v5 ad=0.65 pd=3.3 as=0 ps=0 w=1 l=0.5
X9528 BLP22 rr3t3r_0[4|22]/a_60_290# sky130_fd_pr_reram__reram_cell area_ox=0.0676
X9529 BLZ22 rr3t3r_0[4|22]/a_460_290# sky130_fd_pr_reram__reram_cell area_ox=0.0676
X9530 rr3t3r_0[4|22]/a_460_290# WL4 SL22 VSS sky130_fd_pr__nfet_g5v0d10v5 ad=0.65 pd=3.3 as=0 ps=0 w=1 l=0.5
X9531 BLN22 rr3t3r_0[4|22]/a_860_290# sky130_fd_pr_reram__reram_cell area_ox=0.0676
X9532 rr3t3r_0[4|22]/a_60_290# WL4 SL22 VSS sky130_fd_pr__nfet_g5v0d10v5 ad=0.65 pd=3.3 as=0 ps=0 w=1 l=0.5
X9533 rr3t3r_0[4|22]/a_860_290# WL4 SL22 VSS sky130_fd_pr__nfet_g5v0d10v5 ad=0.65 pd=3.3 as=0 ps=0 w=1 l=0.5
X9534 BLP22 rr3t3r_0[5|22]/a_60_290# sky130_fd_pr_reram__reram_cell area_ox=0.0676
X9535 BLZ22 rr3t3r_0[5|22]/a_460_290# sky130_fd_pr_reram__reram_cell area_ox=0.0676
X9536 rr3t3r_0[5|22]/a_460_290# WL5 SL22 VSS sky130_fd_pr__nfet_g5v0d10v5 ad=0.65 pd=3.3 as=0 ps=0 w=1 l=0.5
X9537 BLN22 rr3t3r_0[5|22]/a_860_290# sky130_fd_pr_reram__reram_cell area_ox=0.0676
X9538 rr3t3r_0[5|22]/a_60_290# WL5 SL22 VSS sky130_fd_pr__nfet_g5v0d10v5 ad=0.65 pd=3.3 as=0 ps=0 w=1 l=0.5
X9539 rr3t3r_0[5|22]/a_860_290# WL5 SL22 VSS sky130_fd_pr__nfet_g5v0d10v5 ad=0.65 pd=3.3 as=0 ps=0 w=1 l=0.5
X9540 BLP22 rr3t3r_0[6|22]/a_60_290# sky130_fd_pr_reram__reram_cell area_ox=0.0676
X9541 BLZ22 rr3t3r_0[6|22]/a_460_290# sky130_fd_pr_reram__reram_cell area_ox=0.0676
X9542 rr3t3r_0[6|22]/a_460_290# WL6 SL22 VSS sky130_fd_pr__nfet_g5v0d10v5 ad=0.65 pd=3.3 as=0 ps=0 w=1 l=0.5
X9543 BLN22 rr3t3r_0[6|22]/a_860_290# sky130_fd_pr_reram__reram_cell area_ox=0.0676
X9544 rr3t3r_0[6|22]/a_60_290# WL6 SL22 VSS sky130_fd_pr__nfet_g5v0d10v5 ad=0.65 pd=3.3 as=0 ps=0 w=1 l=0.5
X9545 rr3t3r_0[6|22]/a_860_290# WL6 SL22 VSS sky130_fd_pr__nfet_g5v0d10v5 ad=0.65 pd=3.3 as=0 ps=0 w=1 l=0.5
X9546 BLP22 rr3t3r_0[7|22]/a_60_290# sky130_fd_pr_reram__reram_cell area_ox=0.0676
X9547 BLZ22 rr3t3r_0[7|22]/a_460_290# sky130_fd_pr_reram__reram_cell area_ox=0.0676
X9548 rr3t3r_0[7|22]/a_460_290# WL7 SL22 VSS sky130_fd_pr__nfet_g5v0d10v5 ad=0.65 pd=3.3 as=0 ps=0 w=1 l=0.5
X9549 BLN22 rr3t3r_0[7|22]/a_860_290# sky130_fd_pr_reram__reram_cell area_ox=0.0676
X9550 rr3t3r_0[7|22]/a_60_290# WL7 SL22 VSS sky130_fd_pr__nfet_g5v0d10v5 ad=0.65 pd=3.3 as=0 ps=0 w=1 l=0.5
X9551 rr3t3r_0[7|22]/a_860_290# WL7 SL22 VSS sky130_fd_pr__nfet_g5v0d10v5 ad=0.65 pd=3.3 as=0 ps=0 w=1 l=0.5
X9552 BLP22 rr3t3r_0[8|22]/a_60_290# sky130_fd_pr_reram__reram_cell area_ox=0.0676
X9553 BLZ22 rr3t3r_0[8|22]/a_460_290# sky130_fd_pr_reram__reram_cell area_ox=0.0676
X9554 rr3t3r_0[8|22]/a_460_290# WL8 SL22 VSS sky130_fd_pr__nfet_g5v0d10v5 ad=0.65 pd=3.3 as=0 ps=0 w=1 l=0.5
X9555 BLN22 rr3t3r_0[8|22]/a_860_290# sky130_fd_pr_reram__reram_cell area_ox=0.0676
X9556 rr3t3r_0[8|22]/a_60_290# WL8 SL22 VSS sky130_fd_pr__nfet_g5v0d10v5 ad=0.65 pd=3.3 as=0 ps=0 w=1 l=0.5
X9557 rr3t3r_0[8|22]/a_860_290# WL8 SL22 VSS sky130_fd_pr__nfet_g5v0d10v5 ad=0.65 pd=3.3 as=0 ps=0 w=1 l=0.5
X9558 BLP22 rr3t3r_0[9|22]/a_60_290# sky130_fd_pr_reram__reram_cell area_ox=0.0676
X9559 BLZ22 rr3t3r_0[9|22]/a_460_290# sky130_fd_pr_reram__reram_cell area_ox=0.0676
X9560 rr3t3r_0[9|22]/a_460_290# WL9 SL22 VSS sky130_fd_pr__nfet_g5v0d10v5 ad=0.65 pd=3.3 as=0 ps=0 w=1 l=0.5
X9561 BLN22 rr3t3r_0[9|22]/a_860_290# sky130_fd_pr_reram__reram_cell area_ox=0.0676
X9562 rr3t3r_0[9|22]/a_60_290# WL9 SL22 VSS sky130_fd_pr__nfet_g5v0d10v5 ad=0.65 pd=3.3 as=0 ps=0 w=1 l=0.5
X9563 rr3t3r_0[9|22]/a_860_290# WL9 SL22 VSS sky130_fd_pr__nfet_g5v0d10v5 ad=0.65 pd=3.3 as=0 ps=0 w=1 l=0.5
X9564 BLP22 rr3t3r_0[10|22]/a_60_290# sky130_fd_pr_reram__reram_cell area_ox=0.0676
X9565 BLZ22 rr3t3r_0[10|22]/a_460_290# sky130_fd_pr_reram__reram_cell area_ox=0.0676
X9566 rr3t3r_0[10|22]/a_460_290# WL10 SL22 VSS sky130_fd_pr__nfet_g5v0d10v5 ad=0.65 pd=3.3 as=0 ps=0 w=1 l=0.5
X9567 BLN22 rr3t3r_0[10|22]/a_860_290# sky130_fd_pr_reram__reram_cell area_ox=0.0676
X9568 rr3t3r_0[10|22]/a_60_290# WL10 SL22 VSS sky130_fd_pr__nfet_g5v0d10v5 ad=0.65 pd=3.3 as=0 ps=0 w=1 l=0.5
X9569 rr3t3r_0[10|22]/a_860_290# WL10 SL22 VSS sky130_fd_pr__nfet_g5v0d10v5 ad=0.65 pd=3.3 as=0 ps=0 w=1 l=0.5
X9570 BLP22 rr3t3r_0[11|22]/a_60_290# sky130_fd_pr_reram__reram_cell area_ox=0.0676
X9571 BLZ22 rr3t3r_0[11|22]/a_460_290# sky130_fd_pr_reram__reram_cell area_ox=0.0676
X9572 rr3t3r_0[11|22]/a_460_290# WL11 SL22 VSS sky130_fd_pr__nfet_g5v0d10v5 ad=0.65 pd=3.3 as=0 ps=0 w=1 l=0.5
X9573 BLN22 rr3t3r_0[11|22]/a_860_290# sky130_fd_pr_reram__reram_cell area_ox=0.0676
X9574 rr3t3r_0[11|22]/a_60_290# WL11 SL22 VSS sky130_fd_pr__nfet_g5v0d10v5 ad=0.65 pd=3.3 as=0 ps=0 w=1 l=0.5
X9575 rr3t3r_0[11|22]/a_860_290# WL11 SL22 VSS sky130_fd_pr__nfet_g5v0d10v5 ad=0.65 pd=3.3 as=0 ps=0 w=1 l=0.5
X9576 BLP22 rr3t3r_0[12|22]/a_60_290# sky130_fd_pr_reram__reram_cell area_ox=0.0676
X9577 BLZ22 rr3t3r_0[12|22]/a_460_290# sky130_fd_pr_reram__reram_cell area_ox=0.0676
X9578 rr3t3r_0[12|22]/a_460_290# WL12 SL22 VSS sky130_fd_pr__nfet_g5v0d10v5 ad=0.65 pd=3.3 as=0 ps=0 w=1 l=0.5
X9579 BLN22 rr3t3r_0[12|22]/a_860_290# sky130_fd_pr_reram__reram_cell area_ox=0.0676
X9580 rr3t3r_0[12|22]/a_60_290# WL12 SL22 VSS sky130_fd_pr__nfet_g5v0d10v5 ad=0.65 pd=3.3 as=0 ps=0 w=1 l=0.5
X9581 rr3t3r_0[12|22]/a_860_290# WL12 SL22 VSS sky130_fd_pr__nfet_g5v0d10v5 ad=0.65 pd=3.3 as=0 ps=0 w=1 l=0.5
X9582 BLP22 rr3t3r_0[13|22]/a_60_290# sky130_fd_pr_reram__reram_cell area_ox=0.0676
X9583 BLZ22 rr3t3r_0[13|22]/a_460_290# sky130_fd_pr_reram__reram_cell area_ox=0.0676
X9584 rr3t3r_0[13|22]/a_460_290# WL13 SL22 VSS sky130_fd_pr__nfet_g5v0d10v5 ad=0.65 pd=3.3 as=0 ps=0 w=1 l=0.5
X9585 BLN22 rr3t3r_0[13|22]/a_860_290# sky130_fd_pr_reram__reram_cell area_ox=0.0676
X9586 rr3t3r_0[13|22]/a_60_290# WL13 SL22 VSS sky130_fd_pr__nfet_g5v0d10v5 ad=0.65 pd=3.3 as=0 ps=0 w=1 l=0.5
X9587 rr3t3r_0[13|22]/a_860_290# WL13 SL22 VSS sky130_fd_pr__nfet_g5v0d10v5 ad=0.65 pd=3.3 as=0 ps=0 w=1 l=0.5
X9588 BLP22 rr3t3r_0[14|22]/a_60_290# sky130_fd_pr_reram__reram_cell area_ox=0.0676
X9589 BLZ22 rr3t3r_0[14|22]/a_460_290# sky130_fd_pr_reram__reram_cell area_ox=0.0676
X9590 rr3t3r_0[14|22]/a_460_290# WL14 SL22 VSS sky130_fd_pr__nfet_g5v0d10v5 ad=0.65 pd=3.3 as=0 ps=0 w=1 l=0.5
X9591 BLN22 rr3t3r_0[14|22]/a_860_290# sky130_fd_pr_reram__reram_cell area_ox=0.0676
X9592 rr3t3r_0[14|22]/a_60_290# WL14 SL22 VSS sky130_fd_pr__nfet_g5v0d10v5 ad=0.65 pd=3.3 as=0 ps=0 w=1 l=0.5
X9593 rr3t3r_0[14|22]/a_860_290# WL14 SL22 VSS sky130_fd_pr__nfet_g5v0d10v5 ad=0.65 pd=3.3 as=0 ps=0 w=1 l=0.5
X9594 BLP22 rr3t3r_0[15|22]/a_60_290# sky130_fd_pr_reram__reram_cell area_ox=0.0676
X9595 BLZ22 rr3t3r_0[15|22]/a_460_290# sky130_fd_pr_reram__reram_cell area_ox=0.0676
X9596 rr3t3r_0[15|22]/a_460_290# WL15 SL22 VSS sky130_fd_pr__nfet_g5v0d10v5 ad=0.65 pd=3.3 as=0 ps=0 w=1 l=0.5
X9597 BLN22 rr3t3r_0[15|22]/a_860_290# sky130_fd_pr_reram__reram_cell area_ox=0.0676
X9598 rr3t3r_0[15|22]/a_60_290# WL15 SL22 VSS sky130_fd_pr__nfet_g5v0d10v5 ad=0.65 pd=3.3 as=0 ps=0 w=1 l=0.5
X9599 rr3t3r_0[15|22]/a_860_290# WL15 SL22 VSS sky130_fd_pr__nfet_g5v0d10v5 ad=0.65 pd=3.3 as=0 ps=0 w=1 l=0.5
X9600 BLP22 rr3t3r_0[16|22]/a_60_290# sky130_fd_pr_reram__reram_cell area_ox=0.0676
X9601 BLZ22 rr3t3r_0[16|22]/a_460_290# sky130_fd_pr_reram__reram_cell area_ox=0.0676
X9602 rr3t3r_0[16|22]/a_460_290# WL16 SL22 VSS sky130_fd_pr__nfet_g5v0d10v5 ad=0.65 pd=3.3 as=0 ps=0 w=1 l=0.5
X9603 BLN22 rr3t3r_0[16|22]/a_860_290# sky130_fd_pr_reram__reram_cell area_ox=0.0676
X9604 rr3t3r_0[16|22]/a_60_290# WL16 SL22 VSS sky130_fd_pr__nfet_g5v0d10v5 ad=0.65 pd=3.3 as=0 ps=0 w=1 l=0.5
X9605 rr3t3r_0[16|22]/a_860_290# WL16 SL22 VSS sky130_fd_pr__nfet_g5v0d10v5 ad=0.65 pd=3.3 as=0 ps=0 w=1 l=0.5
X9606 BLP22 rr3t3r_0[17|22]/a_60_290# sky130_fd_pr_reram__reram_cell area_ox=0.0676
X9607 BLZ22 rr3t3r_0[17|22]/a_460_290# sky130_fd_pr_reram__reram_cell area_ox=0.0676
X9608 rr3t3r_0[17|22]/a_460_290# WL17 SL22 VSS sky130_fd_pr__nfet_g5v0d10v5 ad=0.65 pd=3.3 as=0 ps=0 w=1 l=0.5
X9609 BLN22 rr3t3r_0[17|22]/a_860_290# sky130_fd_pr_reram__reram_cell area_ox=0.0676
X9610 rr3t3r_0[17|22]/a_60_290# WL17 SL22 VSS sky130_fd_pr__nfet_g5v0d10v5 ad=0.65 pd=3.3 as=0 ps=0 w=1 l=0.5
X9611 rr3t3r_0[17|22]/a_860_290# WL17 SL22 VSS sky130_fd_pr__nfet_g5v0d10v5 ad=0.65 pd=3.3 as=0 ps=0 w=1 l=0.5
X9612 BLP22 rr3t3r_0[18|22]/a_60_290# sky130_fd_pr_reram__reram_cell area_ox=0.0676
X9613 BLZ22 rr3t3r_0[18|22]/a_460_290# sky130_fd_pr_reram__reram_cell area_ox=0.0676
X9614 rr3t3r_0[18|22]/a_460_290# WL18 SL22 VSS sky130_fd_pr__nfet_g5v0d10v5 ad=0.65 pd=3.3 as=0 ps=0 w=1 l=0.5
X9615 BLN22 rr3t3r_0[18|22]/a_860_290# sky130_fd_pr_reram__reram_cell area_ox=0.0676
X9616 rr3t3r_0[18|22]/a_60_290# WL18 SL22 VSS sky130_fd_pr__nfet_g5v0d10v5 ad=0.65 pd=3.3 as=0 ps=0 w=1 l=0.5
X9617 rr3t3r_0[18|22]/a_860_290# WL18 SL22 VSS sky130_fd_pr__nfet_g5v0d10v5 ad=0.65 pd=3.3 as=0 ps=0 w=1 l=0.5
X9618 BLP22 rr3t3r_0[19|22]/a_60_290# sky130_fd_pr_reram__reram_cell area_ox=0.0676
X9619 BLZ22 rr3t3r_0[19|22]/a_460_290# sky130_fd_pr_reram__reram_cell area_ox=0.0676
X9620 rr3t3r_0[19|22]/a_460_290# WL19 SL22 VSS sky130_fd_pr__nfet_g5v0d10v5 ad=0.65 pd=3.3 as=0 ps=0 w=1 l=0.5
X9621 BLN22 rr3t3r_0[19|22]/a_860_290# sky130_fd_pr_reram__reram_cell area_ox=0.0676
X9622 rr3t3r_0[19|22]/a_60_290# WL19 SL22 VSS sky130_fd_pr__nfet_g5v0d10v5 ad=0.65 pd=3.3 as=0 ps=0 w=1 l=0.5
X9623 rr3t3r_0[19|22]/a_860_290# WL19 SL22 VSS sky130_fd_pr__nfet_g5v0d10v5 ad=0.65 pd=3.3 as=0 ps=0 w=1 l=0.5
X9624 BLP22 rr3t3r_0[20|22]/a_60_290# sky130_fd_pr_reram__reram_cell area_ox=0.0676
X9625 BLZ22 rr3t3r_0[20|22]/a_460_290# sky130_fd_pr_reram__reram_cell area_ox=0.0676
X9626 rr3t3r_0[20|22]/a_460_290# WL20 SL22 VSS sky130_fd_pr__nfet_g5v0d10v5 ad=0.65 pd=3.3 as=0 ps=0 w=1 l=0.5
X9627 BLN22 rr3t3r_0[20|22]/a_860_290# sky130_fd_pr_reram__reram_cell area_ox=0.0676
X9628 rr3t3r_0[20|22]/a_60_290# WL20 SL22 VSS sky130_fd_pr__nfet_g5v0d10v5 ad=0.65 pd=3.3 as=0 ps=0 w=1 l=0.5
X9629 rr3t3r_0[20|22]/a_860_290# WL20 SL22 VSS sky130_fd_pr__nfet_g5v0d10v5 ad=0.65 pd=3.3 as=0 ps=0 w=1 l=0.5
X9630 BLP22 rr3t3r_0[21|22]/a_60_290# sky130_fd_pr_reram__reram_cell area_ox=0.0676
X9631 BLZ22 rr3t3r_0[21|22]/a_460_290# sky130_fd_pr_reram__reram_cell area_ox=0.0676
X9632 rr3t3r_0[21|22]/a_460_290# WL21 SL22 VSS sky130_fd_pr__nfet_g5v0d10v5 ad=0.65 pd=3.3 as=0 ps=0 w=1 l=0.5
X9633 BLN22 rr3t3r_0[21|22]/a_860_290# sky130_fd_pr_reram__reram_cell area_ox=0.0676
X9634 rr3t3r_0[21|22]/a_60_290# WL21 SL22 VSS sky130_fd_pr__nfet_g5v0d10v5 ad=0.65 pd=3.3 as=0 ps=0 w=1 l=0.5
X9635 rr3t3r_0[21|22]/a_860_290# WL21 SL22 VSS sky130_fd_pr__nfet_g5v0d10v5 ad=0.65 pd=3.3 as=0 ps=0 w=1 l=0.5
X9636 BLP22 rr3t3r_0[22|22]/a_60_290# sky130_fd_pr_reram__reram_cell area_ox=0.0676
X9637 BLZ22 rr3t3r_0[22|22]/a_460_290# sky130_fd_pr_reram__reram_cell area_ox=0.0676
X9638 rr3t3r_0[22|22]/a_460_290# WL22 SL22 VSS sky130_fd_pr__nfet_g5v0d10v5 ad=0.65 pd=3.3 as=0 ps=0 w=1 l=0.5
X9639 BLN22 rr3t3r_0[22|22]/a_860_290# sky130_fd_pr_reram__reram_cell area_ox=0.0676
X9640 rr3t3r_0[22|22]/a_60_290# WL22 SL22 VSS sky130_fd_pr__nfet_g5v0d10v5 ad=0.65 pd=3.3 as=0 ps=0 w=1 l=0.5
X9641 rr3t3r_0[22|22]/a_860_290# WL22 SL22 VSS sky130_fd_pr__nfet_g5v0d10v5 ad=0.65 pd=3.3 as=0 ps=0 w=1 l=0.5
X9642 BLP22 rr3t3r_0[23|22]/a_60_290# sky130_fd_pr_reram__reram_cell area_ox=0.0676
X9643 BLZ22 rr3t3r_0[23|22]/a_460_290# sky130_fd_pr_reram__reram_cell area_ox=0.0676
X9644 rr3t3r_0[23|22]/a_460_290# WL23 SL22 VSS sky130_fd_pr__nfet_g5v0d10v5 ad=0.65 pd=3.3 as=0 ps=0 w=1 l=0.5
X9645 BLN22 rr3t3r_0[23|22]/a_860_290# sky130_fd_pr_reram__reram_cell area_ox=0.0676
X9646 rr3t3r_0[23|22]/a_60_290# WL23 SL22 VSS sky130_fd_pr__nfet_g5v0d10v5 ad=0.65 pd=3.3 as=0 ps=0 w=1 l=0.5
X9647 rr3t3r_0[23|22]/a_860_290# WL23 SL22 VSS sky130_fd_pr__nfet_g5v0d10v5 ad=0.65 pd=3.3 as=0 ps=0 w=1 l=0.5
X9648 BLP22 rr3t3r_0[24|22]/a_60_290# sky130_fd_pr_reram__reram_cell area_ox=0.0676
X9649 BLZ22 rr3t3r_0[24|22]/a_460_290# sky130_fd_pr_reram__reram_cell area_ox=0.0676
X9650 rr3t3r_0[24|22]/a_460_290# WL24 SL22 VSS sky130_fd_pr__nfet_g5v0d10v5 ad=0.65 pd=3.3 as=0 ps=0 w=1 l=0.5
X9651 BLN22 rr3t3r_0[24|22]/a_860_290# sky130_fd_pr_reram__reram_cell area_ox=0.0676
X9652 rr3t3r_0[24|22]/a_60_290# WL24 SL22 VSS sky130_fd_pr__nfet_g5v0d10v5 ad=0.65 pd=3.3 as=0 ps=0 w=1 l=0.5
X9653 rr3t3r_0[24|22]/a_860_290# WL24 SL22 VSS sky130_fd_pr__nfet_g5v0d10v5 ad=0.65 pd=3.3 as=0 ps=0 w=1 l=0.5
X9654 BLP22 rr3t3r_0[25|22]/a_60_290# sky130_fd_pr_reram__reram_cell area_ox=0.0676
X9655 BLZ22 rr3t3r_0[25|22]/a_460_290# sky130_fd_pr_reram__reram_cell area_ox=0.0676
X9656 rr3t3r_0[25|22]/a_460_290# WL25 SL22 VSS sky130_fd_pr__nfet_g5v0d10v5 ad=0.65 pd=3.3 as=0 ps=0 w=1 l=0.5
X9657 BLN22 rr3t3r_0[25|22]/a_860_290# sky130_fd_pr_reram__reram_cell area_ox=0.0676
X9658 rr3t3r_0[25|22]/a_60_290# WL25 SL22 VSS sky130_fd_pr__nfet_g5v0d10v5 ad=0.65 pd=3.3 as=0 ps=0 w=1 l=0.5
X9659 rr3t3r_0[25|22]/a_860_290# WL25 SL22 VSS sky130_fd_pr__nfet_g5v0d10v5 ad=0.65 pd=3.3 as=0 ps=0 w=1 l=0.5
X9660 BLP22 rr3t3r_0[26|22]/a_60_290# sky130_fd_pr_reram__reram_cell area_ox=0.0676
X9661 BLZ22 rr3t3r_0[26|22]/a_460_290# sky130_fd_pr_reram__reram_cell area_ox=0.0676
X9662 rr3t3r_0[26|22]/a_460_290# WL26 SL22 VSS sky130_fd_pr__nfet_g5v0d10v5 ad=0.65 pd=3.3 as=0 ps=0 w=1 l=0.5
X9663 BLN22 rr3t3r_0[26|22]/a_860_290# sky130_fd_pr_reram__reram_cell area_ox=0.0676
X9664 rr3t3r_0[26|22]/a_60_290# WL26 SL22 VSS sky130_fd_pr__nfet_g5v0d10v5 ad=0.65 pd=3.3 as=0 ps=0 w=1 l=0.5
X9665 rr3t3r_0[26|22]/a_860_290# WL26 SL22 VSS sky130_fd_pr__nfet_g5v0d10v5 ad=0.65 pd=3.3 as=0 ps=0 w=1 l=0.5
X9666 BLP22 rr3t3r_0[27|22]/a_60_290# sky130_fd_pr_reram__reram_cell area_ox=0.0676
X9667 BLZ22 rr3t3r_0[27|22]/a_460_290# sky130_fd_pr_reram__reram_cell area_ox=0.0676
X9668 rr3t3r_0[27|22]/a_460_290# WL27 SL22 VSS sky130_fd_pr__nfet_g5v0d10v5 ad=0.65 pd=3.3 as=0 ps=0 w=1 l=0.5
X9669 BLN22 rr3t3r_0[27|22]/a_860_290# sky130_fd_pr_reram__reram_cell area_ox=0.0676
X9670 rr3t3r_0[27|22]/a_60_290# WL27 SL22 VSS sky130_fd_pr__nfet_g5v0d10v5 ad=0.65 pd=3.3 as=0 ps=0 w=1 l=0.5
X9671 rr3t3r_0[27|22]/a_860_290# WL27 SL22 VSS sky130_fd_pr__nfet_g5v0d10v5 ad=0.65 pd=3.3 as=0 ps=0 w=1 l=0.5
X9672 BLP22 rr3t3r_0[28|22]/a_60_290# sky130_fd_pr_reram__reram_cell area_ox=0.0676
X9673 BLZ22 rr3t3r_0[28|22]/a_460_290# sky130_fd_pr_reram__reram_cell area_ox=0.0676
X9674 rr3t3r_0[28|22]/a_460_290# WL28 SL22 VSS sky130_fd_pr__nfet_g5v0d10v5 ad=0.65 pd=3.3 as=0 ps=0 w=1 l=0.5
X9675 BLN22 rr3t3r_0[28|22]/a_860_290# sky130_fd_pr_reram__reram_cell area_ox=0.0676
X9676 rr3t3r_0[28|22]/a_60_290# WL28 SL22 VSS sky130_fd_pr__nfet_g5v0d10v5 ad=0.65 pd=3.3 as=0 ps=0 w=1 l=0.5
X9677 rr3t3r_0[28|22]/a_860_290# WL28 SL22 VSS sky130_fd_pr__nfet_g5v0d10v5 ad=0.65 pd=3.3 as=0 ps=0 w=1 l=0.5
X9678 BLP22 rr3t3r_0[29|22]/a_60_290# sky130_fd_pr_reram__reram_cell area_ox=0.0676
X9679 BLZ22 rr3t3r_0[29|22]/a_460_290# sky130_fd_pr_reram__reram_cell area_ox=0.0676
X9680 rr3t3r_0[29|22]/a_460_290# WL29 SL22 VSS sky130_fd_pr__nfet_g5v0d10v5 ad=0.65 pd=3.3 as=0 ps=0 w=1 l=0.5
X9681 BLN22 rr3t3r_0[29|22]/a_860_290# sky130_fd_pr_reram__reram_cell area_ox=0.0676
X9682 rr3t3r_0[29|22]/a_60_290# WL29 SL22 VSS sky130_fd_pr__nfet_g5v0d10v5 ad=0.65 pd=3.3 as=0 ps=0 w=1 l=0.5
X9683 rr3t3r_0[29|22]/a_860_290# WL29 SL22 VSS sky130_fd_pr__nfet_g5v0d10v5 ad=0.65 pd=3.3 as=0 ps=0 w=1 l=0.5
X9684 BLP22 rr3t3r_0[30|22]/a_60_290# sky130_fd_pr_reram__reram_cell area_ox=0.0676
X9685 BLZ22 rr3t3r_0[30|22]/a_460_290# sky130_fd_pr_reram__reram_cell area_ox=0.0676
X9686 rr3t3r_0[30|22]/a_460_290# WL30 SL22 VSS sky130_fd_pr__nfet_g5v0d10v5 ad=0.65 pd=3.3 as=0 ps=0 w=1 l=0.5
X9687 BLN22 rr3t3r_0[30|22]/a_860_290# sky130_fd_pr_reram__reram_cell area_ox=0.0676
X9688 rr3t3r_0[30|22]/a_60_290# WL30 SL22 VSS sky130_fd_pr__nfet_g5v0d10v5 ad=0.65 pd=3.3 as=0 ps=0 w=1 l=0.5
X9689 rr3t3r_0[30|22]/a_860_290# WL30 SL22 VSS sky130_fd_pr__nfet_g5v0d10v5 ad=0.65 pd=3.3 as=0 ps=0 w=1 l=0.5
X9690 BLP22 rr3t3r_0[31|22]/a_60_290# sky130_fd_pr_reram__reram_cell area_ox=0.0676
X9691 BLZ22 rr3t3r_0[31|22]/a_460_290# sky130_fd_pr_reram__reram_cell area_ox=0.0676
X9692 rr3t3r_0[31|22]/a_460_290# WL31 SL22 VSS sky130_fd_pr__nfet_g5v0d10v5 ad=0.65 pd=3.3 as=0 ps=0 w=1 l=0.5
X9693 BLN22 rr3t3r_0[31|22]/a_860_290# sky130_fd_pr_reram__reram_cell area_ox=0.0676
X9694 rr3t3r_0[31|22]/a_60_290# WL31 SL22 VSS sky130_fd_pr__nfet_g5v0d10v5 ad=0.65 pd=3.3 as=0 ps=0 w=1 l=0.5
X9695 rr3t3r_0[31|22]/a_860_290# WL31 SL22 VSS sky130_fd_pr__nfet_g5v0d10v5 ad=0.65 pd=3.3 as=0 ps=0 w=1 l=0.5
X9696 BLP22 rr3t3r_0[32|22]/a_60_290# sky130_fd_pr_reram__reram_cell area_ox=0.0676
X9697 BLZ22 rr3t3r_0[32|22]/a_460_290# sky130_fd_pr_reram__reram_cell area_ox=0.0676
X9698 rr3t3r_0[32|22]/a_460_290# WL32 SL22 VSS sky130_fd_pr__nfet_g5v0d10v5 ad=0.65 pd=3.3 as=0 ps=0 w=1 l=0.5
X9699 BLN22 rr3t3r_0[32|22]/a_860_290# sky130_fd_pr_reram__reram_cell area_ox=0.0676
X9700 rr3t3r_0[32|22]/a_60_290# WL32 SL22 VSS sky130_fd_pr__nfet_g5v0d10v5 ad=0.65 pd=3.3 as=0 ps=0 w=1 l=0.5
X9701 rr3t3r_0[32|22]/a_860_290# WL32 SL22 VSS sky130_fd_pr__nfet_g5v0d10v5 ad=0.65 pd=3.3 as=0 ps=0 w=1 l=0.5
X9702 BLP22 rr3t3r_0[33|22]/a_60_290# sky130_fd_pr_reram__reram_cell area_ox=0.0676
X9703 BLZ22 rr3t3r_0[33|22]/a_460_290# sky130_fd_pr_reram__reram_cell area_ox=0.0676
X9704 rr3t3r_0[33|22]/a_460_290# WL33 SL22 VSS sky130_fd_pr__nfet_g5v0d10v5 ad=0.65 pd=3.3 as=0 ps=0 w=1 l=0.5
X9705 BLN22 rr3t3r_0[33|22]/a_860_290# sky130_fd_pr_reram__reram_cell area_ox=0.0676
X9706 rr3t3r_0[33|22]/a_60_290# WL33 SL22 VSS sky130_fd_pr__nfet_g5v0d10v5 ad=0.65 pd=3.3 as=0 ps=0 w=1 l=0.5
X9707 rr3t3r_0[33|22]/a_860_290# WL33 SL22 VSS sky130_fd_pr__nfet_g5v0d10v5 ad=0.65 pd=3.3 as=0 ps=0 w=1 l=0.5
X9708 BLP22 rr3t3r_0[34|22]/a_60_290# sky130_fd_pr_reram__reram_cell area_ox=0.0676
X9709 BLZ22 rr3t3r_0[34|22]/a_460_290# sky130_fd_pr_reram__reram_cell area_ox=0.0676
X9710 rr3t3r_0[34|22]/a_460_290# WL34 SL22 VSS sky130_fd_pr__nfet_g5v0d10v5 ad=0.65 pd=3.3 as=0 ps=0 w=1 l=0.5
X9711 BLN22 rr3t3r_0[34|22]/a_860_290# sky130_fd_pr_reram__reram_cell area_ox=0.0676
X9712 rr3t3r_0[34|22]/a_60_290# WL34 SL22 VSS sky130_fd_pr__nfet_g5v0d10v5 ad=0.65 pd=3.3 as=0 ps=0 w=1 l=0.5
X9713 rr3t3r_0[34|22]/a_860_290# WL34 SL22 VSS sky130_fd_pr__nfet_g5v0d10v5 ad=0.65 pd=3.3 as=0 ps=0 w=1 l=0.5
X9714 BLP22 rr3t3r_0[35|22]/a_60_290# sky130_fd_pr_reram__reram_cell area_ox=0.0676
X9715 BLZ22 rr3t3r_0[35|22]/a_460_290# sky130_fd_pr_reram__reram_cell area_ox=0.0676
X9716 rr3t3r_0[35|22]/a_460_290# WL35 SL22 VSS sky130_fd_pr__nfet_g5v0d10v5 ad=0.65 pd=3.3 as=0 ps=0 w=1 l=0.5
X9717 BLN22 rr3t3r_0[35|22]/a_860_290# sky130_fd_pr_reram__reram_cell area_ox=0.0676
X9718 rr3t3r_0[35|22]/a_60_290# WL35 SL22 VSS sky130_fd_pr__nfet_g5v0d10v5 ad=0.65 pd=3.3 as=0 ps=0 w=1 l=0.5
X9719 rr3t3r_0[35|22]/a_860_290# WL35 SL22 VSS sky130_fd_pr__nfet_g5v0d10v5 ad=0.65 pd=3.3 as=0 ps=0 w=1 l=0.5
X9720 BLP22 rr3t3r_0[36|22]/a_60_290# sky130_fd_pr_reram__reram_cell area_ox=0.0676
X9721 BLZ22 rr3t3r_0[36|22]/a_460_290# sky130_fd_pr_reram__reram_cell area_ox=0.0676
X9722 rr3t3r_0[36|22]/a_460_290# WL36 SL22 VSS sky130_fd_pr__nfet_g5v0d10v5 ad=0.65 pd=3.3 as=0 ps=0 w=1 l=0.5
X9723 BLN22 rr3t3r_0[36|22]/a_860_290# sky130_fd_pr_reram__reram_cell area_ox=0.0676
X9724 rr3t3r_0[36|22]/a_60_290# WL36 SL22 VSS sky130_fd_pr__nfet_g5v0d10v5 ad=0.65 pd=3.3 as=0 ps=0 w=1 l=0.5
X9725 rr3t3r_0[36|22]/a_860_290# WL36 SL22 VSS sky130_fd_pr__nfet_g5v0d10v5 ad=0.65 pd=3.3 as=0 ps=0 w=1 l=0.5
X9726 BLP22 rr3t3r_0[37|22]/a_60_290# sky130_fd_pr_reram__reram_cell area_ox=0.0676
X9727 BLZ22 rr3t3r_0[37|22]/a_460_290# sky130_fd_pr_reram__reram_cell area_ox=0.0676
X9728 rr3t3r_0[37|22]/a_460_290# WL37 SL22 VSS sky130_fd_pr__nfet_g5v0d10v5 ad=0.65 pd=3.3 as=0 ps=0 w=1 l=0.5
X9729 BLN22 rr3t3r_0[37|22]/a_860_290# sky130_fd_pr_reram__reram_cell area_ox=0.0676
X9730 rr3t3r_0[37|22]/a_60_290# WL37 SL22 VSS sky130_fd_pr__nfet_g5v0d10v5 ad=0.65 pd=3.3 as=0 ps=0 w=1 l=0.5
X9731 rr3t3r_0[37|22]/a_860_290# WL37 SL22 VSS sky130_fd_pr__nfet_g5v0d10v5 ad=0.65 pd=3.3 as=0 ps=0 w=1 l=0.5
X9732 BLP22 rr3t3r_0[38|22]/a_60_290# sky130_fd_pr_reram__reram_cell area_ox=0.0676
X9733 BLZ22 rr3t3r_0[38|22]/a_460_290# sky130_fd_pr_reram__reram_cell area_ox=0.0676
X9734 rr3t3r_0[38|22]/a_460_290# WL38 SL22 VSS sky130_fd_pr__nfet_g5v0d10v5 ad=0.65 pd=3.3 as=0 ps=0 w=1 l=0.5
X9735 BLN22 rr3t3r_0[38|22]/a_860_290# sky130_fd_pr_reram__reram_cell area_ox=0.0676
X9736 rr3t3r_0[38|22]/a_60_290# WL38 SL22 VSS sky130_fd_pr__nfet_g5v0d10v5 ad=0.65 pd=3.3 as=0 ps=0 w=1 l=0.5
X9737 rr3t3r_0[38|22]/a_860_290# WL38 SL22 VSS sky130_fd_pr__nfet_g5v0d10v5 ad=0.65 pd=3.3 as=0 ps=0 w=1 l=0.5
X9738 BLP22 rr3t3r_0[39|22]/a_60_290# sky130_fd_pr_reram__reram_cell area_ox=0.0676
X9739 BLZ22 rr3t3r_0[39|22]/a_460_290# sky130_fd_pr_reram__reram_cell area_ox=0.0676
X9740 rr3t3r_0[39|22]/a_460_290# WL39 SL22 VSS sky130_fd_pr__nfet_g5v0d10v5 ad=0.65 pd=3.3 as=0 ps=0 w=1 l=0.5
X9741 BLN22 rr3t3r_0[39|22]/a_860_290# sky130_fd_pr_reram__reram_cell area_ox=0.0676
X9742 rr3t3r_0[39|22]/a_60_290# WL39 SL22 VSS sky130_fd_pr__nfet_g5v0d10v5 ad=0.65 pd=3.3 as=0 ps=0 w=1 l=0.5
X9743 rr3t3r_0[39|22]/a_860_290# WL39 SL22 VSS sky130_fd_pr__nfet_g5v0d10v5 ad=0.65 pd=3.3 as=0 ps=0 w=1 l=0.5
X9744 BLP22 rr3t3r_0[40|22]/a_60_290# sky130_fd_pr_reram__reram_cell area_ox=0.0676
X9745 BLZ22 rr3t3r_0[40|22]/a_460_290# sky130_fd_pr_reram__reram_cell area_ox=0.0676
X9746 rr3t3r_0[40|22]/a_460_290# WL40 SL22 VSS sky130_fd_pr__nfet_g5v0d10v5 ad=0.65 pd=3.3 as=0 ps=0 w=1 l=0.5
X9747 BLN22 rr3t3r_0[40|22]/a_860_290# sky130_fd_pr_reram__reram_cell area_ox=0.0676
X9748 rr3t3r_0[40|22]/a_60_290# WL40 SL22 VSS sky130_fd_pr__nfet_g5v0d10v5 ad=0.65 pd=3.3 as=0 ps=0 w=1 l=0.5
X9749 rr3t3r_0[40|22]/a_860_290# WL40 SL22 VSS sky130_fd_pr__nfet_g5v0d10v5 ad=0.65 pd=3.3 as=0 ps=0 w=1 l=0.5
X9750 BLP22 rr3t3r_0[41|22]/a_60_290# sky130_fd_pr_reram__reram_cell area_ox=0.0676
X9751 BLZ22 rr3t3r_0[41|22]/a_460_290# sky130_fd_pr_reram__reram_cell area_ox=0.0676
X9752 rr3t3r_0[41|22]/a_460_290# WL41 SL22 VSS sky130_fd_pr__nfet_g5v0d10v5 ad=0.65 pd=3.3 as=0 ps=0 w=1 l=0.5
X9753 BLN22 rr3t3r_0[41|22]/a_860_290# sky130_fd_pr_reram__reram_cell area_ox=0.0676
X9754 rr3t3r_0[41|22]/a_60_290# WL41 SL22 VSS sky130_fd_pr__nfet_g5v0d10v5 ad=0.65 pd=3.3 as=0 ps=0 w=1 l=0.5
X9755 rr3t3r_0[41|22]/a_860_290# WL41 SL22 VSS sky130_fd_pr__nfet_g5v0d10v5 ad=0.65 pd=3.3 as=0 ps=0 w=1 l=0.5
X9756 BLP22 rr3t3r_0[42|22]/a_60_290# sky130_fd_pr_reram__reram_cell area_ox=0.0676
X9757 BLZ22 rr3t3r_0[42|22]/a_460_290# sky130_fd_pr_reram__reram_cell area_ox=0.0676
X9758 rr3t3r_0[42|22]/a_460_290# WL42 SL22 VSS sky130_fd_pr__nfet_g5v0d10v5 ad=0.65 pd=3.3 as=0 ps=0 w=1 l=0.5
X9759 BLN22 rr3t3r_0[42|22]/a_860_290# sky130_fd_pr_reram__reram_cell area_ox=0.0676
X9760 rr3t3r_0[42|22]/a_60_290# WL42 SL22 VSS sky130_fd_pr__nfet_g5v0d10v5 ad=0.65 pd=3.3 as=0 ps=0 w=1 l=0.5
X9761 rr3t3r_0[42|22]/a_860_290# WL42 SL22 VSS sky130_fd_pr__nfet_g5v0d10v5 ad=0.65 pd=3.3 as=0 ps=0 w=1 l=0.5
X9762 BLP22 rr3t3r_0[43|22]/a_60_290# sky130_fd_pr_reram__reram_cell area_ox=0.0676
X9763 BLZ22 rr3t3r_0[43|22]/a_460_290# sky130_fd_pr_reram__reram_cell area_ox=0.0676
X9764 rr3t3r_0[43|22]/a_460_290# WL43 SL22 VSS sky130_fd_pr__nfet_g5v0d10v5 ad=0.65 pd=3.3 as=0 ps=0 w=1 l=0.5
X9765 BLN22 rr3t3r_0[43|22]/a_860_290# sky130_fd_pr_reram__reram_cell area_ox=0.0676
X9766 rr3t3r_0[43|22]/a_60_290# WL43 SL22 VSS sky130_fd_pr__nfet_g5v0d10v5 ad=0.65 pd=3.3 as=0 ps=0 w=1 l=0.5
X9767 rr3t3r_0[43|22]/a_860_290# WL43 SL22 VSS sky130_fd_pr__nfet_g5v0d10v5 ad=0.65 pd=3.3 as=0 ps=0 w=1 l=0.5
X9768 BLP22 rr3t3r_0[44|22]/a_60_290# sky130_fd_pr_reram__reram_cell area_ox=0.0676
X9769 BLZ22 rr3t3r_0[44|22]/a_460_290# sky130_fd_pr_reram__reram_cell area_ox=0.0676
X9770 rr3t3r_0[44|22]/a_460_290# WL44 SL22 VSS sky130_fd_pr__nfet_g5v0d10v5 ad=0.65 pd=3.3 as=0 ps=0 w=1 l=0.5
X9771 BLN22 rr3t3r_0[44|22]/a_860_290# sky130_fd_pr_reram__reram_cell area_ox=0.0676
X9772 rr3t3r_0[44|22]/a_60_290# WL44 SL22 VSS sky130_fd_pr__nfet_g5v0d10v5 ad=0.65 pd=3.3 as=0 ps=0 w=1 l=0.5
X9773 rr3t3r_0[44|22]/a_860_290# WL44 SL22 VSS sky130_fd_pr__nfet_g5v0d10v5 ad=0.65 pd=3.3 as=0 ps=0 w=1 l=0.5
X9774 BLP22 rr3t3r_0[45|22]/a_60_290# sky130_fd_pr_reram__reram_cell area_ox=0.0676
X9775 BLZ22 rr3t3r_0[45|22]/a_460_290# sky130_fd_pr_reram__reram_cell area_ox=0.0676
X9776 rr3t3r_0[45|22]/a_460_290# WL45 SL22 VSS sky130_fd_pr__nfet_g5v0d10v5 ad=0.65 pd=3.3 as=0 ps=0 w=1 l=0.5
X9777 BLN22 rr3t3r_0[45|22]/a_860_290# sky130_fd_pr_reram__reram_cell area_ox=0.0676
X9778 rr3t3r_0[45|22]/a_60_290# WL45 SL22 VSS sky130_fd_pr__nfet_g5v0d10v5 ad=0.65 pd=3.3 as=0 ps=0 w=1 l=0.5
X9779 rr3t3r_0[45|22]/a_860_290# WL45 SL22 VSS sky130_fd_pr__nfet_g5v0d10v5 ad=0.65 pd=3.3 as=0 ps=0 w=1 l=0.5
X9780 BLP22 rr3t3r_0[46|22]/a_60_290# sky130_fd_pr_reram__reram_cell area_ox=0.0676
X9781 BLZ22 rr3t3r_0[46|22]/a_460_290# sky130_fd_pr_reram__reram_cell area_ox=0.0676
X9782 rr3t3r_0[46|22]/a_460_290# WL46 SL22 VSS sky130_fd_pr__nfet_g5v0d10v5 ad=0.65 pd=3.3 as=0 ps=0 w=1 l=0.5
X9783 BLN22 rr3t3r_0[46|22]/a_860_290# sky130_fd_pr_reram__reram_cell area_ox=0.0676
X9784 rr3t3r_0[46|22]/a_60_290# WL46 SL22 VSS sky130_fd_pr__nfet_g5v0d10v5 ad=0.65 pd=3.3 as=0 ps=0 w=1 l=0.5
X9785 rr3t3r_0[46|22]/a_860_290# WL46 SL22 VSS sky130_fd_pr__nfet_g5v0d10v5 ad=0.65 pd=3.3 as=0 ps=0 w=1 l=0.5
X9786 BLP22 rr3t3r_0[47|22]/a_60_290# sky130_fd_pr_reram__reram_cell area_ox=0.0676
X9787 BLZ22 rr3t3r_0[47|22]/a_460_290# sky130_fd_pr_reram__reram_cell area_ox=0.0676
X9788 rr3t3r_0[47|22]/a_460_290# WL47 SL22 VSS sky130_fd_pr__nfet_g5v0d10v5 ad=0.65 pd=3.3 as=0 ps=0 w=1 l=0.5
X9789 BLN22 rr3t3r_0[47|22]/a_860_290# sky130_fd_pr_reram__reram_cell area_ox=0.0676
X9790 rr3t3r_0[47|22]/a_60_290# WL47 SL22 VSS sky130_fd_pr__nfet_g5v0d10v5 ad=0.65 pd=3.3 as=0 ps=0 w=1 l=0.5
X9791 rr3t3r_0[47|22]/a_860_290# WL47 SL22 VSS sky130_fd_pr__nfet_g5v0d10v5 ad=0.65 pd=3.3 as=0 ps=0 w=1 l=0.5
X9792 BLP22 rr3t3r_0[48|22]/a_60_290# sky130_fd_pr_reram__reram_cell area_ox=0.0676
X9793 BLZ22 rr3t3r_0[48|22]/a_460_290# sky130_fd_pr_reram__reram_cell area_ox=0.0676
X9794 rr3t3r_0[48|22]/a_460_290# WL48 SL22 VSS sky130_fd_pr__nfet_g5v0d10v5 ad=0.65 pd=3.3 as=0 ps=0 w=1 l=0.5
X9795 BLN22 rr3t3r_0[48|22]/a_860_290# sky130_fd_pr_reram__reram_cell area_ox=0.0676
X9796 rr3t3r_0[48|22]/a_60_290# WL48 SL22 VSS sky130_fd_pr__nfet_g5v0d10v5 ad=0.65 pd=3.3 as=0 ps=0 w=1 l=0.5
X9797 rr3t3r_0[48|22]/a_860_290# WL48 SL22 VSS sky130_fd_pr__nfet_g5v0d10v5 ad=0.65 pd=3.3 as=0 ps=0 w=1 l=0.5
X9798 BLP22 rr3t3r_0[49|22]/a_60_290# sky130_fd_pr_reram__reram_cell area_ox=0.0676
X9799 BLZ22 rr3t3r_0[49|22]/a_460_290# sky130_fd_pr_reram__reram_cell area_ox=0.0676
X9800 rr3t3r_0[49|22]/a_460_290# WL49 SL22 VSS sky130_fd_pr__nfet_g5v0d10v5 ad=0.65 pd=3.3 as=0 ps=0 w=1 l=0.5
X9801 BLN22 rr3t3r_0[49|22]/a_860_290# sky130_fd_pr_reram__reram_cell area_ox=0.0676
X9802 rr3t3r_0[49|22]/a_60_290# WL49 SL22 VSS sky130_fd_pr__nfet_g5v0d10v5 ad=0.65 pd=3.3 as=0 ps=0 w=1 l=0.5
X9803 rr3t3r_0[49|22]/a_860_290# WL49 SL22 VSS sky130_fd_pr__nfet_g5v0d10v5 ad=0.65 pd=3.3 as=0 ps=0 w=1 l=0.5
X9804 BLP22 rr3t3r_0[50|22]/a_60_290# sky130_fd_pr_reram__reram_cell area_ox=0.0676
X9805 BLZ22 rr3t3r_0[50|22]/a_460_290# sky130_fd_pr_reram__reram_cell area_ox=0.0676
X9806 rr3t3r_0[50|22]/a_460_290# WL50 SL22 VSS sky130_fd_pr__nfet_g5v0d10v5 ad=0.65 pd=3.3 as=0 ps=0 w=1 l=0.5
X9807 BLN22 rr3t3r_0[50|22]/a_860_290# sky130_fd_pr_reram__reram_cell area_ox=0.0676
X9808 rr3t3r_0[50|22]/a_60_290# WL50 SL22 VSS sky130_fd_pr__nfet_g5v0d10v5 ad=0.65 pd=3.3 as=0 ps=0 w=1 l=0.5
X9809 rr3t3r_0[50|22]/a_860_290# WL50 SL22 VSS sky130_fd_pr__nfet_g5v0d10v5 ad=0.65 pd=3.3 as=0 ps=0 w=1 l=0.5
X9810 BLP22 rr3t3r_0[51|22]/a_60_290# sky130_fd_pr_reram__reram_cell area_ox=0.0676
X9811 BLZ22 rr3t3r_0[51|22]/a_460_290# sky130_fd_pr_reram__reram_cell area_ox=0.0676
X9812 rr3t3r_0[51|22]/a_460_290# WL51 SL22 VSS sky130_fd_pr__nfet_g5v0d10v5 ad=0.65 pd=3.3 as=0 ps=0 w=1 l=0.5
X9813 BLN22 rr3t3r_0[51|22]/a_860_290# sky130_fd_pr_reram__reram_cell area_ox=0.0676
X9814 rr3t3r_0[51|22]/a_60_290# WL51 SL22 VSS sky130_fd_pr__nfet_g5v0d10v5 ad=0.65 pd=3.3 as=0 ps=0 w=1 l=0.5
X9815 rr3t3r_0[51|22]/a_860_290# WL51 SL22 VSS sky130_fd_pr__nfet_g5v0d10v5 ad=0.65 pd=3.3 as=0 ps=0 w=1 l=0.5
X9816 BLP22 rr3t3r_0[52|22]/a_60_290# sky130_fd_pr_reram__reram_cell area_ox=0.0676
X9817 BLZ22 rr3t3r_0[52|22]/a_460_290# sky130_fd_pr_reram__reram_cell area_ox=0.0676
X9818 rr3t3r_0[52|22]/a_460_290# WL52 SL22 VSS sky130_fd_pr__nfet_g5v0d10v5 ad=0.65 pd=3.3 as=0 ps=0 w=1 l=0.5
X9819 BLN22 rr3t3r_0[52|22]/a_860_290# sky130_fd_pr_reram__reram_cell area_ox=0.0676
X9820 rr3t3r_0[52|22]/a_60_290# WL52 SL22 VSS sky130_fd_pr__nfet_g5v0d10v5 ad=0.65 pd=3.3 as=0 ps=0 w=1 l=0.5
X9821 rr3t3r_0[52|22]/a_860_290# WL52 SL22 VSS sky130_fd_pr__nfet_g5v0d10v5 ad=0.65 pd=3.3 as=0 ps=0 w=1 l=0.5
X9822 BLP22 rr3t3r_0[53|22]/a_60_290# sky130_fd_pr_reram__reram_cell area_ox=0.0676
X9823 BLZ22 rr3t3r_0[53|22]/a_460_290# sky130_fd_pr_reram__reram_cell area_ox=0.0676
X9824 rr3t3r_0[53|22]/a_460_290# WL53 SL22 VSS sky130_fd_pr__nfet_g5v0d10v5 ad=0.65 pd=3.3 as=0 ps=0 w=1 l=0.5
X9825 BLN22 rr3t3r_0[53|22]/a_860_290# sky130_fd_pr_reram__reram_cell area_ox=0.0676
X9826 rr3t3r_0[53|22]/a_60_290# WL53 SL22 VSS sky130_fd_pr__nfet_g5v0d10v5 ad=0.65 pd=3.3 as=0 ps=0 w=1 l=0.5
X9827 rr3t3r_0[53|22]/a_860_290# WL53 SL22 VSS sky130_fd_pr__nfet_g5v0d10v5 ad=0.65 pd=3.3 as=0 ps=0 w=1 l=0.5
X9828 BLP22 rr3t3r_0[54|22]/a_60_290# sky130_fd_pr_reram__reram_cell area_ox=0.0676
X9829 BLZ22 rr3t3r_0[54|22]/a_460_290# sky130_fd_pr_reram__reram_cell area_ox=0.0676
X9830 rr3t3r_0[54|22]/a_460_290# WL54 SL22 VSS sky130_fd_pr__nfet_g5v0d10v5 ad=0.65 pd=3.3 as=0 ps=0 w=1 l=0.5
X9831 BLN22 rr3t3r_0[54|22]/a_860_290# sky130_fd_pr_reram__reram_cell area_ox=0.0676
X9832 rr3t3r_0[54|22]/a_60_290# WL54 SL22 VSS sky130_fd_pr__nfet_g5v0d10v5 ad=0.65 pd=3.3 as=0 ps=0 w=1 l=0.5
X9833 rr3t3r_0[54|22]/a_860_290# WL54 SL22 VSS sky130_fd_pr__nfet_g5v0d10v5 ad=0.65 pd=3.3 as=0 ps=0 w=1 l=0.5
X9834 BLP22 rr3t3r_0[55|22]/a_60_290# sky130_fd_pr_reram__reram_cell area_ox=0.0676
X9835 BLZ22 rr3t3r_0[55|22]/a_460_290# sky130_fd_pr_reram__reram_cell area_ox=0.0676
X9836 rr3t3r_0[55|22]/a_460_290# WL55 SL22 VSS sky130_fd_pr__nfet_g5v0d10v5 ad=0.65 pd=3.3 as=0 ps=0 w=1 l=0.5
X9837 BLN22 rr3t3r_0[55|22]/a_860_290# sky130_fd_pr_reram__reram_cell area_ox=0.0676
X9838 rr3t3r_0[55|22]/a_60_290# WL55 SL22 VSS sky130_fd_pr__nfet_g5v0d10v5 ad=0.65 pd=3.3 as=0 ps=0 w=1 l=0.5
X9839 rr3t3r_0[55|22]/a_860_290# WL55 SL22 VSS sky130_fd_pr__nfet_g5v0d10v5 ad=0.65 pd=3.3 as=0 ps=0 w=1 l=0.5
X9840 BLP22 rr3t3r_0[56|22]/a_60_290# sky130_fd_pr_reram__reram_cell area_ox=0.0676
X9841 BLZ22 rr3t3r_0[56|22]/a_460_290# sky130_fd_pr_reram__reram_cell area_ox=0.0676
X9842 rr3t3r_0[56|22]/a_460_290# WL56 SL22 VSS sky130_fd_pr__nfet_g5v0d10v5 ad=0.65 pd=3.3 as=0 ps=0 w=1 l=0.5
X9843 BLN22 rr3t3r_0[56|22]/a_860_290# sky130_fd_pr_reram__reram_cell area_ox=0.0676
X9844 rr3t3r_0[56|22]/a_60_290# WL56 SL22 VSS sky130_fd_pr__nfet_g5v0d10v5 ad=0.65 pd=3.3 as=0 ps=0 w=1 l=0.5
X9845 rr3t3r_0[56|22]/a_860_290# WL56 SL22 VSS sky130_fd_pr__nfet_g5v0d10v5 ad=0.65 pd=3.3 as=0 ps=0 w=1 l=0.5
X9846 BLP22 rr3t3r_0[57|22]/a_60_290# sky130_fd_pr_reram__reram_cell area_ox=0.0676
X9847 BLZ22 rr3t3r_0[57|22]/a_460_290# sky130_fd_pr_reram__reram_cell area_ox=0.0676
X9848 rr3t3r_0[57|22]/a_460_290# WL57 SL22 VSS sky130_fd_pr__nfet_g5v0d10v5 ad=0.65 pd=3.3 as=0 ps=0 w=1 l=0.5
X9849 BLN22 rr3t3r_0[57|22]/a_860_290# sky130_fd_pr_reram__reram_cell area_ox=0.0676
X9850 rr3t3r_0[57|22]/a_60_290# WL57 SL22 VSS sky130_fd_pr__nfet_g5v0d10v5 ad=0.65 pd=3.3 as=0 ps=0 w=1 l=0.5
X9851 rr3t3r_0[57|22]/a_860_290# WL57 SL22 VSS sky130_fd_pr__nfet_g5v0d10v5 ad=0.65 pd=3.3 as=0 ps=0 w=1 l=0.5
X9852 BLP22 rr3t3r_0[58|22]/a_60_290# sky130_fd_pr_reram__reram_cell area_ox=0.0676
X9853 BLZ22 rr3t3r_0[58|22]/a_460_290# sky130_fd_pr_reram__reram_cell area_ox=0.0676
X9854 rr3t3r_0[58|22]/a_460_290# WL58 SL22 VSS sky130_fd_pr__nfet_g5v0d10v5 ad=0.65 pd=3.3 as=0 ps=0 w=1 l=0.5
X9855 BLN22 rr3t3r_0[58|22]/a_860_290# sky130_fd_pr_reram__reram_cell area_ox=0.0676
X9856 rr3t3r_0[58|22]/a_60_290# WL58 SL22 VSS sky130_fd_pr__nfet_g5v0d10v5 ad=0.65 pd=3.3 as=0 ps=0 w=1 l=0.5
X9857 rr3t3r_0[58|22]/a_860_290# WL58 SL22 VSS sky130_fd_pr__nfet_g5v0d10v5 ad=0.65 pd=3.3 as=0 ps=0 w=1 l=0.5
X9858 BLP22 rr3t3r_0[59|22]/a_60_290# sky130_fd_pr_reram__reram_cell area_ox=0.0676
X9859 BLZ22 rr3t3r_0[59|22]/a_460_290# sky130_fd_pr_reram__reram_cell area_ox=0.0676
X9860 rr3t3r_0[59|22]/a_460_290# WL59 SL22 VSS sky130_fd_pr__nfet_g5v0d10v5 ad=0.65 pd=3.3 as=0 ps=0 w=1 l=0.5
X9861 BLN22 rr3t3r_0[59|22]/a_860_290# sky130_fd_pr_reram__reram_cell area_ox=0.0676
X9862 rr3t3r_0[59|22]/a_60_290# WL59 SL22 VSS sky130_fd_pr__nfet_g5v0d10v5 ad=0.65 pd=3.3 as=0 ps=0 w=1 l=0.5
X9863 rr3t3r_0[59|22]/a_860_290# WL59 SL22 VSS sky130_fd_pr__nfet_g5v0d10v5 ad=0.65 pd=3.3 as=0 ps=0 w=1 l=0.5
X9864 BLP22 rr3t3r_0[60|22]/a_60_290# sky130_fd_pr_reram__reram_cell area_ox=0.0676
X9865 BLZ22 rr3t3r_0[60|22]/a_460_290# sky130_fd_pr_reram__reram_cell area_ox=0.0676
X9866 rr3t3r_0[60|22]/a_460_290# WL60 SL22 VSS sky130_fd_pr__nfet_g5v0d10v5 ad=0.65 pd=3.3 as=0 ps=0 w=1 l=0.5
X9867 BLN22 rr3t3r_0[60|22]/a_860_290# sky130_fd_pr_reram__reram_cell area_ox=0.0676
X9868 rr3t3r_0[60|22]/a_60_290# WL60 SL22 VSS sky130_fd_pr__nfet_g5v0d10v5 ad=0.65 pd=3.3 as=0 ps=0 w=1 l=0.5
X9869 rr3t3r_0[60|22]/a_860_290# WL60 SL22 VSS sky130_fd_pr__nfet_g5v0d10v5 ad=0.65 pd=3.3 as=0 ps=0 w=1 l=0.5
X9870 BLP22 rr3t3r_0[61|22]/a_60_290# sky130_fd_pr_reram__reram_cell area_ox=0.0676
X9871 BLZ22 rr3t3r_0[61|22]/a_460_290# sky130_fd_pr_reram__reram_cell area_ox=0.0676
X9872 rr3t3r_0[61|22]/a_460_290# WL61 SL22 VSS sky130_fd_pr__nfet_g5v0d10v5 ad=0.65 pd=3.3 as=0 ps=0 w=1 l=0.5
X9873 BLN22 rr3t3r_0[61|22]/a_860_290# sky130_fd_pr_reram__reram_cell area_ox=0.0676
X9874 rr3t3r_0[61|22]/a_60_290# WL61 SL22 VSS sky130_fd_pr__nfet_g5v0d10v5 ad=0.65 pd=3.3 as=0 ps=0 w=1 l=0.5
X9875 rr3t3r_0[61|22]/a_860_290# WL61 SL22 VSS sky130_fd_pr__nfet_g5v0d10v5 ad=0.65 pd=3.3 as=0 ps=0 w=1 l=0.5
X9876 BLP22 rr3t3r_0[62|22]/a_60_290# sky130_fd_pr_reram__reram_cell area_ox=0.0676
X9877 BLZ22 rr3t3r_0[62|22]/a_460_290# sky130_fd_pr_reram__reram_cell area_ox=0.0676
X9878 rr3t3r_0[62|22]/a_460_290# WL62 SL22 VSS sky130_fd_pr__nfet_g5v0d10v5 ad=0.65 pd=3.3 as=0 ps=0 w=1 l=0.5
X9879 BLN22 rr3t3r_0[62|22]/a_860_290# sky130_fd_pr_reram__reram_cell area_ox=0.0676
X9880 rr3t3r_0[62|22]/a_60_290# WL62 SL22 VSS sky130_fd_pr__nfet_g5v0d10v5 ad=0.65 pd=3.3 as=0 ps=0 w=1 l=0.5
X9881 rr3t3r_0[62|22]/a_860_290# WL62 SL22 VSS sky130_fd_pr__nfet_g5v0d10v5 ad=0.65 pd=3.3 as=0 ps=0 w=1 l=0.5
X9882 BLP22 rr3t3r_0[63|22]/a_60_290# sky130_fd_pr_reram__reram_cell area_ox=0.0676
X9883 BLZ22 rr3t3r_0[63|22]/a_460_290# sky130_fd_pr_reram__reram_cell area_ox=0.0676
X9884 rr3t3r_0[63|22]/a_460_290# WL63 SL22 VSS sky130_fd_pr__nfet_g5v0d10v5 ad=0.65 pd=3.3 as=0 ps=0 w=1 l=0.5
X9885 BLN22 rr3t3r_0[63|22]/a_860_290# sky130_fd_pr_reram__reram_cell area_ox=0.0676
X9886 rr3t3r_0[63|22]/a_60_290# WL63 SL22 VSS sky130_fd_pr__nfet_g5v0d10v5 ad=0.65 pd=3.3 as=0 ps=0 w=1 l=0.5
X9887 rr3t3r_0[63|22]/a_860_290# WL63 SL22 VSS sky130_fd_pr__nfet_g5v0d10v5 ad=0.65 pd=3.3 as=0 ps=0 w=1 l=0.5
X9888 BLP22 rr3t3r_0[64|22]/a_60_290# sky130_fd_pr_reram__reram_cell area_ox=0.0676
X9889 BLZ22 rr3t3r_0[64|22]/a_460_290# sky130_fd_pr_reram__reram_cell area_ox=0.0676
X9890 rr3t3r_0[64|22]/a_460_290# WL64 SL22 VSS sky130_fd_pr__nfet_g5v0d10v5 ad=0.65 pd=3.3 as=0 ps=0 w=1 l=0.5
X9891 BLN22 rr3t3r_0[64|22]/a_860_290# sky130_fd_pr_reram__reram_cell area_ox=0.0676
X9892 rr3t3r_0[64|22]/a_60_290# WL64 SL22 VSS sky130_fd_pr__nfet_g5v0d10v5 ad=0.65 pd=3.3 as=0 ps=0 w=1 l=0.5
X9893 rr3t3r_0[64|22]/a_860_290# WL64 SL22 VSS sky130_fd_pr__nfet_g5v0d10v5 ad=0.65 pd=3.3 as=0 ps=0 w=1 l=0.5
X9894 BLP22 rr3t3r_0[65|22]/a_60_290# sky130_fd_pr_reram__reram_cell area_ox=0.0676
X9895 BLZ22 rr3t3r_0[65|22]/a_460_290# sky130_fd_pr_reram__reram_cell area_ox=0.0676
X9896 rr3t3r_0[65|22]/a_460_290# WL65 SL22 VSS sky130_fd_pr__nfet_g5v0d10v5 ad=0.65 pd=3.3 as=0 ps=0 w=1 l=0.5
X9897 BLN22 rr3t3r_0[65|22]/a_860_290# sky130_fd_pr_reram__reram_cell area_ox=0.0676
X9898 rr3t3r_0[65|22]/a_60_290# WL65 SL22 VSS sky130_fd_pr__nfet_g5v0d10v5 ad=0.65 pd=3.3 as=0 ps=0 w=1 l=0.5
X9899 rr3t3r_0[65|22]/a_860_290# WL65 SL22 VSS sky130_fd_pr__nfet_g5v0d10v5 ad=0.65 pd=3.3 as=0 ps=0 w=1 l=0.5
X9900 BLP22 rr3t3r_0[66|22]/a_60_290# sky130_fd_pr_reram__reram_cell area_ox=0.0676
X9901 BLZ22 rr3t3r_0[66|22]/a_460_290# sky130_fd_pr_reram__reram_cell area_ox=0.0676
X9902 rr3t3r_0[66|22]/a_460_290# WL66 SL22 VSS sky130_fd_pr__nfet_g5v0d10v5 ad=0.65 pd=3.3 as=0 ps=0 w=1 l=0.5
X9903 BLN22 rr3t3r_0[66|22]/a_860_290# sky130_fd_pr_reram__reram_cell area_ox=0.0676
X9904 rr3t3r_0[66|22]/a_60_290# WL66 SL22 VSS sky130_fd_pr__nfet_g5v0d10v5 ad=0.65 pd=3.3 as=0 ps=0 w=1 l=0.5
X9905 rr3t3r_0[66|22]/a_860_290# WL66 SL22 VSS sky130_fd_pr__nfet_g5v0d10v5 ad=0.65 pd=3.3 as=0 ps=0 w=1 l=0.5
X9906 BLP22 rr3t3r_0[67|22]/a_60_290# sky130_fd_pr_reram__reram_cell area_ox=0.0676
X9907 BLZ22 rr3t3r_0[67|22]/a_460_290# sky130_fd_pr_reram__reram_cell area_ox=0.0676
X9908 rr3t3r_0[67|22]/a_460_290# WL67 SL22 VSS sky130_fd_pr__nfet_g5v0d10v5 ad=0.65 pd=3.3 as=0 ps=0 w=1 l=0.5
X9909 BLN22 rr3t3r_0[67|22]/a_860_290# sky130_fd_pr_reram__reram_cell area_ox=0.0676
X9910 rr3t3r_0[67|22]/a_60_290# WL67 SL22 VSS sky130_fd_pr__nfet_g5v0d10v5 ad=0.65 pd=3.3 as=0 ps=0 w=1 l=0.5
X9911 rr3t3r_0[67|22]/a_860_290# WL67 SL22 VSS sky130_fd_pr__nfet_g5v0d10v5 ad=0.65 pd=3.3 as=0 ps=0 w=1 l=0.5
X9912 BLP22 rr3t3r_0[68|22]/a_60_290# sky130_fd_pr_reram__reram_cell area_ox=0.0676
X9913 BLZ22 rr3t3r_0[68|22]/a_460_290# sky130_fd_pr_reram__reram_cell area_ox=0.0676
X9914 rr3t3r_0[68|22]/a_460_290# WL68 SL22 VSS sky130_fd_pr__nfet_g5v0d10v5 ad=0.65 pd=3.3 as=0 ps=0 w=1 l=0.5
X9915 BLN22 rr3t3r_0[68|22]/a_860_290# sky130_fd_pr_reram__reram_cell area_ox=0.0676
X9916 rr3t3r_0[68|22]/a_60_290# WL68 SL22 VSS sky130_fd_pr__nfet_g5v0d10v5 ad=0.65 pd=3.3 as=0 ps=0 w=1 l=0.5
X9917 rr3t3r_0[68|22]/a_860_290# WL68 SL22 VSS sky130_fd_pr__nfet_g5v0d10v5 ad=0.65 pd=3.3 as=0 ps=0 w=1 l=0.5
X9918 BLP22 rr3t3r_0[69|22]/a_60_290# sky130_fd_pr_reram__reram_cell area_ox=0.0676
X9919 BLZ22 rr3t3r_0[69|22]/a_460_290# sky130_fd_pr_reram__reram_cell area_ox=0.0676
X9920 rr3t3r_0[69|22]/a_460_290# WL69 SL22 VSS sky130_fd_pr__nfet_g5v0d10v5 ad=0.65 pd=3.3 as=0 ps=0 w=1 l=0.5
X9921 BLN22 rr3t3r_0[69|22]/a_860_290# sky130_fd_pr_reram__reram_cell area_ox=0.0676
X9922 rr3t3r_0[69|22]/a_60_290# WL69 SL22 VSS sky130_fd_pr__nfet_g5v0d10v5 ad=0.65 pd=3.3 as=0 ps=0 w=1 l=0.5
X9923 rr3t3r_0[69|22]/a_860_290# WL69 SL22 VSS sky130_fd_pr__nfet_g5v0d10v5 ad=0.65 pd=3.3 as=0 ps=0 w=1 l=0.5
X9924 BLP22 rr3t3r_0[70|22]/a_60_290# sky130_fd_pr_reram__reram_cell area_ox=0.0676
X9925 BLZ22 rr3t3r_0[70|22]/a_460_290# sky130_fd_pr_reram__reram_cell area_ox=0.0676
X9926 rr3t3r_0[70|22]/a_460_290# WL70 SL22 VSS sky130_fd_pr__nfet_g5v0d10v5 ad=0.65 pd=3.3 as=0 ps=0 w=1 l=0.5
X9927 BLN22 rr3t3r_0[70|22]/a_860_290# sky130_fd_pr_reram__reram_cell area_ox=0.0676
X9928 rr3t3r_0[70|22]/a_60_290# WL70 SL22 VSS sky130_fd_pr__nfet_g5v0d10v5 ad=0.65 pd=3.3 as=0 ps=0 w=1 l=0.5
X9929 rr3t3r_0[70|22]/a_860_290# WL70 SL22 VSS sky130_fd_pr__nfet_g5v0d10v5 ad=0.65 pd=3.3 as=0 ps=0 w=1 l=0.5
X9930 BLP22 rr3t3r_0[71|22]/a_60_290# sky130_fd_pr_reram__reram_cell area_ox=0.0676
X9931 BLZ22 rr3t3r_0[71|22]/a_460_290# sky130_fd_pr_reram__reram_cell area_ox=0.0676
X9932 rr3t3r_0[71|22]/a_460_290# WL71 SL22 VSS sky130_fd_pr__nfet_g5v0d10v5 ad=0.65 pd=3.3 as=0 ps=0 w=1 l=0.5
X9933 BLN22 rr3t3r_0[71|22]/a_860_290# sky130_fd_pr_reram__reram_cell area_ox=0.0676
X9934 rr3t3r_0[71|22]/a_60_290# WL71 SL22 VSS sky130_fd_pr__nfet_g5v0d10v5 ad=0.65 pd=3.3 as=0 ps=0 w=1 l=0.5
X9935 rr3t3r_0[71|22]/a_860_290# WL71 SL22 VSS sky130_fd_pr__nfet_g5v0d10v5 ad=0.65 pd=3.3 as=0 ps=0 w=1 l=0.5
X9936 BLP23 rr3t3r_0[0|23]/a_60_290# sky130_fd_pr_reram__reram_cell area_ox=0.0676
X9937 BLZ23 rr3t3r_0[0|23]/a_460_290# sky130_fd_pr_reram__reram_cell area_ox=0.0676
X9938 rr3t3r_0[0|23]/a_460_290# WL0 SL23 VSS sky130_fd_pr__nfet_g5v0d10v5 ad=0.65 pd=3.3 as=162 ps=756 w=1 l=0.5
X9939 BLN23 rr3t3r_0[0|23]/a_860_290# sky130_fd_pr_reram__reram_cell area_ox=0.0676
X9940 rr3t3r_0[0|23]/a_60_290# WL0 SL23 VSS sky130_fd_pr__nfet_g5v0d10v5 ad=0.65 pd=3.3 as=0 ps=0 w=1 l=0.5
X9941 rr3t3r_0[0|23]/a_860_290# WL0 SL23 VSS sky130_fd_pr__nfet_g5v0d10v5 ad=0.65 pd=3.3 as=0 ps=0 w=1 l=0.5
X9942 BLP23 rr3t3r_0[1|23]/a_60_290# sky130_fd_pr_reram__reram_cell area_ox=0.0676
X9943 BLZ23 rr3t3r_0[1|23]/a_460_290# sky130_fd_pr_reram__reram_cell area_ox=0.0676
X9944 rr3t3r_0[1|23]/a_460_290# WL1 SL23 VSS sky130_fd_pr__nfet_g5v0d10v5 ad=0.65 pd=3.3 as=0 ps=0 w=1 l=0.5
X9945 BLN23 rr3t3r_0[1|23]/a_860_290# sky130_fd_pr_reram__reram_cell area_ox=0.0676
X9946 rr3t3r_0[1|23]/a_60_290# WL1 SL23 VSS sky130_fd_pr__nfet_g5v0d10v5 ad=0.65 pd=3.3 as=0 ps=0 w=1 l=0.5
X9947 rr3t3r_0[1|23]/a_860_290# WL1 SL23 VSS sky130_fd_pr__nfet_g5v0d10v5 ad=0.65 pd=3.3 as=0 ps=0 w=1 l=0.5
X9948 BLP23 rr3t3r_0[2|23]/a_60_290# sky130_fd_pr_reram__reram_cell area_ox=0.0676
X9949 BLZ23 rr3t3r_0[2|23]/a_460_290# sky130_fd_pr_reram__reram_cell area_ox=0.0676
X9950 rr3t3r_0[2|23]/a_460_290# WL2 SL23 VSS sky130_fd_pr__nfet_g5v0d10v5 ad=0.65 pd=3.3 as=0 ps=0 w=1 l=0.5
X9951 BLN23 rr3t3r_0[2|23]/a_860_290# sky130_fd_pr_reram__reram_cell area_ox=0.0676
X9952 rr3t3r_0[2|23]/a_60_290# WL2 SL23 VSS sky130_fd_pr__nfet_g5v0d10v5 ad=0.65 pd=3.3 as=0 ps=0 w=1 l=0.5
X9953 rr3t3r_0[2|23]/a_860_290# WL2 SL23 VSS sky130_fd_pr__nfet_g5v0d10v5 ad=0.65 pd=3.3 as=0 ps=0 w=1 l=0.5
X9954 BLP23 rr3t3r_0[3|23]/a_60_290# sky130_fd_pr_reram__reram_cell area_ox=0.0676
X9955 BLZ23 rr3t3r_0[3|23]/a_460_290# sky130_fd_pr_reram__reram_cell area_ox=0.0676
X9956 rr3t3r_0[3|23]/a_460_290# WL3 SL23 VSS sky130_fd_pr__nfet_g5v0d10v5 ad=0.65 pd=3.3 as=0 ps=0 w=1 l=0.5
X9957 BLN23 rr3t3r_0[3|23]/a_860_290# sky130_fd_pr_reram__reram_cell area_ox=0.0676
X9958 rr3t3r_0[3|23]/a_60_290# WL3 SL23 VSS sky130_fd_pr__nfet_g5v0d10v5 ad=0.65 pd=3.3 as=0 ps=0 w=1 l=0.5
X9959 rr3t3r_0[3|23]/a_860_290# WL3 SL23 VSS sky130_fd_pr__nfet_g5v0d10v5 ad=0.65 pd=3.3 as=0 ps=0 w=1 l=0.5
X9960 BLP23 rr3t3r_0[4|23]/a_60_290# sky130_fd_pr_reram__reram_cell area_ox=0.0676
X9961 BLZ23 rr3t3r_0[4|23]/a_460_290# sky130_fd_pr_reram__reram_cell area_ox=0.0676
X9962 rr3t3r_0[4|23]/a_460_290# WL4 SL23 VSS sky130_fd_pr__nfet_g5v0d10v5 ad=0.65 pd=3.3 as=0 ps=0 w=1 l=0.5
X9963 BLN23 rr3t3r_0[4|23]/a_860_290# sky130_fd_pr_reram__reram_cell area_ox=0.0676
X9964 rr3t3r_0[4|23]/a_60_290# WL4 SL23 VSS sky130_fd_pr__nfet_g5v0d10v5 ad=0.65 pd=3.3 as=0 ps=0 w=1 l=0.5
X9965 rr3t3r_0[4|23]/a_860_290# WL4 SL23 VSS sky130_fd_pr__nfet_g5v0d10v5 ad=0.65 pd=3.3 as=0 ps=0 w=1 l=0.5
X9966 BLP23 rr3t3r_0[5|23]/a_60_290# sky130_fd_pr_reram__reram_cell area_ox=0.0676
X9967 BLZ23 rr3t3r_0[5|23]/a_460_290# sky130_fd_pr_reram__reram_cell area_ox=0.0676
X9968 rr3t3r_0[5|23]/a_460_290# WL5 SL23 VSS sky130_fd_pr__nfet_g5v0d10v5 ad=0.65 pd=3.3 as=0 ps=0 w=1 l=0.5
X9969 BLN23 rr3t3r_0[5|23]/a_860_290# sky130_fd_pr_reram__reram_cell area_ox=0.0676
X9970 rr3t3r_0[5|23]/a_60_290# WL5 SL23 VSS sky130_fd_pr__nfet_g5v0d10v5 ad=0.65 pd=3.3 as=0 ps=0 w=1 l=0.5
X9971 rr3t3r_0[5|23]/a_860_290# WL5 SL23 VSS sky130_fd_pr__nfet_g5v0d10v5 ad=0.65 pd=3.3 as=0 ps=0 w=1 l=0.5
X9972 BLP23 rr3t3r_0[6|23]/a_60_290# sky130_fd_pr_reram__reram_cell area_ox=0.0676
X9973 BLZ23 rr3t3r_0[6|23]/a_460_290# sky130_fd_pr_reram__reram_cell area_ox=0.0676
X9974 rr3t3r_0[6|23]/a_460_290# WL6 SL23 VSS sky130_fd_pr__nfet_g5v0d10v5 ad=0.65 pd=3.3 as=0 ps=0 w=1 l=0.5
X9975 BLN23 rr3t3r_0[6|23]/a_860_290# sky130_fd_pr_reram__reram_cell area_ox=0.0676
X9976 rr3t3r_0[6|23]/a_60_290# WL6 SL23 VSS sky130_fd_pr__nfet_g5v0d10v5 ad=0.65 pd=3.3 as=0 ps=0 w=1 l=0.5
X9977 rr3t3r_0[6|23]/a_860_290# WL6 SL23 VSS sky130_fd_pr__nfet_g5v0d10v5 ad=0.65 pd=3.3 as=0 ps=0 w=1 l=0.5
X9978 BLP23 rr3t3r_0[7|23]/a_60_290# sky130_fd_pr_reram__reram_cell area_ox=0.0676
X9979 BLZ23 rr3t3r_0[7|23]/a_460_290# sky130_fd_pr_reram__reram_cell area_ox=0.0676
X9980 rr3t3r_0[7|23]/a_460_290# WL7 SL23 VSS sky130_fd_pr__nfet_g5v0d10v5 ad=0.65 pd=3.3 as=0 ps=0 w=1 l=0.5
X9981 BLN23 rr3t3r_0[7|23]/a_860_290# sky130_fd_pr_reram__reram_cell area_ox=0.0676
X9982 rr3t3r_0[7|23]/a_60_290# WL7 SL23 VSS sky130_fd_pr__nfet_g5v0d10v5 ad=0.65 pd=3.3 as=0 ps=0 w=1 l=0.5
X9983 rr3t3r_0[7|23]/a_860_290# WL7 SL23 VSS sky130_fd_pr__nfet_g5v0d10v5 ad=0.65 pd=3.3 as=0 ps=0 w=1 l=0.5
X9984 BLP23 rr3t3r_0[8|23]/a_60_290# sky130_fd_pr_reram__reram_cell area_ox=0.0676
X9985 BLZ23 rr3t3r_0[8|23]/a_460_290# sky130_fd_pr_reram__reram_cell area_ox=0.0676
X9986 rr3t3r_0[8|23]/a_460_290# WL8 SL23 VSS sky130_fd_pr__nfet_g5v0d10v5 ad=0.65 pd=3.3 as=0 ps=0 w=1 l=0.5
X9987 BLN23 rr3t3r_0[8|23]/a_860_290# sky130_fd_pr_reram__reram_cell area_ox=0.0676
X9988 rr3t3r_0[8|23]/a_60_290# WL8 SL23 VSS sky130_fd_pr__nfet_g5v0d10v5 ad=0.65 pd=3.3 as=0 ps=0 w=1 l=0.5
X9989 rr3t3r_0[8|23]/a_860_290# WL8 SL23 VSS sky130_fd_pr__nfet_g5v0d10v5 ad=0.65 pd=3.3 as=0 ps=0 w=1 l=0.5
X9990 BLP23 rr3t3r_0[9|23]/a_60_290# sky130_fd_pr_reram__reram_cell area_ox=0.0676
X9991 BLZ23 rr3t3r_0[9|23]/a_460_290# sky130_fd_pr_reram__reram_cell area_ox=0.0676
X9992 rr3t3r_0[9|23]/a_460_290# WL9 SL23 VSS sky130_fd_pr__nfet_g5v0d10v5 ad=0.65 pd=3.3 as=0 ps=0 w=1 l=0.5
X9993 BLN23 rr3t3r_0[9|23]/a_860_290# sky130_fd_pr_reram__reram_cell area_ox=0.0676
X9994 rr3t3r_0[9|23]/a_60_290# WL9 SL23 VSS sky130_fd_pr__nfet_g5v0d10v5 ad=0.65 pd=3.3 as=0 ps=0 w=1 l=0.5
X9995 rr3t3r_0[9|23]/a_860_290# WL9 SL23 VSS sky130_fd_pr__nfet_g5v0d10v5 ad=0.65 pd=3.3 as=0 ps=0 w=1 l=0.5
X9996 BLP23 rr3t3r_0[10|23]/a_60_290# sky130_fd_pr_reram__reram_cell area_ox=0.0676
X9997 BLZ23 rr3t3r_0[10|23]/a_460_290# sky130_fd_pr_reram__reram_cell area_ox=0.0676
X9998 rr3t3r_0[10|23]/a_460_290# WL10 SL23 VSS sky130_fd_pr__nfet_g5v0d10v5 ad=0.65 pd=3.3 as=0 ps=0 w=1 l=0.5
X9999 BLN23 rr3t3r_0[10|23]/a_860_290# sky130_fd_pr_reram__reram_cell area_ox=0.0676
X10000 rr3t3r_0[10|23]/a_60_290# WL10 SL23 VSS sky130_fd_pr__nfet_g5v0d10v5 ad=0.65 pd=3.3 as=0 ps=0 w=1 l=0.5
X10001 rr3t3r_0[10|23]/a_860_290# WL10 SL23 VSS sky130_fd_pr__nfet_g5v0d10v5 ad=0.65 pd=3.3 as=0 ps=0 w=1 l=0.5
X10002 BLP23 rr3t3r_0[11|23]/a_60_290# sky130_fd_pr_reram__reram_cell area_ox=0.0676
X10003 BLZ23 rr3t3r_0[11|23]/a_460_290# sky130_fd_pr_reram__reram_cell area_ox=0.0676
X10004 rr3t3r_0[11|23]/a_460_290# WL11 SL23 VSS sky130_fd_pr__nfet_g5v0d10v5 ad=0.65 pd=3.3 as=0 ps=0 w=1 l=0.5
X10005 BLN23 rr3t3r_0[11|23]/a_860_290# sky130_fd_pr_reram__reram_cell area_ox=0.0676
X10006 rr3t3r_0[11|23]/a_60_290# WL11 SL23 VSS sky130_fd_pr__nfet_g5v0d10v5 ad=0.65 pd=3.3 as=0 ps=0 w=1 l=0.5
X10007 rr3t3r_0[11|23]/a_860_290# WL11 SL23 VSS sky130_fd_pr__nfet_g5v0d10v5 ad=0.65 pd=3.3 as=0 ps=0 w=1 l=0.5
X10008 BLP23 rr3t3r_0[12|23]/a_60_290# sky130_fd_pr_reram__reram_cell area_ox=0.0676
X10009 BLZ23 rr3t3r_0[12|23]/a_460_290# sky130_fd_pr_reram__reram_cell area_ox=0.0676
X10010 rr3t3r_0[12|23]/a_460_290# WL12 SL23 VSS sky130_fd_pr__nfet_g5v0d10v5 ad=0.65 pd=3.3 as=0 ps=0 w=1 l=0.5
X10011 BLN23 rr3t3r_0[12|23]/a_860_290# sky130_fd_pr_reram__reram_cell area_ox=0.0676
X10012 rr3t3r_0[12|23]/a_60_290# WL12 SL23 VSS sky130_fd_pr__nfet_g5v0d10v5 ad=0.65 pd=3.3 as=0 ps=0 w=1 l=0.5
X10013 rr3t3r_0[12|23]/a_860_290# WL12 SL23 VSS sky130_fd_pr__nfet_g5v0d10v5 ad=0.65 pd=3.3 as=0 ps=0 w=1 l=0.5
X10014 BLP23 rr3t3r_0[13|23]/a_60_290# sky130_fd_pr_reram__reram_cell area_ox=0.0676
X10015 BLZ23 rr3t3r_0[13|23]/a_460_290# sky130_fd_pr_reram__reram_cell area_ox=0.0676
X10016 rr3t3r_0[13|23]/a_460_290# WL13 SL23 VSS sky130_fd_pr__nfet_g5v0d10v5 ad=0.65 pd=3.3 as=0 ps=0 w=1 l=0.5
X10017 BLN23 rr3t3r_0[13|23]/a_860_290# sky130_fd_pr_reram__reram_cell area_ox=0.0676
X10018 rr3t3r_0[13|23]/a_60_290# WL13 SL23 VSS sky130_fd_pr__nfet_g5v0d10v5 ad=0.65 pd=3.3 as=0 ps=0 w=1 l=0.5
X10019 rr3t3r_0[13|23]/a_860_290# WL13 SL23 VSS sky130_fd_pr__nfet_g5v0d10v5 ad=0.65 pd=3.3 as=0 ps=0 w=1 l=0.5
X10020 BLP23 rr3t3r_0[14|23]/a_60_290# sky130_fd_pr_reram__reram_cell area_ox=0.0676
X10021 BLZ23 rr3t3r_0[14|23]/a_460_290# sky130_fd_pr_reram__reram_cell area_ox=0.0676
X10022 rr3t3r_0[14|23]/a_460_290# WL14 SL23 VSS sky130_fd_pr__nfet_g5v0d10v5 ad=0.65 pd=3.3 as=0 ps=0 w=1 l=0.5
X10023 BLN23 rr3t3r_0[14|23]/a_860_290# sky130_fd_pr_reram__reram_cell area_ox=0.0676
X10024 rr3t3r_0[14|23]/a_60_290# WL14 SL23 VSS sky130_fd_pr__nfet_g5v0d10v5 ad=0.65 pd=3.3 as=0 ps=0 w=1 l=0.5
X10025 rr3t3r_0[14|23]/a_860_290# WL14 SL23 VSS sky130_fd_pr__nfet_g5v0d10v5 ad=0.65 pd=3.3 as=0 ps=0 w=1 l=0.5
X10026 BLP23 rr3t3r_0[15|23]/a_60_290# sky130_fd_pr_reram__reram_cell area_ox=0.0676
X10027 BLZ23 rr3t3r_0[15|23]/a_460_290# sky130_fd_pr_reram__reram_cell area_ox=0.0676
X10028 rr3t3r_0[15|23]/a_460_290# WL15 SL23 VSS sky130_fd_pr__nfet_g5v0d10v5 ad=0.65 pd=3.3 as=0 ps=0 w=1 l=0.5
X10029 BLN23 rr3t3r_0[15|23]/a_860_290# sky130_fd_pr_reram__reram_cell area_ox=0.0676
X10030 rr3t3r_0[15|23]/a_60_290# WL15 SL23 VSS sky130_fd_pr__nfet_g5v0d10v5 ad=0.65 pd=3.3 as=0 ps=0 w=1 l=0.5
X10031 rr3t3r_0[15|23]/a_860_290# WL15 SL23 VSS sky130_fd_pr__nfet_g5v0d10v5 ad=0.65 pd=3.3 as=0 ps=0 w=1 l=0.5
X10032 BLP23 rr3t3r_0[16|23]/a_60_290# sky130_fd_pr_reram__reram_cell area_ox=0.0676
X10033 BLZ23 rr3t3r_0[16|23]/a_460_290# sky130_fd_pr_reram__reram_cell area_ox=0.0676
X10034 rr3t3r_0[16|23]/a_460_290# WL16 SL23 VSS sky130_fd_pr__nfet_g5v0d10v5 ad=0.65 pd=3.3 as=0 ps=0 w=1 l=0.5
X10035 BLN23 rr3t3r_0[16|23]/a_860_290# sky130_fd_pr_reram__reram_cell area_ox=0.0676
X10036 rr3t3r_0[16|23]/a_60_290# WL16 SL23 VSS sky130_fd_pr__nfet_g5v0d10v5 ad=0.65 pd=3.3 as=0 ps=0 w=1 l=0.5
X10037 rr3t3r_0[16|23]/a_860_290# WL16 SL23 VSS sky130_fd_pr__nfet_g5v0d10v5 ad=0.65 pd=3.3 as=0 ps=0 w=1 l=0.5
X10038 BLP23 rr3t3r_0[17|23]/a_60_290# sky130_fd_pr_reram__reram_cell area_ox=0.0676
X10039 BLZ23 rr3t3r_0[17|23]/a_460_290# sky130_fd_pr_reram__reram_cell area_ox=0.0676
X10040 rr3t3r_0[17|23]/a_460_290# WL17 SL23 VSS sky130_fd_pr__nfet_g5v0d10v5 ad=0.65 pd=3.3 as=0 ps=0 w=1 l=0.5
X10041 BLN23 rr3t3r_0[17|23]/a_860_290# sky130_fd_pr_reram__reram_cell area_ox=0.0676
X10042 rr3t3r_0[17|23]/a_60_290# WL17 SL23 VSS sky130_fd_pr__nfet_g5v0d10v5 ad=0.65 pd=3.3 as=0 ps=0 w=1 l=0.5
X10043 rr3t3r_0[17|23]/a_860_290# WL17 SL23 VSS sky130_fd_pr__nfet_g5v0d10v5 ad=0.65 pd=3.3 as=0 ps=0 w=1 l=0.5
X10044 BLP23 rr3t3r_0[18|23]/a_60_290# sky130_fd_pr_reram__reram_cell area_ox=0.0676
X10045 BLZ23 rr3t3r_0[18|23]/a_460_290# sky130_fd_pr_reram__reram_cell area_ox=0.0676
X10046 rr3t3r_0[18|23]/a_460_290# WL18 SL23 VSS sky130_fd_pr__nfet_g5v0d10v5 ad=0.65 pd=3.3 as=0 ps=0 w=1 l=0.5
X10047 BLN23 rr3t3r_0[18|23]/a_860_290# sky130_fd_pr_reram__reram_cell area_ox=0.0676
X10048 rr3t3r_0[18|23]/a_60_290# WL18 SL23 VSS sky130_fd_pr__nfet_g5v0d10v5 ad=0.65 pd=3.3 as=0 ps=0 w=1 l=0.5
X10049 rr3t3r_0[18|23]/a_860_290# WL18 SL23 VSS sky130_fd_pr__nfet_g5v0d10v5 ad=0.65 pd=3.3 as=0 ps=0 w=1 l=0.5
X10050 BLP23 rr3t3r_0[19|23]/a_60_290# sky130_fd_pr_reram__reram_cell area_ox=0.0676
X10051 BLZ23 rr3t3r_0[19|23]/a_460_290# sky130_fd_pr_reram__reram_cell area_ox=0.0676
X10052 rr3t3r_0[19|23]/a_460_290# WL19 SL23 VSS sky130_fd_pr__nfet_g5v0d10v5 ad=0.65 pd=3.3 as=0 ps=0 w=1 l=0.5
X10053 BLN23 rr3t3r_0[19|23]/a_860_290# sky130_fd_pr_reram__reram_cell area_ox=0.0676
X10054 rr3t3r_0[19|23]/a_60_290# WL19 SL23 VSS sky130_fd_pr__nfet_g5v0d10v5 ad=0.65 pd=3.3 as=0 ps=0 w=1 l=0.5
X10055 rr3t3r_0[19|23]/a_860_290# WL19 SL23 VSS sky130_fd_pr__nfet_g5v0d10v5 ad=0.65 pd=3.3 as=0 ps=0 w=1 l=0.5
X10056 BLP23 rr3t3r_0[20|23]/a_60_290# sky130_fd_pr_reram__reram_cell area_ox=0.0676
X10057 BLZ23 rr3t3r_0[20|23]/a_460_290# sky130_fd_pr_reram__reram_cell area_ox=0.0676
X10058 rr3t3r_0[20|23]/a_460_290# WL20 SL23 VSS sky130_fd_pr__nfet_g5v0d10v5 ad=0.65 pd=3.3 as=0 ps=0 w=1 l=0.5
X10059 BLN23 rr3t3r_0[20|23]/a_860_290# sky130_fd_pr_reram__reram_cell area_ox=0.0676
X10060 rr3t3r_0[20|23]/a_60_290# WL20 SL23 VSS sky130_fd_pr__nfet_g5v0d10v5 ad=0.65 pd=3.3 as=0 ps=0 w=1 l=0.5
X10061 rr3t3r_0[20|23]/a_860_290# WL20 SL23 VSS sky130_fd_pr__nfet_g5v0d10v5 ad=0.65 pd=3.3 as=0 ps=0 w=1 l=0.5
X10062 BLP23 rr3t3r_0[21|23]/a_60_290# sky130_fd_pr_reram__reram_cell area_ox=0.0676
X10063 BLZ23 rr3t3r_0[21|23]/a_460_290# sky130_fd_pr_reram__reram_cell area_ox=0.0676
X10064 rr3t3r_0[21|23]/a_460_290# WL21 SL23 VSS sky130_fd_pr__nfet_g5v0d10v5 ad=0.65 pd=3.3 as=0 ps=0 w=1 l=0.5
X10065 BLN23 rr3t3r_0[21|23]/a_860_290# sky130_fd_pr_reram__reram_cell area_ox=0.0676
X10066 rr3t3r_0[21|23]/a_60_290# WL21 SL23 VSS sky130_fd_pr__nfet_g5v0d10v5 ad=0.65 pd=3.3 as=0 ps=0 w=1 l=0.5
X10067 rr3t3r_0[21|23]/a_860_290# WL21 SL23 VSS sky130_fd_pr__nfet_g5v0d10v5 ad=0.65 pd=3.3 as=0 ps=0 w=1 l=0.5
X10068 BLP23 rr3t3r_0[22|23]/a_60_290# sky130_fd_pr_reram__reram_cell area_ox=0.0676
X10069 BLZ23 rr3t3r_0[22|23]/a_460_290# sky130_fd_pr_reram__reram_cell area_ox=0.0676
X10070 rr3t3r_0[22|23]/a_460_290# WL22 SL23 VSS sky130_fd_pr__nfet_g5v0d10v5 ad=0.65 pd=3.3 as=0 ps=0 w=1 l=0.5
X10071 BLN23 rr3t3r_0[22|23]/a_860_290# sky130_fd_pr_reram__reram_cell area_ox=0.0676
X10072 rr3t3r_0[22|23]/a_60_290# WL22 SL23 VSS sky130_fd_pr__nfet_g5v0d10v5 ad=0.65 pd=3.3 as=0 ps=0 w=1 l=0.5
X10073 rr3t3r_0[22|23]/a_860_290# WL22 SL23 VSS sky130_fd_pr__nfet_g5v0d10v5 ad=0.65 pd=3.3 as=0 ps=0 w=1 l=0.5
X10074 BLP23 rr3t3r_0[23|23]/a_60_290# sky130_fd_pr_reram__reram_cell area_ox=0.0676
X10075 BLZ23 rr3t3r_0[23|23]/a_460_290# sky130_fd_pr_reram__reram_cell area_ox=0.0676
X10076 rr3t3r_0[23|23]/a_460_290# WL23 SL23 VSS sky130_fd_pr__nfet_g5v0d10v5 ad=0.65 pd=3.3 as=0 ps=0 w=1 l=0.5
X10077 BLN23 rr3t3r_0[23|23]/a_860_290# sky130_fd_pr_reram__reram_cell area_ox=0.0676
X10078 rr3t3r_0[23|23]/a_60_290# WL23 SL23 VSS sky130_fd_pr__nfet_g5v0d10v5 ad=0.65 pd=3.3 as=0 ps=0 w=1 l=0.5
X10079 rr3t3r_0[23|23]/a_860_290# WL23 SL23 VSS sky130_fd_pr__nfet_g5v0d10v5 ad=0.65 pd=3.3 as=0 ps=0 w=1 l=0.5
X10080 BLP23 rr3t3r_0[24|23]/a_60_290# sky130_fd_pr_reram__reram_cell area_ox=0.0676
X10081 BLZ23 rr3t3r_0[24|23]/a_460_290# sky130_fd_pr_reram__reram_cell area_ox=0.0676
X10082 rr3t3r_0[24|23]/a_460_290# WL24 SL23 VSS sky130_fd_pr__nfet_g5v0d10v5 ad=0.65 pd=3.3 as=0 ps=0 w=1 l=0.5
X10083 BLN23 rr3t3r_0[24|23]/a_860_290# sky130_fd_pr_reram__reram_cell area_ox=0.0676
X10084 rr3t3r_0[24|23]/a_60_290# WL24 SL23 VSS sky130_fd_pr__nfet_g5v0d10v5 ad=0.65 pd=3.3 as=0 ps=0 w=1 l=0.5
X10085 rr3t3r_0[24|23]/a_860_290# WL24 SL23 VSS sky130_fd_pr__nfet_g5v0d10v5 ad=0.65 pd=3.3 as=0 ps=0 w=1 l=0.5
X10086 BLP23 rr3t3r_0[25|23]/a_60_290# sky130_fd_pr_reram__reram_cell area_ox=0.0676
X10087 BLZ23 rr3t3r_0[25|23]/a_460_290# sky130_fd_pr_reram__reram_cell area_ox=0.0676
X10088 rr3t3r_0[25|23]/a_460_290# WL25 SL23 VSS sky130_fd_pr__nfet_g5v0d10v5 ad=0.65 pd=3.3 as=0 ps=0 w=1 l=0.5
X10089 BLN23 rr3t3r_0[25|23]/a_860_290# sky130_fd_pr_reram__reram_cell area_ox=0.0676
X10090 rr3t3r_0[25|23]/a_60_290# WL25 SL23 VSS sky130_fd_pr__nfet_g5v0d10v5 ad=0.65 pd=3.3 as=0 ps=0 w=1 l=0.5
X10091 rr3t3r_0[25|23]/a_860_290# WL25 SL23 VSS sky130_fd_pr__nfet_g5v0d10v5 ad=0.65 pd=3.3 as=0 ps=0 w=1 l=0.5
X10092 BLP23 rr3t3r_0[26|23]/a_60_290# sky130_fd_pr_reram__reram_cell area_ox=0.0676
X10093 BLZ23 rr3t3r_0[26|23]/a_460_290# sky130_fd_pr_reram__reram_cell area_ox=0.0676
X10094 rr3t3r_0[26|23]/a_460_290# WL26 SL23 VSS sky130_fd_pr__nfet_g5v0d10v5 ad=0.65 pd=3.3 as=0 ps=0 w=1 l=0.5
X10095 BLN23 rr3t3r_0[26|23]/a_860_290# sky130_fd_pr_reram__reram_cell area_ox=0.0676
X10096 rr3t3r_0[26|23]/a_60_290# WL26 SL23 VSS sky130_fd_pr__nfet_g5v0d10v5 ad=0.65 pd=3.3 as=0 ps=0 w=1 l=0.5
X10097 rr3t3r_0[26|23]/a_860_290# WL26 SL23 VSS sky130_fd_pr__nfet_g5v0d10v5 ad=0.65 pd=3.3 as=0 ps=0 w=1 l=0.5
X10098 BLP23 rr3t3r_0[27|23]/a_60_290# sky130_fd_pr_reram__reram_cell area_ox=0.0676
X10099 BLZ23 rr3t3r_0[27|23]/a_460_290# sky130_fd_pr_reram__reram_cell area_ox=0.0676
X10100 rr3t3r_0[27|23]/a_460_290# WL27 SL23 VSS sky130_fd_pr__nfet_g5v0d10v5 ad=0.65 pd=3.3 as=0 ps=0 w=1 l=0.5
X10101 BLN23 rr3t3r_0[27|23]/a_860_290# sky130_fd_pr_reram__reram_cell area_ox=0.0676
X10102 rr3t3r_0[27|23]/a_60_290# WL27 SL23 VSS sky130_fd_pr__nfet_g5v0d10v5 ad=0.65 pd=3.3 as=0 ps=0 w=1 l=0.5
X10103 rr3t3r_0[27|23]/a_860_290# WL27 SL23 VSS sky130_fd_pr__nfet_g5v0d10v5 ad=0.65 pd=3.3 as=0 ps=0 w=1 l=0.5
X10104 BLP23 rr3t3r_0[28|23]/a_60_290# sky130_fd_pr_reram__reram_cell area_ox=0.0676
X10105 BLZ23 rr3t3r_0[28|23]/a_460_290# sky130_fd_pr_reram__reram_cell area_ox=0.0676
X10106 rr3t3r_0[28|23]/a_460_290# WL28 SL23 VSS sky130_fd_pr__nfet_g5v0d10v5 ad=0.65 pd=3.3 as=0 ps=0 w=1 l=0.5
X10107 BLN23 rr3t3r_0[28|23]/a_860_290# sky130_fd_pr_reram__reram_cell area_ox=0.0676
X10108 rr3t3r_0[28|23]/a_60_290# WL28 SL23 VSS sky130_fd_pr__nfet_g5v0d10v5 ad=0.65 pd=3.3 as=0 ps=0 w=1 l=0.5
X10109 rr3t3r_0[28|23]/a_860_290# WL28 SL23 VSS sky130_fd_pr__nfet_g5v0d10v5 ad=0.65 pd=3.3 as=0 ps=0 w=1 l=0.5
X10110 BLP23 rr3t3r_0[29|23]/a_60_290# sky130_fd_pr_reram__reram_cell area_ox=0.0676
X10111 BLZ23 rr3t3r_0[29|23]/a_460_290# sky130_fd_pr_reram__reram_cell area_ox=0.0676
X10112 rr3t3r_0[29|23]/a_460_290# WL29 SL23 VSS sky130_fd_pr__nfet_g5v0d10v5 ad=0.65 pd=3.3 as=0 ps=0 w=1 l=0.5
X10113 BLN23 rr3t3r_0[29|23]/a_860_290# sky130_fd_pr_reram__reram_cell area_ox=0.0676
X10114 rr3t3r_0[29|23]/a_60_290# WL29 SL23 VSS sky130_fd_pr__nfet_g5v0d10v5 ad=0.65 pd=3.3 as=0 ps=0 w=1 l=0.5
X10115 rr3t3r_0[29|23]/a_860_290# WL29 SL23 VSS sky130_fd_pr__nfet_g5v0d10v5 ad=0.65 pd=3.3 as=0 ps=0 w=1 l=0.5
X10116 BLP23 rr3t3r_0[30|23]/a_60_290# sky130_fd_pr_reram__reram_cell area_ox=0.0676
X10117 BLZ23 rr3t3r_0[30|23]/a_460_290# sky130_fd_pr_reram__reram_cell area_ox=0.0676
X10118 rr3t3r_0[30|23]/a_460_290# WL30 SL23 VSS sky130_fd_pr__nfet_g5v0d10v5 ad=0.65 pd=3.3 as=0 ps=0 w=1 l=0.5
X10119 BLN23 rr3t3r_0[30|23]/a_860_290# sky130_fd_pr_reram__reram_cell area_ox=0.0676
X10120 rr3t3r_0[30|23]/a_60_290# WL30 SL23 VSS sky130_fd_pr__nfet_g5v0d10v5 ad=0.65 pd=3.3 as=0 ps=0 w=1 l=0.5
X10121 rr3t3r_0[30|23]/a_860_290# WL30 SL23 VSS sky130_fd_pr__nfet_g5v0d10v5 ad=0.65 pd=3.3 as=0 ps=0 w=1 l=0.5
X10122 BLP23 rr3t3r_0[31|23]/a_60_290# sky130_fd_pr_reram__reram_cell area_ox=0.0676
X10123 BLZ23 rr3t3r_0[31|23]/a_460_290# sky130_fd_pr_reram__reram_cell area_ox=0.0676
X10124 rr3t3r_0[31|23]/a_460_290# WL31 SL23 VSS sky130_fd_pr__nfet_g5v0d10v5 ad=0.65 pd=3.3 as=0 ps=0 w=1 l=0.5
X10125 BLN23 rr3t3r_0[31|23]/a_860_290# sky130_fd_pr_reram__reram_cell area_ox=0.0676
X10126 rr3t3r_0[31|23]/a_60_290# WL31 SL23 VSS sky130_fd_pr__nfet_g5v0d10v5 ad=0.65 pd=3.3 as=0 ps=0 w=1 l=0.5
X10127 rr3t3r_0[31|23]/a_860_290# WL31 SL23 VSS sky130_fd_pr__nfet_g5v0d10v5 ad=0.65 pd=3.3 as=0 ps=0 w=1 l=0.5
X10128 BLP23 rr3t3r_0[32|23]/a_60_290# sky130_fd_pr_reram__reram_cell area_ox=0.0676
X10129 BLZ23 rr3t3r_0[32|23]/a_460_290# sky130_fd_pr_reram__reram_cell area_ox=0.0676
X10130 rr3t3r_0[32|23]/a_460_290# WL32 SL23 VSS sky130_fd_pr__nfet_g5v0d10v5 ad=0.65 pd=3.3 as=0 ps=0 w=1 l=0.5
X10131 BLN23 rr3t3r_0[32|23]/a_860_290# sky130_fd_pr_reram__reram_cell area_ox=0.0676
X10132 rr3t3r_0[32|23]/a_60_290# WL32 SL23 VSS sky130_fd_pr__nfet_g5v0d10v5 ad=0.65 pd=3.3 as=0 ps=0 w=1 l=0.5
X10133 rr3t3r_0[32|23]/a_860_290# WL32 SL23 VSS sky130_fd_pr__nfet_g5v0d10v5 ad=0.65 pd=3.3 as=0 ps=0 w=1 l=0.5
X10134 BLP23 rr3t3r_0[33|23]/a_60_290# sky130_fd_pr_reram__reram_cell area_ox=0.0676
X10135 BLZ23 rr3t3r_0[33|23]/a_460_290# sky130_fd_pr_reram__reram_cell area_ox=0.0676
X10136 rr3t3r_0[33|23]/a_460_290# WL33 SL23 VSS sky130_fd_pr__nfet_g5v0d10v5 ad=0.65 pd=3.3 as=0 ps=0 w=1 l=0.5
X10137 BLN23 rr3t3r_0[33|23]/a_860_290# sky130_fd_pr_reram__reram_cell area_ox=0.0676
X10138 rr3t3r_0[33|23]/a_60_290# WL33 SL23 VSS sky130_fd_pr__nfet_g5v0d10v5 ad=0.65 pd=3.3 as=0 ps=0 w=1 l=0.5
X10139 rr3t3r_0[33|23]/a_860_290# WL33 SL23 VSS sky130_fd_pr__nfet_g5v0d10v5 ad=0.65 pd=3.3 as=0 ps=0 w=1 l=0.5
X10140 BLP23 rr3t3r_0[34|23]/a_60_290# sky130_fd_pr_reram__reram_cell area_ox=0.0676
X10141 BLZ23 rr3t3r_0[34|23]/a_460_290# sky130_fd_pr_reram__reram_cell area_ox=0.0676
X10142 rr3t3r_0[34|23]/a_460_290# WL34 SL23 VSS sky130_fd_pr__nfet_g5v0d10v5 ad=0.65 pd=3.3 as=0 ps=0 w=1 l=0.5
X10143 BLN23 rr3t3r_0[34|23]/a_860_290# sky130_fd_pr_reram__reram_cell area_ox=0.0676
X10144 rr3t3r_0[34|23]/a_60_290# WL34 SL23 VSS sky130_fd_pr__nfet_g5v0d10v5 ad=0.65 pd=3.3 as=0 ps=0 w=1 l=0.5
X10145 rr3t3r_0[34|23]/a_860_290# WL34 SL23 VSS sky130_fd_pr__nfet_g5v0d10v5 ad=0.65 pd=3.3 as=0 ps=0 w=1 l=0.5
X10146 BLP23 rr3t3r_0[35|23]/a_60_290# sky130_fd_pr_reram__reram_cell area_ox=0.0676
X10147 BLZ23 rr3t3r_0[35|23]/a_460_290# sky130_fd_pr_reram__reram_cell area_ox=0.0676
X10148 rr3t3r_0[35|23]/a_460_290# WL35 SL23 VSS sky130_fd_pr__nfet_g5v0d10v5 ad=0.65 pd=3.3 as=0 ps=0 w=1 l=0.5
X10149 BLN23 rr3t3r_0[35|23]/a_860_290# sky130_fd_pr_reram__reram_cell area_ox=0.0676
X10150 rr3t3r_0[35|23]/a_60_290# WL35 SL23 VSS sky130_fd_pr__nfet_g5v0d10v5 ad=0.65 pd=3.3 as=0 ps=0 w=1 l=0.5
X10151 rr3t3r_0[35|23]/a_860_290# WL35 SL23 VSS sky130_fd_pr__nfet_g5v0d10v5 ad=0.65 pd=3.3 as=0 ps=0 w=1 l=0.5
X10152 BLP23 rr3t3r_0[36|23]/a_60_290# sky130_fd_pr_reram__reram_cell area_ox=0.0676
X10153 BLZ23 rr3t3r_0[36|23]/a_460_290# sky130_fd_pr_reram__reram_cell area_ox=0.0676
X10154 rr3t3r_0[36|23]/a_460_290# WL36 SL23 VSS sky130_fd_pr__nfet_g5v0d10v5 ad=0.65 pd=3.3 as=0 ps=0 w=1 l=0.5
X10155 BLN23 rr3t3r_0[36|23]/a_860_290# sky130_fd_pr_reram__reram_cell area_ox=0.0676
X10156 rr3t3r_0[36|23]/a_60_290# WL36 SL23 VSS sky130_fd_pr__nfet_g5v0d10v5 ad=0.65 pd=3.3 as=0 ps=0 w=1 l=0.5
X10157 rr3t3r_0[36|23]/a_860_290# WL36 SL23 VSS sky130_fd_pr__nfet_g5v0d10v5 ad=0.65 pd=3.3 as=0 ps=0 w=1 l=0.5
X10158 BLP23 rr3t3r_0[37|23]/a_60_290# sky130_fd_pr_reram__reram_cell area_ox=0.0676
X10159 BLZ23 rr3t3r_0[37|23]/a_460_290# sky130_fd_pr_reram__reram_cell area_ox=0.0676
X10160 rr3t3r_0[37|23]/a_460_290# WL37 SL23 VSS sky130_fd_pr__nfet_g5v0d10v5 ad=0.65 pd=3.3 as=0 ps=0 w=1 l=0.5
X10161 BLN23 rr3t3r_0[37|23]/a_860_290# sky130_fd_pr_reram__reram_cell area_ox=0.0676
X10162 rr3t3r_0[37|23]/a_60_290# WL37 SL23 VSS sky130_fd_pr__nfet_g5v0d10v5 ad=0.65 pd=3.3 as=0 ps=0 w=1 l=0.5
X10163 rr3t3r_0[37|23]/a_860_290# WL37 SL23 VSS sky130_fd_pr__nfet_g5v0d10v5 ad=0.65 pd=3.3 as=0 ps=0 w=1 l=0.5
X10164 BLP23 rr3t3r_0[38|23]/a_60_290# sky130_fd_pr_reram__reram_cell area_ox=0.0676
X10165 BLZ23 rr3t3r_0[38|23]/a_460_290# sky130_fd_pr_reram__reram_cell area_ox=0.0676
X10166 rr3t3r_0[38|23]/a_460_290# WL38 SL23 VSS sky130_fd_pr__nfet_g5v0d10v5 ad=0.65 pd=3.3 as=0 ps=0 w=1 l=0.5
X10167 BLN23 rr3t3r_0[38|23]/a_860_290# sky130_fd_pr_reram__reram_cell area_ox=0.0676
X10168 rr3t3r_0[38|23]/a_60_290# WL38 SL23 VSS sky130_fd_pr__nfet_g5v0d10v5 ad=0.65 pd=3.3 as=0 ps=0 w=1 l=0.5
X10169 rr3t3r_0[38|23]/a_860_290# WL38 SL23 VSS sky130_fd_pr__nfet_g5v0d10v5 ad=0.65 pd=3.3 as=0 ps=0 w=1 l=0.5
X10170 BLP23 rr3t3r_0[39|23]/a_60_290# sky130_fd_pr_reram__reram_cell area_ox=0.0676
X10171 BLZ23 rr3t3r_0[39|23]/a_460_290# sky130_fd_pr_reram__reram_cell area_ox=0.0676
X10172 rr3t3r_0[39|23]/a_460_290# WL39 SL23 VSS sky130_fd_pr__nfet_g5v0d10v5 ad=0.65 pd=3.3 as=0 ps=0 w=1 l=0.5
X10173 BLN23 rr3t3r_0[39|23]/a_860_290# sky130_fd_pr_reram__reram_cell area_ox=0.0676
X10174 rr3t3r_0[39|23]/a_60_290# WL39 SL23 VSS sky130_fd_pr__nfet_g5v0d10v5 ad=0.65 pd=3.3 as=0 ps=0 w=1 l=0.5
X10175 rr3t3r_0[39|23]/a_860_290# WL39 SL23 VSS sky130_fd_pr__nfet_g5v0d10v5 ad=0.65 pd=3.3 as=0 ps=0 w=1 l=0.5
X10176 BLP23 rr3t3r_0[40|23]/a_60_290# sky130_fd_pr_reram__reram_cell area_ox=0.0676
X10177 BLZ23 rr3t3r_0[40|23]/a_460_290# sky130_fd_pr_reram__reram_cell area_ox=0.0676
X10178 rr3t3r_0[40|23]/a_460_290# WL40 SL23 VSS sky130_fd_pr__nfet_g5v0d10v5 ad=0.65 pd=3.3 as=0 ps=0 w=1 l=0.5
X10179 BLN23 rr3t3r_0[40|23]/a_860_290# sky130_fd_pr_reram__reram_cell area_ox=0.0676
X10180 rr3t3r_0[40|23]/a_60_290# WL40 SL23 VSS sky130_fd_pr__nfet_g5v0d10v5 ad=0.65 pd=3.3 as=0 ps=0 w=1 l=0.5
X10181 rr3t3r_0[40|23]/a_860_290# WL40 SL23 VSS sky130_fd_pr__nfet_g5v0d10v5 ad=0.65 pd=3.3 as=0 ps=0 w=1 l=0.5
X10182 BLP23 rr3t3r_0[41|23]/a_60_290# sky130_fd_pr_reram__reram_cell area_ox=0.0676
X10183 BLZ23 rr3t3r_0[41|23]/a_460_290# sky130_fd_pr_reram__reram_cell area_ox=0.0676
X10184 rr3t3r_0[41|23]/a_460_290# WL41 SL23 VSS sky130_fd_pr__nfet_g5v0d10v5 ad=0.65 pd=3.3 as=0 ps=0 w=1 l=0.5
X10185 BLN23 rr3t3r_0[41|23]/a_860_290# sky130_fd_pr_reram__reram_cell area_ox=0.0676
X10186 rr3t3r_0[41|23]/a_60_290# WL41 SL23 VSS sky130_fd_pr__nfet_g5v0d10v5 ad=0.65 pd=3.3 as=0 ps=0 w=1 l=0.5
X10187 rr3t3r_0[41|23]/a_860_290# WL41 SL23 VSS sky130_fd_pr__nfet_g5v0d10v5 ad=0.65 pd=3.3 as=0 ps=0 w=1 l=0.5
X10188 BLP23 rr3t3r_0[42|23]/a_60_290# sky130_fd_pr_reram__reram_cell area_ox=0.0676
X10189 BLZ23 rr3t3r_0[42|23]/a_460_290# sky130_fd_pr_reram__reram_cell area_ox=0.0676
X10190 rr3t3r_0[42|23]/a_460_290# WL42 SL23 VSS sky130_fd_pr__nfet_g5v0d10v5 ad=0.65 pd=3.3 as=0 ps=0 w=1 l=0.5
X10191 BLN23 rr3t3r_0[42|23]/a_860_290# sky130_fd_pr_reram__reram_cell area_ox=0.0676
X10192 rr3t3r_0[42|23]/a_60_290# WL42 SL23 VSS sky130_fd_pr__nfet_g5v0d10v5 ad=0.65 pd=3.3 as=0 ps=0 w=1 l=0.5
X10193 rr3t3r_0[42|23]/a_860_290# WL42 SL23 VSS sky130_fd_pr__nfet_g5v0d10v5 ad=0.65 pd=3.3 as=0 ps=0 w=1 l=0.5
X10194 BLP23 rr3t3r_0[43|23]/a_60_290# sky130_fd_pr_reram__reram_cell area_ox=0.0676
X10195 BLZ23 rr3t3r_0[43|23]/a_460_290# sky130_fd_pr_reram__reram_cell area_ox=0.0676
X10196 rr3t3r_0[43|23]/a_460_290# WL43 SL23 VSS sky130_fd_pr__nfet_g5v0d10v5 ad=0.65 pd=3.3 as=0 ps=0 w=1 l=0.5
X10197 BLN23 rr3t3r_0[43|23]/a_860_290# sky130_fd_pr_reram__reram_cell area_ox=0.0676
X10198 rr3t3r_0[43|23]/a_60_290# WL43 SL23 VSS sky130_fd_pr__nfet_g5v0d10v5 ad=0.65 pd=3.3 as=0 ps=0 w=1 l=0.5
X10199 rr3t3r_0[43|23]/a_860_290# WL43 SL23 VSS sky130_fd_pr__nfet_g5v0d10v5 ad=0.65 pd=3.3 as=0 ps=0 w=1 l=0.5
X10200 BLP23 rr3t3r_0[44|23]/a_60_290# sky130_fd_pr_reram__reram_cell area_ox=0.0676
X10201 BLZ23 rr3t3r_0[44|23]/a_460_290# sky130_fd_pr_reram__reram_cell area_ox=0.0676
X10202 rr3t3r_0[44|23]/a_460_290# WL44 SL23 VSS sky130_fd_pr__nfet_g5v0d10v5 ad=0.65 pd=3.3 as=0 ps=0 w=1 l=0.5
X10203 BLN23 rr3t3r_0[44|23]/a_860_290# sky130_fd_pr_reram__reram_cell area_ox=0.0676
X10204 rr3t3r_0[44|23]/a_60_290# WL44 SL23 VSS sky130_fd_pr__nfet_g5v0d10v5 ad=0.65 pd=3.3 as=0 ps=0 w=1 l=0.5
X10205 rr3t3r_0[44|23]/a_860_290# WL44 SL23 VSS sky130_fd_pr__nfet_g5v0d10v5 ad=0.65 pd=3.3 as=0 ps=0 w=1 l=0.5
X10206 BLP23 rr3t3r_0[45|23]/a_60_290# sky130_fd_pr_reram__reram_cell area_ox=0.0676
X10207 BLZ23 rr3t3r_0[45|23]/a_460_290# sky130_fd_pr_reram__reram_cell area_ox=0.0676
X10208 rr3t3r_0[45|23]/a_460_290# WL45 SL23 VSS sky130_fd_pr__nfet_g5v0d10v5 ad=0.65 pd=3.3 as=0 ps=0 w=1 l=0.5
X10209 BLN23 rr3t3r_0[45|23]/a_860_290# sky130_fd_pr_reram__reram_cell area_ox=0.0676
X10210 rr3t3r_0[45|23]/a_60_290# WL45 SL23 VSS sky130_fd_pr__nfet_g5v0d10v5 ad=0.65 pd=3.3 as=0 ps=0 w=1 l=0.5
X10211 rr3t3r_0[45|23]/a_860_290# WL45 SL23 VSS sky130_fd_pr__nfet_g5v0d10v5 ad=0.65 pd=3.3 as=0 ps=0 w=1 l=0.5
X10212 BLP23 rr3t3r_0[46|23]/a_60_290# sky130_fd_pr_reram__reram_cell area_ox=0.0676
X10213 BLZ23 rr3t3r_0[46|23]/a_460_290# sky130_fd_pr_reram__reram_cell area_ox=0.0676
X10214 rr3t3r_0[46|23]/a_460_290# WL46 SL23 VSS sky130_fd_pr__nfet_g5v0d10v5 ad=0.65 pd=3.3 as=0 ps=0 w=1 l=0.5
X10215 BLN23 rr3t3r_0[46|23]/a_860_290# sky130_fd_pr_reram__reram_cell area_ox=0.0676
X10216 rr3t3r_0[46|23]/a_60_290# WL46 SL23 VSS sky130_fd_pr__nfet_g5v0d10v5 ad=0.65 pd=3.3 as=0 ps=0 w=1 l=0.5
X10217 rr3t3r_0[46|23]/a_860_290# WL46 SL23 VSS sky130_fd_pr__nfet_g5v0d10v5 ad=0.65 pd=3.3 as=0 ps=0 w=1 l=0.5
X10218 BLP23 rr3t3r_0[47|23]/a_60_290# sky130_fd_pr_reram__reram_cell area_ox=0.0676
X10219 BLZ23 rr3t3r_0[47|23]/a_460_290# sky130_fd_pr_reram__reram_cell area_ox=0.0676
X10220 rr3t3r_0[47|23]/a_460_290# WL47 SL23 VSS sky130_fd_pr__nfet_g5v0d10v5 ad=0.65 pd=3.3 as=0 ps=0 w=1 l=0.5
X10221 BLN23 rr3t3r_0[47|23]/a_860_290# sky130_fd_pr_reram__reram_cell area_ox=0.0676
X10222 rr3t3r_0[47|23]/a_60_290# WL47 SL23 VSS sky130_fd_pr__nfet_g5v0d10v5 ad=0.65 pd=3.3 as=0 ps=0 w=1 l=0.5
X10223 rr3t3r_0[47|23]/a_860_290# WL47 SL23 VSS sky130_fd_pr__nfet_g5v0d10v5 ad=0.65 pd=3.3 as=0 ps=0 w=1 l=0.5
X10224 BLP23 rr3t3r_0[48|23]/a_60_290# sky130_fd_pr_reram__reram_cell area_ox=0.0676
X10225 BLZ23 rr3t3r_0[48|23]/a_460_290# sky130_fd_pr_reram__reram_cell area_ox=0.0676
X10226 rr3t3r_0[48|23]/a_460_290# WL48 SL23 VSS sky130_fd_pr__nfet_g5v0d10v5 ad=0.65 pd=3.3 as=0 ps=0 w=1 l=0.5
X10227 BLN23 rr3t3r_0[48|23]/a_860_290# sky130_fd_pr_reram__reram_cell area_ox=0.0676
X10228 rr3t3r_0[48|23]/a_60_290# WL48 SL23 VSS sky130_fd_pr__nfet_g5v0d10v5 ad=0.65 pd=3.3 as=0 ps=0 w=1 l=0.5
X10229 rr3t3r_0[48|23]/a_860_290# WL48 SL23 VSS sky130_fd_pr__nfet_g5v0d10v5 ad=0.65 pd=3.3 as=0 ps=0 w=1 l=0.5
X10230 BLP23 rr3t3r_0[49|23]/a_60_290# sky130_fd_pr_reram__reram_cell area_ox=0.0676
X10231 BLZ23 rr3t3r_0[49|23]/a_460_290# sky130_fd_pr_reram__reram_cell area_ox=0.0676
X10232 rr3t3r_0[49|23]/a_460_290# WL49 SL23 VSS sky130_fd_pr__nfet_g5v0d10v5 ad=0.65 pd=3.3 as=0 ps=0 w=1 l=0.5
X10233 BLN23 rr3t3r_0[49|23]/a_860_290# sky130_fd_pr_reram__reram_cell area_ox=0.0676
X10234 rr3t3r_0[49|23]/a_60_290# WL49 SL23 VSS sky130_fd_pr__nfet_g5v0d10v5 ad=0.65 pd=3.3 as=0 ps=0 w=1 l=0.5
X10235 rr3t3r_0[49|23]/a_860_290# WL49 SL23 VSS sky130_fd_pr__nfet_g5v0d10v5 ad=0.65 pd=3.3 as=0 ps=0 w=1 l=0.5
X10236 BLP23 rr3t3r_0[50|23]/a_60_290# sky130_fd_pr_reram__reram_cell area_ox=0.0676
X10237 BLZ23 rr3t3r_0[50|23]/a_460_290# sky130_fd_pr_reram__reram_cell area_ox=0.0676
X10238 rr3t3r_0[50|23]/a_460_290# WL50 SL23 VSS sky130_fd_pr__nfet_g5v0d10v5 ad=0.65 pd=3.3 as=0 ps=0 w=1 l=0.5
X10239 BLN23 rr3t3r_0[50|23]/a_860_290# sky130_fd_pr_reram__reram_cell area_ox=0.0676
X10240 rr3t3r_0[50|23]/a_60_290# WL50 SL23 VSS sky130_fd_pr__nfet_g5v0d10v5 ad=0.65 pd=3.3 as=0 ps=0 w=1 l=0.5
X10241 rr3t3r_0[50|23]/a_860_290# WL50 SL23 VSS sky130_fd_pr__nfet_g5v0d10v5 ad=0.65 pd=3.3 as=0 ps=0 w=1 l=0.5
X10242 BLP23 rr3t3r_0[51|23]/a_60_290# sky130_fd_pr_reram__reram_cell area_ox=0.0676
X10243 BLZ23 rr3t3r_0[51|23]/a_460_290# sky130_fd_pr_reram__reram_cell area_ox=0.0676
X10244 rr3t3r_0[51|23]/a_460_290# WL51 SL23 VSS sky130_fd_pr__nfet_g5v0d10v5 ad=0.65 pd=3.3 as=0 ps=0 w=1 l=0.5
X10245 BLN23 rr3t3r_0[51|23]/a_860_290# sky130_fd_pr_reram__reram_cell area_ox=0.0676
X10246 rr3t3r_0[51|23]/a_60_290# WL51 SL23 VSS sky130_fd_pr__nfet_g5v0d10v5 ad=0.65 pd=3.3 as=0 ps=0 w=1 l=0.5
X10247 rr3t3r_0[51|23]/a_860_290# WL51 SL23 VSS sky130_fd_pr__nfet_g5v0d10v5 ad=0.65 pd=3.3 as=0 ps=0 w=1 l=0.5
X10248 BLP23 rr3t3r_0[52|23]/a_60_290# sky130_fd_pr_reram__reram_cell area_ox=0.0676
X10249 BLZ23 rr3t3r_0[52|23]/a_460_290# sky130_fd_pr_reram__reram_cell area_ox=0.0676
X10250 rr3t3r_0[52|23]/a_460_290# WL52 SL23 VSS sky130_fd_pr__nfet_g5v0d10v5 ad=0.65 pd=3.3 as=0 ps=0 w=1 l=0.5
X10251 BLN23 rr3t3r_0[52|23]/a_860_290# sky130_fd_pr_reram__reram_cell area_ox=0.0676
X10252 rr3t3r_0[52|23]/a_60_290# WL52 SL23 VSS sky130_fd_pr__nfet_g5v0d10v5 ad=0.65 pd=3.3 as=0 ps=0 w=1 l=0.5
X10253 rr3t3r_0[52|23]/a_860_290# WL52 SL23 VSS sky130_fd_pr__nfet_g5v0d10v5 ad=0.65 pd=3.3 as=0 ps=0 w=1 l=0.5
X10254 BLP23 rr3t3r_0[53|23]/a_60_290# sky130_fd_pr_reram__reram_cell area_ox=0.0676
X10255 BLZ23 rr3t3r_0[53|23]/a_460_290# sky130_fd_pr_reram__reram_cell area_ox=0.0676
X10256 rr3t3r_0[53|23]/a_460_290# WL53 SL23 VSS sky130_fd_pr__nfet_g5v0d10v5 ad=0.65 pd=3.3 as=0 ps=0 w=1 l=0.5
X10257 BLN23 rr3t3r_0[53|23]/a_860_290# sky130_fd_pr_reram__reram_cell area_ox=0.0676
X10258 rr3t3r_0[53|23]/a_60_290# WL53 SL23 VSS sky130_fd_pr__nfet_g5v0d10v5 ad=0.65 pd=3.3 as=0 ps=0 w=1 l=0.5
X10259 rr3t3r_0[53|23]/a_860_290# WL53 SL23 VSS sky130_fd_pr__nfet_g5v0d10v5 ad=0.65 pd=3.3 as=0 ps=0 w=1 l=0.5
X10260 BLP23 rr3t3r_0[54|23]/a_60_290# sky130_fd_pr_reram__reram_cell area_ox=0.0676
X10261 BLZ23 rr3t3r_0[54|23]/a_460_290# sky130_fd_pr_reram__reram_cell area_ox=0.0676
X10262 rr3t3r_0[54|23]/a_460_290# WL54 SL23 VSS sky130_fd_pr__nfet_g5v0d10v5 ad=0.65 pd=3.3 as=0 ps=0 w=1 l=0.5
X10263 BLN23 rr3t3r_0[54|23]/a_860_290# sky130_fd_pr_reram__reram_cell area_ox=0.0676
X10264 rr3t3r_0[54|23]/a_60_290# WL54 SL23 VSS sky130_fd_pr__nfet_g5v0d10v5 ad=0.65 pd=3.3 as=0 ps=0 w=1 l=0.5
X10265 rr3t3r_0[54|23]/a_860_290# WL54 SL23 VSS sky130_fd_pr__nfet_g5v0d10v5 ad=0.65 pd=3.3 as=0 ps=0 w=1 l=0.5
X10266 BLP23 rr3t3r_0[55|23]/a_60_290# sky130_fd_pr_reram__reram_cell area_ox=0.0676
X10267 BLZ23 rr3t3r_0[55|23]/a_460_290# sky130_fd_pr_reram__reram_cell area_ox=0.0676
X10268 rr3t3r_0[55|23]/a_460_290# WL55 SL23 VSS sky130_fd_pr__nfet_g5v0d10v5 ad=0.65 pd=3.3 as=0 ps=0 w=1 l=0.5
X10269 BLN23 rr3t3r_0[55|23]/a_860_290# sky130_fd_pr_reram__reram_cell area_ox=0.0676
X10270 rr3t3r_0[55|23]/a_60_290# WL55 SL23 VSS sky130_fd_pr__nfet_g5v0d10v5 ad=0.65 pd=3.3 as=0 ps=0 w=1 l=0.5
X10271 rr3t3r_0[55|23]/a_860_290# WL55 SL23 VSS sky130_fd_pr__nfet_g5v0d10v5 ad=0.65 pd=3.3 as=0 ps=0 w=1 l=0.5
X10272 BLP23 rr3t3r_0[56|23]/a_60_290# sky130_fd_pr_reram__reram_cell area_ox=0.0676
X10273 BLZ23 rr3t3r_0[56|23]/a_460_290# sky130_fd_pr_reram__reram_cell area_ox=0.0676
X10274 rr3t3r_0[56|23]/a_460_290# WL56 SL23 VSS sky130_fd_pr__nfet_g5v0d10v5 ad=0.65 pd=3.3 as=0 ps=0 w=1 l=0.5
X10275 BLN23 rr3t3r_0[56|23]/a_860_290# sky130_fd_pr_reram__reram_cell area_ox=0.0676
X10276 rr3t3r_0[56|23]/a_60_290# WL56 SL23 VSS sky130_fd_pr__nfet_g5v0d10v5 ad=0.65 pd=3.3 as=0 ps=0 w=1 l=0.5
X10277 rr3t3r_0[56|23]/a_860_290# WL56 SL23 VSS sky130_fd_pr__nfet_g5v0d10v5 ad=0.65 pd=3.3 as=0 ps=0 w=1 l=0.5
X10278 BLP23 rr3t3r_0[57|23]/a_60_290# sky130_fd_pr_reram__reram_cell area_ox=0.0676
X10279 BLZ23 rr3t3r_0[57|23]/a_460_290# sky130_fd_pr_reram__reram_cell area_ox=0.0676
X10280 rr3t3r_0[57|23]/a_460_290# WL57 SL23 VSS sky130_fd_pr__nfet_g5v0d10v5 ad=0.65 pd=3.3 as=0 ps=0 w=1 l=0.5
X10281 BLN23 rr3t3r_0[57|23]/a_860_290# sky130_fd_pr_reram__reram_cell area_ox=0.0676
X10282 rr3t3r_0[57|23]/a_60_290# WL57 SL23 VSS sky130_fd_pr__nfet_g5v0d10v5 ad=0.65 pd=3.3 as=0 ps=0 w=1 l=0.5
X10283 rr3t3r_0[57|23]/a_860_290# WL57 SL23 VSS sky130_fd_pr__nfet_g5v0d10v5 ad=0.65 pd=3.3 as=0 ps=0 w=1 l=0.5
X10284 BLP23 rr3t3r_0[58|23]/a_60_290# sky130_fd_pr_reram__reram_cell area_ox=0.0676
X10285 BLZ23 rr3t3r_0[58|23]/a_460_290# sky130_fd_pr_reram__reram_cell area_ox=0.0676
X10286 rr3t3r_0[58|23]/a_460_290# WL58 SL23 VSS sky130_fd_pr__nfet_g5v0d10v5 ad=0.65 pd=3.3 as=0 ps=0 w=1 l=0.5
X10287 BLN23 rr3t3r_0[58|23]/a_860_290# sky130_fd_pr_reram__reram_cell area_ox=0.0676
X10288 rr3t3r_0[58|23]/a_60_290# WL58 SL23 VSS sky130_fd_pr__nfet_g5v0d10v5 ad=0.65 pd=3.3 as=0 ps=0 w=1 l=0.5
X10289 rr3t3r_0[58|23]/a_860_290# WL58 SL23 VSS sky130_fd_pr__nfet_g5v0d10v5 ad=0.65 pd=3.3 as=0 ps=0 w=1 l=0.5
X10290 BLP23 rr3t3r_0[59|23]/a_60_290# sky130_fd_pr_reram__reram_cell area_ox=0.0676
X10291 BLZ23 rr3t3r_0[59|23]/a_460_290# sky130_fd_pr_reram__reram_cell area_ox=0.0676
X10292 rr3t3r_0[59|23]/a_460_290# WL59 SL23 VSS sky130_fd_pr__nfet_g5v0d10v5 ad=0.65 pd=3.3 as=0 ps=0 w=1 l=0.5
X10293 BLN23 rr3t3r_0[59|23]/a_860_290# sky130_fd_pr_reram__reram_cell area_ox=0.0676
X10294 rr3t3r_0[59|23]/a_60_290# WL59 SL23 VSS sky130_fd_pr__nfet_g5v0d10v5 ad=0.65 pd=3.3 as=0 ps=0 w=1 l=0.5
X10295 rr3t3r_0[59|23]/a_860_290# WL59 SL23 VSS sky130_fd_pr__nfet_g5v0d10v5 ad=0.65 pd=3.3 as=0 ps=0 w=1 l=0.5
X10296 BLP23 rr3t3r_0[60|23]/a_60_290# sky130_fd_pr_reram__reram_cell area_ox=0.0676
X10297 BLZ23 rr3t3r_0[60|23]/a_460_290# sky130_fd_pr_reram__reram_cell area_ox=0.0676
X10298 rr3t3r_0[60|23]/a_460_290# WL60 SL23 VSS sky130_fd_pr__nfet_g5v0d10v5 ad=0.65 pd=3.3 as=0 ps=0 w=1 l=0.5
X10299 BLN23 rr3t3r_0[60|23]/a_860_290# sky130_fd_pr_reram__reram_cell area_ox=0.0676
X10300 rr3t3r_0[60|23]/a_60_290# WL60 SL23 VSS sky130_fd_pr__nfet_g5v0d10v5 ad=0.65 pd=3.3 as=0 ps=0 w=1 l=0.5
X10301 rr3t3r_0[60|23]/a_860_290# WL60 SL23 VSS sky130_fd_pr__nfet_g5v0d10v5 ad=0.65 pd=3.3 as=0 ps=0 w=1 l=0.5
X10302 BLP23 rr3t3r_0[61|23]/a_60_290# sky130_fd_pr_reram__reram_cell area_ox=0.0676
X10303 BLZ23 rr3t3r_0[61|23]/a_460_290# sky130_fd_pr_reram__reram_cell area_ox=0.0676
X10304 rr3t3r_0[61|23]/a_460_290# WL61 SL23 VSS sky130_fd_pr__nfet_g5v0d10v5 ad=0.65 pd=3.3 as=0 ps=0 w=1 l=0.5
X10305 BLN23 rr3t3r_0[61|23]/a_860_290# sky130_fd_pr_reram__reram_cell area_ox=0.0676
X10306 rr3t3r_0[61|23]/a_60_290# WL61 SL23 VSS sky130_fd_pr__nfet_g5v0d10v5 ad=0.65 pd=3.3 as=0 ps=0 w=1 l=0.5
X10307 rr3t3r_0[61|23]/a_860_290# WL61 SL23 VSS sky130_fd_pr__nfet_g5v0d10v5 ad=0.65 pd=3.3 as=0 ps=0 w=1 l=0.5
X10308 BLP23 rr3t3r_0[62|23]/a_60_290# sky130_fd_pr_reram__reram_cell area_ox=0.0676
X10309 BLZ23 rr3t3r_0[62|23]/a_460_290# sky130_fd_pr_reram__reram_cell area_ox=0.0676
X10310 rr3t3r_0[62|23]/a_460_290# WL62 SL23 VSS sky130_fd_pr__nfet_g5v0d10v5 ad=0.65 pd=3.3 as=0 ps=0 w=1 l=0.5
X10311 BLN23 rr3t3r_0[62|23]/a_860_290# sky130_fd_pr_reram__reram_cell area_ox=0.0676
X10312 rr3t3r_0[62|23]/a_60_290# WL62 SL23 VSS sky130_fd_pr__nfet_g5v0d10v5 ad=0.65 pd=3.3 as=0 ps=0 w=1 l=0.5
X10313 rr3t3r_0[62|23]/a_860_290# WL62 SL23 VSS sky130_fd_pr__nfet_g5v0d10v5 ad=0.65 pd=3.3 as=0 ps=0 w=1 l=0.5
X10314 BLP23 rr3t3r_0[63|23]/a_60_290# sky130_fd_pr_reram__reram_cell area_ox=0.0676
X10315 BLZ23 rr3t3r_0[63|23]/a_460_290# sky130_fd_pr_reram__reram_cell area_ox=0.0676
X10316 rr3t3r_0[63|23]/a_460_290# WL63 SL23 VSS sky130_fd_pr__nfet_g5v0d10v5 ad=0.65 pd=3.3 as=0 ps=0 w=1 l=0.5
X10317 BLN23 rr3t3r_0[63|23]/a_860_290# sky130_fd_pr_reram__reram_cell area_ox=0.0676
X10318 rr3t3r_0[63|23]/a_60_290# WL63 SL23 VSS sky130_fd_pr__nfet_g5v0d10v5 ad=0.65 pd=3.3 as=0 ps=0 w=1 l=0.5
X10319 rr3t3r_0[63|23]/a_860_290# WL63 SL23 VSS sky130_fd_pr__nfet_g5v0d10v5 ad=0.65 pd=3.3 as=0 ps=0 w=1 l=0.5
X10320 BLP23 rr3t3r_0[64|23]/a_60_290# sky130_fd_pr_reram__reram_cell area_ox=0.0676
X10321 BLZ23 rr3t3r_0[64|23]/a_460_290# sky130_fd_pr_reram__reram_cell area_ox=0.0676
X10322 rr3t3r_0[64|23]/a_460_290# WL64 SL23 VSS sky130_fd_pr__nfet_g5v0d10v5 ad=0.65 pd=3.3 as=0 ps=0 w=1 l=0.5
X10323 BLN23 rr3t3r_0[64|23]/a_860_290# sky130_fd_pr_reram__reram_cell area_ox=0.0676
X10324 rr3t3r_0[64|23]/a_60_290# WL64 SL23 VSS sky130_fd_pr__nfet_g5v0d10v5 ad=0.65 pd=3.3 as=0 ps=0 w=1 l=0.5
X10325 rr3t3r_0[64|23]/a_860_290# WL64 SL23 VSS sky130_fd_pr__nfet_g5v0d10v5 ad=0.65 pd=3.3 as=0 ps=0 w=1 l=0.5
X10326 BLP23 rr3t3r_0[65|23]/a_60_290# sky130_fd_pr_reram__reram_cell area_ox=0.0676
X10327 BLZ23 rr3t3r_0[65|23]/a_460_290# sky130_fd_pr_reram__reram_cell area_ox=0.0676
X10328 rr3t3r_0[65|23]/a_460_290# WL65 SL23 VSS sky130_fd_pr__nfet_g5v0d10v5 ad=0.65 pd=3.3 as=0 ps=0 w=1 l=0.5
X10329 BLN23 rr3t3r_0[65|23]/a_860_290# sky130_fd_pr_reram__reram_cell area_ox=0.0676
X10330 rr3t3r_0[65|23]/a_60_290# WL65 SL23 VSS sky130_fd_pr__nfet_g5v0d10v5 ad=0.65 pd=3.3 as=0 ps=0 w=1 l=0.5
X10331 rr3t3r_0[65|23]/a_860_290# WL65 SL23 VSS sky130_fd_pr__nfet_g5v0d10v5 ad=0.65 pd=3.3 as=0 ps=0 w=1 l=0.5
X10332 BLP23 rr3t3r_0[66|23]/a_60_290# sky130_fd_pr_reram__reram_cell area_ox=0.0676
X10333 BLZ23 rr3t3r_0[66|23]/a_460_290# sky130_fd_pr_reram__reram_cell area_ox=0.0676
X10334 rr3t3r_0[66|23]/a_460_290# WL66 SL23 VSS sky130_fd_pr__nfet_g5v0d10v5 ad=0.65 pd=3.3 as=0 ps=0 w=1 l=0.5
X10335 BLN23 rr3t3r_0[66|23]/a_860_290# sky130_fd_pr_reram__reram_cell area_ox=0.0676
X10336 rr3t3r_0[66|23]/a_60_290# WL66 SL23 VSS sky130_fd_pr__nfet_g5v0d10v5 ad=0.65 pd=3.3 as=0 ps=0 w=1 l=0.5
X10337 rr3t3r_0[66|23]/a_860_290# WL66 SL23 VSS sky130_fd_pr__nfet_g5v0d10v5 ad=0.65 pd=3.3 as=0 ps=0 w=1 l=0.5
X10338 BLP23 rr3t3r_0[67|23]/a_60_290# sky130_fd_pr_reram__reram_cell area_ox=0.0676
X10339 BLZ23 rr3t3r_0[67|23]/a_460_290# sky130_fd_pr_reram__reram_cell area_ox=0.0676
X10340 rr3t3r_0[67|23]/a_460_290# WL67 SL23 VSS sky130_fd_pr__nfet_g5v0d10v5 ad=0.65 pd=3.3 as=0 ps=0 w=1 l=0.5
X10341 BLN23 rr3t3r_0[67|23]/a_860_290# sky130_fd_pr_reram__reram_cell area_ox=0.0676
X10342 rr3t3r_0[67|23]/a_60_290# WL67 SL23 VSS sky130_fd_pr__nfet_g5v0d10v5 ad=0.65 pd=3.3 as=0 ps=0 w=1 l=0.5
X10343 rr3t3r_0[67|23]/a_860_290# WL67 SL23 VSS sky130_fd_pr__nfet_g5v0d10v5 ad=0.65 pd=3.3 as=0 ps=0 w=1 l=0.5
X10344 BLP23 rr3t3r_0[68|23]/a_60_290# sky130_fd_pr_reram__reram_cell area_ox=0.0676
X10345 BLZ23 rr3t3r_0[68|23]/a_460_290# sky130_fd_pr_reram__reram_cell area_ox=0.0676
X10346 rr3t3r_0[68|23]/a_460_290# WL68 SL23 VSS sky130_fd_pr__nfet_g5v0d10v5 ad=0.65 pd=3.3 as=0 ps=0 w=1 l=0.5
X10347 BLN23 rr3t3r_0[68|23]/a_860_290# sky130_fd_pr_reram__reram_cell area_ox=0.0676
X10348 rr3t3r_0[68|23]/a_60_290# WL68 SL23 VSS sky130_fd_pr__nfet_g5v0d10v5 ad=0.65 pd=3.3 as=0 ps=0 w=1 l=0.5
X10349 rr3t3r_0[68|23]/a_860_290# WL68 SL23 VSS sky130_fd_pr__nfet_g5v0d10v5 ad=0.65 pd=3.3 as=0 ps=0 w=1 l=0.5
X10350 BLP23 rr3t3r_0[69|23]/a_60_290# sky130_fd_pr_reram__reram_cell area_ox=0.0676
X10351 BLZ23 rr3t3r_0[69|23]/a_460_290# sky130_fd_pr_reram__reram_cell area_ox=0.0676
X10352 rr3t3r_0[69|23]/a_460_290# WL69 SL23 VSS sky130_fd_pr__nfet_g5v0d10v5 ad=0.65 pd=3.3 as=0 ps=0 w=1 l=0.5
X10353 BLN23 rr3t3r_0[69|23]/a_860_290# sky130_fd_pr_reram__reram_cell area_ox=0.0676
X10354 rr3t3r_0[69|23]/a_60_290# WL69 SL23 VSS sky130_fd_pr__nfet_g5v0d10v5 ad=0.65 pd=3.3 as=0 ps=0 w=1 l=0.5
X10355 rr3t3r_0[69|23]/a_860_290# WL69 SL23 VSS sky130_fd_pr__nfet_g5v0d10v5 ad=0.65 pd=3.3 as=0 ps=0 w=1 l=0.5
X10356 BLP23 rr3t3r_0[70|23]/a_60_290# sky130_fd_pr_reram__reram_cell area_ox=0.0676
X10357 BLZ23 rr3t3r_0[70|23]/a_460_290# sky130_fd_pr_reram__reram_cell area_ox=0.0676
X10358 rr3t3r_0[70|23]/a_460_290# WL70 SL23 VSS sky130_fd_pr__nfet_g5v0d10v5 ad=0.65 pd=3.3 as=0 ps=0 w=1 l=0.5
X10359 BLN23 rr3t3r_0[70|23]/a_860_290# sky130_fd_pr_reram__reram_cell area_ox=0.0676
X10360 rr3t3r_0[70|23]/a_60_290# WL70 SL23 VSS sky130_fd_pr__nfet_g5v0d10v5 ad=0.65 pd=3.3 as=0 ps=0 w=1 l=0.5
X10361 rr3t3r_0[70|23]/a_860_290# WL70 SL23 VSS sky130_fd_pr__nfet_g5v0d10v5 ad=0.65 pd=3.3 as=0 ps=0 w=1 l=0.5
X10362 BLP23 rr3t3r_0[71|23]/a_60_290# sky130_fd_pr_reram__reram_cell area_ox=0.0676
X10363 BLZ23 rr3t3r_0[71|23]/a_460_290# sky130_fd_pr_reram__reram_cell area_ox=0.0676
X10364 rr3t3r_0[71|23]/a_460_290# WL71 SL23 VSS sky130_fd_pr__nfet_g5v0d10v5 ad=0.65 pd=3.3 as=0 ps=0 w=1 l=0.5
X10365 BLN23 rr3t3r_0[71|23]/a_860_290# sky130_fd_pr_reram__reram_cell area_ox=0.0676
X10366 rr3t3r_0[71|23]/a_60_290# WL71 SL23 VSS sky130_fd_pr__nfet_g5v0d10v5 ad=0.65 pd=3.3 as=0 ps=0 w=1 l=0.5
X10367 rr3t3r_0[71|23]/a_860_290# WL71 SL23 VSS sky130_fd_pr__nfet_g5v0d10v5 ad=0.65 pd=3.3 as=0 ps=0 w=1 l=0.5
.ends
