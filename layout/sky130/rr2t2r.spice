* NGSPICE file created from rr2t2r.ext - technology: sky130B

.subckt rr2t2r
X0 a_460_290# a_0_190# a_60_40# a_0_494# sky130_fd_pr__nfet_g5v0d10v5 ad=0.65 pd=3.3 as=0.75 ps=3.5 w=1 l=0.5
X1 m2_124_0# a_60_290# sky130_fd_pr_reram__reram_cell area_ox=0.0676
X2 m2_524_0# a_460_290# sky130_fd_pr_reram__reram_cell area_ox=0.0676
X3 a_60_290# a_0_190# a_60_40# a_0_494# sky130_fd_pr__nfet_g5v0d10v5 ad=0.65 pd=3.3 as=0.75 ps=3.5 w=1 l=0.5
.ends
