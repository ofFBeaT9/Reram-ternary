* schematic netlist of layout/tcim_wld72.gds: 72 word-line drivers
.SUBCKT tcim_wld72 in0 in1 in2 in3 in4 in5 in6 in7 in8 in9 in10 in11 in12 in13 in14 in15
+ in16 in17 in18 in19 in20 in21 in22 in23 in24 in25 in26 in27 in28 in29 in30 in31
+ in32 in33 in34 in35 in36 in37 in38 in39 in40 in41 in42 in43 in44 in45 in46 in47
+ in48 in49 in50 in51 in52 in53 in54 in55 in56 in57 in58 in59 in60 in61 in62 in63
+ in64 in65 in66 in67 in68 in69 in70 in71 out0 out1 out2 out3 out4 out5 out6 out7
+ out8 out9 out10 out11 out12 out13 out14 out15 out16 out17 out18 out19 out20 out21 out22 out23
+ out24 out25 out26 out27 out28 out29 out30 out31 out32 out33 out34 out35 out36 out37 out38 out39
+ out40 out41 out42 out43 out44 out45 out46 out47 out48 out49 out50 out51 out52 out53 out54 out55
+ out56 out57 out58 out59 out60 out61 out62 out63 out64 out65 out66 out67 out68 out69 out70 out71
+ vss vr
M0 out0 in0 vss vss sg13_hv_nmos w=6u l=0.45u ng=1 m=1
M1 out1 in1 vss vss sg13_hv_nmos w=6u l=0.45u ng=1 m=1
M2 out0 in0 vr vr sg13_hv_pmos w=12u l=0.45u ng=1 m=1
M3 out1 in1 vr vr sg13_hv_pmos w=12u l=0.45u ng=1 m=1
M4 out2 in2 vss vss sg13_hv_nmos w=6u l=0.45u ng=1 m=1
M5 out3 in3 vss vss sg13_hv_nmos w=6u l=0.45u ng=1 m=1
M6 out2 in2 vr vr sg13_hv_pmos w=12u l=0.45u ng=1 m=1
M7 out3 in3 vr vr sg13_hv_pmos w=12u l=0.45u ng=1 m=1
M8 out4 in4 vss vss sg13_hv_nmos w=6u l=0.45u ng=1 m=1
M9 out5 in5 vss vss sg13_hv_nmos w=6u l=0.45u ng=1 m=1
M10 out4 in4 vr vr sg13_hv_pmos w=12u l=0.45u ng=1 m=1
M11 out5 in5 vr vr sg13_hv_pmos w=12u l=0.45u ng=1 m=1
M12 out6 in6 vss vss sg13_hv_nmos w=6u l=0.45u ng=1 m=1
M13 out7 in7 vss vss sg13_hv_nmos w=6u l=0.45u ng=1 m=1
M14 out6 in6 vr vr sg13_hv_pmos w=12u l=0.45u ng=1 m=1
M15 out7 in7 vr vr sg13_hv_pmos w=12u l=0.45u ng=1 m=1
M16 out8 in8 vss vss sg13_hv_nmos w=6u l=0.45u ng=1 m=1
M17 out9 in9 vss vss sg13_hv_nmos w=6u l=0.45u ng=1 m=1
M18 out8 in8 vr vr sg13_hv_pmos w=12u l=0.45u ng=1 m=1
M19 out9 in9 vr vr sg13_hv_pmos w=12u l=0.45u ng=1 m=1
M20 out10 in10 vss vss sg13_hv_nmos w=6u l=0.45u ng=1 m=1
M21 out11 in11 vss vss sg13_hv_nmos w=6u l=0.45u ng=1 m=1
M22 out10 in10 vr vr sg13_hv_pmos w=12u l=0.45u ng=1 m=1
M23 out11 in11 vr vr sg13_hv_pmos w=12u l=0.45u ng=1 m=1
M24 out12 in12 vss vss sg13_hv_nmos w=6u l=0.45u ng=1 m=1
M25 out13 in13 vss vss sg13_hv_nmos w=6u l=0.45u ng=1 m=1
M26 out12 in12 vr vr sg13_hv_pmos w=12u l=0.45u ng=1 m=1
M27 out13 in13 vr vr sg13_hv_pmos w=12u l=0.45u ng=1 m=1
M28 out14 in14 vss vss sg13_hv_nmos w=6u l=0.45u ng=1 m=1
M29 out15 in15 vss vss sg13_hv_nmos w=6u l=0.45u ng=1 m=1
M30 out14 in14 vr vr sg13_hv_pmos w=12u l=0.45u ng=1 m=1
M31 out15 in15 vr vr sg13_hv_pmos w=12u l=0.45u ng=1 m=1
M32 out16 in16 vss vss sg13_hv_nmos w=6u l=0.45u ng=1 m=1
M33 out17 in17 vss vss sg13_hv_nmos w=6u l=0.45u ng=1 m=1
M34 out16 in16 vr vr sg13_hv_pmos w=12u l=0.45u ng=1 m=1
M35 out17 in17 vr vr sg13_hv_pmos w=12u l=0.45u ng=1 m=1
M36 out18 in18 vss vss sg13_hv_nmos w=6u l=0.45u ng=1 m=1
M37 out19 in19 vss vss sg13_hv_nmos w=6u l=0.45u ng=1 m=1
M38 out18 in18 vr vr sg13_hv_pmos w=12u l=0.45u ng=1 m=1
M39 out19 in19 vr vr sg13_hv_pmos w=12u l=0.45u ng=1 m=1
M40 out20 in20 vss vss sg13_hv_nmos w=6u l=0.45u ng=1 m=1
M41 out21 in21 vss vss sg13_hv_nmos w=6u l=0.45u ng=1 m=1
M42 out20 in20 vr vr sg13_hv_pmos w=12u l=0.45u ng=1 m=1
M43 out21 in21 vr vr sg13_hv_pmos w=12u l=0.45u ng=1 m=1
M44 out22 in22 vss vss sg13_hv_nmos w=6u l=0.45u ng=1 m=1
M45 out23 in23 vss vss sg13_hv_nmos w=6u l=0.45u ng=1 m=1
M46 out22 in22 vr vr sg13_hv_pmos w=12u l=0.45u ng=1 m=1
M47 out23 in23 vr vr sg13_hv_pmos w=12u l=0.45u ng=1 m=1
M48 out24 in24 vss vss sg13_hv_nmos w=6u l=0.45u ng=1 m=1
M49 out25 in25 vss vss sg13_hv_nmos w=6u l=0.45u ng=1 m=1
M50 out24 in24 vr vr sg13_hv_pmos w=12u l=0.45u ng=1 m=1
M51 out25 in25 vr vr sg13_hv_pmos w=12u l=0.45u ng=1 m=1
M52 out26 in26 vss vss sg13_hv_nmos w=6u l=0.45u ng=1 m=1
M53 out27 in27 vss vss sg13_hv_nmos w=6u l=0.45u ng=1 m=1
M54 out26 in26 vr vr sg13_hv_pmos w=12u l=0.45u ng=1 m=1
M55 out27 in27 vr vr sg13_hv_pmos w=12u l=0.45u ng=1 m=1
M56 out28 in28 vss vss sg13_hv_nmos w=6u l=0.45u ng=1 m=1
M57 out29 in29 vss vss sg13_hv_nmos w=6u l=0.45u ng=1 m=1
M58 out28 in28 vr vr sg13_hv_pmos w=12u l=0.45u ng=1 m=1
M59 out29 in29 vr vr sg13_hv_pmos w=12u l=0.45u ng=1 m=1
M60 out30 in30 vss vss sg13_hv_nmos w=6u l=0.45u ng=1 m=1
M61 out31 in31 vss vss sg13_hv_nmos w=6u l=0.45u ng=1 m=1
M62 out30 in30 vr vr sg13_hv_pmos w=12u l=0.45u ng=1 m=1
M63 out31 in31 vr vr sg13_hv_pmos w=12u l=0.45u ng=1 m=1
M64 out32 in32 vss vss sg13_hv_nmos w=6u l=0.45u ng=1 m=1
M65 out33 in33 vss vss sg13_hv_nmos w=6u l=0.45u ng=1 m=1
M66 out32 in32 vr vr sg13_hv_pmos w=12u l=0.45u ng=1 m=1
M67 out33 in33 vr vr sg13_hv_pmos w=12u l=0.45u ng=1 m=1
M68 out34 in34 vss vss sg13_hv_nmos w=6u l=0.45u ng=1 m=1
M69 out35 in35 vss vss sg13_hv_nmos w=6u l=0.45u ng=1 m=1
M70 out34 in34 vr vr sg13_hv_pmos w=12u l=0.45u ng=1 m=1
M71 out35 in35 vr vr sg13_hv_pmos w=12u l=0.45u ng=1 m=1
M72 out36 in36 vss vss sg13_hv_nmos w=6u l=0.45u ng=1 m=1
M73 out37 in37 vss vss sg13_hv_nmos w=6u l=0.45u ng=1 m=1
M74 out36 in36 vr vr sg13_hv_pmos w=12u l=0.45u ng=1 m=1
M75 out37 in37 vr vr sg13_hv_pmos w=12u l=0.45u ng=1 m=1
M76 out38 in38 vss vss sg13_hv_nmos w=6u l=0.45u ng=1 m=1
M77 out39 in39 vss vss sg13_hv_nmos w=6u l=0.45u ng=1 m=1
M78 out38 in38 vr vr sg13_hv_pmos w=12u l=0.45u ng=1 m=1
M79 out39 in39 vr vr sg13_hv_pmos w=12u l=0.45u ng=1 m=1
M80 out40 in40 vss vss sg13_hv_nmos w=6u l=0.45u ng=1 m=1
M81 out41 in41 vss vss sg13_hv_nmos w=6u l=0.45u ng=1 m=1
M82 out40 in40 vr vr sg13_hv_pmos w=12u l=0.45u ng=1 m=1
M83 out41 in41 vr vr sg13_hv_pmos w=12u l=0.45u ng=1 m=1
M84 out42 in42 vss vss sg13_hv_nmos w=6u l=0.45u ng=1 m=1
M85 out43 in43 vss vss sg13_hv_nmos w=6u l=0.45u ng=1 m=1
M86 out42 in42 vr vr sg13_hv_pmos w=12u l=0.45u ng=1 m=1
M87 out43 in43 vr vr sg13_hv_pmos w=12u l=0.45u ng=1 m=1
M88 out44 in44 vss vss sg13_hv_nmos w=6u l=0.45u ng=1 m=1
M89 out45 in45 vss vss sg13_hv_nmos w=6u l=0.45u ng=1 m=1
M90 out44 in44 vr vr sg13_hv_pmos w=12u l=0.45u ng=1 m=1
M91 out45 in45 vr vr sg13_hv_pmos w=12u l=0.45u ng=1 m=1
M92 out46 in46 vss vss sg13_hv_nmos w=6u l=0.45u ng=1 m=1
M93 out47 in47 vss vss sg13_hv_nmos w=6u l=0.45u ng=1 m=1
M94 out46 in46 vr vr sg13_hv_pmos w=12u l=0.45u ng=1 m=1
M95 out47 in47 vr vr sg13_hv_pmos w=12u l=0.45u ng=1 m=1
M96 out48 in48 vss vss sg13_hv_nmos w=6u l=0.45u ng=1 m=1
M97 out49 in49 vss vss sg13_hv_nmos w=6u l=0.45u ng=1 m=1
M98 out48 in48 vr vr sg13_hv_pmos w=12u l=0.45u ng=1 m=1
M99 out49 in49 vr vr sg13_hv_pmos w=12u l=0.45u ng=1 m=1
M100 out50 in50 vss vss sg13_hv_nmos w=6u l=0.45u ng=1 m=1
M101 out51 in51 vss vss sg13_hv_nmos w=6u l=0.45u ng=1 m=1
M102 out50 in50 vr vr sg13_hv_pmos w=12u l=0.45u ng=1 m=1
M103 out51 in51 vr vr sg13_hv_pmos w=12u l=0.45u ng=1 m=1
M104 out52 in52 vss vss sg13_hv_nmos w=6u l=0.45u ng=1 m=1
M105 out53 in53 vss vss sg13_hv_nmos w=6u l=0.45u ng=1 m=1
M106 out52 in52 vr vr sg13_hv_pmos w=12u l=0.45u ng=1 m=1
M107 out53 in53 vr vr sg13_hv_pmos w=12u l=0.45u ng=1 m=1
M108 out54 in54 vss vss sg13_hv_nmos w=6u l=0.45u ng=1 m=1
M109 out55 in55 vss vss sg13_hv_nmos w=6u l=0.45u ng=1 m=1
M110 out54 in54 vr vr sg13_hv_pmos w=12u l=0.45u ng=1 m=1
M111 out55 in55 vr vr sg13_hv_pmos w=12u l=0.45u ng=1 m=1
M112 out56 in56 vss vss sg13_hv_nmos w=6u l=0.45u ng=1 m=1
M113 out57 in57 vss vss sg13_hv_nmos w=6u l=0.45u ng=1 m=1
M114 out56 in56 vr vr sg13_hv_pmos w=12u l=0.45u ng=1 m=1
M115 out57 in57 vr vr sg13_hv_pmos w=12u l=0.45u ng=1 m=1
M116 out58 in58 vss vss sg13_hv_nmos w=6u l=0.45u ng=1 m=1
M117 out59 in59 vss vss sg13_hv_nmos w=6u l=0.45u ng=1 m=1
M118 out58 in58 vr vr sg13_hv_pmos w=12u l=0.45u ng=1 m=1
M119 out59 in59 vr vr sg13_hv_pmos w=12u l=0.45u ng=1 m=1
M120 out60 in60 vss vss sg13_hv_nmos w=6u l=0.45u ng=1 m=1
M121 out61 in61 vss vss sg13_hv_nmos w=6u l=0.45u ng=1 m=1
M122 out60 in60 vr vr sg13_hv_pmos w=12u l=0.45u ng=1 m=1
M123 out61 in61 vr vr sg13_hv_pmos w=12u l=0.45u ng=1 m=1
M124 out62 in62 vss vss sg13_hv_nmos w=6u l=0.45u ng=1 m=1
M125 out63 in63 vss vss sg13_hv_nmos w=6u l=0.45u ng=1 m=1
M126 out62 in62 vr vr sg13_hv_pmos w=12u l=0.45u ng=1 m=1
M127 out63 in63 vr vr sg13_hv_pmos w=12u l=0.45u ng=1 m=1
M128 out64 in64 vss vss sg13_hv_nmos w=6u l=0.45u ng=1 m=1
M129 out65 in65 vss vss sg13_hv_nmos w=6u l=0.45u ng=1 m=1
M130 out64 in64 vr vr sg13_hv_pmos w=12u l=0.45u ng=1 m=1
M131 out65 in65 vr vr sg13_hv_pmos w=12u l=0.45u ng=1 m=1
M132 out66 in66 vss vss sg13_hv_nmos w=6u l=0.45u ng=1 m=1
M133 out67 in67 vss vss sg13_hv_nmos w=6u l=0.45u ng=1 m=1
M134 out66 in66 vr vr sg13_hv_pmos w=12u l=0.45u ng=1 m=1
M135 out67 in67 vr vr sg13_hv_pmos w=12u l=0.45u ng=1 m=1
M136 out68 in68 vss vss sg13_hv_nmos w=6u l=0.45u ng=1 m=1
M137 out69 in69 vss vss sg13_hv_nmos w=6u l=0.45u ng=1 m=1
M138 out68 in68 vr vr sg13_hv_pmos w=12u l=0.45u ng=1 m=1
M139 out69 in69 vr vr sg13_hv_pmos w=12u l=0.45u ng=1 m=1
M140 out70 in70 vss vss sg13_hv_nmos w=6u l=0.45u ng=1 m=1
M141 out71 in71 vss vss sg13_hv_nmos w=6u l=0.45u ng=1 m=1
M142 out70 in70 vr vr sg13_hv_pmos w=12u l=0.45u ng=1 m=1
M143 out71 in71 vr vr sg13_hv_pmos w=12u l=0.45u ng=1 m=1
.ENDS tcim_wld72
